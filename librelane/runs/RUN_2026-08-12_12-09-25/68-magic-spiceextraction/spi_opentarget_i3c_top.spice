* NGSPICE file created from spi_opentarget_i3c_top.ext - technology: gf180mcuD

* Black-box entry subcircuit for gf180mcu_fd_sc_mcu7t5v0__fillcap_16 abstract view
.subckt gf180mcu_fd_sc_mcu7t5v0__fillcap_16 VDD VNW VPW VSS
.ends

* Black-box entry subcircuit for gf180mcu_fd_sc_mcu7t5v0__dffrnq_1 abstract view
.subckt gf180mcu_fd_sc_mcu7t5v0__dffrnq_1 D RN CLK Q VDD VNW VPW VSS
.ends

* Black-box entry subcircuit for gf180mcu_fd_sc_mcu7t5v0__mux2_2 abstract view
.subckt gf180mcu_fd_sc_mcu7t5v0__mux2_2 I0 I1 S Z VDD VNW VPW VSS
.ends

* Black-box entry subcircuit for gf180mcu_fd_sc_mcu7t5v0__or2_1 abstract view
.subckt gf180mcu_fd_sc_mcu7t5v0__or2_1 A1 A2 Z VDD VNW VPW VSS
.ends

* Black-box entry subcircuit for gf180mcu_fd_sc_mcu7t5v0__fill_1 abstract view
.subckt gf180mcu_fd_sc_mcu7t5v0__fill_1 VDD VNW VPW VSS
.ends

* Black-box entry subcircuit for gf180mcu_fd_sc_mcu7t5v0__dffq_1 abstract view
.subckt gf180mcu_fd_sc_mcu7t5v0__dffq_1 D CLK Q VDD VNW VPW VSS
.ends

* Black-box entry subcircuit for gf180mcu_fd_sc_mcu7t5v0__filltie abstract view
.subckt gf180mcu_fd_sc_mcu7t5v0__filltie VDD VSS
.ends

* Black-box entry subcircuit for gf180mcu_fd_sc_mcu7t5v0__fillcap_8 abstract view
.subckt gf180mcu_fd_sc_mcu7t5v0__fillcap_8 VDD VNW VPW VSS
.ends

* Black-box entry subcircuit for gf180mcu_fd_sc_mcu7t5v0__fillcap_4 abstract view
.subckt gf180mcu_fd_sc_mcu7t5v0__fillcap_4 VDD VNW VPW VSS
.ends

* Black-box entry subcircuit for gf180mcu_fd_sc_mcu7t5v0__fillcap_32 abstract view
.subckt gf180mcu_fd_sc_mcu7t5v0__fillcap_32 VDD VNW VPW VSS
.ends

* Black-box entry subcircuit for gf180mcu_fd_sc_mcu7t5v0__fill_2 abstract view
.subckt gf180mcu_fd_sc_mcu7t5v0__fill_2 VDD VNW VPW VSS
.ends

* Black-box entry subcircuit for gf180mcu_fd_sc_mcu7t5v0__clkinv_1 abstract view
.subckt gf180mcu_fd_sc_mcu7t5v0__clkinv_1 I ZN VDD VNW VPW VSS
.ends

* Black-box entry subcircuit for gf180mcu_fd_sc_mcu7t5v0__mux4_1 abstract view
.subckt gf180mcu_fd_sc_mcu7t5v0__mux4_1 I0 I1 I2 I3 S0 S1 Z VDD VNW VPW VSS
.ends

* Black-box entry subcircuit for gf180mcu_fd_sc_mcu7t5v0__oai211_1 abstract view
.subckt gf180mcu_fd_sc_mcu7t5v0__oai211_1 A1 A2 B C ZN VDD VNW VPW VSS
.ends

* Black-box entry subcircuit for gf180mcu_fd_sc_mcu7t5v0__or2_2 abstract view
.subckt gf180mcu_fd_sc_mcu7t5v0__or2_2 A1 A2 Z VDD VNW VPW VSS
.ends

* Black-box entry subcircuit for gf180mcu_fd_sc_mcu7t5v0__aoi21_1 abstract view
.subckt gf180mcu_fd_sc_mcu7t5v0__aoi21_1 A1 A2 B ZN VDD VNW VPW VSS
.ends

* Black-box entry subcircuit for gf180mcu_fd_sc_mcu7t5v0__and3_1 abstract view
.subckt gf180mcu_fd_sc_mcu7t5v0__and3_1 A1 A2 A3 Z VDD VNW VPW VSS
.ends

* Black-box entry subcircuit for gf180mcu_fd_sc_mcu7t5v0__clkbuf_4 abstract view
.subckt gf180mcu_fd_sc_mcu7t5v0__clkbuf_4 I Z VDD VNW VPW VSS
.ends

* Black-box entry subcircuit for gf180mcu_fd_sc_mcu7t5v0__nand2_1 abstract view
.subckt gf180mcu_fd_sc_mcu7t5v0__nand2_1 A1 A2 ZN VDD VNW VPW VSS
.ends

* Black-box entry subcircuit for gf180mcu_fd_sc_mcu7t5v0__aoi22_1 abstract view
.subckt gf180mcu_fd_sc_mcu7t5v0__aoi22_1 A1 A2 B1 B2 ZN VDD VNW VPW VSS
.ends

* Black-box entry subcircuit for gf180mcu_fd_sc_mcu7t5v0__endcap abstract view
.subckt gf180mcu_fd_sc_mcu7t5v0__endcap VDD VSS
.ends

* Black-box entry subcircuit for gf180mcu_fd_sc_mcu7t5v0__oai21_1 abstract view
.subckt gf180mcu_fd_sc_mcu7t5v0__oai21_1 A1 A2 B ZN VDD VNW VPW VSS
.ends

* Black-box entry subcircuit for gf180mcu_fd_sc_mcu7t5v0__nor2_1 abstract view
.subckt gf180mcu_fd_sc_mcu7t5v0__nor2_1 A1 A2 ZN VDD VNW VPW VSS
.ends

* Black-box entry subcircuit for gf180mcu_fd_sc_mcu7t5v0__buf_4 abstract view
.subckt gf180mcu_fd_sc_mcu7t5v0__buf_4 I Z VDD VNW VPW VSS
.ends

* Black-box entry subcircuit for gf180mcu_fd_sc_mcu7t5v0__and2_1 abstract view
.subckt gf180mcu_fd_sc_mcu7t5v0__and2_1 A1 A2 Z VDD VNW VPW VSS
.ends

* Black-box entry subcircuit for gf180mcu_fd_sc_mcu7t5v0__dlyc_1 abstract view
.subckt gf180mcu_fd_sc_mcu7t5v0__dlyc_1 I Z VDD VNW VPW VSS
.ends

* Black-box entry subcircuit for gf180mcu_fd_sc_mcu7t5v0__nor3_1 abstract view
.subckt gf180mcu_fd_sc_mcu7t5v0__nor3_1 A1 A2 A3 ZN VDD VNW VPW VSS
.ends

* Black-box entry subcircuit for gf180mcu_fd_sc_mcu7t5v0__oai31_1 abstract view
.subckt gf180mcu_fd_sc_mcu7t5v0__oai31_1 A1 A2 A3 B ZN VDD VNW VPW VSS
.ends

* Black-box entry subcircuit for gf180mcu_fd_sc_mcu7t5v0__dlyb_1 abstract view
.subckt gf180mcu_fd_sc_mcu7t5v0__dlyb_1 I Z VDD VNW VPW VSS
.ends

* Black-box entry subcircuit for gf180mcu_fd_sc_mcu7t5v0__nor4_1 abstract view
.subckt gf180mcu_fd_sc_mcu7t5v0__nor4_1 A1 A2 A3 A4 ZN VDD VNW VPW VSS
.ends

* Black-box entry subcircuit for gf180mcu_fd_sc_mcu7t5v0__xnor2_1 abstract view
.subckt gf180mcu_fd_sc_mcu7t5v0__xnor2_1 A1 A2 ZN VDD VNW VPW VSS
.ends

* Black-box entry subcircuit for gf180mcu_fd_sc_mcu7t5v0__fillcap_64 abstract view
.subckt gf180mcu_fd_sc_mcu7t5v0__fillcap_64 VDD VNW VPW VSS
.ends

* Black-box entry subcircuit for gf180mcu_fd_sc_mcu7t5v0__aoi211_1 abstract view
.subckt gf180mcu_fd_sc_mcu7t5v0__aoi211_1 A1 A2 B C ZN VDD VNW VPW VSS
.ends

* Black-box entry subcircuit for gf180mcu_fd_sc_mcu7t5v0__nand3_1 abstract view
.subckt gf180mcu_fd_sc_mcu7t5v0__nand3_1 A1 A2 A3 ZN VDD VNW VPW VSS
.ends

* Black-box entry subcircuit for gf180mcu_fd_sc_mcu7t5v0__aoi221_1 abstract view
.subckt gf180mcu_fd_sc_mcu7t5v0__aoi221_1 A1 A2 B1 B2 C ZN VDD VNW VPW VSS
.ends

* Black-box entry subcircuit for gf180mcu_fd_sc_mcu7t5v0__xor2_1 abstract view
.subckt gf180mcu_fd_sc_mcu7t5v0__xor2_1 A1 A2 Z VDD VNW VPW VSS
.ends

* Black-box entry subcircuit for gf180mcu_fd_sc_mcu7t5v0__nand4_1 abstract view
.subckt gf180mcu_fd_sc_mcu7t5v0__nand4_1 A1 A2 A3 A4 ZN VDD VNW VPW VSS
.ends

* Black-box entry subcircuit for gf180mcu_fd_sc_mcu7t5v0__dffsnq_1 abstract view
.subckt gf180mcu_fd_sc_mcu7t5v0__dffsnq_1 D SETN CLK Q VDD VNW VPW VSS
.ends

* Black-box entry subcircuit for gf180mcu_fd_sc_mcu7t5v0__clkbuf_16 abstract view
.subckt gf180mcu_fd_sc_mcu7t5v0__clkbuf_16 I Z VDD VNW VPW VSS
.ends

* Black-box entry subcircuit for gf180mcu_fd_sc_mcu7t5v0__or3_1 abstract view
.subckt gf180mcu_fd_sc_mcu7t5v0__or3_1 A1 A2 A3 Z VDD VNW VPW VSS
.ends

* Black-box entry subcircuit for gf180mcu_fd_sc_mcu7t5v0__inv_2 abstract view
.subckt gf180mcu_fd_sc_mcu7t5v0__inv_2 I ZN VDD VNW VPW VSS
.ends

* Black-box entry subcircuit for gf180mcu_fd_sc_mcu7t5v0__inv_3 abstract view
.subckt gf180mcu_fd_sc_mcu7t5v0__inv_3 I ZN VDD VNW VPW VSS
.ends

* Black-box entry subcircuit for gf180mcu_fd_sc_mcu7t5v0__clkinv_2 abstract view
.subckt gf180mcu_fd_sc_mcu7t5v0__clkinv_2 I ZN VDD VNW VPW VSS
.ends

* Black-box entry subcircuit for gf180mcu_fd_sc_mcu7t5v0__clkinv_3 abstract view
.subckt gf180mcu_fd_sc_mcu7t5v0__clkinv_3 I ZN VDD VNW VPW VSS
.ends

* Black-box entry subcircuit for gf180mcu_fd_sc_mcu7t5v0__clkinv_4 abstract view
.subckt gf180mcu_fd_sc_mcu7t5v0__clkinv_4 I ZN VDD VNW VPW VSS
.ends

* Black-box entry subcircuit for gf180mcu_fd_sc_mcu7t5v0__inv_4 abstract view
.subckt gf180mcu_fd_sc_mcu7t5v0__inv_4 I ZN VDD VNW VPW VSS
.ends

* Black-box entry subcircuit for gf180mcu_fd_sc_mcu7t5v0__buf_20 abstract view
.subckt gf180mcu_fd_sc_mcu7t5v0__buf_20 I Z VDD VNW VPW VSS
.ends

* Black-box entry subcircuit for gf180mcu_fd_sc_mcu7t5v0__oai221_1 abstract view
.subckt gf180mcu_fd_sc_mcu7t5v0__oai221_1 A1 A2 B1 B2 C ZN VDD VNW VPW VSS
.ends

* Black-box entry subcircuit for gf180mcu_fd_sc_mcu7t5v0__oai22_1 abstract view
.subckt gf180mcu_fd_sc_mcu7t5v0__oai22_1 A1 A2 B1 B2 ZN VDD VNW VPW VSS
.ends

* Black-box entry subcircuit for gf180mcu_fd_sc_mcu7t5v0__clkbuf_1 abstract view
.subckt gf180mcu_fd_sc_mcu7t5v0__clkbuf_1 I Z VDD VNW VPW VSS
.ends

* Black-box entry subcircuit for gf180mcu_fd_sc_mcu7t5v0__clkinv_8 abstract view
.subckt gf180mcu_fd_sc_mcu7t5v0__clkinv_8 I ZN VDD VNW VPW VSS
.ends

* Black-box entry subcircuit for gf180mcu_fd_sc_mcu7t5v0__aoi222_1 abstract view
.subckt gf180mcu_fd_sc_mcu7t5v0__aoi222_1 A1 A2 B1 B2 C1 C2 ZN VDD VNW VPW VSS
.ends

* Black-box entry subcircuit for gf180mcu_fd_sc_mcu7t5v0__inv_8 abstract view
.subckt gf180mcu_fd_sc_mcu7t5v0__inv_8 I ZN VDD VNW VPW VSS
.ends

* Black-box entry subcircuit for gf180mcu_fd_sc_mcu7t5v0__nor2_2 abstract view
.subckt gf180mcu_fd_sc_mcu7t5v0__nor2_2 A1 A2 ZN VDD VNW VPW VSS
.ends

* Black-box entry subcircuit for gf180mcu_fd_sc_mcu7t5v0__buf_8 abstract view
.subckt gf180mcu_fd_sc_mcu7t5v0__buf_8 I Z VDD VNW VPW VSS
.ends

* Black-box entry subcircuit for gf180mcu_fd_sc_mcu7t5v0__clkbuf_2 abstract view
.subckt gf180mcu_fd_sc_mcu7t5v0__clkbuf_2 I Z VDD VNW VPW VSS
.ends

* Black-box entry subcircuit for gf180mcu_fd_sc_mcu7t5v0__buf_12 abstract view
.subckt gf180mcu_fd_sc_mcu7t5v0__buf_12 I Z VDD VNW VPW VSS
.ends

* Black-box entry subcircuit for gf180mcu_fd_sc_mcu7t5v0__and4_1 abstract view
.subckt gf180mcu_fd_sc_mcu7t5v0__and4_1 A1 A2 A3 A4 Z VDD VNW VPW VSS
.ends

* Black-box entry subcircuit for gf180mcu_fd_sc_mcu7t5v0__nand4_2 abstract view
.subckt gf180mcu_fd_sc_mcu7t5v0__nand4_2 A1 A2 A3 A4 ZN VDD VNW VPW VSS
.ends

* Black-box entry subcircuit for gf180mcu_fd_sc_mcu7t5v0__oai32_1 abstract view
.subckt gf180mcu_fd_sc_mcu7t5v0__oai32_1 A1 A2 A3 B1 B2 ZN VDD VNW VPW VSS
.ends

* Black-box entry subcircuit for gf180mcu_fd_sc_mcu7t5v0__oai222_1 abstract view
.subckt gf180mcu_fd_sc_mcu7t5v0__oai222_1 A1 A2 B1 B2 C1 C2 ZN VDD VNW VPW VSS
.ends

* Black-box entry subcircuit for gf180mcu_fd_sc_mcu7t5v0__or4_1 abstract view
.subckt gf180mcu_fd_sc_mcu7t5v0__or4_1 A1 A2 A3 A4 Z VDD VNW VPW VSS
.ends

* Black-box entry subcircuit for gf180mcu_fd_sc_mcu7t5v0__buf_2 abstract view
.subckt gf180mcu_fd_sc_mcu7t5v0__buf_2 I Z VDD VNW VPW VSS
.ends

* Black-box entry subcircuit for gf180mcu_fd_sc_mcu7t5v0__nand2_2 abstract view
.subckt gf180mcu_fd_sc_mcu7t5v0__nand2_2 A1 A2 ZN VDD VNW VPW VSS
.ends

.subckt spi_opentarget_i3c_top VDD VSS clk_i host_clk_i irq_o rst_ni scl_pad_i sda_pad_i
+ sda_pad_o sda_pad_oe spi_cs_ni spi_miso_o spi_mosi_i spi_sclk_i
XFILLER_79_391 VDD VDD VSS VSS gf180mcu_fd_sc_mcu7t5v0__fillcap_16
X_3155_ _3155_/D _3328_/RN clkload7/I _3155_/Q VDD VDD VSS VSS gf180mcu_fd_sc_mcu7t5v0__dffrnq_1
X_3086_ _3086_/D _3328_/RN _3328_/CLK _3086_/Q VDD VDD VSS VSS gf180mcu_fd_sc_mcu7t5v0__dffrnq_1
X_2106_ _3117_/Q _3057_/Q _2107_/S _3057_/D VDD VDD VSS VSS gf180mcu_fd_sc_mcu7t5v0__mux2_2
X_2037_ _3030_/Q _2039_/A2 _2037_/Z VDD VDD VSS VSS gf180mcu_fd_sc_mcu7t5v0__or2_1
XFILLER_54_247 VDD VDD VSS VSS gf180mcu_fd_sc_mcu7t5v0__fillcap_16
XFILLER_54_269 VDD VDD VSS VSS gf180mcu_fd_sc_mcu7t5v0__fill_1
X_2939_ _2939_/D _3253_/CLK _2939_/Q VDD VDD VSS VSS gf180mcu_fd_sc_mcu7t5v0__dffq_1
XTAP_TAPCELL_ROW_75_1019 VDD VSS gf180mcu_fd_sc_mcu7t5v0__filltie
XFILLER_89_111 VDD VDD VSS VSS gf180mcu_fd_sc_mcu7t5v0__fillcap_16
XFILLER_2_516 VDD VDD VSS VSS gf180mcu_fd_sc_mcu7t5v0__fillcap_8
XFILLER_2_527 VDD VDD VSS VSS gf180mcu_fd_sc_mcu7t5v0__fillcap_16
XFILLER_100_661 VDD VDD VSS VSS gf180mcu_fd_sc_mcu7t5v0__fillcap_4
XTAP_TAPCELL_ROW_86_1137 VDD VSS gf180mcu_fd_sc_mcu7t5v0__filltie
XFILLER_45_236 VDD VDD VSS VSS gf180mcu_fd_sc_mcu7t5v0__fill_1
XFILLER_58_597 VDD VDD VSS VSS gf180mcu_fd_sc_mcu7t5v0__fillcap_8
XFILLER_93_58 VDD VDD VSS VSS gf180mcu_fd_sc_mcu7t5v0__fillcap_8
XFILLER_73_556 VDD VDD VSS VSS gf180mcu_fd_sc_mcu7t5v0__fillcap_4
XFILLER_14_612 VDD VDD VSS VSS gf180mcu_fd_sc_mcu7t5v0__fillcap_32
XFILLER_26_52 VDD VDD VSS VSS gf180mcu_fd_sc_mcu7t5v0__fillcap_8
XFILLER_61_729 VDD VDD VSS VSS gf180mcu_fd_sc_mcu7t5v0__fill_2
XFILLER_14_667 VDD VDD VSS VSS gf180mcu_fd_sc_mcu7t5v0__fillcap_16
XFILLER_9_104 VDD VDD VSS VSS gf180mcu_fd_sc_mcu7t5v0__fill_2
XTAP_TAPCELL_ROW_11_345 VDD VSS gf180mcu_fd_sc_mcu7t5v0__filltie
XTAP_TAPCELL_ROW_97_1255 VDD VSS gf180mcu_fd_sc_mcu7t5v0__filltie
XFILLER_108_750 VDD VDD VSS VSS gf180mcu_fd_sc_mcu7t5v0__fillcap_8
XFILLER_107_282 VDD VDD VSS VSS gf180mcu_fd_sc_mcu7t5v0__fillcap_8
XFILLER_95_125 VDD VDD VSS VSS gf180mcu_fd_sc_mcu7t5v0__fillcap_8
XTAP_TAPCELL_ROW_47_732 VDD VSS gf180mcu_fd_sc_mcu7t5v0__filltie
XTAP_TAPCELL_ROW_19_434 VDD VSS gf180mcu_fd_sc_mcu7t5v0__filltie
XFILLER_24_409 VDD VDD VSS VSS gf180mcu_fd_sc_mcu7t5v0__fill_1
XFILLER_36_247 VDD VDD VSS VSS gf180mcu_fd_sc_mcu7t5v0__fill_1
XTAP_TAPCELL_ROW_106_1351 VDD VSS gf180mcu_fd_sc_mcu7t5v0__filltie
XFILLER_83_80 VDD VDD VSS VSS gf180mcu_fd_sc_mcu7t5v0__fillcap_32
XFILLER_32_453 VDD VDD VSS VSS gf180mcu_fd_sc_mcu7t5v0__fill_2
XFILLER_80_2 VDD VDD VSS VSS gf180mcu_fd_sc_mcu7t5v0__fillcap_32
XFILLER_8_181 VDD VDD VSS VSS gf180mcu_fd_sc_mcu7t5v0__fill_2
X_2724_ _2724_/I _3273_/D VDD VDD VSS VSS gf180mcu_fd_sc_mcu7t5v0__clkinv_1
X_2655_ _2956_/Q _2948_/Q _2940_/Q _2932_/Q _2675_/S0 _2675_/S1 _2655_/Z VDD VDD VSS
+ VSS gf180mcu_fd_sc_mcu7t5v0__mux4_1
X_1606_ _1606_/A1 _1606_/A2 _1606_/B _1606_/C _1607_/A2 VDD VDD VSS VSS gf180mcu_fd_sc_mcu7t5v0__oai211_1
X_2586_ _3213_/Q _2598_/A3 _2680_/C VDD VDD VSS VSS gf180mcu_fd_sc_mcu7t5v0__or2_2
XFILLER_87_626 VDD VDD VSS VSS gf180mcu_fd_sc_mcu7t5v0__fillcap_4
X_1537_ _1561_/A1 _1559_/B1 _1537_/B _1568_/A2 VDD VDD VSS VSS gf180mcu_fd_sc_mcu7t5v0__aoi21_1
X_1468_ _3406_/Q _3407_/Q _1458_/Z _1718_/S VDD VDD VSS VSS gf180mcu_fd_sc_mcu7t5v0__and3_1
XFILLER_101_458 VDD VDD VSS VSS gf180mcu_fd_sc_mcu7t5v0__fill_2
XFILLER_95_670 VDD VDD VSS VSS gf180mcu_fd_sc_mcu7t5v0__fillcap_16
X_3207_ _3207_/D _3303_/RN _3292_/CLK _3207_/Q VDD VDD VSS VSS gf180mcu_fd_sc_mcu7t5v0__dffrnq_1
X_1399_ _3100_/Q _2255_/A2 VDD VDD VSS VSS gf180mcu_fd_sc_mcu7t5v0__clkinv_1
X_3138_ _3138_/D _3369_/RN _3297_/CLK _3138_/Q VDD VDD VSS VSS gf180mcu_fd_sc_mcu7t5v0__dffrnq_1
XFILLER_27_236 VDD VDD VSS VSS gf180mcu_fd_sc_mcu7t5v0__fillcap_4
XFILLER_82_364 VDD VDD VSS VSS gf180mcu_fd_sc_mcu7t5v0__fillcap_16
X_3069_ _3069_/D _3328_/RN _3119_/CLK _3069_/Q VDD VDD VSS VSS gf180mcu_fd_sc_mcu7t5v0__dffrnq_1
XTAP_TAPCELL_ROW_81_1089 VDD VSS gf180mcu_fd_sc_mcu7t5v0__filltie
XFILLER_6_107 VDD VDD VSS VSS gf180mcu_fd_sc_mcu7t5v0__fillcap_16
Xclkbuf_4_8_0_host_clk_i clkbuf_0_host_clk_i/Z _2892_/CLK VDD VDD VSS VSS gf180mcu_fd_sc_mcu7t5v0__clkbuf_4
XFILLER_2_335 VDD VDD VSS VSS gf180mcu_fd_sc_mcu7t5v0__fill_1
XFILLER_104_263 VDD VDD VSS VSS gf180mcu_fd_sc_mcu7t5v0__fillcap_8
XFILLER_104_241 VDD VDD VSS VSS gf180mcu_fd_sc_mcu7t5v0__fillcap_4
XTAP_TAPCELL_ROW_92_1196 VDD VSS gf180mcu_fd_sc_mcu7t5v0__filltie
XFILLER_78_626 VDD VDD VSS VSS gf180mcu_fd_sc_mcu7t5v0__fillcap_8
XFILLER_77_136 VDD VDD VSS VSS gf180mcu_fd_sc_mcu7t5v0__fillcap_4
XFILLER_93_629 VDD VDD VSS VSS gf180mcu_fd_sc_mcu7t5v0__fill_1
XFILLER_18_247 VDD VDD VSS VSS gf180mcu_fd_sc_mcu7t5v0__fillcap_32
XTAP_TAPCELL_ROW_16_404 VDD VSS gf180mcu_fd_sc_mcu7t5v0__filltie
XFILLER_61_559 VDD VDD VSS VSS gf180mcu_fd_sc_mcu7t5v0__fill_1
XFILLER_14_453 VDD VDD VSS VSS gf180mcu_fd_sc_mcu7t5v0__fill_2
XFILLER_42_762 VDD VDD VSS VSS gf180mcu_fd_sc_mcu7t5v0__fill_2
XFILLER_53_72 VDD VDD VSS VSS gf180mcu_fd_sc_mcu7t5v0__fill_2
XTAP_TAPCELL_ROW_24_481 VDD VSS gf180mcu_fd_sc_mcu7t5v0__filltie
XTAP_TAPCELL_ROW_101_1292 VDD VSS gf180mcu_fd_sc_mcu7t5v0__filltie
XFILLER_108_580 VDD VDD VSS VSS gf180mcu_fd_sc_mcu7t5v0__fillcap_32
X_2440_ _3327_/Q _2440_/A2 _2470_/A3 VDD VDD VSS VSS gf180mcu_fd_sc_mcu7t5v0__nand2_1
X_2371_ _3137_/Q _2409_/A1 _2383_/B VDD VDD VSS VSS gf180mcu_fd_sc_mcu7t5v0__nand2_1
XFILLER_68_158 VDD VDD VSS VSS gf180mcu_fd_sc_mcu7t5v0__fillcap_16
XFILLER_83_128 VDD VDD VSS VSS gf180mcu_fd_sc_mcu7t5v0__fillcap_4
XFILLER_49_372 VDD VDD VSS VSS gf180mcu_fd_sc_mcu7t5v0__fill_2
XFILLER_94_90 VDD VDD VSS VSS gf180mcu_fd_sc_mcu7t5v0__fillcap_8
XFILLER_24_217 VDD VDD VSS VSS gf180mcu_fd_sc_mcu7t5v0__fillcap_4
XFILLER_25_718 VDD VDD VSS VSS gf180mcu_fd_sc_mcu7t5v0__fillcap_8
XFILLER_91_194 VDD VDD VSS VSS gf180mcu_fd_sc_mcu7t5v0__fill_1
XFILLER_106_506 VDD VDD VSS VSS gf180mcu_fd_sc_mcu7t5v0__fill_1
X_2707_ _3265_/Q _2680_/C _2729_/B1 _3083_/Q _2708_/I VDD VDD VSS VSS gf180mcu_fd_sc_mcu7t5v0__aoi22_1
X_2638_ _3354_/Q _2637_/Z _2638_/B _2640_/A3 VDD VDD VSS VSS gf180mcu_fd_sc_mcu7t5v0__aoi21_1
XFILLER_99_261 VDD VDD VSS VSS gf180mcu_fd_sc_mcu7t5v0__fillcap_8
X_2569_ _3187_/Q _3229_/Q _2569_/S _3229_/D VDD VDD VSS VSS gf180mcu_fd_sc_mcu7t5v0__mux2_2
XFILLER_102_734 VDD VDD VSS VSS gf180mcu_fd_sc_mcu7t5v0__fill_1
XFILLER_87_489 VDD VDD VSS VSS gf180mcu_fd_sc_mcu7t5v0__fill_1
XTAP_TAPCELL_ROW_58_838 VDD VSS gf180mcu_fd_sc_mcu7t5v0__filltie
XFILLER_28_567 VDD VDD VSS VSS gf180mcu_fd_sc_mcu7t5v0__fillcap_16
XTAP_TAPCELL_ROW_83_1107 VDD VSS gf180mcu_fd_sc_mcu7t5v0__filltie
XFILLER_70_312 VDD VDD VSS VSS gf180mcu_fd_sc_mcu7t5v0__fill_2
XFILLER_43_559 VDD VDD VSS VSS gf180mcu_fd_sc_mcu7t5v0__fill_1
XFILLER_70_345 VDD VDD VSS VSS gf180mcu_fd_sc_mcu7t5v0__fill_2
XFILLER_90_37 VDD VDD VSS VSS gf180mcu_fd_sc_mcu7t5v0__fillcap_16
XFILLER_11_489 VDD VDD VSS VSS gf180mcu_fd_sc_mcu7t5v0__fill_1
XTAP_TAPCELL_ROW_21_451 VDD VSS gf180mcu_fd_sc_mcu7t5v0__filltie
XTAP_TAPCELL_ROW_94_1225 VDD VSS gf180mcu_fd_sc_mcu7t5v0__filltie
XFILLER_97_209 VDD VDD VSS VSS gf180mcu_fd_sc_mcu7t5v0__fill_1
XTAP_TAPCELL_ROW_29_540 VDD VSS gf180mcu_fd_sc_mcu7t5v0__filltie
XFILLER_46_397 VDD VDD VSS VSS gf180mcu_fd_sc_mcu7t5v0__fill_1
XFILLER_61_323 VDD VDD VSS VSS gf180mcu_fd_sc_mcu7t5v0__fillcap_4
XFILLER_15_762 VDD VDD VSS VSS gf180mcu_fd_sc_mcu7t5v0__fill_2
XFILLER_14_272 VDD VDD VSS VSS gf180mcu_fd_sc_mcu7t5v0__fill_1
X_1940_ _2962_/Q _3114_/Q _1944_/S _2962_/D VDD VDD VSS VSS gf180mcu_fd_sc_mcu7t5v0__mux2_2
XFILLER_61_389 VDD VDD VSS VSS gf180mcu_fd_sc_mcu7t5v0__fillcap_16
XFILLER_9_88 VDD VDD VSS VSS gf180mcu_fd_sc_mcu7t5v0__fill_1
X_1871_ _2904_/Q _3112_/Q _1877_/S _2904_/D VDD VDD VSS VSS gf180mcu_fd_sc_mcu7t5v0__mux2_2
XPHY_EDGE_ROW_104_Right_104 VDD VSS gf180mcu_fd_sc_mcu7t5v0__endcap
X_2423_ _1637_/Z _1701_/B _2428_/B2 VDD VDD VSS VSS gf180mcu_fd_sc_mcu7t5v0__nand2_1
X_2354_ _2378_/B _2348_/Z _2354_/B _2406_/C _2355_/C VDD VDD VSS VSS gf180mcu_fd_sc_mcu7t5v0__oai211_1
X_2285_ _1702_/C _1701_/B _2285_/B _2288_/A3 VDD VDD VSS VSS gf180mcu_fd_sc_mcu7t5v0__oai21_1
XFILLER_57_629 VDD VDD VSS VSS gf180mcu_fd_sc_mcu7t5v0__fill_1
XFILLER_37_342 VDD VDD VSS VSS gf180mcu_fd_sc_mcu7t5v0__fillcap_8
XTAP_TAPCELL_ROW_55_808 VDD VSS gf180mcu_fd_sc_mcu7t5v0__filltie
XFILLER_25_504 VDD VDD VSS VSS gf180mcu_fd_sc_mcu7t5v0__fill_1
XFILLER_21_710 VDD VDD VSS VSS gf180mcu_fd_sc_mcu7t5v0__fill_1
XTAP_TAPCELL_ROW_35_598 VDD VSS gf180mcu_fd_sc_mcu7t5v0__filltie
XTAP_TAPCELL_ROW_63_896 VDD VSS gf180mcu_fd_sc_mcu7t5v0__filltie
XFILLER_0_614 VDD VDD VSS VSS gf180mcu_fd_sc_mcu7t5v0__fillcap_32
XFILLER_47_128 VDD VDD VSS VSS gf180mcu_fd_sc_mcu7t5v0__fillcap_8
XFILLER_56_662 VDD VDD VSS VSS gf180mcu_fd_sc_mcu7t5v0__fill_2
XFILLER_83_492 VDD VDD VSS VSS gf180mcu_fd_sc_mcu7t5v0__fill_2
XTAP_TAPCELL_ROW_26_510 VDD VSS gf180mcu_fd_sc_mcu7t5v0__filltie
XFILLER_71_643 VDD VDD VSS VSS gf180mcu_fd_sc_mcu7t5v0__fill_2
XFILLER_71_632 VDD VDD VSS VSS gf180mcu_fd_sc_mcu7t5v0__fillcap_4
XFILLER_16_559 VDD VDD VSS VSS gf180mcu_fd_sc_mcu7t5v0__fill_2
XFILLER_70_142 VDD VDD VSS VSS gf180mcu_fd_sc_mcu7t5v0__fillcap_8
XFILLER_3_430 VDD VDD VSS VSS gf180mcu_fd_sc_mcu7t5v0__fillcap_4
XFILLER_50_95 VDD VDD VSS VSS gf180mcu_fd_sc_mcu7t5v0__fillcap_8
XFILLER_3_474 VDD VDD VSS VSS gf180mcu_fd_sc_mcu7t5v0__fill_1
XFILLER_3_496 VDD VDD VSS VSS gf180mcu_fd_sc_mcu7t5v0__fill_2
XFILLER_93_212 VDD VDD VSS VSS gf180mcu_fd_sc_mcu7t5v0__fillcap_4
XFILLER_15_6 VDD VDD VSS VSS gf180mcu_fd_sc_mcu7t5v0__fill_1
X_2070_ _2101_/A1 _1544_/Z _2091_/A2 VDD VDD VSS VSS gf180mcu_fd_sc_mcu7t5v0__nor2_1
XFILLER_93_278 VDD VDD VSS VSS gf180mcu_fd_sc_mcu7t5v0__fill_2
Xload_slew30 _3352_/Q _2674_/S1 VDD VDD VSS VSS gf180mcu_fd_sc_mcu7t5v0__buf_4
XFILLER_34_301 VDD VDD VSS VSS gf180mcu_fd_sc_mcu7t5v0__fill_1
XFILLER_34_312 VDD VDD VSS VSS gf180mcu_fd_sc_mcu7t5v0__fill_2
XFILLER_62_621 VDD VDD VSS VSS gf180mcu_fd_sc_mcu7t5v0__fillcap_4
XFILLER_34_356 VDD VDD VSS VSS gf180mcu_fd_sc_mcu7t5v0__fillcap_4
XFILLER_61_142 VDD VDD VSS VSS gf180mcu_fd_sc_mcu7t5v0__fill_2
X_2972_ _2972_/D _2984_/CLK _2972_/Q VDD VDD VSS VSS gf180mcu_fd_sc_mcu7t5v0__dffq_1
XFILLER_61_164 VDD VDD VSS VSS gf180mcu_fd_sc_mcu7t5v0__fillcap_32
X_1923_ _3116_/Q _2948_/Q _1925_/S _2948_/D VDD VDD VSS VSS gf180mcu_fd_sc_mcu7t5v0__mux2_2
XTAP_TAPCELL_ROW_60_866 VDD VSS gf180mcu_fd_sc_mcu7t5v0__filltie
XTAP_TAPCELL_ROW_32_568 VDD VSS gf180mcu_fd_sc_mcu7t5v0__filltie
X_1854_ _3282_/Q _2889_/Q _1859_/S _2889_/D VDD VDD VSS VSS gf180mcu_fd_sc_mcu7t5v0__mux2_2
X_1785_ _2830_/Q _3287_/Q _1785_/S _2830_/D VDD VDD VSS VSS gf180mcu_fd_sc_mcu7t5v0__mux2_2
X_2406_ _2378_/B _2405_/Z _2406_/B _2406_/C _2407_/C VDD VDD VSS VSS gf180mcu_fd_sc_mcu7t5v0__oai211_1
XFILLER_97_562 VDD VDD VSS VSS gf180mcu_fd_sc_mcu7t5v0__fillcap_4
X_3386_ hold63/Z input1/Z _3398_/CLK _3386_/Q VDD VDD VSS VSS gf180mcu_fd_sc_mcu7t5v0__dffrnq_1
XFILLER_85_702 VDD VDD VSS VSS gf180mcu_fd_sc_mcu7t5v0__fillcap_8
XFILLER_84_201 VDD VDD VSS VSS gf180mcu_fd_sc_mcu7t5v0__fill_2
XFILLER_57_426 VDD VDD VSS VSS gf180mcu_fd_sc_mcu7t5v0__fill_2
X_2337_ _3394_/Q _2336_/Z _2340_/A2 VDD VDD VSS VSS gf180mcu_fd_sc_mcu7t5v0__nand2_1
X_2268_ _2274_/A1 _2268_/A2 _2268_/Z VDD VDD VSS VSS gf180mcu_fd_sc_mcu7t5v0__and2_1
XTAP_TAPCELL_ROW_68_944 VDD VSS gf180mcu_fd_sc_mcu7t5v0__filltie
XFILLER_37_150 VDD VDD VSS VSS gf180mcu_fd_sc_mcu7t5v0__fillcap_4
XFILLER_38_662 VDD VDD VSS VSS gf180mcu_fd_sc_mcu7t5v0__fill_2
XFILLER_44_109 VDD VDD VSS VSS gf180mcu_fd_sc_mcu7t5v0__fill_1
X_2199_ _2199_/A1 _2199_/A2 _2199_/Z VDD VDD VSS VSS gf180mcu_fd_sc_mcu7t5v0__or2_1
XFILLER_53_632 VDD VDD VSS VSS gf180mcu_fd_sc_mcu7t5v0__fillcap_16
XFILLER_65_492 VDD VDD VSS VSS gf180mcu_fd_sc_mcu7t5v0__fillcap_4
XFILLER_53_654 VDD VDD VSS VSS gf180mcu_fd_sc_mcu7t5v0__fill_1
XFILLER_21_562 VDD VDD VSS VSS gf180mcu_fd_sc_mcu7t5v0__fillcap_8
XFILLER_20_10 VDD VDD VSS VSS gf180mcu_fd_sc_mcu7t5v0__fillcap_4
XFILLER_106_100 VDD VDD VSS VSS gf180mcu_fd_sc_mcu7t5v0__fillcap_4
XFILLER_20_32 VDD VDD VSS VSS gf180mcu_fd_sc_mcu7t5v0__fill_2
XFILLER_106_177 VDD VDD VSS VSS gf180mcu_fd_sc_mcu7t5v0__fillcap_16
XFILLER_0_444 VDD VDD VSS VSS gf180mcu_fd_sc_mcu7t5v0__fillcap_32
XFILLER_75_212 VDD VDD VSS VSS gf180mcu_fd_sc_mcu7t5v0__fillcap_4
XFILLER_75_201 VDD VDD VSS VSS gf180mcu_fd_sc_mcu7t5v0__fill_2
Xhold41 hold41/I hold41/Z VDD VDD VSS VSS gf180mcu_fd_sc_mcu7t5v0__dlyc_1
Xhold63 hold63/I hold63/Z VDD VDD VSS VSS gf180mcu_fd_sc_mcu7t5v0__dlyc_1
XFILLER_76_757 VDD VDD VSS VSS gf180mcu_fd_sc_mcu7t5v0__fillcap_8
Xhold52 hold52/I hold52/Z VDD VDD VSS VSS gf180mcu_fd_sc_mcu7t5v0__dlyc_1
XTAP_TAPCELL_ROW_89_1168 VDD VSS gf180mcu_fd_sc_mcu7t5v0__filltie
XFILLER_90_215 VDD VDD VSS VSS gf180mcu_fd_sc_mcu7t5v0__fill_1
XFILLER_16_301 VDD VDD VSS VSS gf180mcu_fd_sc_mcu7t5v0__fill_1
XFILLER_44_610 VDD VDD VSS VSS gf180mcu_fd_sc_mcu7t5v0__fill_1
XFILLER_44_621 VDD VDD VSS VSS gf180mcu_fd_sc_mcu7t5v0__fillcap_4
XFILLER_43_142 VDD VDD VSS VSS gf180mcu_fd_sc_mcu7t5v0__fill_2
XFILLER_45_84 VDD VDD VSS VSS gf180mcu_fd_sc_mcu7t5v0__fill_1
XFILLER_61_72 VDD VDD VSS VSS gf180mcu_fd_sc_mcu7t5v0__fillcap_4
XFILLER_61_83 VDD VDD VSS VSS gf180mcu_fd_sc_mcu7t5v0__fillcap_4
XFILLER_6_34 VDD VDD VSS VSS gf180mcu_fd_sc_mcu7t5v0__fill_1
X_1570_ _2420_/B _1570_/A2 _2111_/A2 _1571_/B VDD VDD VSS VSS gf180mcu_fd_sc_mcu7t5v0__nor3_1
XFILLER_4_761 VDD VDD VSS VSS gf180mcu_fd_sc_mcu7t5v0__fillcap_4
XFILLER_6_89 VDD VDD VSS VSS gf180mcu_fd_sc_mcu7t5v0__fill_1
X_3240_ _3240_/D _3328_/RN _3240_/CLK _3240_/Q VDD VDD VSS VSS gf180mcu_fd_sc_mcu7t5v0__dffrnq_1
X_3171_ _3171_/D _3328_/RN _3257_/CLK _3171_/Q VDD VDD VSS VSS gf180mcu_fd_sc_mcu7t5v0__dffrnq_1
X_2122_ _3062_/Q _2122_/A2 _2123_/A3 VDD VDD VSS VSS gf180mcu_fd_sc_mcu7t5v0__nand2_1
XFILLER_19_150 VDD VDD VSS VSS gf180mcu_fd_sc_mcu7t5v0__fillcap_4
XTAP_TAPCELL_ROW_65_914 VDD VSS gf180mcu_fd_sc_mcu7t5v0__filltie
X_2053_ _1606_/C _2050_/C _2050_/B _2053_/B _3034_/D VDD VDD VSS VSS gf180mcu_fd_sc_mcu7t5v0__oai31_1
XFILLER_35_632 VDD VDD VSS VSS gf180mcu_fd_sc_mcu7t5v0__fillcap_16
XTAP_TAPCELL_ROW_37_627 VDD VSS gf180mcu_fd_sc_mcu7t5v0__filltie
XFILLER_47_492 VDD VDD VSS VSS gf180mcu_fd_sc_mcu7t5v0__fillcap_16
XFILLER_62_440 VDD VDD VSS VSS gf180mcu_fd_sc_mcu7t5v0__fillcap_8
XFILLER_34_197 VDD VDD VSS VSS gf180mcu_fd_sc_mcu7t5v0__fill_2
X_2955_ _2955_/D _2982_/CLK _2955_/Q VDD VDD VSS VSS gf180mcu_fd_sc_mcu7t5v0__dffq_1
X_2886_ _2886_/D _2894_/CLK _2886_/Q VDD VDD VSS VSS gf180mcu_fd_sc_mcu7t5v0__dffq_1
X_1906_ _2933_/Q _3117_/Q _1907_/S _2933_/D VDD VDD VSS VSS gf180mcu_fd_sc_mcu7t5v0__mux2_2
X_1837_ _3283_/Q _2874_/Q _1841_/S _2874_/D VDD VDD VSS VSS gf180mcu_fd_sc_mcu7t5v0__mux2_2
XFILLER_89_304 VDD VDD VSS VSS gf180mcu_fd_sc_mcu7t5v0__fillcap_16
X_1768_ _1842_/A1 _1777_/A2 _1776_/S VDD VDD VSS VSS gf180mcu_fd_sc_mcu7t5v0__nand2_1
XFILLER_104_626 VDD VDD VSS VSS gf180mcu_fd_sc_mcu7t5v0__fillcap_4
X_1699_ _1699_/A1 _1699_/A2 _2267_/C _1700_/I0 VDD VDD VSS VSS gf180mcu_fd_sc_mcu7t5v0__aoi21_1
XFILLER_103_147 VDD VDD VSS VSS gf180mcu_fd_sc_mcu7t5v0__fillcap_16
X_3369_ _3369_/D _3369_/RN _3369_/CLK _3369_/Q VDD VDD VSS VSS gf180mcu_fd_sc_mcu7t5v0__dffrnq_1
XFILLER_85_554 VDD VDD VSS VSS gf180mcu_fd_sc_mcu7t5v0__fillcap_4
XFILLER_85_521 VDD VDD VSS VSS gf180mcu_fd_sc_mcu7t5v0__fill_1
XFILLER_57_212 VDD VDD VSS VSS gf180mcu_fd_sc_mcu7t5v0__fillcap_16
XFILLER_57_267 VDD VDD VSS VSS gf180mcu_fd_sc_mcu7t5v0__fillcap_8
XFILLER_85_598 VDD VDD VSS VSS gf180mcu_fd_sc_mcu7t5v0__fill_1
XTAP_TAPCELL_ROW_0_230 VDD VSS gf180mcu_fd_sc_mcu7t5v0__filltie
XFILLER_72_237 VDD VDD VSS VSS gf180mcu_fd_sc_mcu7t5v0__fill_1
XFILLER_25_142 VDD VDD VSS VSS gf180mcu_fd_sc_mcu7t5v0__fillcap_16
XFILLER_13_337 VDD VDD VSS VSS gf180mcu_fd_sc_mcu7t5v0__fillcap_8
XFILLER_9_308 VDD VDD VSS VSS gf180mcu_fd_sc_mcu7t5v0__fill_2
XFILLER_31_64 VDD VDD VSS VSS gf180mcu_fd_sc_mcu7t5v0__fillcap_4
XFILLER_5_558 VDD VDD VSS VSS gf180mcu_fd_sc_mcu7t5v0__fill_2
Xoutput7 output7/I sda_pad_o VDD VDD VSS VSS gf180mcu_fd_sc_mcu7t5v0__dlyb_1
XFILLER_1_764 VDD VDD VSS VSS gf180mcu_fd_sc_mcu7t5v0__fill_1
XFILLER_49_702 VDD VDD VSS VSS gf180mcu_fd_sc_mcu7t5v0__fillcap_4
XFILLER_0_274 VDD VDD VSS VSS gf180mcu_fd_sc_mcu7t5v0__fillcap_8
XFILLER_17_632 VDD VDD VSS VSS gf180mcu_fd_sc_mcu7t5v0__fillcap_4
XFILLER_56_61 VDD VDD VSS VSS gf180mcu_fd_sc_mcu7t5v0__fill_1
XFILLER_29_492 VDD VDD VSS VSS gf180mcu_fd_sc_mcu7t5v0__fillcap_16
XFILLER_44_451 VDD VDD VSS VSS gf180mcu_fd_sc_mcu7t5v0__fillcap_4
XFILLER_31_112 VDD VDD VSS VSS gf180mcu_fd_sc_mcu7t5v0__fill_2
XTAP_TAPCELL_ROW_70_972 VDD VSS gf180mcu_fd_sc_mcu7t5v0__filltie
XFILLER_82_6 VDD VDD VSS VSS gf180mcu_fd_sc_mcu7t5v0__fill_1
XTAP_TAPCELL_ROW_14_376 VDD VSS gf180mcu_fd_sc_mcu7t5v0__filltie
XTAP_TAPCELL_ROW_42_674 VDD VSS gf180mcu_fd_sc_mcu7t5v0__filltie
X_2740_ _3215_/Q _3281_/Q _2746_/S _3281_/D VDD VDD VSS VSS gf180mcu_fd_sc_mcu7t5v0__mux2_2
X_2671_ _2607_/Z _2671_/A2 _2671_/B _2671_/C _3252_/D VDD VDD VSS VSS gf180mcu_fd_sc_mcu7t5v0__oai211_1
X_1622_ _3051_/Q _3052_/Q _1556_/Z _1622_/A4 _3410_/D VDD VDD VSS VSS gf180mcu_fd_sc_mcu7t5v0__nor4_1
XFILLER_99_602 VDD VDD VSS VSS gf180mcu_fd_sc_mcu7t5v0__fillcap_16
XFILLER_98_101 VDD VDD VSS VSS gf180mcu_fd_sc_mcu7t5v0__fillcap_4
X_1553_ _3122_/Q _1553_/A2 _1553_/B _1562_/A1 VDD VDD VSS VSS gf180mcu_fd_sc_mcu7t5v0__aoi21_1
X_1484_ _3354_/Q _1484_/A2 _3358_/D VDD VDD VSS VSS gf180mcu_fd_sc_mcu7t5v0__xnor2_1
XFILLER_98_189 VDD VDD VSS VSS gf180mcu_fd_sc_mcu7t5v0__fill_2
X_3223_ _3223_/D _3303_/RN clkload9/I _3223_/Q VDD VDD VSS VSS gf180mcu_fd_sc_mcu7t5v0__dffrnq_1
XFILLER_39_212 VDD VDD VSS VSS gf180mcu_fd_sc_mcu7t5v0__fillcap_64
XFILLER_94_362 VDD VDD VSS VSS gf180mcu_fd_sc_mcu7t5v0__fillcap_16
X_3154_ _3154_/D _3303_/RN clkload9/I _3154_/Q VDD VDD VSS VSS gf180mcu_fd_sc_mcu7t5v0__dffrnq_1
XFILLER_94_384 VDD VDD VSS VSS gf180mcu_fd_sc_mcu7t5v0__fill_1
X_3085_ _3085_/D _3328_/RN _3328_/CLK _3085_/Q VDD VDD VSS VSS gf180mcu_fd_sc_mcu7t5v0__dffrnq_1
X_2105_ _3116_/Q _3056_/Q _2107_/S _3056_/D VDD VDD VSS VSS gf180mcu_fd_sc_mcu7t5v0__mux2_2
X_2036_ _2036_/A1 _2036_/A2 _2036_/B _2050_/C _3029_/D VDD VDD VSS VSS gf180mcu_fd_sc_mcu7t5v0__aoi211_1
XFILLER_35_440 VDD VDD VSS VSS gf180mcu_fd_sc_mcu7t5v0__fillcap_4
XFILLER_23_624 VDD VDD VSS VSS gf180mcu_fd_sc_mcu7t5v0__fillcap_4
XFILLER_50_454 VDD VDD VSS VSS gf180mcu_fd_sc_mcu7t5v0__fill_1
X_2938_ _2938_/D _3313_/CLK _2938_/Q VDD VDD VSS VSS gf180mcu_fd_sc_mcu7t5v0__dffq_1
XFILLER_108_206 VDD VDD VSS VSS gf180mcu_fd_sc_mcu7t5v0__fillcap_16
X_2869_ _2869_/D _2891_/CLK _2869_/Q VDD VDD VSS VSS gf180mcu_fd_sc_mcu7t5v0__dffq_1
XFILLER_104_489 VDD VDD VSS VSS gf180mcu_fd_sc_mcu7t5v0__fillcap_4
XFILLER_58_510 VDD VDD VSS VSS gf180mcu_fd_sc_mcu7t5v0__fill_1
XFILLER_18_407 VDD VDD VSS VSS gf180mcu_fd_sc_mcu7t5v0__fill_1
XTAP_TAPCELL_ROW_86_1138 VDD VSS gf180mcu_fd_sc_mcu7t5v0__filltie
XFILLER_26_451 VDD VDD VSS VSS gf180mcu_fd_sc_mcu7t5v0__fillcap_4
XFILLER_26_473 VDD VDD VSS VSS gf180mcu_fd_sc_mcu7t5v0__fillcap_8
XFILLER_60_218 VDD VDD VSS VSS gf180mcu_fd_sc_mcu7t5v0__fillcap_16
XTAP_TAPCELL_ROW_11_346 VDD VSS gf180mcu_fd_sc_mcu7t5v0__filltie
XTAP_TAPCELL_ROW_97_1256 VDD VSS gf180mcu_fd_sc_mcu7t5v0__filltie
XFILLER_108_762 VDD VDD VSS VSS gf180mcu_fd_sc_mcu7t5v0__fill_2
XFILLER_5_333 VDD VDD VSS VSS gf180mcu_fd_sc_mcu7t5v0__fillcap_16
XFILLER_95_137 VDD VDD VSS VSS gf180mcu_fd_sc_mcu7t5v0__fill_2
XFILLER_76_395 VDD VDD VSS VSS gf180mcu_fd_sc_mcu7t5v0__fillcap_4
XFILLER_76_373 VDD VDD VSS VSS gf180mcu_fd_sc_mcu7t5v0__fillcap_8
XFILLER_36_215 VDD VDD VSS VSS gf180mcu_fd_sc_mcu7t5v0__fillcap_16
XFILLER_64_524 VDD VDD VSS VSS gf180mcu_fd_sc_mcu7t5v0__fill_1
XTAP_TAPCELL_ROW_19_435 VDD VSS gf180mcu_fd_sc_mcu7t5v0__filltie
XFILLER_64_557 VDD VDD VSS VSS gf180mcu_fd_sc_mcu7t5v0__fillcap_16
XTAP_TAPCELL_ROW_106_1352 VDD VSS gf180mcu_fd_sc_mcu7t5v0__filltie
XFILLER_91_376 VDD VDD VSS VSS gf180mcu_fd_sc_mcu7t5v0__fillcap_4
XFILLER_64_579 VDD VDD VSS VSS gf180mcu_fd_sc_mcu7t5v0__fill_1
XFILLER_32_410 VDD VDD VSS VSS gf180mcu_fd_sc_mcu7t5v0__fill_1
XFILLER_72_590 VDD VDD VSS VSS gf180mcu_fd_sc_mcu7t5v0__fillcap_4
XFILLER_20_649 VDD VDD VSS VSS gf180mcu_fd_sc_mcu7t5v0__fillcap_16
X_2723_ _3273_/Q _2680_/C _2729_/B1 _3091_/Q _2724_/I VDD VDD VSS VSS gf180mcu_fd_sc_mcu7t5v0__aoi22_1
XFILLER_73_2 VDD VDD VSS VSS gf180mcu_fd_sc_mcu7t5v0__fillcap_4
X_2654_ _2924_/Q _2916_/Q _2908_/Q _2900_/Q _2675_/S0 _2674_/S1 _2654_/Z VDD VDD VSS
+ VSS gf180mcu_fd_sc_mcu7t5v0__mux4_1
X_1605_ _3030_/Q _3029_/Q _3027_/Q _3028_/Q _1606_/A2 VDD VDD VSS VSS gf180mcu_fd_sc_mcu7t5v0__nor4_1
X_2585_ _3203_/Q _3245_/Q _2585_/S _3245_/D VDD VDD VSS VSS gf180mcu_fd_sc_mcu7t5v0__mux2_2
X_1536_ _1546_/A3 _1558_/A2 _1559_/B1 VDD VDD VSS VSS gf180mcu_fd_sc_mcu7t5v0__nand2_1
XFILLER_86_104 VDD VDD VSS VSS gf180mcu_fd_sc_mcu7t5v0__fill_1
X_1467_ _1467_/I _3401_/D VDD VDD VSS VSS gf180mcu_fd_sc_mcu7t5v0__clkinv_1
X_1398_ _3380_/Q _1439_/A1 VDD VDD VSS VSS gf180mcu_fd_sc_mcu7t5v0__clkinv_1
XFILLER_28_716 VDD VDD VSS VSS gf180mcu_fd_sc_mcu7t5v0__fillcap_16
X_3206_ _3206_/D _3328_/RN _3215_/CLK _3206_/Q VDD VDD VSS VSS gf180mcu_fd_sc_mcu7t5v0__dffrnq_1
XFILLER_27_204 VDD VDD VSS VSS gf180mcu_fd_sc_mcu7t5v0__fillcap_4
X_3137_ _3137_/D _3369_/RN _3285_/CLK _3137_/Q VDD VDD VSS VSS gf180mcu_fd_sc_mcu7t5v0__dffrnq_1
XFILLER_82_387 VDD VDD VSS VSS gf180mcu_fd_sc_mcu7t5v0__fillcap_4
X_3068_ _3068_/D _3328_/RN _3119_/CLK _3068_/Q VDD VDD VSS VSS gf180mcu_fd_sc_mcu7t5v0__dffrnq_1
X_2019_ _2022_/A2 _2019_/A2 _3024_/D VDD VDD VSS VSS gf180mcu_fd_sc_mcu7t5v0__and2_1
XFILLER_50_251 VDD VDD VSS VSS gf180mcu_fd_sc_mcu7t5v0__fill_2
XFILLER_11_627 VDD VDD VSS VSS gf180mcu_fd_sc_mcu7t5v0__fill_2
XFILLER_10_115 VDD VDD VSS VSS gf180mcu_fd_sc_mcu7t5v0__fill_2
XFILLER_23_476 VDD VDD VSS VSS gf180mcu_fd_sc_mcu7t5v0__fillcap_4
XFILLER_88_37 VDD VDD VSS VSS gf180mcu_fd_sc_mcu7t5v0__fillcap_16
XFILLER_12_99 VDD VDD VSS VSS gf180mcu_fd_sc_mcu7t5v0__fillcap_4
XTAP_TAPCELL_ROW_92_1197 VDD VSS gf180mcu_fd_sc_mcu7t5v0__filltie
XFILLER_78_638 VDD VDD VSS VSS gf180mcu_fd_sc_mcu7t5v0__fill_1
XFILLER_92_107 VDD VDD VSS VSS gf180mcu_fd_sc_mcu7t5v0__fill_1
Xclkbuf_leaf_42_clk_i clkload3/I _3253_/CLK VDD VDD VSS VSS gf180mcu_fd_sc_mcu7t5v0__clkbuf_4
XTAP_TAPCELL_ROW_16_405 VDD VSS gf180mcu_fd_sc_mcu7t5v0__filltie
XFILLER_27_760 VDD VDD VSS VSS gf180mcu_fd_sc_mcu7t5v0__fillcap_4
XTAP_TAPCELL_ROW_52_780 VDD VSS gf180mcu_fd_sc_mcu7t5v0__filltie
XTAP_TAPCELL_ROW_101_1293 VDD VSS gf180mcu_fd_sc_mcu7t5v0__filltie
XTAP_TAPCELL_ROW_24_482 VDD VSS gf180mcu_fd_sc_mcu7t5v0__filltie
XFILLER_10_682 VDD VDD VSS VSS gf180mcu_fd_sc_mcu7t5v0__fillcap_8
XFILLER_6_631 VDD VDD VSS VSS gf180mcu_fd_sc_mcu7t5v0__fillcap_4
XFILLER_6_675 VDD VDD VSS VSS gf180mcu_fd_sc_mcu7t5v0__fillcap_4
XFILLER_68_104 VDD VDD VSS VSS gf180mcu_fd_sc_mcu7t5v0__fill_1
X_2370_ _2409_/A1 _2370_/A2 _2370_/B _3136_/D VDD VDD VSS VSS gf180mcu_fd_sc_mcu7t5v0__oai21_1
XFILLER_96_457 VDD VDD VSS VSS gf180mcu_fd_sc_mcu7t5v0__fillcap_16
XFILLER_37_557 VDD VDD VSS VSS gf180mcu_fd_sc_mcu7t5v0__fill_2
XFILLER_52_527 VDD VDD VSS VSS gf180mcu_fd_sc_mcu7t5v0__fillcap_64
XFILLER_64_387 VDD VDD VSS VSS gf180mcu_fd_sc_mcu7t5v0__fill_2
XFILLER_32_251 VDD VDD VSS VSS gf180mcu_fd_sc_mcu7t5v0__fill_2
XFILLER_20_457 VDD VDD VSS VSS gf180mcu_fd_sc_mcu7t5v0__fillcap_16
X_2706_ _2706_/I _3264_/D VDD VDD VSS VSS gf180mcu_fd_sc_mcu7t5v0__clkinv_1
XPHY_EDGE_ROW_12_Right_12 VDD VSS gf180mcu_fd_sc_mcu7t5v0__endcap
X_2637_ _2636_/Z _2635_/Z _3353_/Q _2637_/Z VDD VDD VSS VSS gf180mcu_fd_sc_mcu7t5v0__mux2_2
XFILLER_99_251 VDD VDD VSS VSS gf180mcu_fd_sc_mcu7t5v0__fill_2
X_2568_ _3186_/Q _3228_/Q _2585_/S _3228_/D VDD VDD VSS VSS gf180mcu_fd_sc_mcu7t5v0__mux2_2
XFILLER_58_18 VDD VDD VSS VSS gf180mcu_fd_sc_mcu7t5v0__fill_2
XFILLER_101_212 VDD VDD VSS VSS gf180mcu_fd_sc_mcu7t5v0__fillcap_16
X_2499_ _2508_/A1 _2499_/A2 wire13/I VDD VDD VSS VSS gf180mcu_fd_sc_mcu7t5v0__nor2_1
X_1519_ _3326_/Q _1519_/A2 _1520_/I VDD VDD VSS VSS gf180mcu_fd_sc_mcu7t5v0__nand2_1
XFILLER_59_104 VDD VDD VSS VSS gf180mcu_fd_sc_mcu7t5v0__fillcap_8
XFILLER_59_137 VDD VDD VSS VSS gf180mcu_fd_sc_mcu7t5v0__fill_2
XFILLER_28_524 VDD VDD VSS VSS gf180mcu_fd_sc_mcu7t5v0__fill_1
XTAP_TAPCELL_ROW_58_839 VDD VSS gf180mcu_fd_sc_mcu7t5v0__filltie
XFILLER_74_107 VDD VDD VSS VSS gf180mcu_fd_sc_mcu7t5v0__fillcap_4
XFILLER_28_535 VDD VDD VSS VSS gf180mcu_fd_sc_mcu7t5v0__fill_2
XTAP_TAPCELL_ROW_83_1108 VDD VSS gf180mcu_fd_sc_mcu7t5v0__filltie
XPHY_EDGE_ROW_21_Right_21 VDD VSS gf180mcu_fd_sc_mcu7t5v0__endcap
XFILLER_55_376 VDD VDD VSS VSS gf180mcu_fd_sc_mcu7t5v0__fill_2
XFILLER_24_730 VDD VDD VSS VSS gf180mcu_fd_sc_mcu7t5v0__fillcap_4
XFILLER_70_357 VDD VDD VSS VSS gf180mcu_fd_sc_mcu7t5v0__fillcap_16
XFILLER_23_262 VDD VDD VSS VSS gf180mcu_fd_sc_mcu7t5v0__fill_2
XFILLER_23_32 VDD VDD VSS VSS gf180mcu_fd_sc_mcu7t5v0__fill_1
XFILLER_11_479 VDD VDD VSS VSS gf180mcu_fd_sc_mcu7t5v0__fillcap_8
XTAP_TAPCELL_ROW_21_452 VDD VSS gf180mcu_fd_sc_mcu7t5v0__filltie
XPHY_EDGE_ROW_30_Right_30 VDD VSS gf180mcu_fd_sc_mcu7t5v0__endcap
XFILLER_99_58 VDD VDD VSS VSS gf180mcu_fd_sc_mcu7t5v0__fillcap_4
XTAP_TAPCELL_ROW_94_1226 VDD VSS gf180mcu_fd_sc_mcu7t5v0__filltie
XFILLER_105_562 VDD VDD VSS VSS gf180mcu_fd_sc_mcu7t5v0__fill_2
XFILLER_3_2 VDD VDD VSS VSS gf180mcu_fd_sc_mcu7t5v0__fillcap_64
XFILLER_2_177 VDD VDD VSS VSS gf180mcu_fd_sc_mcu7t5v0__fill_2
XFILLER_78_457 VDD VDD VSS VSS gf180mcu_fd_sc_mcu7t5v0__fillcap_16
XFILLER_48_51 VDD VDD VSS VSS gf180mcu_fd_sc_mcu7t5v0__fillcap_16
XFILLER_19_557 VDD VDD VSS VSS gf180mcu_fd_sc_mcu7t5v0__fill_2
XFILLER_58_181 VDD VDD VSS VSS gf180mcu_fd_sc_mcu7t5v0__fill_2
XFILLER_0_36 VDD VDD VSS VSS gf180mcu_fd_sc_mcu7t5v0__fillcap_32
XTAP_TAPCELL_ROW_29_541 VDD VSS gf180mcu_fd_sc_mcu7t5v0__filltie
XFILLER_34_505 VDD VDD VSS VSS gf180mcu_fd_sc_mcu7t5v0__fillcap_16
XFILLER_46_365 VDD VDD VSS VSS gf180mcu_fd_sc_mcu7t5v0__fill_1
XPHY_EDGE_ROW_14_Left_123 VDD VSS gf180mcu_fd_sc_mcu7t5v0__endcap
XFILLER_34_527 VDD VDD VSS VSS gf180mcu_fd_sc_mcu7t5v0__fillcap_64
XFILLER_46_387 VDD VDD VSS VSS gf180mcu_fd_sc_mcu7t5v0__fillcap_8
XTAP_TAPCELL_ROW_103_1311 VDD VSS gf180mcu_fd_sc_mcu7t5v0__filltie
XFILLER_14_262 VDD VDD VSS VSS gf180mcu_fd_sc_mcu7t5v0__fillcap_8
XFILLER_9_34 VDD VDD VSS VSS gf180mcu_fd_sc_mcu7t5v0__fillcap_8
XFILLER_42_571 VDD VDD VSS VSS gf180mcu_fd_sc_mcu7t5v0__fillcap_4
XFILLER_14_284 VDD VDD VSS VSS gf180mcu_fd_sc_mcu7t5v0__fillcap_16
X_1870_ _2903_/Q _3111_/Q _1876_/S _2903_/D VDD VDD VSS VSS gf180mcu_fd_sc_mcu7t5v0__mux2_2
XFILLER_6_450 VDD VDD VSS VSS gf180mcu_fd_sc_mcu7t5v0__fillcap_4
XPHY_EDGE_ROW_23_Left_132 VDD VSS gf180mcu_fd_sc_mcu7t5v0__endcap
X_2422_ _2422_/I0 _3143_/Q _2422_/S _3143_/D VDD VDD VSS VSS gf180mcu_fd_sc_mcu7t5v0__mux2_2
X_2353_ _2378_/B _2353_/A2 _2353_/A3 _2354_/B VDD VDD VSS VSS gf180mcu_fd_sc_mcu7t5v0__nand3_1
XFILLER_36_2 VDD VDD VSS VSS gf180mcu_fd_sc_mcu7t5v0__fillcap_8
XFILLER_97_755 VDD VDD VSS VSS gf180mcu_fd_sc_mcu7t5v0__fillcap_8
X_2284_ _2425_/A1 _2284_/A2 _3124_/D VDD VDD VSS VSS gf180mcu_fd_sc_mcu7t5v0__nand2_1
XFILLER_56_107 VDD VDD VSS VSS gf180mcu_fd_sc_mcu7t5v0__fill_2
XPHY_EDGE_ROW_32_Left_141 VDD VSS gf180mcu_fd_sc_mcu7t5v0__endcap
XTAP_TAPCELL_ROW_55_809 VDD VSS gf180mcu_fd_sc_mcu7t5v0__filltie
XFILLER_100_37 VDD VDD VSS VSS gf180mcu_fd_sc_mcu7t5v0__fillcap_16
XTAP_TAPCELL_ROW_35_599 VDD VSS gf180mcu_fd_sc_mcu7t5v0__filltie
XTAP_TAPCELL_ROW_63_897 VDD VSS gf180mcu_fd_sc_mcu7t5v0__filltie
XFILLER_20_298 VDD VDD VSS VSS gf180mcu_fd_sc_mcu7t5v0__fillcap_4
X_1999_ _3118_/Q _3014_/Q _1999_/S _3014_/D VDD VDD VSS VSS gf180mcu_fd_sc_mcu7t5v0__mux2_2
XPHY_EDGE_ROW_41_Left_150 VDD VSS gf180mcu_fd_sc_mcu7t5v0__endcap
XFILLER_102_521 VDD VDD VSS VSS gf180mcu_fd_sc_mcu7t5v0__fillcap_4
XFILLER_102_554 VDD VDD VSS VSS gf180mcu_fd_sc_mcu7t5v0__fillcap_16
XFILLER_0_648 VDD VDD VSS VSS gf180mcu_fd_sc_mcu7t5v0__fillcap_32
XFILLER_87_265 VDD VDD VSS VSS gf180mcu_fd_sc_mcu7t5v0__fillcap_4
XFILLER_68_490 VDD VDD VSS VSS gf180mcu_fd_sc_mcu7t5v0__fill_1
XFILLER_28_343 VDD VDD VSS VSS gf180mcu_fd_sc_mcu7t5v0__fillcap_4
XFILLER_16_527 VDD VDD VSS VSS gf180mcu_fd_sc_mcu7t5v0__fillcap_32
XTAP_TAPCELL_ROW_26_511 VDD VSS gf180mcu_fd_sc_mcu7t5v0__filltie
XFILLER_28_387 VDD VDD VSS VSS gf180mcu_fd_sc_mcu7t5v0__fillcap_8
XFILLER_43_302 VDD VDD VSS VSS gf180mcu_fd_sc_mcu7t5v0__fill_2
XFILLER_71_677 VDD VDD VSS VSS gf180mcu_fd_sc_mcu7t5v0__fillcap_16
XFILLER_24_560 VDD VDD VSS VSS gf180mcu_fd_sc_mcu7t5v0__fill_2
XFILLER_34_53 VDD VDD VSS VSS gf180mcu_fd_sc_mcu7t5v0__fillcap_8
XFILLER_71_699 VDD VDD VSS VSS gf180mcu_fd_sc_mcu7t5v0__fill_1
XFILLER_8_737 VDD VDD VSS VSS gf180mcu_fd_sc_mcu7t5v0__fillcap_16
XFILLER_11_298 VDD VDD VSS VSS gf180mcu_fd_sc_mcu7t5v0__fillcap_4
XFILLER_11_276 VDD VDD VSS VSS gf180mcu_fd_sc_mcu7t5v0__fillcap_4
XFILLER_50_30 VDD VDD VSS VSS gf180mcu_fd_sc_mcu7t5v0__fillcap_4
XFILLER_7_269 VDD VDD VSS VSS gf180mcu_fd_sc_mcu7t5v0__fillcap_4
XFILLER_98_519 VDD VDD VSS VSS gf180mcu_fd_sc_mcu7t5v0__fillcap_4
XFILLER_39_608 VDD VDD VSS VSS gf180mcu_fd_sc_mcu7t5v0__fill_2
XFILLER_59_72 VDD VDD VSS VSS gf180mcu_fd_sc_mcu7t5v0__fillcap_32
XFILLER_93_202 VDD VDD VSS VSS gf180mcu_fd_sc_mcu7t5v0__fillcap_8
XFILLER_38_107 VDD VDD VSS VSS gf180mcu_fd_sc_mcu7t5v0__fillcap_16
XFILLER_81_419 VDD VDD VSS VSS gf180mcu_fd_sc_mcu7t5v0__fill_1
XFILLER_75_82 VDD VDD VSS VSS gf180mcu_fd_sc_mcu7t5v0__fill_1
Xload_slew31 _3352_/Q _2673_/S1 VDD VDD VSS VSS gf180mcu_fd_sc_mcu7t5v0__buf_4
XFILLER_47_696 VDD VDD VSS VSS gf180mcu_fd_sc_mcu7t5v0__fillcap_4
X_2971_ _2971_/D _2982_/CLK _2971_/Q VDD VDD VSS VSS gf180mcu_fd_sc_mcu7t5v0__dffq_1
X_1922_ _3115_/Q _2947_/Q _1925_/S _2947_/D VDD VDD VSS VSS gf180mcu_fd_sc_mcu7t5v0__mux2_2
X_1853_ _3281_/Q _2888_/Q _1859_/S _2888_/D VDD VDD VSS VSS gf180mcu_fd_sc_mcu7t5v0__mux2_2
XTAP_TAPCELL_ROW_32_569 VDD VSS gf180mcu_fd_sc_mcu7t5v0__filltie
XTAP_TAPCELL_ROW_60_867 VDD VSS gf180mcu_fd_sc_mcu7t5v0__filltie
X_1784_ _2829_/Q _3286_/Q _1785_/S _2829_/D VDD VDD VSS VSS gf180mcu_fd_sc_mcu7t5v0__mux2_2
X_2405_ _2403_/Z _2404_/Z _2405_/S _2405_/Z VDD VDD VSS VSS gf180mcu_fd_sc_mcu7t5v0__mux2_2
X_3385_ _3408_/Q input1/Z _3399_/CLK hold56/I VDD VDD VSS VSS gf180mcu_fd_sc_mcu7t5v0__dffrnq_1
XFILLER_69_243 VDD VDD VSS VSS gf180mcu_fd_sc_mcu7t5v0__fillcap_4
XFILLER_85_714 VDD VDD VSS VSS gf180mcu_fd_sc_mcu7t5v0__fill_2
X_2336_ _2792_/Q _2784_/Q _2776_/Q _2768_/Q _2388_/S0 _2388_/S1 _2336_/Z VDD VDD VSS
+ VSS gf180mcu_fd_sc_mcu7t5v0__mux4_1
X_2267_ _2267_/A1 _2267_/A2 _2426_/A1 _2273_/A3 _2267_/C _2268_/A2 VDD VDD VSS VSS
+ gf180mcu_fd_sc_mcu7t5v0__aoi221_1
XFILLER_84_235 VDD VDD VSS VSS gf180mcu_fd_sc_mcu7t5v0__fill_2
XTAP_TAPCELL_ROW_68_945 VDD VSS gf180mcu_fd_sc_mcu7t5v0__filltie
X_2198_ _1513_/B _2222_/A2 _2198_/B _2199_/A2 VDD VDD VSS VSS gf180mcu_fd_sc_mcu7t5v0__aoi21_1
XFILLER_25_335 VDD VDD VSS VSS gf180mcu_fd_sc_mcu7t5v0__fill_1
XFILLER_53_699 VDD VDD VSS VSS gf180mcu_fd_sc_mcu7t5v0__fill_1
XFILLER_106_123 VDD VDD VSS VSS gf180mcu_fd_sc_mcu7t5v0__fill_2
XFILLER_76_725 VDD VDD VSS VSS gf180mcu_fd_sc_mcu7t5v0__fillcap_8
XFILLER_102_384 VDD VDD VSS VSS gf180mcu_fd_sc_mcu7t5v0__fill_1
Xhold42 hold42/I hold42/Z VDD VDD VSS VSS gf180mcu_fd_sc_mcu7t5v0__dlyc_1
Xhold53 hold53/I hold53/Z VDD VDD VSS VSS gf180mcu_fd_sc_mcu7t5v0__dlyc_1
Xhold64 hold64/I hold64/Z VDD VDD VSS VSS gf180mcu_fd_sc_mcu7t5v0__dlyc_1
XTAP_TAPCELL_ROW_89_1169 VDD VSS gf180mcu_fd_sc_mcu7t5v0__filltie
XFILLER_75_279 VDD VDD VSS VSS gf180mcu_fd_sc_mcu7t5v0__fill_1
XTAP_TAPCELL_ROW_3_261 VDD VSS gf180mcu_fd_sc_mcu7t5v0__filltie
XFILLER_29_674 VDD VDD VSS VSS gf180mcu_fd_sc_mcu7t5v0__fillcap_16
XFILLER_63_419 VDD VDD VSS VSS gf180mcu_fd_sc_mcu7t5v0__fill_1
XFILLER_44_655 VDD VDD VSS VSS gf180mcu_fd_sc_mcu7t5v0__fillcap_8
XFILLER_31_349 VDD VDD VSS VSS gf180mcu_fd_sc_mcu7t5v0__fill_1
XFILLER_8_556 VDD VDD VSS VSS gf180mcu_fd_sc_mcu7t5v0__fillcap_8
XFILLER_98_327 VDD VDD VSS VSS gf180mcu_fd_sc_mcu7t5v0__fillcap_16
XFILLER_79_552 VDD VDD VSS VSS gf180mcu_fd_sc_mcu7t5v0__fillcap_8
X_3170_ _3170_/D _3328_/RN _3273_/CLK _3170_/Q VDD VDD VSS VSS gf180mcu_fd_sc_mcu7t5v0__dffrnq_1
XFILLER_67_725 VDD VDD VSS VSS gf180mcu_fd_sc_mcu7t5v0__fillcap_4
XFILLER_94_522 VDD VDD VSS VSS gf180mcu_fd_sc_mcu7t5v0__fill_2
X_2121_ _2115_/B _2122_/A2 _3062_/Q _2124_/B VDD VDD VSS VSS gf180mcu_fd_sc_mcu7t5v0__aoi21_1
X_2052_ _1606_/C _2058_/A4 _2053_/B VDD VDD VSS VSS gf180mcu_fd_sc_mcu7t5v0__nand2_1
XTAP_TAPCELL_ROW_65_915 VDD VSS gf180mcu_fd_sc_mcu7t5v0__filltie
XFILLER_66_279 VDD VDD VSS VSS gf180mcu_fd_sc_mcu7t5v0__fillcap_16
XFILLER_35_699 VDD VDD VSS VSS gf180mcu_fd_sc_mcu7t5v0__fill_1
XFILLER_62_452 VDD VDD VSS VSS gf180mcu_fd_sc_mcu7t5v0__fill_2
XFILLER_22_349 VDD VDD VSS VSS gf180mcu_fd_sc_mcu7t5v0__fill_1
XFILLER_50_658 VDD VDD VSS VSS gf180mcu_fd_sc_mcu7t5v0__fillcap_4
X_2954_ _2954_/D _2954_/CLK _2954_/Q VDD VDD VSS VSS gf180mcu_fd_sc_mcu7t5v0__dffq_1
X_2885_ _2885_/D _2893_/CLK _2885_/Q VDD VDD VSS VSS gf180mcu_fd_sc_mcu7t5v0__dffq_1
X_1905_ _2932_/Q _3116_/Q _1907_/S _2932_/D VDD VDD VSS VSS gf180mcu_fd_sc_mcu7t5v0__mux2_2
XFILLER_30_382 VDD VDD VSS VSS gf180mcu_fd_sc_mcu7t5v0__fill_2
X_1836_ _3282_/Q _2873_/Q _1841_/S _2873_/D VDD VDD VSS VSS gf180mcu_fd_sc_mcu7t5v0__mux2_2
XPHY_EDGE_ROW_6_Right_6 VDD VSS gf180mcu_fd_sc_mcu7t5v0__endcap
X_1767_ _3287_/Q _2814_/Q _1767_/S _2814_/D VDD VDD VSS VSS gf180mcu_fd_sc_mcu7t5v0__mux2_2
XTAP_TAPCELL_ROW_77_1040 VDD VSS gf180mcu_fd_sc_mcu7t5v0__filltie
X_1698_ _2249_/B _2214_/A2 _1699_/A2 VDD VDD VSS VSS gf180mcu_fd_sc_mcu7t5v0__nor2_1
XFILLER_1_209 VDD VDD VSS VSS gf180mcu_fd_sc_mcu7t5v0__fill_1
XFILLER_103_137 VDD VDD VSS VSS gf180mcu_fd_sc_mcu7t5v0__fill_2
XFILLER_89_349 VDD VDD VSS VSS gf180mcu_fd_sc_mcu7t5v0__fill_1
XFILLER_97_371 VDD VDD VSS VSS gf180mcu_fd_sc_mcu7t5v0__fillcap_4
X_3368_ _3368_/D _3369_/RN _3369_/CLK _3368_/Q VDD VDD VSS VSS gf180mcu_fd_sc_mcu7t5v0__dffrnq_1
XFILLER_66_18 VDD VDD VSS VSS gf180mcu_fd_sc_mcu7t5v0__fill_1
X_2319_ _3133_/Q _2409_/A1 _2331_/B VDD VDD VSS VSS gf180mcu_fd_sc_mcu7t5v0__nand2_1
XFILLER_85_566 VDD VDD VSS VSS gf180mcu_fd_sc_mcu7t5v0__fill_1
X_3299_ _3299_/D _3303_/RN _3302_/CLK _3299_/Q VDD VDD VSS VSS gf180mcu_fd_sc_mcu7t5v0__dffrnq_1
XTAP_TAPCELL_ROW_0_220 VDD VSS gf180mcu_fd_sc_mcu7t5v0__filltie
XFILLER_57_279 VDD VDD VSS VSS gf180mcu_fd_sc_mcu7t5v0__fill_1
XTAP_TAPCELL_ROW_0_231 VDD VSS gf180mcu_fd_sc_mcu7t5v0__filltie
XFILLER_13_316 VDD VDD VSS VSS gf180mcu_fd_sc_mcu7t5v0__fillcap_4
XFILLER_41_625 VDD VDD VSS VSS gf180mcu_fd_sc_mcu7t5v0__fillcap_4
XFILLER_13_349 VDD VDD VSS VSS gf180mcu_fd_sc_mcu7t5v0__fill_1
XFILLER_5_504 VDD VDD VSS VSS gf180mcu_fd_sc_mcu7t5v0__fill_1
XFILLER_103_2 VDD VDD VSS VSS gf180mcu_fd_sc_mcu7t5v0__fillcap_64
XFILLER_31_87 VDD VDD VSS VSS gf180mcu_fd_sc_mcu7t5v0__fillcap_8
Xoutput8 output8/I sda_pad_oe VDD VDD VSS VSS gf180mcu_fd_sc_mcu7t5v0__dlyb_1
XTAP_TAPCELL_ROW_8_320 VDD VSS gf180mcu_fd_sc_mcu7t5v0__filltie
XFILLER_76_522 VDD VDD VSS VSS gf180mcu_fd_sc_mcu7t5v0__fill_2
XFILLER_76_566 VDD VDD VSS VSS gf180mcu_fd_sc_mcu7t5v0__fillcap_4
XFILLER_48_257 VDD VDD VSS VSS gf180mcu_fd_sc_mcu7t5v0__fill_1
XFILLER_29_471 VDD VDD VSS VSS gf180mcu_fd_sc_mcu7t5v0__fill_2
XFILLER_63_227 VDD VDD VSS VSS gf180mcu_fd_sc_mcu7t5v0__fillcap_4
XFILLER_17_699 VDD VDD VSS VSS gf180mcu_fd_sc_mcu7t5v0__fill_1
XFILLER_72_761 VDD VDD VSS VSS gf180mcu_fd_sc_mcu7t5v0__fillcap_4
XFILLER_71_282 VDD VDD VSS VSS gf180mcu_fd_sc_mcu7t5v0__fillcap_16
XTAP_TAPCELL_ROW_70_973 VDD VSS gf180mcu_fd_sc_mcu7t5v0__filltie
XTAP_TAPCELL_ROW_14_377 VDD VSS gf180mcu_fd_sc_mcu7t5v0__filltie
XFILLER_12_382 VDD VDD VSS VSS gf180mcu_fd_sc_mcu7t5v0__fill_2
XTAP_TAPCELL_ROW_42_675 VDD VSS gf180mcu_fd_sc_mcu7t5v0__filltie
XPHY_EDGE_ROW_59_Right_59 VDD VSS gf180mcu_fd_sc_mcu7t5v0__endcap
X_2670_ _2670_/A1 _2669_/Z _2671_/B VDD VDD VSS VSS gf180mcu_fd_sc_mcu7t5v0__nand2_1
X_1621_ _2098_/A1 _3052_/Q _1556_/Z _1622_/A4 _3411_/D VDD VDD VSS VSS gf180mcu_fd_sc_mcu7t5v0__nor4_1
X_1552_ _1561_/B2 _1561_/B1 _1553_/A2 VDD VDD VSS VSS gf180mcu_fd_sc_mcu7t5v0__nor2_1
X_1483_ _3354_/Q _1478_/Z _3354_/D VDD VDD VSS VSS gf180mcu_fd_sc_mcu7t5v0__xor2_1
XFILLER_100_107 VDD VDD VSS VSS gf180mcu_fd_sc_mcu7t5v0__fillcap_64
XFILLER_98_157 VDD VDD VSS VSS gf180mcu_fd_sc_mcu7t5v0__fill_1
XFILLER_97_91 VDD VDD VSS VSS gf180mcu_fd_sc_mcu7t5v0__fillcap_4
X_3222_ _3222_/D _3303_/RN _3222_/CLK _3222_/Q VDD VDD VSS VSS gf180mcu_fd_sc_mcu7t5v0__dffrnq_1
XFILLER_67_500 VDD VDD VSS VSS gf180mcu_fd_sc_mcu7t5v0__fill_2
X_3153_ _3153_/D _3303_/RN clkload9/I _3153_/Q VDD VDD VSS VSS gf180mcu_fd_sc_mcu7t5v0__dffrnq_1
XFILLER_67_533 VDD VDD VSS VSS gf180mcu_fd_sc_mcu7t5v0__fillcap_8
XPHY_EDGE_ROW_68_Right_68 VDD VSS gf180mcu_fd_sc_mcu7t5v0__endcap
X_2104_ _2104_/A1 _3310_/D _2104_/B _3055_/D VDD VDD VSS VSS gf180mcu_fd_sc_mcu7t5v0__oai21_1
XFILLER_67_566 VDD VDD VSS VSS gf180mcu_fd_sc_mcu7t5v0__fill_2
X_3084_ _3084_/D _3328_/RN _3276_/CLK _3084_/Q VDD VDD VSS VSS gf180mcu_fd_sc_mcu7t5v0__dffrnq_1
XPHY_EDGE_ROW_6_Left_115 VDD VSS gf180mcu_fd_sc_mcu7t5v0__endcap
X_2035_ _2061_/A2 _2039_/A2 _2036_/B VDD VDD VSS VSS gf180mcu_fd_sc_mcu7t5v0__nor2_1
XFILLER_50_422 VDD VDD VSS VSS gf180mcu_fd_sc_mcu7t5v0__fill_1
XPHY_EDGE_ROW_77_Right_77 VDD VSS gf180mcu_fd_sc_mcu7t5v0__endcap
XFILLER_10_308 VDD VDD VSS VSS gf180mcu_fd_sc_mcu7t5v0__fill_2
X_2937_ _2937_/D _2954_/CLK _2937_/Q VDD VDD VSS VSS gf180mcu_fd_sc_mcu7t5v0__dffq_1
X_2868_ _2868_/D _2892_/CLK _2868_/Q VDD VDD VSS VSS gf180mcu_fd_sc_mcu7t5v0__dffq_1
X_2799_ _2799_/D _3408_/CLK _2799_/Q VDD VDD VSS VSS gf180mcu_fd_sc_mcu7t5v0__dffq_1
X_1819_ _2859_/Q _3284_/Q _1822_/S _2859_/D VDD VDD VSS VSS gf180mcu_fd_sc_mcu7t5v0__mux2_2
XFILLER_89_135 VDD VDD VSS VSS gf180mcu_fd_sc_mcu7t5v0__fillcap_4
XPHY_EDGE_ROW_86_Right_86 VDD VSS gf180mcu_fd_sc_mcu7t5v0__endcap
XFILLER_85_352 VDD VDD VSS VSS gf180mcu_fd_sc_mcu7t5v0__fillcap_4
XFILLER_58_577 VDD VDD VSS VSS gf180mcu_fd_sc_mcu7t5v0__fillcap_16
XFILLER_45_216 VDD VDD VSS VSS gf180mcu_fd_sc_mcu7t5v0__fill_2
XTAP_TAPCELL_ROW_86_1139 VDD VSS gf180mcu_fd_sc_mcu7t5v0__filltie
XFILLER_54_761 VDD VDD VSS VSS gf180mcu_fd_sc_mcu7t5v0__fillcap_4
XPHY_EDGE_ROW_95_Right_95 VDD VSS gf180mcu_fd_sc_mcu7t5v0__endcap
XFILLER_26_98 VDD VDD VSS VSS gf180mcu_fd_sc_mcu7t5v0__fillcap_4
XFILLER_41_422 VDD VDD VSS VSS gf180mcu_fd_sc_mcu7t5v0__fill_1
XTAP_TAPCELL_ROW_11_347 VDD VSS gf180mcu_fd_sc_mcu7t5v0__filltie
XFILLER_22_691 VDD VDD VSS VSS gf180mcu_fd_sc_mcu7t5v0__fill_2
XTAP_TAPCELL_ROW_97_1257 VDD VSS gf180mcu_fd_sc_mcu7t5v0__filltie
XPHY_EDGE_ROW_79_Left_188 VDD VSS gf180mcu_fd_sc_mcu7t5v0__endcap
XFILLER_67_72 VDD VDD VSS VSS gf180mcu_fd_sc_mcu7t5v0__fillcap_4
XTAP_TAPCELL_ROW_47_723 VDD VSS gf180mcu_fd_sc_mcu7t5v0__filltie
XTAP_TAPCELL_ROW_19_436 VDD VSS gf180mcu_fd_sc_mcu7t5v0__filltie
XTAP_TAPCELL_ROW_106_1342 VDD VSS gf180mcu_fd_sc_mcu7t5v0__filltie
XPHY_EDGE_ROW_88_Left_197 VDD VSS gf180mcu_fd_sc_mcu7t5v0__endcap
XFILLER_20_617 VDD VDD VSS VSS gf180mcu_fd_sc_mcu7t5v0__fillcap_32
X_2722_ _2722_/I _3272_/D VDD VDD VSS VSS gf180mcu_fd_sc_mcu7t5v0__clkinv_1
XFILLER_8_172 VDD VDD VSS VSS gf180mcu_fd_sc_mcu7t5v0__fill_2
XFILLER_8_150 VDD VDD VSS VSS gf180mcu_fd_sc_mcu7t5v0__fill_1
X_2653_ _3020_/Q _3012_/Q _3004_/Q _2996_/Q _2673_/S0 _2673_/S1 _2653_/Z VDD VDD VSS
+ VSS gf180mcu_fd_sc_mcu7t5v0__mux4_1
XFILLER_66_2 VDD VDD VSS VSS gf180mcu_fd_sc_mcu7t5v0__fillcap_16
X_1604_ _3032_/Q _3031_/Q _3033_/Q _1606_/A1 VDD VDD VSS VSS gf180mcu_fd_sc_mcu7t5v0__nand3_1
XTAP_TAPCELL_ROW_74_1010 VDD VSS gf180mcu_fd_sc_mcu7t5v0__filltie
X_2584_ _3202_/Q _3244_/Q _2585_/S _3244_/D VDD VDD VSS VSS gf180mcu_fd_sc_mcu7t5v0__mux2_2
XFILLER_99_422 VDD VDD VSS VSS gf180mcu_fd_sc_mcu7t5v0__fill_2
X_1535_ _3055_/Q _3058_/Q _1558_/A2 VDD VDD VSS VSS gf180mcu_fd_sc_mcu7t5v0__nor2_1
X_1466_ _3406_/Q _1466_/A2 _1467_/I VDD VDD VSS VSS gf180mcu_fd_sc_mcu7t5v0__xor2_1
X_3205_ _3205_/D _3328_/RN _3215_/CLK _3205_/Q VDD VDD VSS VSS gf180mcu_fd_sc_mcu7t5v0__dffrnq_1
X_1397_ _3055_/Q _2104_/A1 VDD VDD VSS VSS gf180mcu_fd_sc_mcu7t5v0__clkinv_1
XFILLER_67_341 VDD VDD VSS VSS gf180mcu_fd_sc_mcu7t5v0__fill_1
XFILLER_67_352 VDD VDD VSS VSS gf180mcu_fd_sc_mcu7t5v0__fillcap_4
XFILLER_95_694 VDD VDD VSS VSS gf180mcu_fd_sc_mcu7t5v0__fillcap_4
XFILLER_94_171 VDD VDD VSS VSS gf180mcu_fd_sc_mcu7t5v0__fillcap_4
XFILLER_27_216 VDD VDD VSS VSS gf180mcu_fd_sc_mcu7t5v0__fill_2
X_3136_ _3136_/D _3369_/RN _3285_/CLK _3136_/Q VDD VDD VSS VSS gf180mcu_fd_sc_mcu7t5v0__dffrnq_1
XFILLER_27_249 VDD VDD VSS VSS gf180mcu_fd_sc_mcu7t5v0__fillcap_16
X_3067_ _3067_/D _3328_/RN _3119_/CLK _3067_/Q VDD VDD VSS VSS gf180mcu_fd_sc_mcu7t5v0__dffrnq_1
XFILLER_55_547 VDD VDD VSS VSS gf180mcu_fd_sc_mcu7t5v0__fillcap_8
X_2018_ _2050_/C _2018_/A2 _2019_/A2 VDD VDD VSS VSS gf180mcu_fd_sc_mcu7t5v0__nor2_1
XFILLER_36_761 VDD VDD VSS VSS gf180mcu_fd_sc_mcu7t5v0__fillcap_4
XFILLER_23_422 VDD VDD VSS VSS gf180mcu_fd_sc_mcu7t5v0__fillcap_8
XFILLER_63_580 VDD VDD VSS VSS gf180mcu_fd_sc_mcu7t5v0__fill_1
XFILLER_51_753 VDD VDD VSS VSS gf180mcu_fd_sc_mcu7t5v0__fillcap_8
XFILLER_12_34 VDD VDD VSS VSS gf180mcu_fd_sc_mcu7t5v0__fill_1
XTAP_TAPCELL_ROW_92_1198 VDD VSS gf180mcu_fd_sc_mcu7t5v0__filltie
XFILLER_19_717 VDD VDD VSS VSS gf180mcu_fd_sc_mcu7t5v0__fillcap_8
XTAP_TAPCELL_ROW_16_406 VDD VSS gf180mcu_fd_sc_mcu7t5v0__filltie
XFILLER_54_580 VDD VDD VSS VSS gf180mcu_fd_sc_mcu7t5v0__fillcap_8
XFILLER_42_764 VDD VDD VSS VSS gf180mcu_fd_sc_mcu7t5v0__fill_1
XFILLER_53_30 VDD VDD VSS VSS gf180mcu_fd_sc_mcu7t5v0__fill_1
XFILLER_14_477 VDD VDD VSS VSS gf180mcu_fd_sc_mcu7t5v0__fill_2
XFILLER_41_274 VDD VDD VSS VSS gf180mcu_fd_sc_mcu7t5v0__fillcap_4
XTAP_TAPCELL_ROW_52_781 VDD VSS gf180mcu_fd_sc_mcu7t5v0__filltie
XTAP_TAPCELL_ROW_24_483 VDD VSS gf180mcu_fd_sc_mcu7t5v0__filltie
XTAP_TAPCELL_ROW_101_1294 VDD VSS gf180mcu_fd_sc_mcu7t5v0__filltie
XFILLER_10_650 VDD VDD VSS VSS gf180mcu_fd_sc_mcu7t5v0__fillcap_8
XFILLER_10_694 VDD VDD VSS VSS gf180mcu_fd_sc_mcu7t5v0__fill_1
XFILLER_5_142 VDD VDD VSS VSS gf180mcu_fd_sc_mcu7t5v0__fillcap_8
XFILLER_96_403 VDD VDD VSS VSS gf180mcu_fd_sc_mcu7t5v0__fillcap_8
XFILLER_49_352 VDD VDD VSS VSS gf180mcu_fd_sc_mcu7t5v0__fillcap_16
XFILLER_49_374 VDD VDD VSS VSS gf180mcu_fd_sc_mcu7t5v0__fill_1
XFILLER_18_761 VDD VDD VSS VSS gf180mcu_fd_sc_mcu7t5v0__fillcap_4
XPHY_EDGE_ROW_96_Left_205 VDD VSS gf180mcu_fd_sc_mcu7t5v0__endcap
XFILLER_92_697 VDD VDD VSS VSS gf180mcu_fd_sc_mcu7t5v0__fillcap_4
XFILLER_17_282 VDD VDD VSS VSS gf180mcu_fd_sc_mcu7t5v0__fillcap_16
XFILLER_32_296 VDD VDD VSS VSS gf180mcu_fd_sc_mcu7t5v0__fillcap_4
XFILLER_9_492 VDD VDD VSS VSS gf180mcu_fd_sc_mcu7t5v0__fillcap_4
X_2705_ _3264_/Q _2680_/C _2729_/B1 _3082_/Q _2706_/I VDD VDD VSS VSS gf180mcu_fd_sc_mcu7t5v0__aoi22_1
X_2636_ _2954_/Q _2946_/Q _2938_/Q _2930_/Q _2675_/S0 _2675_/S1 _2636_/Z VDD VDD VSS
+ VSS gf180mcu_fd_sc_mcu7t5v0__mux4_1
X_2567_ _3185_/Q _3227_/Q _2585_/S _3227_/D VDD VDD VSS VSS gf180mcu_fd_sc_mcu7t5v0__mux2_2
X_2498_ _3163_/Q _3156_/Q _2498_/S _3163_/D VDD VDD VSS VSS gf180mcu_fd_sc_mcu7t5v0__mux2_2
X_1518_ _3063_/Q _1517_/Z _3320_/Q _1519_/A2 VDD VDD VSS VSS gf180mcu_fd_sc_mcu7t5v0__oai21_1
XFILLER_59_116 VDD VDD VSS VSS gf180mcu_fd_sc_mcu7t5v0__fill_1
X_1449_ _2405_/S _1449_/A2 _3398_/D VDD VDD VSS VSS gf180mcu_fd_sc_mcu7t5v0__xor2_1
XFILLER_68_683 VDD VDD VSS VSS gf180mcu_fd_sc_mcu7t5v0__fillcap_8
XFILLER_74_119 VDD VDD VSS VSS gf180mcu_fd_sc_mcu7t5v0__fill_2
XFILLER_74_18 VDD VDD VSS VSS gf180mcu_fd_sc_mcu7t5v0__fill_1
XFILLER_83_686 VDD VDD VSS VSS gf180mcu_fd_sc_mcu7t5v0__fillcap_8
XTAP_TAPCELL_ROW_83_1109 VDD VSS gf180mcu_fd_sc_mcu7t5v0__filltie
X_3119_ _3119_/D _3369_/RN _3119_/CLK _3119_/Q VDD VDD VSS VSS gf180mcu_fd_sc_mcu7t5v0__dffrnq_1
XFILLER_70_314 VDD VDD VSS VSS gf180mcu_fd_sc_mcu7t5v0__fill_1
XFILLER_24_753 VDD VDD VSS VSS gf180mcu_fd_sc_mcu7t5v0__fillcap_8
XFILLER_51_550 VDD VDD VSS VSS gf180mcu_fd_sc_mcu7t5v0__fillcap_8
XTAP_TAPCELL_ROW_21_453 VDD VSS gf180mcu_fd_sc_mcu7t5v0__filltie
XTAP_TAPCELL_ROW_94_1216 VDD VSS gf180mcu_fd_sc_mcu7t5v0__filltie
XFILLER_2_101 VDD VDD VSS VSS gf180mcu_fd_sc_mcu7t5v0__fillcap_4
XFILLER_2_123 VDD VDD VSS VSS gf180mcu_fd_sc_mcu7t5v0__fill_1
XFILLER_46_311 VDD VDD VSS VSS gf180mcu_fd_sc_mcu7t5v0__fillcap_4
XTAP_TAPCELL_ROW_29_542 VDD VSS gf180mcu_fd_sc_mcu7t5v0__filltie
XFILLER_46_344 VDD VDD VSS VSS gf180mcu_fd_sc_mcu7t5v0__fillcap_8
XTAP_TAPCELL_ROW_103_1312 VDD VSS gf180mcu_fd_sc_mcu7t5v0__filltie
XFILLER_15_764 VDD VDD VSS VSS gf180mcu_fd_sc_mcu7t5v0__fill_1
XFILLER_61_347 VDD VDD VSS VSS gf180mcu_fd_sc_mcu7t5v0__fill_2
XFILLER_61_358 VDD VDD VSS VSS gf180mcu_fd_sc_mcu7t5v0__fill_2
XFILLER_9_46 VDD VDD VSS VSS gf180mcu_fd_sc_mcu7t5v0__fill_1
XFILLER_42_594 VDD VDD VSS VSS gf180mcu_fd_sc_mcu7t5v0__fill_1
X_2421_ _2421_/I0 _3142_/Q _2421_/S _3142_/D VDD VDD VSS VSS gf180mcu_fd_sc_mcu7t5v0__mux2_2
X_2352_ _2405_/S _2351_/Z _2353_/A3 VDD VDD VSS VSS gf180mcu_fd_sc_mcu7t5v0__nand2_1
XFILLER_96_244 VDD VDD VSS VSS gf180mcu_fd_sc_mcu7t5v0__fill_1
X_2283_ _2267_/C _1665_/B _3124_/Q _2284_/A2 VDD VDD VSS VSS gf180mcu_fd_sc_mcu7t5v0__oai21_1
XFILLER_96_299 VDD VDD VSS VSS gf180mcu_fd_sc_mcu7t5v0__fill_1
XFILLER_92_450 VDD VDD VSS VSS gf180mcu_fd_sc_mcu7t5v0__fillcap_4
XFILLER_52_314 VDD VDD VSS VSS gf180mcu_fd_sc_mcu7t5v0__fill_1
XFILLER_64_174 VDD VDD VSS VSS gf180mcu_fd_sc_mcu7t5v0__fill_1
XFILLER_80_667 VDD VDD VSS VSS gf180mcu_fd_sc_mcu7t5v0__fillcap_8
XFILLER_80_645 VDD VDD VSS VSS gf180mcu_fd_sc_mcu7t5v0__fillcap_8
XFILLER_52_369 VDD VDD VSS VSS gf180mcu_fd_sc_mcu7t5v0__fill_1
XFILLER_64_196 VDD VDD VSS VSS gf180mcu_fd_sc_mcu7t5v0__fill_2
XTAP_TAPCELL_ROW_63_898 VDD VSS gf180mcu_fd_sc_mcu7t5v0__filltie
XFILLER_33_594 VDD VDD VSS VSS gf180mcu_fd_sc_mcu7t5v0__fillcap_16
XFILLER_20_255 VDD VDD VSS VSS gf180mcu_fd_sc_mcu7t5v0__fill_1
Xclkbuf_leaf_41_clk_i clkload3/I _3324_/CLK VDD VDD VSS VSS gf180mcu_fd_sc_mcu7t5v0__clkbuf_4
X_1998_ _3117_/Q _3013_/Q _1999_/S _3013_/D VDD VDD VSS VSS gf180mcu_fd_sc_mcu7t5v0__mux2_2
XFILLER_106_305 VDD VDD VSS VSS gf180mcu_fd_sc_mcu7t5v0__fillcap_8
X_2619_ _2619_/A1 _2619_/A2 _3247_/D VDD VDD VSS VSS gf180mcu_fd_sc_mcu7t5v0__nand2_1
Xclkbuf_leaf_56_clk_i clkbuf_leaf_5_clk_i/I _3264_/CLK VDD VDD VSS VSS gf180mcu_fd_sc_mcu7t5v0__clkbuf_4
XFILLER_87_255 VDD VDD VSS VSS gf180mcu_fd_sc_mcu7t5v0__fill_2
XFILLER_75_417 VDD VDD VSS VSS gf180mcu_fd_sc_mcu7t5v0__fill_2
XFILLER_75_439 VDD VDD VSS VSS gf180mcu_fd_sc_mcu7t5v0__fillcap_32
XFILLER_68_480 VDD VDD VSS VSS gf180mcu_fd_sc_mcu7t5v0__fillcap_8
XFILLER_56_664 VDD VDD VSS VSS gf180mcu_fd_sc_mcu7t5v0__fill_1
XFILLER_83_494 VDD VDD VSS VSS gf180mcu_fd_sc_mcu7t5v0__fill_1
XTAP_TAPCELL_ROW_26_512 VDD VSS gf180mcu_fd_sc_mcu7t5v0__filltie
XFILLER_28_399 VDD VDD VSS VSS gf180mcu_fd_sc_mcu7t5v0__fill_2
XFILLER_34_10 VDD VDD VSS VSS gf180mcu_fd_sc_mcu7t5v0__fill_1
XFILLER_43_336 VDD VDD VSS VSS gf180mcu_fd_sc_mcu7t5v0__fillcap_8
XFILLER_34_32 VDD VDD VSS VSS gf180mcu_fd_sc_mcu7t5v0__fill_2
XFILLER_70_166 VDD VDD VSS VSS gf180mcu_fd_sc_mcu7t5v0__fillcap_8
XFILLER_70_177 VDD VDD VSS VSS gf180mcu_fd_sc_mcu7t5v0__fillcap_16
XFILLER_34_65 VDD VDD VSS VSS gf180mcu_fd_sc_mcu7t5v0__fill_1
XFILLER_50_53 VDD VDD VSS VSS gf180mcu_fd_sc_mcu7t5v0__fillcap_8
XFILLER_3_498 VDD VDD VSS VSS gf180mcu_fd_sc_mcu7t5v0__fill_1
XFILLER_78_277 VDD VDD VSS VSS gf180mcu_fd_sc_mcu7t5v0__fillcap_16
XTAP_TAPCELL_ROW_6_292 VDD VSS gf180mcu_fd_sc_mcu7t5v0__filltie
Xload_slew21 _2388_/S1 _2404_/S1 VDD VDD VSS VSS gf180mcu_fd_sc_mcu7t5v0__buf_4
XFILLER_19_344 VDD VDD VSS VSS gf180mcu_fd_sc_mcu7t5v0__fillcap_4
Xload_slew32 _2672_/S0 _2675_/S0 VDD VDD VSS VSS gf180mcu_fd_sc_mcu7t5v0__buf_4
XFILLER_74_472 VDD VDD VSS VSS gf180mcu_fd_sc_mcu7t5v0__fillcap_32
XFILLER_74_461 VDD VDD VSS VSS gf180mcu_fd_sc_mcu7t5v0__fill_1
XFILLER_34_314 VDD VDD VSS VSS gf180mcu_fd_sc_mcu7t5v0__fill_1
XFILLER_62_601 VDD VDD VSS VSS gf180mcu_fd_sc_mcu7t5v0__fill_2
XFILLER_34_336 VDD VDD VSS VSS gf180mcu_fd_sc_mcu7t5v0__fillcap_8
XFILLER_46_196 VDD VDD VSS VSS gf180mcu_fd_sc_mcu7t5v0__fillcap_8
XFILLER_61_122 VDD VDD VSS VSS gf180mcu_fd_sc_mcu7t5v0__fillcap_16
XFILLER_62_656 VDD VDD VSS VSS gf180mcu_fd_sc_mcu7t5v0__fillcap_8
XFILLER_62_667 VDD VDD VSS VSS gf180mcu_fd_sc_mcu7t5v0__fill_2
XFILLER_91_60 VDD VDD VSS VSS gf180mcu_fd_sc_mcu7t5v0__fillcap_8
X_2970_ _2970_/D _2984_/CLK _2970_/Q VDD VDD VSS VSS gf180mcu_fd_sc_mcu7t5v0__dffq_1
X_1921_ _3114_/Q _2946_/Q _1925_/S _2946_/D VDD VDD VSS VSS gf180mcu_fd_sc_mcu7t5v0__mux2_2
XFILLER_30_531 VDD VDD VSS VSS gf180mcu_fd_sc_mcu7t5v0__fill_2
X_1852_ _3280_/Q _2887_/Q _1859_/S _2887_/D VDD VDD VSS VSS gf180mcu_fd_sc_mcu7t5v0__mux2_2
XTAP_TAPCELL_ROW_60_868 VDD VSS gf180mcu_fd_sc_mcu7t5v0__filltie
XFILLER_30_597 VDD VDD VSS VSS gf180mcu_fd_sc_mcu7t5v0__fill_2
X_1783_ _2828_/Q _3285_/Q _1785_/S _2828_/D VDD VDD VSS VSS gf180mcu_fd_sc_mcu7t5v0__mux2_2
X_2404_ _2861_/Q _2853_/Q _2845_/Q _2837_/Q _2404_/S0 _2404_/S1 _2404_/Z VDD VDD VSS
+ VSS gf180mcu_fd_sc_mcu7t5v0__mux4_1
X_3384_ _3403_/Q input1/Z _3399_/CLK hold61/I VDD VDD VSS VSS gf180mcu_fd_sc_mcu7t5v0__dffrnq_1
XFILLER_97_553 VDD VDD VSS VSS gf180mcu_fd_sc_mcu7t5v0__fillcap_4
X_2335_ _2333_/Z _2334_/Z _3394_/Q _2335_/Z VDD VDD VSS VSS gf180mcu_fd_sc_mcu7t5v0__mux2_2
XFILLER_57_417 VDD VDD VSS VSS gf180mcu_fd_sc_mcu7t5v0__fill_2
XFILLER_69_277 VDD VDD VSS VSS gf180mcu_fd_sc_mcu7t5v0__fill_2
X_2266_ _3142_/Q _2417_/A2 _3418_/Q _2266_/C _2273_/A3 VDD VDD VSS VSS gf180mcu_fd_sc_mcu7t5v0__oai211_1
XFILLER_57_428 VDD VDD VSS VSS gf180mcu_fd_sc_mcu7t5v0__fill_1
XTAP_TAPCELL_ROW_68_946 VDD VSS gf180mcu_fd_sc_mcu7t5v0__filltie
X_2197_ _2197_/A1 _3412_/Q _1701_/B _2222_/A2 VDD VDD VSS VSS gf180mcu_fd_sc_mcu7t5v0__nand3_1
XFILLER_84_247 VDD VDD VSS VSS gf180mcu_fd_sc_mcu7t5v0__fillcap_16
XFILLER_38_664 VDD VDD VSS VSS gf180mcu_fd_sc_mcu7t5v0__fill_1
XFILLER_1_80 VDD VDD VSS VSS gf180mcu_fd_sc_mcu7t5v0__fillcap_4
XFILLER_38_675 VDD VDD VSS VSS gf180mcu_fd_sc_mcu7t5v0__fillcap_4
XFILLER_52_177 VDD VDD VSS VSS gf180mcu_fd_sc_mcu7t5v0__fillcap_16
XFILLER_53_689 VDD VDD VSS VSS gf180mcu_fd_sc_mcu7t5v0__fillcap_8
XFILLER_20_34 VDD VDD VSS VSS gf180mcu_fd_sc_mcu7t5v0__fill_1
XFILLER_75_203 VDD VDD VSS VSS gf180mcu_fd_sc_mcu7t5v0__fill_1
Xhold54 hold54/I hold54/Z VDD VDD VSS VSS gf180mcu_fd_sc_mcu7t5v0__dlyc_1
XFILLER_88_597 VDD VDD VSS VSS gf180mcu_fd_sc_mcu7t5v0__fillcap_8
XFILLER_76_737 VDD VDD VSS VSS gf180mcu_fd_sc_mcu7t5v0__fill_2
XFILLER_29_76 VDD VDD VSS VSS gf180mcu_fd_sc_mcu7t5v0__fill_1
Xhold43 hold43/I hold43/Z VDD VDD VSS VSS gf180mcu_fd_sc_mcu7t5v0__dlyc_1
Xhold65 hold65/I hold65/Z VDD VDD VSS VSS gf180mcu_fd_sc_mcu7t5v0__dlyc_1
XFILLER_75_269 VDD VDD VSS VSS gf180mcu_fd_sc_mcu7t5v0__fillcap_8
XTAP_TAPCELL_ROW_3_262 VDD VSS gf180mcu_fd_sc_mcu7t5v0__filltie
XFILLER_29_642 VDD VDD VSS VSS gf180mcu_fd_sc_mcu7t5v0__fillcap_32
XFILLER_16_325 VDD VDD VSS VSS gf180mcu_fd_sc_mcu7t5v0__fillcap_16
XFILLER_45_64 VDD VDD VSS VSS gf180mcu_fd_sc_mcu7t5v0__fillcap_4
XFILLER_44_667 VDD VDD VSS VSS gf180mcu_fd_sc_mcu7t5v0__fillcap_16
XFILLER_12_564 VDD VDD VSS VSS gf180mcu_fd_sc_mcu7t5v0__fillcap_16
XFILLER_8_513 VDD VDD VSS VSS gf180mcu_fd_sc_mcu7t5v0__fillcap_8
XFILLER_24_391 VDD VDD VSS VSS gf180mcu_fd_sc_mcu7t5v0__fillcap_16
XFILLER_12_597 VDD VDD VSS VSS gf180mcu_fd_sc_mcu7t5v0__fillcap_16
XFILLER_8_568 VDD VDD VSS VSS gf180mcu_fd_sc_mcu7t5v0__fill_1
XFILLER_6_69 VDD VDD VSS VSS gf180mcu_fd_sc_mcu7t5v0__fillcap_16
XPHY_EDGE_ROW_60_Left_169 VDD VSS gf180mcu_fd_sc_mcu7t5v0__endcap
XFILLER_39_406 VDD VDD VSS VSS gf180mcu_fd_sc_mcu7t5v0__fillcap_8
X_2120_ _2124_/A1 _2119_/Z _2120_/B _3061_/D VDD VDD VSS VSS gf180mcu_fd_sc_mcu7t5v0__aoi21_1
X_2051_ _2051_/A1 _2055_/A4 _2058_/A4 VDD VDD VSS VSS gf180mcu_fd_sc_mcu7t5v0__nor2_1
XFILLER_66_247 VDD VDD VSS VSS gf180mcu_fd_sc_mcu7t5v0__fillcap_32
XFILLER_82_729 VDD VDD VSS VSS gf180mcu_fd_sc_mcu7t5v0__fillcap_4
XFILLER_34_100 VDD VDD VSS VSS gf180mcu_fd_sc_mcu7t5v0__fillcap_4
XTAP_TAPCELL_ROW_37_618 VDD VSS gf180mcu_fd_sc_mcu7t5v0__filltie
XTAP_TAPCELL_ROW_65_916 VDD VSS gf180mcu_fd_sc_mcu7t5v0__filltie
XFILLER_90_762 VDD VDD VSS VSS gf180mcu_fd_sc_mcu7t5v0__fill_2
XFILLER_96_2 VDD VDD VSS VSS gf180mcu_fd_sc_mcu7t5v0__fillcap_16
XFILLER_22_317 VDD VDD VSS VSS gf180mcu_fd_sc_mcu7t5v0__fillcap_32
X_2953_ _2953_/D _3367_/CLK _2953_/Q VDD VDD VSS VSS gf180mcu_fd_sc_mcu7t5v0__dffq_1
XFILLER_34_177 VDD VDD VSS VSS gf180mcu_fd_sc_mcu7t5v0__fillcap_16
XFILLER_50_626 VDD VDD VSS VSS gf180mcu_fd_sc_mcu7t5v0__fillcap_8
X_1904_ _2931_/Q _3115_/Q _1907_/S _2931_/D VDD VDD VSS VSS gf180mcu_fd_sc_mcu7t5v0__mux2_2
X_2884_ _2884_/D _2892_/CLK _2884_/Q VDD VDD VSS VSS gf180mcu_fd_sc_mcu7t5v0__dffq_1
XFILLER_30_361 VDD VDD VSS VSS gf180mcu_fd_sc_mcu7t5v0__fill_1
X_1835_ _3281_/Q _2872_/Q _1841_/S _2872_/D VDD VDD VSS VSS gf180mcu_fd_sc_mcu7t5v0__mux2_2
X_1766_ _3286_/Q _2813_/Q _1767_/S _2813_/D VDD VDD VSS VSS gf180mcu_fd_sc_mcu7t5v0__mux2_2
XTAP_TAPCELL_ROW_77_1041 VDD VSS gf180mcu_fd_sc_mcu7t5v0__filltie
X_1697_ _1697_/I0 _2764_/Q _1710_/S _2764_/D VDD VDD VSS VSS gf180mcu_fd_sc_mcu7t5v0__mux2_2
XFILLER_106_37 VDD VDD VSS VSS gf180mcu_fd_sc_mcu7t5v0__fillcap_16
X_3367_ _3367_/D _3369_/RN _3367_/CLK _3367_/Q VDD VDD VSS VSS gf180mcu_fd_sc_mcu7t5v0__dffrnq_1
X_2318_ _2413_/A1 _1686_/B _2409_/A1 _2318_/B _3132_/D VDD VDD VSS VSS gf180mcu_fd_sc_mcu7t5v0__oai31_1
XFILLER_58_737 VDD VDD VSS VSS gf180mcu_fd_sc_mcu7t5v0__fillcap_16
X_3298_ _3298_/D _3303_/RN _3410_/CLK _3298_/Q VDD VDD VSS VSS gf180mcu_fd_sc_mcu7t5v0__dffrnq_1
X_2249_ _2766_/Q _2417_/A2 _2249_/B _2250_/A2 VDD VDD VSS VSS gf180mcu_fd_sc_mcu7t5v0__oai21_1
XTAP_TAPCELL_ROW_0_221 VDD VSS gf180mcu_fd_sc_mcu7t5v0__filltie
XTAP_TAPCELL_ROW_0_232 VDD VSS gf180mcu_fd_sc_mcu7t5v0__filltie
XFILLER_26_634 VDD VDD VSS VSS gf180mcu_fd_sc_mcu7t5v0__fill_2
XFILLER_41_615 VDD VDD VSS VSS gf180mcu_fd_sc_mcu7t5v0__fill_2
XFILLER_80_294 VDD VDD VSS VSS gf180mcu_fd_sc_mcu7t5v0__fillcap_16
XFILLER_15_56 VDD VDD VSS VSS gf180mcu_fd_sc_mcu7t5v0__fillcap_8
XFILLER_25_199 VDD VDD VSS VSS gf180mcu_fd_sc_mcu7t5v0__fillcap_8
XFILLER_40_147 VDD VDD VSS VSS gf180mcu_fd_sc_mcu7t5v0__fillcap_4
XFILLER_107_422 VDD VDD VSS VSS gf180mcu_fd_sc_mcu7t5v0__fill_2
XTAP_TAPCELL_ROW_8_321 VDD VSS gf180mcu_fd_sc_mcu7t5v0__filltie
Xoutput9 _3149_/Q spi_miso_o VDD VDD VSS VSS gf180mcu_fd_sc_mcu7t5v0__dlyb_1
XFILLER_103_694 VDD VDD VSS VSS gf180mcu_fd_sc_mcu7t5v0__fillcap_4
XFILLER_102_160 VDD VDD VSS VSS gf180mcu_fd_sc_mcu7t5v0__fillcap_8
XFILLER_48_247 VDD VDD VSS VSS gf180mcu_fd_sc_mcu7t5v0__fillcap_8
XFILLER_16_122 VDD VDD VSS VSS gf180mcu_fd_sc_mcu7t5v0__fill_1
XFILLER_56_96 VDD VDD VSS VSS gf180mcu_fd_sc_mcu7t5v0__fillcap_8
XFILLER_56_280 VDD VDD VSS VSS gf180mcu_fd_sc_mcu7t5v0__fill_1
XFILLER_16_177 VDD VDD VSS VSS gf180mcu_fd_sc_mcu7t5v0__fillcap_8
XTAP_TAPCELL_ROW_14_378 VDD VSS gf180mcu_fd_sc_mcu7t5v0__filltie
XTAP_TAPCELL_ROW_42_676 VDD VSS gf180mcu_fd_sc_mcu7t5v0__filltie
XTAP_TAPCELL_ROW_70_974 VDD VSS gf180mcu_fd_sc_mcu7t5v0__filltie
XFILLER_8_387 VDD VDD VSS VSS gf180mcu_fd_sc_mcu7t5v0__fillcap_16
XFILLER_8_365 VDD VDD VSS VSS gf180mcu_fd_sc_mcu7t5v0__fillcap_16
X_1620_ _3121_/Q _3309_/Q _2414_/B _1622_/A4 VDD VDD VSS VSS gf180mcu_fd_sc_mcu7t5v0__nand3_1
XFILLER_99_626 VDD VDD VSS VSS gf180mcu_fd_sc_mcu7t5v0__fillcap_4
X_1551_ _1544_/Z _1551_/A2 _1553_/B VDD VDD VSS VSS gf180mcu_fd_sc_mcu7t5v0__nand2_1
XFILLER_4_593 VDD VDD VSS VSS gf180mcu_fd_sc_mcu7t5v0__fill_2
X_1482_ _3354_/Q _1478_/Z _1486_/A2 VDD VDD VSS VSS gf180mcu_fd_sc_mcu7t5v0__nor2_1
X_3221_ _3221_/D _3303_/RN _3293_/CLK _3221_/Q VDD VDD VSS VSS gf180mcu_fd_sc_mcu7t5v0__dffrnq_1
X_3152_ _3152_/D _3303_/RN clkload9/I _3152_/Q VDD VDD VSS VSS gf180mcu_fd_sc_mcu7t5v0__dffrnq_1
XFILLER_11_2 VDD VDD VSS VSS gf180mcu_fd_sc_mcu7t5v0__fillcap_16
X_2103_ _3115_/Q _3310_/D _2104_/B VDD VDD VSS VSS gf180mcu_fd_sc_mcu7t5v0__nand2_1
XFILLER_67_556 VDD VDD VSS VSS gf180mcu_fd_sc_mcu7t5v0__fillcap_4
X_3083_ _3083_/D _3328_/RN _3264_/CLK _3083_/Q VDD VDD VSS VSS gf180mcu_fd_sc_mcu7t5v0__dffrnq_1
X_2034_ _3029_/Q _3027_/Q _3028_/Q _2025_/Z _2039_/A2 VDD VDD VSS VSS gf180mcu_fd_sc_mcu7t5v0__nand4_1
XFILLER_35_486 VDD VDD VSS VSS gf180mcu_fd_sc_mcu7t5v0__fillcap_4
XFILLER_62_283 VDD VDD VSS VSS gf180mcu_fd_sc_mcu7t5v0__fill_2
X_2936_ _2936_/D _3324_/CLK _2936_/Q VDD VDD VSS VSS gf180mcu_fd_sc_mcu7t5v0__dffq_1
X_2867_ _2867_/D _2891_/CLK _2867_/Q VDD VDD VSS VSS gf180mcu_fd_sc_mcu7t5v0__dffq_1
XFILLER_31_692 VDD VDD VSS VSS gf180mcu_fd_sc_mcu7t5v0__fillcap_8
XPHY_EDGE_ROW_107_Left_216 VDD VSS gf180mcu_fd_sc_mcu7t5v0__endcap
X_1818_ _2858_/Q _3283_/Q _1822_/S _2858_/D VDD VDD VSS VSS gf180mcu_fd_sc_mcu7t5v0__mux2_2
X_2798_ _2798_/D _3407_/CLK _2798_/Q VDD VDD VSS VSS gf180mcu_fd_sc_mcu7t5v0__dffq_1
X_1749_ _3406_/Q _1786_/A2 _1777_/A2 VDD VDD VSS VSS gf180mcu_fd_sc_mcu7t5v0__nor2_1
X_3419_ input2/Z _3416_/RN _3419_/CLK _3420_/D VDD VDD VSS VSS gf180mcu_fd_sc_mcu7t5v0__dffsnq_1
XFILLER_58_545 VDD VDD VSS VSS gf180mcu_fd_sc_mcu7t5v0__fillcap_32
XFILLER_13_136 VDD VDD VSS VSS gf180mcu_fd_sc_mcu7t5v0__fillcap_4
XFILLER_41_489 VDD VDD VSS VSS gf180mcu_fd_sc_mcu7t5v0__fill_1
Xclkbuf_3_3__f_clk_i clkbuf_0_clk_i/Z clkload2/I VDD VDD VSS VSS gf180mcu_fd_sc_mcu7t5v0__clkbuf_16
XTAP_TAPCELL_ROW_11_348 VDD VSS gf180mcu_fd_sc_mcu7t5v0__filltie
XFILLER_108_764 VDD VDD VSS VSS gf180mcu_fd_sc_mcu7t5v0__fill_1
XFILLER_5_368 VDD VDD VSS VSS gf180mcu_fd_sc_mcu7t5v0__fill_2
XFILLER_1_552 VDD VDD VSS VSS gf180mcu_fd_sc_mcu7t5v0__fillcap_8
XFILLER_95_139 VDD VDD VSS VSS gf180mcu_fd_sc_mcu7t5v0__fill_1
XFILLER_89_692 VDD VDD VSS VSS gf180mcu_fd_sc_mcu7t5v0__fillcap_8
XFILLER_76_331 VDD VDD VSS VSS gf180mcu_fd_sc_mcu7t5v0__fillcap_8
XFILLER_49_556 VDD VDD VSS VSS gf180mcu_fd_sc_mcu7t5v0__fillcap_4
XFILLER_37_718 VDD VDD VSS VSS gf180mcu_fd_sc_mcu7t5v0__fillcap_8
XFILLER_91_334 VDD VDD VSS VSS gf180mcu_fd_sc_mcu7t5v0__fill_2
XTAP_TAPCELL_ROW_19_437 VDD VSS gf180mcu_fd_sc_mcu7t5v0__filltie
XFILLER_36_239 VDD VDD VSS VSS gf180mcu_fd_sc_mcu7t5v0__fillcap_4
XTAP_TAPCELL_ROW_47_724 VDD VSS gf180mcu_fd_sc_mcu7t5v0__filltie
XTAP_TAPCELL_ROW_106_1343 VDD VSS gf180mcu_fd_sc_mcu7t5v0__filltie
X_2721_ _3272_/Q _2680_/C _2729_/B1 _3090_/Q _2722_/I VDD VDD VSS VSS gf180mcu_fd_sc_mcu7t5v0__aoi22_1
XFILLER_9_696 VDD VDD VSS VSS gf180mcu_fd_sc_mcu7t5v0__fillcap_4
X_2652_ _2988_/Q _2980_/Q _2972_/Q _2964_/Q _2672_/S0 _2675_/S1 _2652_/Z VDD VDD VSS
+ VSS gf180mcu_fd_sc_mcu7t5v0__mux4_1
X_1603_ _1597_/Z _1598_/Z _1603_/A3 _3380_/D VDD VDD VSS VSS gf180mcu_fd_sc_mcu7t5v0__nor3_1
XTAP_TAPCELL_ROW_74_1011 VDD VSS gf180mcu_fd_sc_mcu7t5v0__filltie
X_2583_ _3201_/Q _3243_/Q _2585_/S _3243_/D VDD VDD VSS VSS gf180mcu_fd_sc_mcu7t5v0__mux2_2
XFILLER_59_2 VDD VDD VSS VSS gf180mcu_fd_sc_mcu7t5v0__fillcap_8
X_1534_ _2101_/A1 _3054_/Q _1532_/Z _1537_/B VDD VDD VSS VSS gf180mcu_fd_sc_mcu7t5v0__nand3_1
XFILLER_87_618 VDD VDD VSS VSS gf180mcu_fd_sc_mcu7t5v0__fillcap_8
X_1465_ _3406_/Q _1458_/Z _3406_/D VDD VDD VSS VSS gf180mcu_fd_sc_mcu7t5v0__xor2_1
X_3204_ _3204_/D _3328_/RN _3222_/CLK _3204_/Q VDD VDD VSS VSS gf180mcu_fd_sc_mcu7t5v0__dffrnq_1
X_1396_ _3053_/Q _2101_/A1 VDD VDD VSS VSS gf180mcu_fd_sc_mcu7t5v0__clkinv_1
XFILLER_67_331 VDD VDD VSS VSS gf180mcu_fd_sc_mcu7t5v0__fillcap_8
X_3135_ _3135_/D _3369_/RN _3285_/CLK _3135_/Q VDD VDD VSS VSS gf180mcu_fd_sc_mcu7t5v0__dffrnq_1
XFILLER_82_345 VDD VDD VSS VSS gf180mcu_fd_sc_mcu7t5v0__fill_2
XFILLER_27_228 VDD VDD VSS VSS gf180mcu_fd_sc_mcu7t5v0__fillcap_8
X_3066_ _3066_/D _3303_/RN _3119_/CLK _3066_/Q VDD VDD VSS VSS gf180mcu_fd_sc_mcu7t5v0__dffrnq_1
XFILLER_55_559 VDD VDD VSS VSS gf180mcu_fd_sc_mcu7t5v0__fill_1
XFILLER_82_356 VDD VDD VSS VSS gf180mcu_fd_sc_mcu7t5v0__fill_2
X_2017_ _3023_/Q _2010_/Z _3024_/Q _2018_/A2 VDD VDD VSS VSS gf180mcu_fd_sc_mcu7t5v0__aoi21_1
XFILLER_23_412 VDD VDD VSS VSS gf180mcu_fd_sc_mcu7t5v0__fillcap_8
XFILLER_11_629 VDD VDD VSS VSS gf180mcu_fd_sc_mcu7t5v0__fill_1
XFILLER_23_489 VDD VDD VSS VSS gf180mcu_fd_sc_mcu7t5v0__fill_1
XFILLER_50_253 VDD VDD VSS VSS gf180mcu_fd_sc_mcu7t5v0__fill_1
X_2919_ _2919_/D _3369_/CLK _2919_/Q VDD VDD VSS VSS gf180mcu_fd_sc_mcu7t5v0__dffq_1
XFILLER_12_57 VDD VDD VSS VSS gf180mcu_fd_sc_mcu7t5v0__fill_2
XTAP_TAPCELL_ROW_92_1199 VDD VSS gf180mcu_fd_sc_mcu7t5v0__filltie
XFILLER_86_684 VDD VDD VSS VSS gf180mcu_fd_sc_mcu7t5v0__fill_2
XFILLER_86_662 VDD VDD VSS VSS gf180mcu_fd_sc_mcu7t5v0__fill_2
XFILLER_18_228 VDD VDD VSS VSS gf180mcu_fd_sc_mcu7t5v0__fillcap_4
XTAP_TAPCELL_ROW_16_407 VDD VSS gf180mcu_fd_sc_mcu7t5v0__filltie
XFILLER_14_445 VDD VDD VSS VSS gf180mcu_fd_sc_mcu7t5v0__fillcap_8
XFILLER_41_220 VDD VDD VSS VSS gf180mcu_fd_sc_mcu7t5v0__fillcap_4
XFILLER_54_592 VDD VDD VSS VSS gf180mcu_fd_sc_mcu7t5v0__fill_2
XFILLER_53_97 VDD VDD VSS VSS gf180mcu_fd_sc_mcu7t5v0__fill_1
XTAP_TAPCELL_ROW_24_484 VDD VSS gf180mcu_fd_sc_mcu7t5v0__filltie
XTAP_TAPCELL_ROW_52_782 VDD VSS gf180mcu_fd_sc_mcu7t5v0__filltie
XTAP_TAPCELL_ROW_101_1295 VDD VSS gf180mcu_fd_sc_mcu7t5v0__filltie
XFILLER_10_662 VDD VDD VSS VSS gf180mcu_fd_sc_mcu7t5v0__fill_2
XFILLER_69_629 VDD VDD VSS VSS gf180mcu_fd_sc_mcu7t5v0__fill_1
XFILLER_77_673 VDD VDD VSS VSS gf180mcu_fd_sc_mcu7t5v0__fillcap_16
XFILLER_24_209 VDD VDD VSS VSS gf180mcu_fd_sc_mcu7t5v0__fillcap_8
XFILLER_37_559 VDD VDD VSS VSS gf180mcu_fd_sc_mcu7t5v0__fill_1
XTAP_TAPCELL_ROW_80_1070 VDD VSS gf180mcu_fd_sc_mcu7t5v0__filltie
X_2704_ _2687_/Z _2704_/A2 _3263_/D VDD VDD VSS VSS gf180mcu_fd_sc_mcu7t5v0__nand2_1
X_2635_ _2922_/Q _2914_/Q _2906_/Q _2898_/Q _2675_/S0 _2674_/S1 _2635_/Z VDD VDD VSS
+ VSS gf180mcu_fd_sc_mcu7t5v0__mux4_1
X_2566_ _3184_/Q _3226_/Q _2569_/S _3226_/D VDD VDD VSS VSS gf180mcu_fd_sc_mcu7t5v0__mux2_2
XFILLER_102_737 VDD VDD VSS VSS gf180mcu_fd_sc_mcu7t5v0__fillcap_16
X_2497_ _3161_/Q _3160_/Q _3162_/Q _2508_/A1 _2498_/S VDD VDD VSS VSS gf180mcu_fd_sc_mcu7t5v0__nor4_1
X_1517_ _3209_/Q _3210_/Q _3211_/Q _1517_/Z VDD VDD VSS VSS gf180mcu_fd_sc_mcu7t5v0__or3_1
X_1448_ _3394_/Q _1442_/Z _3394_/D VDD VDD VSS VSS gf180mcu_fd_sc_mcu7t5v0__xor2_1
XFILLER_59_139 VDD VDD VSS VSS gf180mcu_fd_sc_mcu7t5v0__fill_1
XFILLER_68_662 VDD VDD VSS VSS gf180mcu_fd_sc_mcu7t5v0__fill_2
XFILLER_95_492 VDD VDD VSS VSS gf180mcu_fd_sc_mcu7t5v0__fillcap_64
X_1379_ _3141_/Q _2219_/B VDD VDD VSS VSS gf180mcu_fd_sc_mcu7t5v0__clkinv_1
XFILLER_28_537 VDD VDD VSS VSS gf180mcu_fd_sc_mcu7t5v0__fill_1
X_3118_ _3118_/D _3288_/CLK _3118_/Q VDD VDD VSS VSS gf180mcu_fd_sc_mcu7t5v0__dffq_1
XFILLER_83_654 VDD VDD VSS VSS gf180mcu_fd_sc_mcu7t5v0__fillcap_32
XFILLER_82_153 VDD VDD VSS VSS gf180mcu_fd_sc_mcu7t5v0__fill_1
XFILLER_83_698 VDD VDD VSS VSS gf180mcu_fd_sc_mcu7t5v0__fill_2
XFILLER_82_186 VDD VDD VSS VSS gf180mcu_fd_sc_mcu7t5v0__fill_1
XFILLER_82_164 VDD VDD VSS VSS gf180mcu_fd_sc_mcu7t5v0__fillcap_4
X_3049_ _3049_/D _3303_/RN _3410_/CLK _3049_/Q VDD VDD VSS VSS gf180mcu_fd_sc_mcu7t5v0__dffrnq_1
XFILLER_36_592 VDD VDD VSS VSS gf180mcu_fd_sc_mcu7t5v0__fill_2
XFILLER_23_264 VDD VDD VSS VSS gf180mcu_fd_sc_mcu7t5v0__fill_1
XFILLER_23_286 VDD VDD VSS VSS gf180mcu_fd_sc_mcu7t5v0__fill_2
XTAP_TAPCELL_ROW_21_454 VDD VSS gf180mcu_fd_sc_mcu7t5v0__filltie
XFILLER_23_67 VDD VDD VSS VSS gf180mcu_fd_sc_mcu7t5v0__fill_2
XTAP_TAPCELL_ROW_94_1217 VDD VSS gf180mcu_fd_sc_mcu7t5v0__filltie
XFILLER_105_564 VDD VDD VSS VSS gf180mcu_fd_sc_mcu7t5v0__fill_1
XFILLER_19_504 VDD VDD VSS VSS gf180mcu_fd_sc_mcu7t5v0__fill_2
XTAP_TAPCELL_ROW_57_830 VDD VSS gf180mcu_fd_sc_mcu7t5v0__filltie
XFILLER_58_172 VDD VDD VSS VSS gf180mcu_fd_sc_mcu7t5v0__fill_2
XFILLER_58_183 VDD VDD VSS VSS gf180mcu_fd_sc_mcu7t5v0__fill_1
XFILLER_19_559 VDD VDD VSS VSS gf180mcu_fd_sc_mcu7t5v0__fill_1
XTAP_TAPCELL_ROW_29_543 VDD VSS gf180mcu_fd_sc_mcu7t5v0__filltie
XFILLER_73_131 VDD VDD VSS VSS gf180mcu_fd_sc_mcu7t5v0__fill_1
XFILLER_27_570 VDD VDD VSS VSS gf180mcu_fd_sc_mcu7t5v0__fill_2
XTAP_TAPCELL_ROW_103_1313 VDD VSS gf180mcu_fd_sc_mcu7t5v0__filltie
XFILLER_73_197 VDD VDD VSS VSS gf180mcu_fd_sc_mcu7t5v0__fillcap_8
XFILLER_108_380 VDD VDD VSS VSS gf180mcu_fd_sc_mcu7t5v0__fill_2
XFILLER_89_60 VDD VDD VSS VSS gf180mcu_fd_sc_mcu7t5v0__fillcap_4
X_2420_ _2434_/B _2420_/A2 _2420_/B _2421_/I0 VDD VDD VSS VSS gf180mcu_fd_sc_mcu7t5v0__aoi21_1
XFILLER_97_702 VDD VDD VSS VSS gf180mcu_fd_sc_mcu7t5v0__fillcap_4
X_2351_ _2889_/Q _2881_/Q _2873_/Q _2865_/Q _2400_/S0 _2390_/S1 _2351_/Z VDD VDD VSS
+ VSS gf180mcu_fd_sc_mcu7t5v0__mux4_1
XFILLER_69_415 VDD VDD VSS VSS gf180mcu_fd_sc_mcu7t5v0__fillcap_4
X_2282_ _3416_/Q _3425_/Q _2427_/B _2425_/A1 VDD VDD VSS VSS gf180mcu_fd_sc_mcu7t5v0__nand3_1
XFILLER_65_632 VDD VDD VSS VSS gf180mcu_fd_sc_mcu7t5v0__fillcap_4
XFILLER_80_657 VDD VDD VSS VSS gf180mcu_fd_sc_mcu7t5v0__fill_2
XFILLER_18_592 VDD VDD VSS VSS gf180mcu_fd_sc_mcu7t5v0__fill_2
XFILLER_80_679 VDD VDD VSS VSS gf180mcu_fd_sc_mcu7t5v0__fill_1
XFILLER_21_702 VDD VDD VSS VSS gf180mcu_fd_sc_mcu7t5v0__fillcap_8
XFILLER_33_562 VDD VDD VSS VSS gf180mcu_fd_sc_mcu7t5v0__fillcap_32
XTAP_TAPCELL_ROW_63_899 VDD VSS gf180mcu_fd_sc_mcu7t5v0__filltie
X_1997_ _3116_/Q _3012_/Q _1999_/S _3012_/D VDD VDD VSS VSS gf180mcu_fd_sc_mcu7t5v0__mux2_2
XFILLER_106_317 VDD VDD VSS VSS gf180mcu_fd_sc_mcu7t5v0__fillcap_16
Xclkload60 _2892_/CLK clkload60/ZN VDD VDD VSS VSS gf180mcu_fd_sc_mcu7t5v0__inv_2
X_2618_ _2670_/A1 _2617_/Z _2619_/A2 VDD VDD VSS VSS gf180mcu_fd_sc_mcu7t5v0__nand2_1
XFILLER_87_212 VDD VDD VSS VSS gf180mcu_fd_sc_mcu7t5v0__fillcap_16
X_2549_ _3171_/Q _3211_/Q _2569_/S _3211_/D VDD VDD VSS VSS gf180mcu_fd_sc_mcu7t5v0__mux2_2
XFILLER_83_451 VDD VDD VSS VSS gf180mcu_fd_sc_mcu7t5v0__fillcap_16
XFILLER_16_507 VDD VDD VSS VSS gf180mcu_fd_sc_mcu7t5v0__fillcap_16
XFILLER_55_131 VDD VDD VSS VSS gf180mcu_fd_sc_mcu7t5v0__fillcap_8
XFILLER_55_142 VDD VDD VSS VSS gf180mcu_fd_sc_mcu7t5v0__fillcap_16
XTAP_TAPCELL_ROW_26_502 VDD VSS gf180mcu_fd_sc_mcu7t5v0__filltie
XFILLER_43_304 VDD VDD VSS VSS gf180mcu_fd_sc_mcu7t5v0__fill_1
XTAP_TAPCELL_ROW_54_800 VDD VSS gf180mcu_fd_sc_mcu7t5v0__filltie
XFILLER_70_101 VDD VDD VSS VSS gf180mcu_fd_sc_mcu7t5v0__fillcap_4
XFILLER_43_348 VDD VDD VSS VSS gf180mcu_fd_sc_mcu7t5v0__fill_2
XFILLER_11_212 VDD VDD VSS VSS gf180mcu_fd_sc_mcu7t5v0__fillcap_4
XTAP_TAPCELL_ROW_34_590 VDD VSS gf180mcu_fd_sc_mcu7t5v0__filltie
XFILLER_7_216 VDD VDD VSS VSS gf180mcu_fd_sc_mcu7t5v0__fill_2
XFILLER_50_10 VDD VDD VSS VSS gf180mcu_fd_sc_mcu7t5v0__fillcap_4
XFILLER_3_422 VDD VDD VSS VSS gf180mcu_fd_sc_mcu7t5v0__fillcap_8
XFILLER_79_702 VDD VDD VSS VSS gf180mcu_fd_sc_mcu7t5v0__fill_2
XFILLER_3_466 VDD VDD VSS VSS gf180mcu_fd_sc_mcu7t5v0__fillcap_8
XFILLER_59_52 VDD VDD VSS VSS gf180mcu_fd_sc_mcu7t5v0__fill_2
XFILLER_93_237 VDD VDD VSS VSS gf180mcu_fd_sc_mcu7t5v0__fill_1
XFILLER_19_312 VDD VDD VSS VSS gf180mcu_fd_sc_mcu7t5v0__fill_2
XTAP_TAPCELL_ROW_6_293 VDD VSS gf180mcu_fd_sc_mcu7t5v0__filltie
XFILLER_47_621 VDD VDD VSS VSS gf180mcu_fd_sc_mcu7t5v0__fillcap_8
XFILLER_47_632 VDD VDD VSS VSS gf180mcu_fd_sc_mcu7t5v0__fillcap_4
XFILLER_59_492 VDD VDD VSS VSS gf180mcu_fd_sc_mcu7t5v0__fillcap_8
Xload_slew22 _2390_/S1 _2388_/S1 VDD VDD VSS VSS gf180mcu_fd_sc_mcu7t5v0__buf_4
XFILLER_74_440 VDD VDD VSS VSS gf180mcu_fd_sc_mcu7t5v0__fillcap_8
XFILLER_19_356 VDD VDD VSS VSS gf180mcu_fd_sc_mcu7t5v0__fill_2
Xload_slew33 _2674_/S0 _2672_/S0 VDD VDD VSS VSS gf180mcu_fd_sc_mcu7t5v0__buf_4
XFILLER_15_562 VDD VDD VSS VSS gf180mcu_fd_sc_mcu7t5v0__fillcap_4
XFILLER_15_584 VDD VDD VSS VSS gf180mcu_fd_sc_mcu7t5v0__fill_2
X_1920_ _3113_/Q _2945_/Q _1925_/S _2945_/D VDD VDD VSS VSS gf180mcu_fd_sc_mcu7t5v0__mux2_2
XFILLER_42_381 VDD VDD VSS VSS gf180mcu_fd_sc_mcu7t5v0__fillcap_4
X_1851_ _1851_/A1 _1851_/A2 _1859_/S VDD VDD VSS VSS gf180mcu_fd_sc_mcu7t5v0__nand2_1
XTAP_TAPCELL_ROW_60_869 VDD VSS gf180mcu_fd_sc_mcu7t5v0__filltie
X_1782_ _2827_/Q _3284_/Q _1785_/S _2827_/D VDD VDD VSS VSS gf180mcu_fd_sc_mcu7t5v0__mux2_2
XFILLER_7_761 VDD VDD VSS VSS gf180mcu_fd_sc_mcu7t5v0__fillcap_4
X_3383_ _3402_/Q _3416_/RN _3398_/CLK hold44/I VDD VDD VSS VSS gf180mcu_fd_sc_mcu7t5v0__dffrnq_1
XFILLER_41_2 VDD VDD VSS VSS gf180mcu_fd_sc_mcu7t5v0__fillcap_4
X_2403_ _2797_/Q _2789_/Q _2781_/Q _2773_/Q _2404_/S0 _2404_/S1 _2403_/Z VDD VDD VSS
+ VSS gf180mcu_fd_sc_mcu7t5v0__mux4_1
X_2334_ _2824_/Q _2816_/Q _2808_/Q _2800_/Q _1439_/B _2373_/S1 _2334_/Z VDD VDD VSS
+ VSS gf180mcu_fd_sc_mcu7t5v0__mux4_1
XFILLER_69_212 VDD VDD VSS VSS gf180mcu_fd_sc_mcu7t5v0__fillcap_16
X_2265_ _2286_/B _2416_/A1 _2265_/B _2274_/A1 VDD VDD VSS VSS gf180mcu_fd_sc_mcu7t5v0__aoi21_1
XFILLER_84_237 VDD VDD VSS VSS gf180mcu_fd_sc_mcu7t5v0__fill_1
XTAP_TAPCELL_ROW_68_947 VDD VSS gf180mcu_fd_sc_mcu7t5v0__filltie
X_2196_ _2196_/A1 _2199_/A1 _2196_/A3 _2200_/A2 VDD VDD VSS VSS gf180mcu_fd_sc_mcu7t5v0__nand3_1
XFILLER_37_142 VDD VDD VSS VSS gf180mcu_fd_sc_mcu7t5v0__fillcap_8
XFILLER_80_465 VDD VDD VSS VSS gf180mcu_fd_sc_mcu7t5v0__fillcap_4
XTAP_TAPCELL_ROW_31_560 VDD VSS gf180mcu_fd_sc_mcu7t5v0__filltie
XFILLER_107_626 VDD VDD VSS VSS gf180mcu_fd_sc_mcu7t5v0__fillcap_4
XFILLER_106_125 VDD VDD VSS VSS gf180mcu_fd_sc_mcu7t5v0__fill_1
Xhold44 hold44/I hold44/Z VDD VDD VSS VSS gf180mcu_fd_sc_mcu7t5v0__dlyc_1
Xhold55 hold55/I hold55/Z VDD VDD VSS VSS gf180mcu_fd_sc_mcu7t5v0__dlyc_1
XFILLER_29_632 VDD VDD VSS VSS gf180mcu_fd_sc_mcu7t5v0__fillcap_4
XTAP_TAPCELL_ROW_3_263 VDD VSS gf180mcu_fd_sc_mcu7t5v0__filltie
XFILLER_29_698 VDD VDD VSS VSS gf180mcu_fd_sc_mcu7t5v0__fill_2
XFILLER_56_484 VDD VDD VSS VSS gf180mcu_fd_sc_mcu7t5v0__fill_1
XFILLER_12_521 VDD VDD VSS VSS gf180mcu_fd_sc_mcu7t5v0__fillcap_4
XFILLER_71_487 VDD VDD VSS VSS gf180mcu_fd_sc_mcu7t5v0__fill_2
XFILLER_6_37 VDD VDD VSS VSS gf180mcu_fd_sc_mcu7t5v0__fillcap_32
XFILLER_4_731 VDD VDD VSS VSS gf180mcu_fd_sc_mcu7t5v0__fillcap_4
XFILLER_4_753 VDD VDD VSS VSS gf180mcu_fd_sc_mcu7t5v0__fillcap_8
XFILLER_79_521 VDD VDD VSS VSS gf180mcu_fd_sc_mcu7t5v0__fill_2
XFILLER_3_274 VDD VDD VSS VSS gf180mcu_fd_sc_mcu7t5v0__fillcap_4
XFILLER_94_535 VDD VDD VSS VSS gf180mcu_fd_sc_mcu7t5v0__fillcap_4
XFILLER_94_524 VDD VDD VSS VSS gf180mcu_fd_sc_mcu7t5v0__fill_1
XFILLER_39_418 VDD VDD VSS VSS gf180mcu_fd_sc_mcu7t5v0__fill_2
X_2050_ _2050_/A1 _2050_/A2 _2050_/B _2050_/C _3033_/D VDD VDD VSS VSS gf180mcu_fd_sc_mcu7t5v0__aoi211_1
XFILLER_19_142 VDD VDD VSS VSS gf180mcu_fd_sc_mcu7t5v0__fillcap_8
Xclkbuf_leaf_40_clk_i clkload3/I _2984_/CLK VDD VDD VSS VSS gf180mcu_fd_sc_mcu7t5v0__clkbuf_4
XTAP_TAPCELL_ROW_37_619 VDD VSS gf180mcu_fd_sc_mcu7t5v0__filltie
XTAP_TAPCELL_ROW_65_917 VDD VSS gf180mcu_fd_sc_mcu7t5v0__filltie
XFILLER_34_156 VDD VDD VSS VSS gf180mcu_fd_sc_mcu7t5v0__fillcap_16
XFILLER_62_454 VDD VDD VSS VSS gf180mcu_fd_sc_mcu7t5v0__fill_1
XFILLER_15_381 VDD VDD VSS VSS gf180mcu_fd_sc_mcu7t5v0__fillcap_16
X_2952_ _2952_/D _3324_/CLK _2952_/Q VDD VDD VSS VSS gf180mcu_fd_sc_mcu7t5v0__dffq_1
Xclkbuf_leaf_55_clk_i clkbuf_leaf_5_clk_i/I _3240_/CLK VDD VDD VSS VSS gf180mcu_fd_sc_mcu7t5v0__clkbuf_4
X_1903_ _2930_/Q _3114_/Q _1907_/S _2930_/D VDD VDD VSS VSS gf180mcu_fd_sc_mcu7t5v0__mux2_2
X_2883_ _2883_/D _2891_/CLK _2883_/Q VDD VDD VSS VSS gf180mcu_fd_sc_mcu7t5v0__dffq_1
XFILLER_89_2 VDD VDD VSS VSS gf180mcu_fd_sc_mcu7t5v0__fillcap_16
X_1834_ _3280_/Q _2871_/Q _1841_/S _2871_/D VDD VDD VSS VSS gf180mcu_fd_sc_mcu7t5v0__mux2_2
XFILLER_30_384 VDD VDD VSS VSS gf180mcu_fd_sc_mcu7t5v0__fill_1
XFILLER_30_395 VDD VDD VSS VSS gf180mcu_fd_sc_mcu7t5v0__fill_2
X_1765_ _3285_/Q _2812_/Q _1767_/S _2812_/D VDD VDD VSS VSS gf180mcu_fd_sc_mcu7t5v0__mux2_2
XTAP_TAPCELL_ROW_77_1042 VDD VSS gf180mcu_fd_sc_mcu7t5v0__filltie
X_1696_ _1699_/A1 _1696_/A2 _2420_/B _1697_/I0 VDD VDD VSS VSS gf180mcu_fd_sc_mcu7t5v0__aoi21_1
XFILLER_103_139 VDD VDD VSS VSS gf180mcu_fd_sc_mcu7t5v0__fill_1
X_3366_ _3366_/D input1/Z _3366_/CLK _3366_/Q VDD VDD VSS VSS gf180mcu_fd_sc_mcu7t5v0__dffrnq_1
X_2317_ _3132_/Q _2409_/A1 _2318_/B VDD VDD VSS VSS gf180mcu_fd_sc_mcu7t5v0__nand2_1
X_3297_ _3297_/D _3303_/RN _3297_/CLK _3297_/Q VDD VDD VSS VSS gf180mcu_fd_sc_mcu7t5v0__dffrnq_1
X_2248_ _3415_/D _2263_/A1 _3132_/Q _2278_/A1 _2417_/A2 VDD VDD VSS VSS gf180mcu_fd_sc_mcu7t5v0__nor4_1
XTAP_TAPCELL_ROW_88_1160 VDD VSS gf180mcu_fd_sc_mcu7t5v0__filltie
XFILLER_38_473 VDD VDD VSS VSS gf180mcu_fd_sc_mcu7t5v0__fill_1
X_2179_ _2179_/A1 _1523_/B _3104_/D VDD VDD VSS VSS gf180mcu_fd_sc_mcu7t5v0__nand2_1
XTAP_TAPCELL_ROW_0_233 VDD VSS gf180mcu_fd_sc_mcu7t5v0__filltie
XTAP_TAPCELL_ROW_0_222 VDD VSS gf180mcu_fd_sc_mcu7t5v0__filltie
XFILLER_72_229 VDD VDD VSS VSS gf180mcu_fd_sc_mcu7t5v0__fillcap_8
XFILLER_81_763 VDD VDD VSS VSS gf180mcu_fd_sc_mcu7t5v0__fill_2
XFILLER_40_104 VDD VDD VSS VSS gf180mcu_fd_sc_mcu7t5v0__fill_1
XFILLER_53_487 VDD VDD VSS VSS gf180mcu_fd_sc_mcu7t5v0__fill_2
XFILLER_15_68 VDD VDD VSS VSS gf180mcu_fd_sc_mcu7t5v0__fill_2
XFILLER_21_384 VDD VDD VSS VSS gf180mcu_fd_sc_mcu7t5v0__fillcap_16
XTAP_TAPCELL_ROW_8_322 VDD VSS gf180mcu_fd_sc_mcu7t5v0__filltie
XFILLER_1_734 VDD VDD VSS VSS gf180mcu_fd_sc_mcu7t5v0__fillcap_16
XFILLER_102_172 VDD VDD VSS VSS gf180mcu_fd_sc_mcu7t5v0__fill_2
XFILLER_76_524 VDD VDD VSS VSS gf180mcu_fd_sc_mcu7t5v0__fill_1
XFILLER_0_299 VDD VDD VSS VSS gf180mcu_fd_sc_mcu7t5v0__fillcap_4
XFILLER_56_53 VDD VDD VSS VSS gf180mcu_fd_sc_mcu7t5v0__fillcap_8
XFILLER_64_719 VDD VDD VSS VSS gf180mcu_fd_sc_mcu7t5v0__fillcap_16
XFILLER_84_590 VDD VDD VSS VSS gf180mcu_fd_sc_mcu7t5v0__fillcap_4
XFILLER_44_465 VDD VDD VSS VSS gf180mcu_fd_sc_mcu7t5v0__fillcap_4
XFILLER_31_137 VDD VDD VSS VSS gf180mcu_fd_sc_mcu7t5v0__fill_2
XTAP_TAPCELL_ROW_70_964 VDD VSS gf180mcu_fd_sc_mcu7t5v0__filltie
XTAP_TAPCELL_ROW_14_379 VDD VSS gf180mcu_fd_sc_mcu7t5v0__filltie
XTAP_TAPCELL_ROW_42_677 VDD VSS gf180mcu_fd_sc_mcu7t5v0__filltie
XFILLER_12_384 VDD VDD VSS VSS gf180mcu_fd_sc_mcu7t5v0__fill_1
X_1550_ _3052_/Q _1547_/B _2076_/C VDD VDD VSS VSS gf180mcu_fd_sc_mcu7t5v0__and2_1
X_1481_ _3354_/Q _1478_/Z _1485_/A2 VDD VDD VSS VSS gf180mcu_fd_sc_mcu7t5v0__nand2_1
XFILLER_79_340 VDD VDD VSS VSS gf180mcu_fd_sc_mcu7t5v0__fillcap_8
X_3220_ _3220_/D _3303_/RN _3293_/CLK _3220_/Q VDD VDD VSS VSS gf180mcu_fd_sc_mcu7t5v0__dffrnq_1
X_3151_ _3151_/D _3303_/RN _3292_/CLK _3151_/Q VDD VDD VSS VSS gf180mcu_fd_sc_mcu7t5v0__dffrnq_1
X_2102_ _3114_/Q _3054_/Q _2107_/S _3054_/D VDD VDD VSS VSS gf180mcu_fd_sc_mcu7t5v0__mux2_2
XFILLER_94_387 VDD VDD VSS VSS gf180mcu_fd_sc_mcu7t5v0__fillcap_32
X_3082_ _3082_/D _3328_/RN _3264_/CLK _3082_/Q VDD VDD VSS VSS gf180mcu_fd_sc_mcu7t5v0__dffrnq_1
X_2033_ _3028_/Q _2010_/Z _2027_/Z _2036_/A2 VDD VDD VSS VSS gf180mcu_fd_sc_mcu7t5v0__nand3_1
XFILLER_63_763 VDD VDD VSS VSS gf180mcu_fd_sc_mcu7t5v0__fill_2
XFILLER_22_115 VDD VDD VSS VSS gf180mcu_fd_sc_mcu7t5v0__fill_1
XFILLER_23_616 VDD VDD VSS VSS gf180mcu_fd_sc_mcu7t5v0__fillcap_8
XFILLER_50_402 VDD VDD VSS VSS gf180mcu_fd_sc_mcu7t5v0__fillcap_16
X_2935_ _2935_/D _2988_/CLK _2935_/Q VDD VDD VSS VSS gf180mcu_fd_sc_mcu7t5v0__dffq_1
XFILLER_22_159 VDD VDD VSS VSS gf180mcu_fd_sc_mcu7t5v0__fillcap_16
X_2866_ _2866_/D _2891_/CLK _2866_/Q VDD VDD VSS VSS gf180mcu_fd_sc_mcu7t5v0__dffq_1
X_1817_ _2857_/Q _3282_/Q _1822_/S _2857_/D VDD VDD VSS VSS gf180mcu_fd_sc_mcu7t5v0__mux2_2
X_2797_ _2797_/D _2893_/CLK _2797_/Q VDD VDD VSS VSS gf180mcu_fd_sc_mcu7t5v0__dffq_1
X_1748_ _3287_/Q _2798_/Q _1748_/S _2798_/D VDD VDD VSS VSS gf180mcu_fd_sc_mcu7t5v0__mux2_2
X_1679_ _2315_/A1 _1658_/Z _1679_/B1 _2218_/B _1679_/C _1689_/A2 VDD VDD VSS VSS gf180mcu_fd_sc_mcu7t5v0__aoi221_1
X_3418_ _3418_/D _3416_/RN _3424_/CLK _3418_/Q VDD VDD VSS VSS gf180mcu_fd_sc_mcu7t5v0__dffsnq_1
XFILLER_98_693 VDD VDD VSS VSS gf180mcu_fd_sc_mcu7t5v0__fill_2
X_3349_ hold49/Z _3369_/RN _3358_/CLK _3349_/Q VDD VDD VSS VSS gf180mcu_fd_sc_mcu7t5v0__dffrnq_1
XFILLER_85_321 VDD VDD VSS VSS gf180mcu_fd_sc_mcu7t5v0__fill_1
XFILLER_45_218 VDD VDD VSS VSS gf180mcu_fd_sc_mcu7t5v0__fill_1
XFILLER_26_34 VDD VDD VSS VSS gf180mcu_fd_sc_mcu7t5v0__fill_1
XFILLER_41_413 VDD VDD VSS VSS gf180mcu_fd_sc_mcu7t5v0__fillcap_4
XFILLER_22_693 VDD VDD VSS VSS gf180mcu_fd_sc_mcu7t5v0__fill_1
XTAP_TAPCELL_ROW_97_1248 VDD VSS gf180mcu_fd_sc_mcu7t5v0__filltie
XTAP_TAPCELL_ROW_11_349 VDD VSS gf180mcu_fd_sc_mcu7t5v0__filltie
Xclkbuf_4_13_0_host_clk_i clkbuf_0_host_clk_i/Z _3407_/CLK VDD VDD VSS VSS gf180mcu_fd_sc_mcu7t5v0__clkbuf_4
XFILLER_107_297 VDD VDD VSS VSS gf180mcu_fd_sc_mcu7t5v0__fillcap_32
XFILLER_107_275 VDD VDD VSS VSS gf180mcu_fd_sc_mcu7t5v0__fillcap_4
XFILLER_89_660 VDD VDD VSS VSS gf180mcu_fd_sc_mcu7t5v0__fillcap_32
XFILLER_103_492 VDD VDD VSS VSS gf180mcu_fd_sc_mcu7t5v0__fillcap_8
XFILLER_91_302 VDD VDD VSS VSS gf180mcu_fd_sc_mcu7t5v0__fillcap_32
XFILLER_49_579 VDD VDD VSS VSS gf180mcu_fd_sc_mcu7t5v0__fillcap_4
XFILLER_76_387 VDD VDD VSS VSS gf180mcu_fd_sc_mcu7t5v0__fillcap_8
XTAP_TAPCELL_ROW_19_438 VDD VSS gf180mcu_fd_sc_mcu7t5v0__filltie
XTAP_TAPCELL_ROW_47_725 VDD VSS gf180mcu_fd_sc_mcu7t5v0__filltie
XFILLER_64_527 VDD VDD VSS VSS gf180mcu_fd_sc_mcu7t5v0__fill_1
XTAP_TAPCELL_ROW_106_1344 VDD VSS gf180mcu_fd_sc_mcu7t5v0__filltie
XFILLER_91_368 VDD VDD VSS VSS gf180mcu_fd_sc_mcu7t5v0__fillcap_8
XFILLER_60_733 VDD VDD VSS VSS gf180mcu_fd_sc_mcu7t5v0__fill_2
XFILLER_32_457 VDD VDD VSS VSS gf180mcu_fd_sc_mcu7t5v0__fillcap_16
X_2720_ _2687_/Z _2720_/A2 _3271_/D VDD VDD VSS VSS gf180mcu_fd_sc_mcu7t5v0__nand2_1
XFILLER_8_130 VDD VDD VSS VSS gf180mcu_fd_sc_mcu7t5v0__fillcap_16
XFILLER_40_490 VDD VDD VSS VSS gf180mcu_fd_sc_mcu7t5v0__fillcap_32
X_2651_ _2651_/A1 _2651_/A2 _3250_/D VDD VDD VSS VSS gf180mcu_fd_sc_mcu7t5v0__nand2_1
X_1602_ _1602_/A1 _1602_/A2 _1602_/A3 _1603_/A3 VDD VDD VSS VSS gf180mcu_fd_sc_mcu7t5v0__nand3_1
XFILLER_8_196 VDD VDD VSS VSS gf180mcu_fd_sc_mcu7t5v0__fill_1
XFILLER_8_174 VDD VDD VSS VSS gf180mcu_fd_sc_mcu7t5v0__fill_1
XTAP_TAPCELL_ROW_74_1012 VDD VSS gf180mcu_fd_sc_mcu7t5v0__filltie
X_2582_ _3200_/Q _3242_/Q _2585_/S _3242_/D VDD VDD VSS VSS gf180mcu_fd_sc_mcu7t5v0__mux2_2
X_1533_ _2098_/A1 _3052_/Q _2101_/A1 _3054_/Q _1561_/B2 VDD VDD VSS VSS gf180mcu_fd_sc_mcu7t5v0__nand4_1
X_1464_ _3406_/Q _1458_/Z _1471_/A2 VDD VDD VSS VSS gf180mcu_fd_sc_mcu7t5v0__nor2_1
XFILLER_86_107 VDD VDD VSS VSS gf180mcu_fd_sc_mcu7t5v0__fillcap_16
X_3203_ _3203_/D _3328_/RN clkload8/I _3203_/Q VDD VDD VSS VSS gf180mcu_fd_sc_mcu7t5v0__dffrnq_1
X_1395_ _3051_/Q _2098_/A1 VDD VDD VSS VSS gf180mcu_fd_sc_mcu7t5v0__clkinv_1
X_3134_ _3134_/D _3369_/RN _3148_/CLK _3134_/Q VDD VDD VSS VSS gf180mcu_fd_sc_mcu7t5v0__dffrnq_1
XFILLER_27_218 VDD VDD VSS VSS gf180mcu_fd_sc_mcu7t5v0__fill_1
X_3065_ _3065_/D _3303_/RN _3222_/CLK _3065_/Q VDD VDD VSS VSS gf180mcu_fd_sc_mcu7t5v0__dffrnq_1
X_2016_ _2010_/Z _2051_/A1 _2023_/B VDD VDD VSS VSS gf180mcu_fd_sc_mcu7t5v0__nand2_1
XTAP_TAPCELL_ROW_85_1130 VDD VSS gf180mcu_fd_sc_mcu7t5v0__filltie
XFILLER_50_221 VDD VDD VSS VSS gf180mcu_fd_sc_mcu7t5v0__fillcap_16
XFILLER_10_107 VDD VDD VSS VSS gf180mcu_fd_sc_mcu7t5v0__fillcap_8
X_2918_ _2918_/D _2926_/CLK _2918_/Q VDD VDD VSS VSS gf180mcu_fd_sc_mcu7t5v0__dffq_1
X_2849_ _2849_/D _3406_/CLK _2849_/Q VDD VDD VSS VSS gf180mcu_fd_sc_mcu7t5v0__dffq_1
XFILLER_105_702 VDD VDD VSS VSS gf180mcu_fd_sc_mcu7t5v0__fillcap_16
XFILLER_88_18 VDD VDD VSS VSS gf180mcu_fd_sc_mcu7t5v0__fillcap_4
XFILLER_104_201 VDD VDD VSS VSS gf180mcu_fd_sc_mcu7t5v0__fillcap_4
XFILLER_2_317 VDD VDD VSS VSS gf180mcu_fd_sc_mcu7t5v0__fillcap_16
XFILLER_100_451 VDD VDD VSS VSS gf180mcu_fd_sc_mcu7t5v0__fillcap_4
XFILLER_58_365 VDD VDD VSS VSS gf180mcu_fd_sc_mcu7t5v0__fillcap_4
XFILLER_46_527 VDD VDD VSS VSS gf180mcu_fd_sc_mcu7t5v0__fillcap_64
XFILLER_58_387 VDD VDD VSS VSS gf180mcu_fd_sc_mcu7t5v0__fillcap_32
XFILLER_37_88 VDD VDD VSS VSS gf180mcu_fd_sc_mcu7t5v0__fill_2
XFILLER_61_508 VDD VDD VSS VSS gf180mcu_fd_sc_mcu7t5v0__fillcap_4
XFILLER_73_368 VDD VDD VSS VSS gf180mcu_fd_sc_mcu7t5v0__fillcap_16
XFILLER_14_457 VDD VDD VSS VSS gf180mcu_fd_sc_mcu7t5v0__fillcap_16
XFILLER_53_65 VDD VDD VSS VSS gf180mcu_fd_sc_mcu7t5v0__fillcap_4
XTAP_TAPCELL_ROW_24_485 VDD VSS gf180mcu_fd_sc_mcu7t5v0__filltie
XTAP_TAPCELL_ROW_52_783 VDD VSS gf180mcu_fd_sc_mcu7t5v0__filltie
XTAP_TAPCELL_ROW_101_1296 VDD VSS gf180mcu_fd_sc_mcu7t5v0__filltie
XFILLER_108_562 VDD VDD VSS VSS gf180mcu_fd_sc_mcu7t5v0__fillcap_16
XFILLER_6_667 VDD VDD VSS VSS gf180mcu_fd_sc_mcu7t5v0__fillcap_8
XFILLER_68_107 VDD VDD VSS VSS gf180mcu_fd_sc_mcu7t5v0__fill_2
XFILLER_64_313 VDD VDD VSS VSS gf180mcu_fd_sc_mcu7t5v0__fill_2
XFILLER_91_132 VDD VDD VSS VSS gf180mcu_fd_sc_mcu7t5v0__fillcap_8
XTAP_TAPCELL_ROW_80_1071 VDD VSS gf180mcu_fd_sc_mcu7t5v0__filltie
XFILLER_32_276 VDD VDD VSS VSS gf180mcu_fd_sc_mcu7t5v0__fillcap_4
X_2703_ _3263_/Q _2680_/C _2729_/B1 _3081_/Q _2704_/A2 VDD VDD VSS VSS gf180mcu_fd_sc_mcu7t5v0__aoi22_1
X_2634_ _3353_/Q _2634_/A2 _2634_/B _3354_/Q _2638_/B VDD VDD VSS VSS gf180mcu_fd_sc_mcu7t5v0__aoi211_1
X_2565_ _3183_/Q _3225_/Q _2569_/S _3225_/D VDD VDD VSS VSS gf180mcu_fd_sc_mcu7t5v0__mux2_2
X_1516_ _3209_/Q _3210_/Q _3211_/Q _2602_/A2 VDD VDD VSS VSS gf180mcu_fd_sc_mcu7t5v0__nor3_1
XFILLER_99_276 VDD VDD VSS VSS gf180mcu_fd_sc_mcu7t5v0__fillcap_4
X_2496_ _1612_/Z _2495_/Z _3162_/D VDD VDD VSS VSS gf180mcu_fd_sc_mcu7t5v0__nor2_1
XFILLER_99_298 VDD VDD VSS VSS gf180mcu_fd_sc_mcu7t5v0__fill_1
X_1447_ _3394_/Q _1442_/Z _1450_/A2 VDD VDD VSS VSS gf180mcu_fd_sc_mcu7t5v0__nand2_1
XFILLER_87_438 VDD VDD VSS VSS gf180mcu_fd_sc_mcu7t5v0__fillcap_4
X_1378_ _3146_/Q _2432_/B2 VDD VDD VSS VSS gf180mcu_fd_sc_mcu7t5v0__clkinv_1
XFILLER_67_151 VDD VDD VSS VSS gf180mcu_fd_sc_mcu7t5v0__fill_1
XFILLER_28_527 VDD VDD VSS VSS gf180mcu_fd_sc_mcu7t5v0__fillcap_8
X_3117_ _3117_/D _3285_/CLK _3117_/Q VDD VDD VSS VSS gf180mcu_fd_sc_mcu7t5v0__dffq_1
XFILLER_55_368 VDD VDD VSS VSS gf180mcu_fd_sc_mcu7t5v0__fillcap_8
XFILLER_24_700 VDD VDD VSS VSS gf180mcu_fd_sc_mcu7t5v0__fill_2
XFILLER_36_560 VDD VDD VSS VSS gf180mcu_fd_sc_mcu7t5v0__fillcap_32
X_3048_ _3048_/D _3416_/RN _3425_/CLK _3048_/Q VDD VDD VSS VSS gf180mcu_fd_sc_mcu7t5v0__dffrnq_1
XTAP_TAPCELL_ROW_21_455 VDD VSS gf180mcu_fd_sc_mcu7t5v0__filltie
XTAP_TAPCELL_ROW_94_1218 VDD VSS gf180mcu_fd_sc_mcu7t5v0__filltie
XFILLER_105_554 VDD VDD VSS VSS gf180mcu_fd_sc_mcu7t5v0__fillcap_4
XFILLER_2_158 VDD VDD VSS VSS gf180mcu_fd_sc_mcu7t5v0__fillcap_16
XFILLER_93_419 VDD VDD VSS VSS gf180mcu_fd_sc_mcu7t5v0__fill_1
XFILLER_100_281 VDD VDD VSS VSS gf180mcu_fd_sc_mcu7t5v0__fillcap_32
XTAP_TAPCELL_ROW_57_831 VDD VSS gf180mcu_fd_sc_mcu7t5v0__filltie
XTAP_TAPCELL_ROW_103_1314 VDD VSS gf180mcu_fd_sc_mcu7t5v0__filltie
XFILLER_61_349 VDD VDD VSS VSS gf180mcu_fd_sc_mcu7t5v0__fill_1
XFILLER_14_243 VDD VDD VSS VSS gf180mcu_fd_sc_mcu7t5v0__fill_2
XFILLER_42_541 VDD VDD VSS VSS gf180mcu_fd_sc_mcu7t5v0__fill_1
X_2350_ _3394_/Q _2349_/Z _2353_/A2 VDD VDD VSS VSS gf180mcu_fd_sc_mcu7t5v0__nand2_1
X_2281_ _2281_/A1 _2281_/A2 _3123_/D VDD VDD VSS VSS gf180mcu_fd_sc_mcu7t5v0__nand2_1
XFILLER_69_438 VDD VDD VSS VSS gf180mcu_fd_sc_mcu7t5v0__fillcap_16
XFILLER_64_154 VDD VDD VSS VSS gf180mcu_fd_sc_mcu7t5v0__fillcap_8
XTAP_TAPCELL_ROW_82_1100 VDD VSS gf180mcu_fd_sc_mcu7t5v0__filltie
XFILLER_64_198 VDD VDD VSS VSS gf180mcu_fd_sc_mcu7t5v0__fill_1
XFILLER_60_382 VDD VDD VSS VSS gf180mcu_fd_sc_mcu7t5v0__fill_2
X_1996_ _3115_/Q _3011_/Q _1999_/S _3011_/D VDD VDD VSS VSS gf180mcu_fd_sc_mcu7t5v0__mux2_2
XFILLER_21_758 VDD VDD VSS VSS gf180mcu_fd_sc_mcu7t5v0__fillcap_4
Xclkload61 _2893_/CLK clkload61/ZN VDD VDD VSS VSS gf180mcu_fd_sc_mcu7t5v0__inv_3
Xclkload50 _3369_/CLK clkload50/ZN VDD VDD VSS VSS gf180mcu_fd_sc_mcu7t5v0__clkinv_2
X_2617_ _2615_/Z _2616_/Z _2614_/Z _2613_/Z _3353_/Q _3354_/Q _2617_/Z VDD VDD VSS
+ VSS gf180mcu_fd_sc_mcu7t5v0__mux4_1
XFILLER_102_513 VDD VDD VSS VSS gf180mcu_fd_sc_mcu7t5v0__fillcap_8
X_2548_ _3170_/Q _3210_/Q _2569_/S _3210_/D VDD VDD VSS VSS gf180mcu_fd_sc_mcu7t5v0__mux2_2
XFILLER_102_535 VDD VDD VSS VSS gf180mcu_fd_sc_mcu7t5v0__fillcap_4
XFILLER_75_419 VDD VDD VSS VSS gf180mcu_fd_sc_mcu7t5v0__fill_1
X_2479_ _3154_/Q _3155_/Q _2480_/S _3155_/D VDD VDD VSS VSS gf180mcu_fd_sc_mcu7t5v0__mux2_2
XFILLER_28_313 VDD VDD VSS VSS gf180mcu_fd_sc_mcu7t5v0__fill_2
XFILLER_28_335 VDD VDD VSS VSS gf180mcu_fd_sc_mcu7t5v0__fill_2
XFILLER_18_79 VDD VDD VSS VSS gf180mcu_fd_sc_mcu7t5v0__fill_2
XTAP_TAPCELL_ROW_26_503 VDD VSS gf180mcu_fd_sc_mcu7t5v0__filltie
XTAP_TAPCELL_ROW_54_801 VDD VSS gf180mcu_fd_sc_mcu7t5v0__filltie
XFILLER_56_699 VDD VDD VSS VSS gf180mcu_fd_sc_mcu7t5v0__fill_2
XFILLER_71_625 VDD VDD VSS VSS gf180mcu_fd_sc_mcu7t5v0__fillcap_4
XFILLER_43_327 VDD VDD VSS VSS gf180mcu_fd_sc_mcu7t5v0__fillcap_4
XFILLER_55_198 VDD VDD VSS VSS gf180mcu_fd_sc_mcu7t5v0__fillcap_8
XFILLER_71_636 VDD VDD VSS VSS gf180mcu_fd_sc_mcu7t5v0__fill_2
XFILLER_34_34 VDD VDD VSS VSS gf180mcu_fd_sc_mcu7t5v0__fill_1
XFILLER_12_714 VDD VDD VSS VSS gf180mcu_fd_sc_mcu7t5v0__fillcap_4
XFILLER_51_360 VDD VDD VSS VSS gf180mcu_fd_sc_mcu7t5v0__fillcap_4
XFILLER_11_246 VDD VDD VSS VSS gf180mcu_fd_sc_mcu7t5v0__fillcap_4
XTAP_TAPCELL_ROW_34_591 VDD VSS gf180mcu_fd_sc_mcu7t5v0__filltie
Xclkload0 clkload0/I clkload0/ZN VDD VDD VSS VSS gf180mcu_fd_sc_mcu7t5v0__clkinv_3
XFILLER_1_2 VDD VDD VSS VSS gf180mcu_fd_sc_mcu7t5v0__fillcap_64
XFILLER_78_224 VDD VDD VSS VSS gf180mcu_fd_sc_mcu7t5v0__fill_2
XFILLER_93_216 VDD VDD VSS VSS gf180mcu_fd_sc_mcu7t5v0__fill_1
XTAP_TAPCELL_ROW_6_294 VDD VSS gf180mcu_fd_sc_mcu7t5v0__filltie
Xload_slew23 _2373_/S1 _2390_/S1 VDD VDD VSS VSS gf180mcu_fd_sc_mcu7t5v0__buf_4
XFILLER_74_452 VDD VDD VSS VSS gf180mcu_fd_sc_mcu7t5v0__fill_2
Xload_slew34 _2673_/S0 _2674_/S0 VDD VDD VSS VSS gf180mcu_fd_sc_mcu7t5v0__buf_4
XFILLER_62_669 VDD VDD VSS VSS gf180mcu_fd_sc_mcu7t5v0__fill_1
X_1850_ _3287_/Q _2886_/Q _1850_/S _2886_/D VDD VDD VSS VSS gf180mcu_fd_sc_mcu7t5v0__mux2_2
XFILLER_91_95 VDD VDD VSS VSS gf180mcu_fd_sc_mcu7t5v0__fill_1
XFILLER_30_533 VDD VDD VSS VSS gf180mcu_fd_sc_mcu7t5v0__fill_1
XTAP_TAPCELL_ROW_60_859 VDD VSS gf180mcu_fd_sc_mcu7t5v0__filltie
X_1781_ _2826_/Q _3283_/Q _1785_/S _2826_/D VDD VDD VSS VSS gf180mcu_fd_sc_mcu7t5v0__mux2_2
XFILLER_30_599 VDD VDD VSS VSS gf180mcu_fd_sc_mcu7t5v0__fill_1
XFILLER_97_500 VDD VDD VSS VSS gf180mcu_fd_sc_mcu7t5v0__fillcap_4
X_2402_ _2378_/B _2402_/A2 _2402_/A3 _2406_/B VDD VDD VSS VSS gf180mcu_fd_sc_mcu7t5v0__nand3_1
X_3382_ _3401_/Q input1/Z _3387_/CLK hold64/I VDD VDD VSS VSS gf180mcu_fd_sc_mcu7t5v0__dffrnq_1
X_2333_ _2888_/Q _2880_/Q _2872_/Q _2864_/Q _1439_/B _2373_/S1 _2333_/Z VDD VDD VSS
+ VSS gf180mcu_fd_sc_mcu7t5v0__mux4_1
XFILLER_34_2 VDD VDD VSS VSS gf180mcu_fd_sc_mcu7t5v0__fillcap_8
XFILLER_97_566 VDD VDD VSS VSS gf180mcu_fd_sc_mcu7t5v0__fill_2
XFILLER_84_227 VDD VDD VSS VSS gf180mcu_fd_sc_mcu7t5v0__fillcap_8
XFILLER_57_419 VDD VDD VSS VSS gf180mcu_fd_sc_mcu7t5v0__fill_1
X_2264_ _2259_/Z _2264_/A2 _2264_/B _2416_/A1 VDD VDD VSS VSS gf180mcu_fd_sc_mcu7t5v0__aoi21_1
XTAP_TAPCELL_ROW_68_948 VDD VSS gf180mcu_fd_sc_mcu7t5v0__filltie
XFILLER_69_279 VDD VDD VSS VSS gf180mcu_fd_sc_mcu7t5v0__fill_1
X_2195_ _2424_/A1 _1672_/B _1686_/C _1686_/B _2196_/A3 VDD VDD VSS VSS gf180mcu_fd_sc_mcu7t5v0__aoi22_1
XFILLER_65_441 VDD VDD VSS VSS gf180mcu_fd_sc_mcu7t5v0__fill_2
XFILLER_37_154 VDD VDD VSS VSS gf180mcu_fd_sc_mcu7t5v0__fill_2
XFILLER_25_327 VDD VDD VSS VSS gf180mcu_fd_sc_mcu7t5v0__fillcap_8
XFILLER_52_102 VDD VDD VSS VSS gf180mcu_fd_sc_mcu7t5v0__fill_2
XFILLER_65_496 VDD VDD VSS VSS gf180mcu_fd_sc_mcu7t5v0__fill_1
XTAP_TAPCELL_ROW_31_561 VDD VSS gf180mcu_fd_sc_mcu7t5v0__filltie
X_1979_ _2996_/Q _3116_/Q _1981_/S _2996_/D VDD VDD VSS VSS gf180mcu_fd_sc_mcu7t5v0__mux2_2
XFILLER_106_104 VDD VDD VSS VSS gf180mcu_fd_sc_mcu7t5v0__fill_1
XFILLER_20_14 VDD VDD VSS VSS gf180mcu_fd_sc_mcu7t5v0__fill_2
XFILLER_96_18 VDD VDD VSS VSS gf180mcu_fd_sc_mcu7t5v0__fillcap_4
XFILLER_102_354 VDD VDD VSS VSS gf180mcu_fd_sc_mcu7t5v0__fillcap_16
XFILLER_102_387 VDD VDD VSS VSS gf180mcu_fd_sc_mcu7t5v0__fillcap_64
Xhold56 hold56/I hold56/Z VDD VDD VSS VSS gf180mcu_fd_sc_mcu7t5v0__dlyc_1
XFILLER_88_588 VDD VDD VSS VSS gf180mcu_fd_sc_mcu7t5v0__fillcap_4
XFILLER_76_739 VDD VDD VSS VSS gf180mcu_fd_sc_mcu7t5v0__fill_1
XFILLER_75_216 VDD VDD VSS VSS gf180mcu_fd_sc_mcu7t5v0__fill_2
Xhold45 hold45/I hold45/Z VDD VDD VSS VSS gf180mcu_fd_sc_mcu7t5v0__dlyc_1
XTAP_TAPCELL_ROW_3_264 VDD VSS gf180mcu_fd_sc_mcu7t5v0__filltie
XFILLER_83_282 VDD VDD VSS VSS gf180mcu_fd_sc_mcu7t5v0__fillcap_16
XFILLER_16_349 VDD VDD VSS VSS gf180mcu_fd_sc_mcu7t5v0__fill_2
XFILLER_44_625 VDD VDD VSS VSS gf180mcu_fd_sc_mcu7t5v0__fill_1
XFILLER_71_422 VDD VDD VSS VSS gf180mcu_fd_sc_mcu7t5v0__fillcap_4
XFILLER_101_72 VDD VDD VSS VSS gf180mcu_fd_sc_mcu7t5v0__fillcap_64
XFILLER_12_544 VDD VDD VSS VSS gf180mcu_fd_sc_mcu7t5v0__fillcap_4
XFILLER_12_588 VDD VDD VSS VSS gf180mcu_fd_sc_mcu7t5v0__fillcap_4
XFILLER_61_76 VDD VDD VSS VSS gf180mcu_fd_sc_mcu7t5v0__fill_2
XFILLER_61_87 VDD VDD VSS VSS gf180mcu_fd_sc_mcu7t5v0__fill_1
XFILLER_67_717 VDD VDD VSS VSS gf180mcu_fd_sc_mcu7t5v0__fillcap_8
XFILLER_94_514 VDD VDD VSS VSS gf180mcu_fd_sc_mcu7t5v0__fillcap_8
XFILLER_19_132 VDD VDD VSS VSS gf180mcu_fd_sc_mcu7t5v0__fillcap_8
XFILLER_19_154 VDD VDD VSS VSS gf180mcu_fd_sc_mcu7t5v0__fill_1
XTAP_TAPCELL_ROW_65_918 VDD VSS gf180mcu_fd_sc_mcu7t5v0__filltie
XFILLER_90_764 VDD VDD VSS VSS gf180mcu_fd_sc_mcu7t5v0__fill_1
X_2951_ _2951_/D _3020_/CLK _2951_/Q VDD VDD VSS VSS gf180mcu_fd_sc_mcu7t5v0__dffq_1
XFILLER_43_680 VDD VDD VSS VSS gf180mcu_fd_sc_mcu7t5v0__fillcap_8
X_1902_ _2929_/Q _3113_/Q _1907_/S _2929_/D VDD VDD VSS VSS gf180mcu_fd_sc_mcu7t5v0__mux2_2
X_2882_ _2882_/D _2891_/CLK _2882_/Q VDD VDD VSS VSS gf180mcu_fd_sc_mcu7t5v0__dffq_1
X_1833_ _1833_/A1 _1851_/A2 _1841_/S VDD VDD VSS VSS gf180mcu_fd_sc_mcu7t5v0__nand2_1
X_1764_ _3284_/Q _2811_/Q _1767_/S _2811_/D VDD VDD VSS VSS gf180mcu_fd_sc_mcu7t5v0__mux2_2
XTAP_TAPCELL_ROW_77_1043 VDD VSS gf180mcu_fd_sc_mcu7t5v0__filltie
X_1695_ _2438_/A2 _1708_/A1 _2267_/A2 _1696_/A2 VDD VDD VSS VSS gf180mcu_fd_sc_mcu7t5v0__nor3_1
XFILLER_97_352 VDD VDD VSS VSS gf180mcu_fd_sc_mcu7t5v0__fillcap_4
X_3365_ _3365_/D input1/Z _3367_/CLK _3365_/Q VDD VDD VSS VSS gf180mcu_fd_sc_mcu7t5v0__dffrnq_1
X_2316_ _2316_/A1 _2316_/A2 _2316_/A3 _2409_/A1 VDD VDD VSS VSS gf180mcu_fd_sc_mcu7t5v0__nand3_1
X_3296_ _3296_/D _3303_/RN _3297_/CLK _3296_/Q VDD VDD VSS VSS gf180mcu_fd_sc_mcu7t5v0__dffrnq_1
XFILLER_85_558 VDD VDD VSS VSS gf180mcu_fd_sc_mcu7t5v0__fill_2
X_2247_ _2263_/A1 _3132_/Q _2278_/A1 _2264_/B VDD VDD VSS VSS gf180mcu_fd_sc_mcu7t5v0__nor3_1
XFILLER_26_614 VDD VDD VSS VSS gf180mcu_fd_sc_mcu7t5v0__fillcap_16
XFILLER_66_761 VDD VDD VSS VSS gf180mcu_fd_sc_mcu7t5v0__fillcap_4
XTAP_TAPCELL_ROW_88_1161 VDD VSS gf180mcu_fd_sc_mcu7t5v0__filltie
XTAP_TAPCELL_ROW_0_223 VDD VSS gf180mcu_fd_sc_mcu7t5v0__filltie
XTAP_TAPCELL_ROW_0_234 VDD VSS gf180mcu_fd_sc_mcu7t5v0__filltie
X_2178_ _3103_/Q _3245_/Q _2178_/S _3103_/D VDD VDD VSS VSS gf180mcu_fd_sc_mcu7t5v0__mux2_2
XFILLER_53_422 VDD VDD VSS VSS gf180mcu_fd_sc_mcu7t5v0__fillcap_16
XFILLER_65_260 VDD VDD VSS VSS gf180mcu_fd_sc_mcu7t5v0__fillcap_16
XFILLER_65_282 VDD VDD VSS VSS gf180mcu_fd_sc_mcu7t5v0__fillcap_64
XFILLER_13_308 VDD VDD VSS VSS gf180mcu_fd_sc_mcu7t5v0__fillcap_8
XFILLER_41_617 VDD VDD VSS VSS gf180mcu_fd_sc_mcu7t5v0__fill_1
XFILLER_21_352 VDD VDD VSS VSS gf180mcu_fd_sc_mcu7t5v0__fillcap_32
XFILLER_31_68 VDD VDD VSS VSS gf180mcu_fd_sc_mcu7t5v0__fill_2
XFILLER_1_702 VDD VDD VSS VSS gf180mcu_fd_sc_mcu7t5v0__fillcap_32
XTAP_TAPCELL_ROW_8_323 VDD VSS gf180mcu_fd_sc_mcu7t5v0__filltie
XFILLER_76_558 VDD VDD VSS VSS gf180mcu_fd_sc_mcu7t5v0__fillcap_8
XFILLER_17_636 VDD VDD VSS VSS gf180mcu_fd_sc_mcu7t5v0__fill_1
XFILLER_16_135 VDD VDD VSS VSS gf180mcu_fd_sc_mcu7t5v0__fill_1
XPHY_EDGE_ROW_19_Right_19 VDD VSS gf180mcu_fd_sc_mcu7t5v0__endcap
XFILLER_72_753 VDD VDD VSS VSS gf180mcu_fd_sc_mcu7t5v0__fillcap_8
XFILLER_72_53 VDD VDD VSS VSS gf180mcu_fd_sc_mcu7t5v0__fillcap_8
XTAP_TAPCELL_ROW_42_678 VDD VSS gf180mcu_fd_sc_mcu7t5v0__filltie
XTAP_TAPCELL_ROW_70_965 VDD VSS gf180mcu_fd_sc_mcu7t5v0__filltie
XPHY_EDGE_ROW_28_Right_28 VDD VSS gf180mcu_fd_sc_mcu7t5v0__endcap
X_1480_ _3353_/Q _1480_/A2 _3357_/D VDD VDD VSS VSS gf180mcu_fd_sc_mcu7t5v0__xnor2_1
XFILLER_106_490 VDD VDD VSS VSS gf180mcu_fd_sc_mcu7t5v0__fillcap_16
XFILLER_79_352 VDD VDD VSS VSS gf180mcu_fd_sc_mcu7t5v0__fill_1
XFILLER_94_300 VDD VDD VSS VSS gf180mcu_fd_sc_mcu7t5v0__fillcap_8
X_3150_ _3150_/D _3303_/RN _3215_/CLK _3150_/Q VDD VDD VSS VSS gf180mcu_fd_sc_mcu7t5v0__dffrnq_1
X_3081_ _3081_/D _3328_/RN _3271_/CLK _3081_/Q VDD VDD VSS VSS gf180mcu_fd_sc_mcu7t5v0__dffrnq_1
X_2101_ _2101_/A1 _3310_/D _2101_/B _3053_/D VDD VDD VSS VSS gf180mcu_fd_sc_mcu7t5v0__oai21_1
X_2032_ _3028_/Q _2032_/A2 _2032_/B _3028_/D VDD VDD VSS VSS gf180mcu_fd_sc_mcu7t5v0__oai21_1
XFILLER_82_506 VDD VDD VSS VSS gf180mcu_fd_sc_mcu7t5v0__fillcap_4
XFILLER_48_750 VDD VDD VSS VSS gf180mcu_fd_sc_mcu7t5v0__fillcap_8
XFILLER_35_422 VDD VDD VSS VSS gf180mcu_fd_sc_mcu7t5v0__fill_2
XPHY_EDGE_ROW_37_Right_37 VDD VSS gf180mcu_fd_sc_mcu7t5v0__endcap
XFILLER_35_444 VDD VDD VSS VSS gf180mcu_fd_sc_mcu7t5v0__fill_2
XFILLER_23_628 VDD VDD VSS VSS gf180mcu_fd_sc_mcu7t5v0__fill_2
XFILLER_62_263 VDD VDD VSS VSS gf180mcu_fd_sc_mcu7t5v0__fillcap_8
XFILLER_62_285 VDD VDD VSS VSS gf180mcu_fd_sc_mcu7t5v0__fill_1
X_2934_ _2934_/D _2954_/CLK _2934_/Q VDD VDD VSS VSS gf180mcu_fd_sc_mcu7t5v0__dffq_1
X_2865_ _2865_/D _2891_/CLK _2865_/Q VDD VDD VSS VSS gf180mcu_fd_sc_mcu7t5v0__dffq_1
XPHY_EDGE_ROW_46_Right_46 VDD VSS gf180mcu_fd_sc_mcu7t5v0__endcap
X_1816_ _2856_/Q _3281_/Q _1822_/S _2856_/D VDD VDD VSS VSS gf180mcu_fd_sc_mcu7t5v0__mux2_2
X_2796_ _2796_/D _2796_/CLK _2796_/Q VDD VDD VSS VSS gf180mcu_fd_sc_mcu7t5v0__dffq_1
X_1747_ _3286_/Q _2797_/Q _1748_/S _2797_/D VDD VDD VSS VSS gf180mcu_fd_sc_mcu7t5v0__mux2_2
X_1678_ _2218_/B _1679_/B1 _2293_/B VDD VDD VSS VSS gf180mcu_fd_sc_mcu7t5v0__nand2_1
XFILLER_89_127 VDD VDD VSS VSS gf180mcu_fd_sc_mcu7t5v0__fillcap_8
XFILLER_104_449 VDD VDD VSS VSS gf180mcu_fd_sc_mcu7t5v0__fillcap_4
X_3417_ _3417_/D _3416_/RN _3424_/CLK _3418_/D VDD VDD VSS VSS gf180mcu_fd_sc_mcu7t5v0__dffsnq_1
X_3348_ hold47/Z input1/Z _3358_/CLK _3348_/Q VDD VDD VSS VSS gf180mcu_fd_sc_mcu7t5v0__dffrnq_1
XFILLER_85_344 VDD VDD VSS VSS gf180mcu_fd_sc_mcu7t5v0__fillcap_4
XPHY_EDGE_ROW_55_Right_55 VDD VSS gf180mcu_fd_sc_mcu7t5v0__endcap
X_3279_ _3279_/D input1/Z _3387_/CLK _3317_/D VDD VDD VSS VSS gf180mcu_fd_sc_mcu7t5v0__dffrnq_1
XFILLER_54_731 VDD VDD VSS VSS gf180mcu_fd_sc_mcu7t5v0__fillcap_4
XFILLER_54_753 VDD VDD VSS VSS gf180mcu_fd_sc_mcu7t5v0__fillcap_8
XFILLER_53_274 VDD VDD VSS VSS gf180mcu_fd_sc_mcu7t5v0__fillcap_4
XFILLER_81_594 VDD VDD VSS VSS gf180mcu_fd_sc_mcu7t5v0__fill_2
XFILLER_42_34 VDD VDD VSS VSS gf180mcu_fd_sc_mcu7t5v0__fill_1
XFILLER_22_683 VDD VDD VSS VSS gf180mcu_fd_sc_mcu7t5v0__fillcap_8
XPHY_EDGE_ROW_64_Right_64 VDD VSS gf180mcu_fd_sc_mcu7t5v0__endcap
XTAP_TAPCELL_ROW_97_1249 VDD VSS gf180mcu_fd_sc_mcu7t5v0__filltie
XPHY_EDGE_ROW_2_Left_111 VDD VSS gf180mcu_fd_sc_mcu7t5v0__endcap
XFILLER_101_2 VDD VDD VSS VSS gf180mcu_fd_sc_mcu7t5v0__fillcap_64
XPHY_EDGE_ROW_39_Left_148 VDD VSS gf180mcu_fd_sc_mcu7t5v0__endcap
Xclkbuf_leaf_54_clk_i clkbuf_leaf_5_clk_i/I _3328_/CLK VDD VDD VSS VSS gf180mcu_fd_sc_mcu7t5v0__clkbuf_4
XFILLER_67_64 VDD VDD VSS VSS gf180mcu_fd_sc_mcu7t5v0__fillcap_4
XPHY_EDGE_ROW_73_Right_73 VDD VSS gf180mcu_fd_sc_mcu7t5v0__endcap
XFILLER_76_399 VDD VDD VSS VSS gf180mcu_fd_sc_mcu7t5v0__fill_1
XFILLER_17_422 VDD VDD VSS VSS gf180mcu_fd_sc_mcu7t5v0__fillcap_16
XFILLER_29_282 VDD VDD VSS VSS gf180mcu_fd_sc_mcu7t5v0__fillcap_4
XTAP_TAPCELL_ROW_47_726 VDD VSS gf180mcu_fd_sc_mcu7t5v0__filltie
XPHY_EDGE_ROW_48_Left_157 VDD VSS gf180mcu_fd_sc_mcu7t5v0__endcap
XTAP_TAPCELL_ROW_106_1345 VDD VSS gf180mcu_fd_sc_mcu7t5v0__filltie
XFILLER_44_241 VDD VDD VSS VSS gf180mcu_fd_sc_mcu7t5v0__fillcap_4
XFILLER_72_594 VDD VDD VSS VSS gf180mcu_fd_sc_mcu7t5v0__fill_1
XPHY_EDGE_ROW_82_Right_82 VDD VSS gf180mcu_fd_sc_mcu7t5v0__endcap
XFILLER_12_171 VDD VDD VSS VSS gf180mcu_fd_sc_mcu7t5v0__fillcap_4
X_2650_ _2670_/A1 _2646_/Z _2650_/B1 _2732_/A3 _2651_/A2 VDD VDD VSS VSS gf180mcu_fd_sc_mcu7t5v0__aoi22_1
XFILLER_73_6 VDD VDD VSS VSS gf180mcu_fd_sc_mcu7t5v0__fill_2
X_1601_ _3388_/Q _3398_/D _1602_/A3 VDD VDD VSS VSS gf180mcu_fd_sc_mcu7t5v0__xnor2_1
XFILLER_8_164 VDD VDD VSS VSS gf180mcu_fd_sc_mcu7t5v0__fillcap_8
XPHY_EDGE_ROW_57_Left_166 VDD VSS gf180mcu_fd_sc_mcu7t5v0__endcap
X_2581_ _3199_/Q _3241_/Q _2585_/S _3241_/D VDD VDD VSS VSS gf180mcu_fd_sc_mcu7t5v0__mux2_2
XTAP_TAPCELL_ROW_74_1013 VDD VSS gf180mcu_fd_sc_mcu7t5v0__filltie
X_1532_ _3051_/Q _3052_/Q _1532_/Z VDD VDD VSS VSS gf180mcu_fd_sc_mcu7t5v0__xor2_1
XFILLER_99_458 VDD VDD VSS VSS gf180mcu_fd_sc_mcu7t5v0__fillcap_32
X_1463_ _3405_/Q _1463_/A2 _3400_/D VDD VDD VSS VSS gf180mcu_fd_sc_mcu7t5v0__xnor2_1
XPHY_EDGE_ROW_91_Right_91 VDD VSS gf180mcu_fd_sc_mcu7t5v0__endcap
X_3202_ _3202_/D _3328_/RN _3276_/CLK _3202_/Q VDD VDD VSS VSS gf180mcu_fd_sc_mcu7t5v0__dffrnq_1
X_1394_ _3039_/Q _2015_/B VDD VDD VSS VSS gf180mcu_fd_sc_mcu7t5v0__clkinv_1
X_3133_ _3133_/D _3369_/RN _3148_/CLK _3133_/Q VDD VDD VSS VSS gf180mcu_fd_sc_mcu7t5v0__dffrnq_1
XFILLER_27_208 VDD VDD VSS VSS gf180mcu_fd_sc_mcu7t5v0__fill_2
XPHY_EDGE_ROW_66_Left_175 VDD VSS gf180mcu_fd_sc_mcu7t5v0__endcap
XFILLER_95_686 VDD VDD VSS VSS gf180mcu_fd_sc_mcu7t5v0__fillcap_8
XFILLER_82_325 VDD VDD VSS VSS gf180mcu_fd_sc_mcu7t5v0__fillcap_4
X_3064_ _3064_/D _3303_/RN _3222_/CLK _3064_/Q VDD VDD VSS VSS gf180mcu_fd_sc_mcu7t5v0__dffrnq_1
X_2015_ _2031_/A2 _2218_/B _2015_/B _2050_/C VDD VDD VSS VSS gf180mcu_fd_sc_mcu7t5v0__oai21_1
XTAP_TAPCELL_ROW_85_1131 VDD VSS gf180mcu_fd_sc_mcu7t5v0__filltie
XFILLER_36_753 VDD VDD VSS VSS gf180mcu_fd_sc_mcu7t5v0__fillcap_8
XFILLER_35_263 VDD VDD VSS VSS gf180mcu_fd_sc_mcu7t5v0__fillcap_4
XFILLER_63_550 VDD VDD VSS VSS gf180mcu_fd_sc_mcu7t5v0__fillcap_8
XFILLER_90_391 VDD VDD VSS VSS gf180mcu_fd_sc_mcu7t5v0__fill_2
X_2917_ _2917_/D _2958_/CLK _2917_/Q VDD VDD VSS VSS gf180mcu_fd_sc_mcu7t5v0__dffq_1
XFILLER_50_288 VDD VDD VSS VSS gf180mcu_fd_sc_mcu7t5v0__fillcap_4
XPHY_EDGE_ROW_75_Left_184 VDD VSS gf180mcu_fd_sc_mcu7t5v0__endcap
XFILLER_12_37 VDD VDD VSS VSS gf180mcu_fd_sc_mcu7t5v0__fillcap_16
XFILLER_12_59 VDD VDD VSS VSS gf180mcu_fd_sc_mcu7t5v0__fill_1
X_2848_ _2848_/D _2858_/CLK _2848_/Q VDD VDD VSS VSS gf180mcu_fd_sc_mcu7t5v0__dffq_1
X_2779_ _2779_/D _2893_/CLK _2779_/Q VDD VDD VSS VSS gf180mcu_fd_sc_mcu7t5v0__dffq_1
XFILLER_98_480 VDD VDD VSS VSS gf180mcu_fd_sc_mcu7t5v0__fill_2
XPHY_EDGE_ROW_84_Left_193 VDD VSS gf180mcu_fd_sc_mcu7t5v0__endcap
XFILLER_86_664 VDD VDD VSS VSS gf180mcu_fd_sc_mcu7t5v0__fill_1
XFILLER_86_686 VDD VDD VSS VSS gf180mcu_fd_sc_mcu7t5v0__fill_1
XFILLER_73_336 VDD VDD VSS VSS gf180mcu_fd_sc_mcu7t5v0__fillcap_4
XFILLER_26_263 VDD VDD VSS VSS gf180mcu_fd_sc_mcu7t5v0__fillcap_4
XFILLER_27_764 VDD VDD VSS VSS gf180mcu_fd_sc_mcu7t5v0__fill_1
XFILLER_54_594 VDD VDD VSS VSS gf180mcu_fd_sc_mcu7t5v0__fill_1
XTAP_TAPCELL_ROW_24_486 VDD VSS gf180mcu_fd_sc_mcu7t5v0__filltie
XFILLER_41_299 VDD VDD VSS VSS gf180mcu_fd_sc_mcu7t5v0__fill_1
XTAP_TAPCELL_ROW_52_784 VDD VSS gf180mcu_fd_sc_mcu7t5v0__filltie
XTAP_TAPCELL_ROW_101_1297 VDD VSS gf180mcu_fd_sc_mcu7t5v0__filltie
XFILLER_10_664 VDD VDD VSS VSS gf180mcu_fd_sc_mcu7t5v0__fill_1
XFILLER_6_635 VDD VDD VSS VSS gf180mcu_fd_sc_mcu7t5v0__fill_1
XFILLER_6_613 VDD VDD VSS VSS gf180mcu_fd_sc_mcu7t5v0__fillcap_4
XFILLER_6_679 VDD VDD VSS VSS gf180mcu_fd_sc_mcu7t5v0__fill_1
XFILLER_78_85 VDD VDD VSS VSS gf180mcu_fd_sc_mcu7t5v0__fill_2
XFILLER_78_96 VDD VDD VSS VSS gf180mcu_fd_sc_mcu7t5v0__fillcap_8
XFILLER_76_130 VDD VDD VSS VSS gf180mcu_fd_sc_mcu7t5v0__fill_2
XFILLER_92_623 VDD VDD VSS VSS gf180mcu_fd_sc_mcu7t5v0__fillcap_8
XFILLER_77_697 VDD VDD VSS VSS gf180mcu_fd_sc_mcu7t5v0__fill_2
XFILLER_76_174 VDD VDD VSS VSS gf180mcu_fd_sc_mcu7t5v0__fill_1
XFILLER_18_753 VDD VDD VSS VSS gf180mcu_fd_sc_mcu7t5v0__fillcap_8
XFILLER_17_252 VDD VDD VSS VSS gf180mcu_fd_sc_mcu7t5v0__fillcap_16
XFILLER_64_369 VDD VDD VSS VSS gf180mcu_fd_sc_mcu7t5v0__fillcap_16
XFILLER_91_199 VDD VDD VSS VSS gf180mcu_fd_sc_mcu7t5v0__fillcap_8
XFILLER_33_745 VDD VDD VSS VSS gf180mcu_fd_sc_mcu7t5v0__fillcap_16
XFILLER_72_391 VDD VDD VSS VSS gf180mcu_fd_sc_mcu7t5v0__fill_2
XFILLER_32_244 VDD VDD VSS VSS gf180mcu_fd_sc_mcu7t5v0__fill_1
XFILLER_20_428 VDD VDD VSS VSS gf180mcu_fd_sc_mcu7t5v0__fillcap_16
XFILLER_60_597 VDD VDD VSS VSS gf180mcu_fd_sc_mcu7t5v0__fillcap_16
XTAP_TAPCELL_ROW_80_1072 VDD VSS gf180mcu_fd_sc_mcu7t5v0__filltie
X_2702_ _2687_/Z _2702_/A2 _3262_/D VDD VDD VSS VSS gf180mcu_fd_sc_mcu7t5v0__nand2_1
XFILLER_9_451 VDD VDD VSS VSS gf180mcu_fd_sc_mcu7t5v0__fillcap_16
X_2633_ _2633_/I _2634_/A2 VDD VDD VSS VSS gf180mcu_fd_sc_mcu7t5v0__clkinv_1
XFILLER_64_2 VDD VDD VSS VSS gf180mcu_fd_sc_mcu7t5v0__fillcap_32
X_2564_ _3182_/Q _3224_/Q _2569_/S _3224_/D VDD VDD VSS VSS gf180mcu_fd_sc_mcu7t5v0__mux2_2
X_1515_ _1515_/A1 _1676_/A2 output7/I VDD VDD VSS VSS gf180mcu_fd_sc_mcu7t5v0__nor2_1
XFILLER_87_417 VDD VDD VSS VSS gf180mcu_fd_sc_mcu7t5v0__fill_2
X_2495_ _3162_/Q _2495_/A2 _2495_/Z VDD VDD VSS VSS gf180mcu_fd_sc_mcu7t5v0__xor2_1
X_1446_ _3394_/Q _1442_/Z _1451_/A2 VDD VDD VSS VSS gf180mcu_fd_sc_mcu7t5v0__nor2_1
XTAP_TAPCELL_ROW_91_1190 VDD VSS gf180mcu_fd_sc_mcu7t5v0__filltie
X_1377_ _3142_/Q _2407_/A1 VDD VDD VSS VSS gf180mcu_fd_sc_mcu7t5v0__clkinv_1
XFILLER_68_664 VDD VDD VSS VSS gf180mcu_fd_sc_mcu7t5v0__fill_1
XFILLER_95_472 VDD VDD VSS VSS gf180mcu_fd_sc_mcu7t5v0__fillcap_4
X_3116_ _3116_/D _3297_/CLK _3116_/Q VDD VDD VSS VSS gf180mcu_fd_sc_mcu7t5v0__dffq_1
XFILLER_67_174 VDD VDD VSS VSS gf180mcu_fd_sc_mcu7t5v0__fillcap_32
X_3047_ _3047_/D _3416_/RN _3425_/CLK _3047_/Q VDD VDD VSS VSS gf180mcu_fd_sc_mcu7t5v0__dffrnq_1
XFILLER_70_317 VDD VDD VSS VSS gf180mcu_fd_sc_mcu7t5v0__fillcap_16
XFILLER_24_734 VDD VDD VSS VSS gf180mcu_fd_sc_mcu7t5v0__fill_1
XFILLER_36_594 VDD VDD VSS VSS gf180mcu_fd_sc_mcu7t5v0__fill_1
XFILLER_23_288 VDD VDD VSS VSS gf180mcu_fd_sc_mcu7t5v0__fill_1
XFILLER_23_69 VDD VDD VSS VSS gf180mcu_fd_sc_mcu7t5v0__fill_1
XTAP_TAPCELL_ROW_21_456 VDD VSS gf180mcu_fd_sc_mcu7t5v0__filltie
XTAP_TAPCELL_ROW_94_1219 VDD VSS gf180mcu_fd_sc_mcu7t5v0__filltie
XFILLER_3_627 VDD VDD VSS VSS gf180mcu_fd_sc_mcu7t5v0__fill_2
XPHY_EDGE_ROW_92_Left_201 VDD VSS gf180mcu_fd_sc_mcu7t5v0__endcap
XFILLER_78_439 VDD VDD VSS VSS gf180mcu_fd_sc_mcu7t5v0__fill_1
XFILLER_58_174 VDD VDD VSS VSS gf180mcu_fd_sc_mcu7t5v0__fill_1
XFILLER_74_667 VDD VDD VSS VSS gf180mcu_fd_sc_mcu7t5v0__fillcap_16
XTAP_TAPCELL_ROW_29_534 VDD VSS gf180mcu_fd_sc_mcu7t5v0__filltie
XTAP_TAPCELL_ROW_57_832 VDD VSS gf180mcu_fd_sc_mcu7t5v0__filltie
XTAP_TAPCELL_ROW_103_1315 VDD VSS gf180mcu_fd_sc_mcu7t5v0__filltie
XFILLER_61_339 VDD VDD VSS VSS gf180mcu_fd_sc_mcu7t5v0__fillcap_8
XFILLER_30_737 VDD VDD VSS VSS gf180mcu_fd_sc_mcu7t5v0__fillcap_16
XFILLER_42_597 VDD VDD VSS VSS gf180mcu_fd_sc_mcu7t5v0__fillcap_8
XFILLER_10_472 VDD VDD VSS VSS gf180mcu_fd_sc_mcu7t5v0__fillcap_4
XFILLER_6_454 VDD VDD VSS VSS gf180mcu_fd_sc_mcu7t5v0__fill_1
XPHY_EDGE_ROW_108_Right_108 VDD VSS gf180mcu_fd_sc_mcu7t5v0__endcap
XFILLER_108_382 VDD VDD VSS VSS gf180mcu_fd_sc_mcu7t5v0__fill_1
X_2280_ _3142_/Q _2414_/B _2435_/B _2280_/A4 _2281_/A2 VDD VDD VSS VSS gf180mcu_fd_sc_mcu7t5v0__nand4_1
XFILLER_77_461 VDD VDD VSS VSS gf180mcu_fd_sc_mcu7t5v0__fillcap_16
XFILLER_77_483 VDD VDD VSS VSS gf180mcu_fd_sc_mcu7t5v0__fillcap_4
XFILLER_64_111 VDD VDD VSS VSS gf180mcu_fd_sc_mcu7t5v0__fill_1
XFILLER_80_659 VDD VDD VSS VSS gf180mcu_fd_sc_mcu7t5v0__fill_1
XFILLER_18_594 VDD VDD VSS VSS gf180mcu_fd_sc_mcu7t5v0__fill_1
XFILLER_33_553 VDD VDD VSS VSS gf180mcu_fd_sc_mcu7t5v0__fillcap_4
XFILLER_60_350 VDD VDD VSS VSS gf180mcu_fd_sc_mcu7t5v0__fill_1
X_1995_ _3114_/Q _3010_/Q _1999_/S _3010_/D VDD VDD VSS VSS gf180mcu_fd_sc_mcu7t5v0__mux2_2
XFILLER_20_247 VDD VDD VSS VSS gf180mcu_fd_sc_mcu7t5v0__fillcap_8
Xclkload62 _2894_/CLK clkload62/ZN VDD VDD VSS VSS gf180mcu_fd_sc_mcu7t5v0__clkinv_4
X_2616_ _2984_/Q _2976_/Q _2968_/Q _2960_/Q _2672_/S0 _2675_/S1 _2616_/Z VDD VDD VSS
+ VSS gf180mcu_fd_sc_mcu7t5v0__mux4_1
Xclkload40 _3366_/CLK clkload40/Z VDD VDD VSS VSS gf180mcu_fd_sc_mcu7t5v0__clkbuf_4
Xclkload51 _3337_/CLK clkload51/ZN VDD VDD VSS VSS gf180mcu_fd_sc_mcu7t5v0__inv_2
X_2547_ _2587_/A1 _2569_/S _2547_/B _3209_/D VDD VDD VSS VSS gf180mcu_fd_sc_mcu7t5v0__aoi21_1
XFILLER_88_737 VDD VDD VSS VSS gf180mcu_fd_sc_mcu7t5v0__fill_2
XFILLER_87_236 VDD VDD VSS VSS gf180mcu_fd_sc_mcu7t5v0__fill_2
X_2478_ _3153_/Q _3154_/Q _2480_/S _3154_/D VDD VDD VSS VSS gf180mcu_fd_sc_mcu7t5v0__mux2_2
XFILLER_87_269 VDD VDD VSS VSS gf180mcu_fd_sc_mcu7t5v0__fill_2
X_1429_ _3369_/Q _1490_/A4 VDD VDD VSS VSS gf180mcu_fd_sc_mcu7t5v0__clkinv_1
XFILLER_28_325 VDD VDD VSS VSS gf180mcu_fd_sc_mcu7t5v0__fillcap_4
XTAP_TAPCELL_ROW_26_504 VDD VSS gf180mcu_fd_sc_mcu7t5v0__filltie
XTAP_TAPCELL_ROW_54_802 VDD VSS gf180mcu_fd_sc_mcu7t5v0__filltie
XFILLER_55_166 VDD VDD VSS VSS gf180mcu_fd_sc_mcu7t5v0__fill_1
XFILLER_56_667 VDD VDD VSS VSS gf180mcu_fd_sc_mcu7t5v0__fillcap_32
XFILLER_12_737 VDD VDD VSS VSS gf180mcu_fd_sc_mcu7t5v0__fillcap_16
XFILLER_24_597 VDD VDD VSS VSS gf180mcu_fd_sc_mcu7t5v0__fill_2
XTAP_TAPCELL_ROW_34_592 VDD VSS gf180mcu_fd_sc_mcu7t5v0__filltie
XTAP_TAPCELL_ROW_62_890 VDD VSS gf180mcu_fd_sc_mcu7t5v0__filltie
Xclkload1 clkload1/I clkload1/ZN VDD VDD VSS VSS gf180mcu_fd_sc_mcu7t5v0__clkinv_3
XFILLER_7_218 VDD VDD VSS VSS gf180mcu_fd_sc_mcu7t5v0__fill_1
XFILLER_50_34 VDD VDD VSS VSS gf180mcu_fd_sc_mcu7t5v0__fill_1
XFILLER_105_352 VDD VDD VSS VSS gf180mcu_fd_sc_mcu7t5v0__fillcap_16
XFILLER_79_748 VDD VDD VSS VSS gf180mcu_fd_sc_mcu7t5v0__fillcap_16
XFILLER_78_247 VDD VDD VSS VSS gf180mcu_fd_sc_mcu7t5v0__fillcap_16
XFILLER_94_729 VDD VDD VSS VSS gf180mcu_fd_sc_mcu7t5v0__fillcap_4
XTAP_TAPCELL_ROW_6_295 VDD VSS gf180mcu_fd_sc_mcu7t5v0__filltie
XFILLER_46_100 VDD VDD VSS VSS gf180mcu_fd_sc_mcu7t5v0__fillcap_4
Xload_slew24 _3392_/Q _2373_/S1 VDD VDD VSS VSS gf180mcu_fd_sc_mcu7t5v0__buf_4
XFILLER_19_336 VDD VDD VSS VSS gf180mcu_fd_sc_mcu7t5v0__fillcap_8
Xload_slew35 _3351_/Q _2673_/S0 VDD VDD VSS VSS gf180mcu_fd_sc_mcu7t5v0__buf_4
XFILLER_47_678 VDD VDD VSS VSS gf180mcu_fd_sc_mcu7t5v0__fillcap_4
XFILLER_46_177 VDD VDD VSS VSS gf180mcu_fd_sc_mcu7t5v0__fillcap_4
X_1780_ _2825_/Q _3282_/Q _1785_/S _2825_/D VDD VDD VSS VSS gf180mcu_fd_sc_mcu7t5v0__mux2_2
X_3381_ _3400_/Q input1/Z _3398_/CLK hold63/I VDD VDD VSS VSS gf180mcu_fd_sc_mcu7t5v0__dffrnq_1
X_2401_ _2405_/S _2400_/Z _2402_/A3 VDD VDD VSS VSS gf180mcu_fd_sc_mcu7t5v0__nand2_1
X_2332_ _3134_/Q _2409_/A1 _2344_/B VDD VDD VSS VSS gf180mcu_fd_sc_mcu7t5v0__nand2_1
XFILLER_27_2 VDD VDD VSS VSS gf180mcu_fd_sc_mcu7t5v0__fillcap_8
XFILLER_57_409 VDD VDD VSS VSS gf180mcu_fd_sc_mcu7t5v0__fillcap_8
XFILLER_69_247 VDD VDD VSS VSS gf180mcu_fd_sc_mcu7t5v0__fill_1
XFILLER_69_236 VDD VDD VSS VSS gf180mcu_fd_sc_mcu7t5v0__fill_2
X_2263_ _2263_/A1 _3097_/Q _2263_/B _2263_/C _2264_/A2 VDD VDD VSS VSS gf180mcu_fd_sc_mcu7t5v0__aoi211_1
X_2194_ _2218_/A1 _2199_/A1 _2316_/A2 VDD VDD VSS VSS gf180mcu_fd_sc_mcu7t5v0__nand2_1
XTAP_TAPCELL_ROW_68_949 VDD VSS gf180mcu_fd_sc_mcu7t5v0__filltie
XFILLER_1_72 VDD VDD VSS VSS gf180mcu_fd_sc_mcu7t5v0__fillcap_8
XFILLER_38_667 VDD VDD VSS VSS gf180mcu_fd_sc_mcu7t5v0__fillcap_8
XFILLER_37_177 VDD VDD VSS VSS gf180mcu_fd_sc_mcu7t5v0__fillcap_16
XFILLER_53_626 VDD VDD VSS VSS gf180mcu_fd_sc_mcu7t5v0__fillcap_4
XFILLER_53_648 VDD VDD VSS VSS gf180mcu_fd_sc_mcu7t5v0__fillcap_4
XFILLER_80_478 VDD VDD VSS VSS gf180mcu_fd_sc_mcu7t5v0__fill_2
XTAP_TAPCELL_ROW_31_562 VDD VSS gf180mcu_fd_sc_mcu7t5v0__filltie
X_1978_ _2995_/Q _3115_/Q _1981_/S _2995_/D VDD VDD VSS VSS gf180mcu_fd_sc_mcu7t5v0__mux2_2
XFILLER_102_311 VDD VDD VSS VSS gf180mcu_fd_sc_mcu7t5v0__fillcap_4
XFILLER_88_523 VDD VDD VSS VSS gf180mcu_fd_sc_mcu7t5v0__fill_2
XFILLER_102_322 VDD VDD VSS VSS gf180mcu_fd_sc_mcu7t5v0__fillcap_32
XFILLER_88_567 VDD VDD VSS VSS gf180mcu_fd_sc_mcu7t5v0__fillcap_4
XFILLER_29_68 VDD VDD VSS VSS gf180mcu_fd_sc_mcu7t5v0__fill_2
Xhold46 hold46/I hold46/Z VDD VDD VSS VSS gf180mcu_fd_sc_mcu7t5v0__dlyc_1
Xhold57 hold57/I hold57/Z VDD VDD VSS VSS gf180mcu_fd_sc_mcu7t5v0__dlyc_1
XFILLER_29_623 VDD VDD VSS VSS gf180mcu_fd_sc_mcu7t5v0__fillcap_4
XFILLER_84_762 VDD VDD VSS VSS gf180mcu_fd_sc_mcu7t5v0__fill_2
XTAP_TAPCELL_ROW_3_265 VDD VSS gf180mcu_fd_sc_mcu7t5v0__filltie
XTAP_TAPCELL_ROW_39_640 VDD VSS gf180mcu_fd_sc_mcu7t5v0__filltie
XFILLER_44_604 VDD VDD VSS VSS gf180mcu_fd_sc_mcu7t5v0__fillcap_4
XFILLER_45_56 VDD VDD VSS VSS gf180mcu_fd_sc_mcu7t5v0__fillcap_8
XFILLER_71_467 VDD VDD VSS VSS gf180mcu_fd_sc_mcu7t5v0__fillcap_16
XFILLER_71_489 VDD VDD VSS VSS gf180mcu_fd_sc_mcu7t5v0__fill_1
XPHY_EDGE_ROW_20_Left_129 VDD VSS gf180mcu_fd_sc_mcu7t5v0__endcap
XFILLER_67_729 VDD VDD VSS VSS gf180mcu_fd_sc_mcu7t5v0__fill_2
XFILLER_81_209 VDD VDD VSS VSS gf180mcu_fd_sc_mcu7t5v0__fill_1
XTAP_TAPCELL_ROW_65_919 VDD VSS gf180mcu_fd_sc_mcu7t5v0__filltie
XFILLER_35_648 VDD VDD VSS VSS gf180mcu_fd_sc_mcu7t5v0__fillcap_4
X_2950_ _2950_/D _2954_/CLK _2950_/Q VDD VDD VSS VSS gf180mcu_fd_sc_mcu7t5v0__dffq_1
XTAP_TAPCELL_ROW_73_996 VDD VSS gf180mcu_fd_sc_mcu7t5v0__filltie
X_2881_ _2881_/D _2891_/CLK _2881_/Q VDD VDD VSS VSS gf180mcu_fd_sc_mcu7t5v0__dffq_1
X_1901_ _2928_/Q _3112_/Q _1907_/S _2928_/D VDD VDD VSS VSS gf180mcu_fd_sc_mcu7t5v0__mux2_2
X_1832_ _3287_/Q _2870_/Q _1832_/S _2870_/D VDD VDD VSS VSS gf180mcu_fd_sc_mcu7t5v0__mux2_2
XFILLER_30_397 VDD VDD VSS VSS gf180mcu_fd_sc_mcu7t5v0__fill_1
X_1763_ _3283_/Q _2810_/Q _1767_/S _2810_/D VDD VDD VSS VSS gf180mcu_fd_sc_mcu7t5v0__mux2_2
X_1694_ _3141_/Q _1672_/B _1694_/A3 _1699_/A1 VDD VDD VSS VSS gf180mcu_fd_sc_mcu7t5v0__nand3_1
XTAP_TAPCELL_ROW_77_1044 VDD VSS gf180mcu_fd_sc_mcu7t5v0__filltie
XFILLER_97_320 VDD VDD VSS VSS gf180mcu_fd_sc_mcu7t5v0__fillcap_16
X_3364_ _3364_/D input1/Z _3367_/CLK _3364_/Q VDD VDD VSS VSS gf180mcu_fd_sc_mcu7t5v0__dffrnq_1
XFILLER_97_375 VDD VDD VSS VSS gf180mcu_fd_sc_mcu7t5v0__fill_1
X_2315_ _2315_/A1 _2315_/A2 _2315_/B _2316_/A3 VDD VDD VSS VSS gf180mcu_fd_sc_mcu7t5v0__aoi21_1
X_3295_ _3295_/D _3303_/RN _3410_/CLK _3295_/Q VDD VDD VSS VSS gf180mcu_fd_sc_mcu7t5v0__dffrnq_1
X_2246_ _3131_/Q _2267_/C _2422_/I0 VDD VDD VSS VSS gf180mcu_fd_sc_mcu7t5v0__nor2_1
XFILLER_57_228 VDD VDD VSS VSS gf180mcu_fd_sc_mcu7t5v0__fillcap_4
XFILLER_38_453 VDD VDD VSS VSS gf180mcu_fd_sc_mcu7t5v0__fill_2
XTAP_TAPCELL_ROW_88_1162 VDD VSS gf180mcu_fd_sc_mcu7t5v0__filltie
XTAP_TAPCELL_ROW_0_224 VDD VSS gf180mcu_fd_sc_mcu7t5v0__filltie
XTAP_TAPCELL_ROW_0_235 VDD VSS gf180mcu_fd_sc_mcu7t5v0__filltie
XTAP_TAPCELL_ROW_36_610 VDD VSS gf180mcu_fd_sc_mcu7t5v0__filltie
X_2177_ _3102_/Q _3220_/Q _2178_/S _3102_/D VDD VDD VSS VSS gf180mcu_fd_sc_mcu7t5v0__mux2_2
XFILLER_25_158 VDD VDD VSS VSS gf180mcu_fd_sc_mcu7t5v0__fill_2
XFILLER_41_629 VDD VDD VSS VSS gf180mcu_fd_sc_mcu7t5v0__fill_1
XFILLER_53_489 VDD VDD VSS VSS gf180mcu_fd_sc_mcu7t5v0__fill_1
XFILLER_40_139 VDD VDD VSS VSS gf180mcu_fd_sc_mcu7t5v0__fillcap_8
XFILLER_107_403 VDD VDD VSS VSS gf180mcu_fd_sc_mcu7t5v0__fillcap_16
XTAP_TAPCELL_ROW_8_313 VDD VSS gf180mcu_fd_sc_mcu7t5v0__filltie
XFILLER_1_758 VDD VDD VSS VSS gf180mcu_fd_sc_mcu7t5v0__fillcap_4
XFILLER_102_174 VDD VDD VSS VSS gf180mcu_fd_sc_mcu7t5v0__fill_1
XFILLER_71_275 VDD VDD VSS VSS gf180mcu_fd_sc_mcu7t5v0__fillcap_4
XFILLER_31_139 VDD VDD VSS VSS gf180mcu_fd_sc_mcu7t5v0__fill_1
XTAP_TAPCELL_ROW_42_679 VDD VSS gf180mcu_fd_sc_mcu7t5v0__filltie
XTAP_TAPCELL_ROW_70_966 VDD VSS gf180mcu_fd_sc_mcu7t5v0__filltie
XFILLER_99_618 VDD VDD VSS VSS gf180mcu_fd_sc_mcu7t5v0__fillcap_8
XFILLER_4_585 VDD VDD VSS VSS gf180mcu_fd_sc_mcu7t5v0__fillcap_8
XFILLER_97_95 VDD VDD VSS VSS gf180mcu_fd_sc_mcu7t5v0__fill_2
XFILLER_94_312 VDD VDD VSS VSS gf180mcu_fd_sc_mcu7t5v0__fill_2
X_3080_ _3080_/D _3369_/RN _3327_/CLK _3080_/Q VDD VDD VSS VSS gf180mcu_fd_sc_mcu7t5v0__dffrnq_1
X_2100_ _3113_/Q _3310_/D _2101_/B VDD VDD VSS VSS gf180mcu_fd_sc_mcu7t5v0__nand2_1
XFILLER_94_378 VDD VDD VSS VSS gf180mcu_fd_sc_mcu7t5v0__fillcap_4
X_2031_ _2015_/B _2031_/A2 _2027_/Z _2032_/A2 VDD VDD VSS VSS gf180mcu_fd_sc_mcu7t5v0__nand3_1
XFILLER_48_762 VDD VDD VSS VSS gf180mcu_fd_sc_mcu7t5v0__fill_2
XFILLER_90_551 VDD VDD VSS VSS gf180mcu_fd_sc_mcu7t5v0__fillcap_4
XFILLER_35_478 VDD VDD VSS VSS gf180mcu_fd_sc_mcu7t5v0__fillcap_8
XFILLER_94_2 VDD VDD VSS VSS gf180mcu_fd_sc_mcu7t5v0__fillcap_8
X_2933_ _2933_/D _3253_/CLK _2933_/Q VDD VDD VSS VSS gf180mcu_fd_sc_mcu7t5v0__dffq_1
X_2864_ _2864_/D _2891_/CLK _2864_/Q VDD VDD VSS VSS gf180mcu_fd_sc_mcu7t5v0__dffq_1
XFILLER_30_172 VDD VDD VSS VSS gf180mcu_fd_sc_mcu7t5v0__fill_2
X_2795_ _2795_/D _2828_/CLK _2795_/Q VDD VDD VSS VSS gf180mcu_fd_sc_mcu7t5v0__dffq_1
XTAP_TAPCELL_ROW_13_370 VDD VSS gf180mcu_fd_sc_mcu7t5v0__filltie
X_1815_ _2855_/Q _3280_/Q _1822_/S _2855_/D VDD VDD VSS VSS gf180mcu_fd_sc_mcu7t5v0__mux2_2
X_1746_ _3285_/Q _2796_/Q _1748_/S _2796_/D VDD VDD VSS VSS gf180mcu_fd_sc_mcu7t5v0__mux2_2
X_1677_ _1681_/A1 _2198_/B _2285_/B _1677_/C _2289_/B1 VDD VDD VSS VSS gf180mcu_fd_sc_mcu7t5v0__oai211_1
XFILLER_89_139 VDD VDD VSS VSS gf180mcu_fd_sc_mcu7t5v0__fill_1
X_3416_ _3416_/D _3416_/RN _3416_/CLK _3416_/Q VDD VDD VSS VSS gf180mcu_fd_sc_mcu7t5v0__dffrnq_1
XFILLER_97_150 VDD VDD VSS VSS gf180mcu_fd_sc_mcu7t5v0__fill_2
X_3347_ hold50/Z input1/Z _3358_/CLK _3347_/Q VDD VDD VSS VSS gf180mcu_fd_sc_mcu7t5v0__dffrnq_1
XFILLER_100_667 VDD VDD VSS VSS gf180mcu_fd_sc_mcu7t5v0__fillcap_4
XFILLER_85_356 VDD VDD VSS VSS gf180mcu_fd_sc_mcu7t5v0__fill_2
X_3278_ _3278_/D _3369_/RN _3313_/CLK _3314_/D VDD VDD VSS VSS gf180mcu_fd_sc_mcu7t5v0__dffrnq_1
XFILLER_45_209 VDD VDD VSS VSS gf180mcu_fd_sc_mcu7t5v0__fill_1
X_2229_ _3108_/Q _2228_/Z _2229_/S _3108_/D VDD VDD VSS VSS gf180mcu_fd_sc_mcu7t5v0__mux2_2
XFILLER_81_562 VDD VDD VSS VSS gf180mcu_fd_sc_mcu7t5v0__fillcap_32
XFILLER_53_297 VDD VDD VSS VSS gf180mcu_fd_sc_mcu7t5v0__fillcap_16
XFILLER_22_662 VDD VDD VSS VSS gf180mcu_fd_sc_mcu7t5v0__fill_2
XFILLER_21_150 VDD VDD VSS VSS gf180mcu_fd_sc_mcu7t5v0__fillcap_4
XFILLER_5_349 VDD VDD VSS VSS gf180mcu_fd_sc_mcu7t5v0__fill_1
XFILLER_107_72 VDD VDD VSS VSS gf180mcu_fd_sc_mcu7t5v0__fillcap_32
XFILLER_95_109 VDD VDD VSS VSS gf180mcu_fd_sc_mcu7t5v0__fillcap_16
XFILLER_1_577 VDD VDD VSS VSS gf180mcu_fd_sc_mcu7t5v0__fillcap_4
XFILLER_67_10 VDD VDD VSS VSS gf180mcu_fd_sc_mcu7t5v0__fill_2
XFILLER_103_483 VDD VDD VSS VSS gf180mcu_fd_sc_mcu7t5v0__fillcap_4
XFILLER_88_172 VDD VDD VSS VSS gf180mcu_fd_sc_mcu7t5v0__fill_2
XFILLER_67_76 VDD VDD VSS VSS gf180mcu_fd_sc_mcu7t5v0__fill_2
XTAP_TAPCELL_ROW_19_429 VDD VSS gf180mcu_fd_sc_mcu7t5v0__filltie
XTAP_TAPCELL_ROW_47_727 VDD VSS gf180mcu_fd_sc_mcu7t5v0__filltie
XFILLER_64_518 VDD VDD VSS VSS gf180mcu_fd_sc_mcu7t5v0__fillcap_4
XPHY_EDGE_ROW_103_Left_212 VDD VSS gf180mcu_fd_sc_mcu7t5v0__endcap
XFILLER_91_348 VDD VDD VSS VSS gf180mcu_fd_sc_mcu7t5v0__fill_2
XFILLER_83_53 VDD VDD VSS VSS gf180mcu_fd_sc_mcu7t5v0__fillcap_4
XTAP_TAPCELL_ROW_106_1346 VDD VSS gf180mcu_fd_sc_mcu7t5v0__filltie
XFILLER_60_713 VDD VDD VSS VSS gf180mcu_fd_sc_mcu7t5v0__fillcap_16
XFILLER_13_695 VDD VDD VSS VSS gf180mcu_fd_sc_mcu7t5v0__fillcap_4
X_1600_ _3387_/Q _3397_/D _1602_/A2 VDD VDD VSS VSS gf180mcu_fd_sc_mcu7t5v0__xnor2_1
XTAP_TAPCELL_ROW_10_340 VDD VSS gf180mcu_fd_sc_mcu7t5v0__filltie
X_2580_ _3198_/Q _3240_/Q _2585_/S _3240_/D VDD VDD VSS VSS gf180mcu_fd_sc_mcu7t5v0__mux2_2
XTAP_TAPCELL_ROW_74_1014 VDD VSS gf180mcu_fd_sc_mcu7t5v0__filltie
X_1531_ _2098_/A1 _3052_/Q _1549_/A1 VDD VDD VSS VSS gf180mcu_fd_sc_mcu7t5v0__nor2_1
XFILLER_4_382 VDD VDD VSS VSS gf180mcu_fd_sc_mcu7t5v0__fill_2
X_1462_ _3404_/Q _1455_/I _3404_/D VDD VDD VSS VSS gf180mcu_fd_sc_mcu7t5v0__xor2_1
X_3201_ _3201_/D _3328_/RN _3328_/CLK _3201_/Q VDD VDD VSS VSS gf180mcu_fd_sc_mcu7t5v0__dffrnq_1
X_1393_ _3029_/Q _2036_/A1 VDD VDD VSS VSS gf180mcu_fd_sc_mcu7t5v0__clkinv_1
X_3132_ _3132_/D _3369_/RN _3148_/CLK _3132_/Q VDD VDD VSS VSS gf180mcu_fd_sc_mcu7t5v0__dffrnq_1
XFILLER_67_323 VDD VDD VSS VSS gf180mcu_fd_sc_mcu7t5v0__fill_2
XFILLER_67_356 VDD VDD VSS VSS gf180mcu_fd_sc_mcu7t5v0__fill_1
XFILLER_95_698 VDD VDD VSS VSS gf180mcu_fd_sc_mcu7t5v0__fill_2
X_3063_ _3063_/D _3369_/RN _3313_/CLK _3063_/Q VDD VDD VSS VSS gf180mcu_fd_sc_mcu7t5v0__dffrnq_1
X_2014_ _3024_/Q _3023_/Q _2010_/Z _2022_/A2 VDD VDD VSS VSS gf180mcu_fd_sc_mcu7t5v0__nand3_1
XFILLER_51_702 VDD VDD VSS VSS gf180mcu_fd_sc_mcu7t5v0__fillcap_4
XFILLER_63_562 VDD VDD VSS VSS gf180mcu_fd_sc_mcu7t5v0__fillcap_16
X_2916_ _2916_/D _2926_/CLK _2916_/Q VDD VDD VSS VSS gf180mcu_fd_sc_mcu7t5v0__dffq_1
X_2847_ _2847_/D _3314_/CLK _2847_/Q VDD VDD VSS VSS gf180mcu_fd_sc_mcu7t5v0__dffq_1
X_2778_ _2778_/D _2893_/CLK _2778_/Q VDD VDD VSS VSS gf180mcu_fd_sc_mcu7t5v0__dffq_1
XFILLER_105_726 VDD VDD VSS VSS gf180mcu_fd_sc_mcu7t5v0__fill_1
X_1729_ _3405_/Q _1729_/A2 _1842_/A1 VDD VDD VSS VSS gf180mcu_fd_sc_mcu7t5v0__nor2_1
XFILLER_104_247 VDD VDD VSS VSS gf180mcu_fd_sc_mcu7t5v0__fillcap_16
XFILLER_58_301 VDD VDD VSS VSS gf180mcu_fd_sc_mcu7t5v0__fillcap_8
XFILLER_85_153 VDD VDD VSS VSS gf180mcu_fd_sc_mcu7t5v0__fill_2
XFILLER_27_710 VDD VDD VSS VSS gf180mcu_fd_sc_mcu7t5v0__fill_2
XFILLER_85_197 VDD VDD VSS VSS gf180mcu_fd_sc_mcu7t5v0__fillcap_4
XFILLER_37_68 VDD VDD VSS VSS gf180mcu_fd_sc_mcu7t5v0__fill_2
XFILLER_26_242 VDD VDD VSS VSS gf180mcu_fd_sc_mcu7t5v0__fill_2
XFILLER_41_212 VDD VDD VSS VSS gf180mcu_fd_sc_mcu7t5v0__fillcap_8
XTAP_TAPCELL_ROW_24_487 VDD VSS gf180mcu_fd_sc_mcu7t5v0__filltie
XFILLER_41_278 VDD VDD VSS VSS gf180mcu_fd_sc_mcu7t5v0__fill_2
XTAP_TAPCELL_ROW_52_785 VDD VSS gf180mcu_fd_sc_mcu7t5v0__filltie
XFILLER_53_89 VDD VDD VSS VSS gf180mcu_fd_sc_mcu7t5v0__fillcap_8
XTAP_TAPCELL_ROW_101_1298 VDD VSS gf180mcu_fd_sc_mcu7t5v0__filltie
XFILLER_1_352 VDD VDD VSS VSS gf180mcu_fd_sc_mcu7t5v0__fillcap_64
XFILLER_89_492 VDD VDD VSS VSS gf180mcu_fd_sc_mcu7t5v0__fillcap_64
XFILLER_77_632 VDD VDD VSS VSS gf180mcu_fd_sc_mcu7t5v0__fillcap_4
XFILLER_49_345 VDD VDD VSS VSS gf180mcu_fd_sc_mcu7t5v0__fillcap_4
XFILLER_94_74 VDD VDD VSS VSS gf180mcu_fd_sc_mcu7t5v0__fillcap_16
XFILLER_18_732 VDD VDD VSS VSS gf180mcu_fd_sc_mcu7t5v0__fill_2
XFILLER_17_220 VDD VDD VSS VSS gf180mcu_fd_sc_mcu7t5v0__fill_2
XFILLER_91_156 VDD VDD VSS VSS gf180mcu_fd_sc_mcu7t5v0__fillcap_4
XFILLER_33_702 VDD VDD VSS VSS gf180mcu_fd_sc_mcu7t5v0__fill_1
XFILLER_45_551 VDD VDD VSS VSS gf180mcu_fd_sc_mcu7t5v0__fillcap_8
XTAP_TAPCELL_ROW_80_1073 VDD VSS gf180mcu_fd_sc_mcu7t5v0__filltie
XFILLER_13_492 VDD VDD VSS VSS gf180mcu_fd_sc_mcu7t5v0__fillcap_8
X_2701_ _3262_/Q _2680_/C _2731_/B1 _3080_/Q _2702_/A2 VDD VDD VSS VSS gf180mcu_fd_sc_mcu7t5v0__aoi22_1
XFILLER_9_496 VDD VDD VSS VSS gf180mcu_fd_sc_mcu7t5v0__fill_2
X_2632_ _2986_/Q _2978_/Q _2970_/Q _2962_/Q _2673_/S0 _2673_/S1 _2633_/I VDD VDD VSS
+ VSS gf180mcu_fd_sc_mcu7t5v0__mux4_1
X_2563_ _3181_/Q _3223_/Q _2569_/S _3223_/D VDD VDD VSS VSS gf180mcu_fd_sc_mcu7t5v0__mux2_2
XFILLER_57_2 VDD VDD VSS VSS gf180mcu_fd_sc_mcu7t5v0__fill_2
X_1514_ _3108_/Q _3107_/Q _1676_/A2 VDD VDD VSS VSS gf180mcu_fd_sc_mcu7t5v0__nand2_1
XFILLER_99_234 VDD VDD VSS VSS gf180mcu_fd_sc_mcu7t5v0__fill_2
XFILLER_99_212 VDD VDD VSS VSS gf180mcu_fd_sc_mcu7t5v0__fill_1
X_2494_ _3161_/Q _3160_/Q _1610_/Z _2495_/A2 VDD VDD VSS VSS gf180mcu_fd_sc_mcu7t5v0__nand3_1
XFILLER_101_228 VDD VDD VSS VSS gf180mcu_fd_sc_mcu7t5v0__fillcap_8
XFILLER_101_206 VDD VDD VSS VSS gf180mcu_fd_sc_mcu7t5v0__fillcap_4
XTAP_TAPCELL_ROW_91_1191 VDD VSS gf180mcu_fd_sc_mcu7t5v0__filltie
X_1445_ _2378_/B _1445_/A2 _3397_/D VDD VDD VSS VSS gf180mcu_fd_sc_mcu7t5v0__xor2_1
X_1376_ _3128_/Q _2300_/A1 VDD VDD VSS VSS gf180mcu_fd_sc_mcu7t5v0__clkinv_1
XFILLER_67_142 VDD VDD VSS VSS gf180mcu_fd_sc_mcu7t5v0__fillcap_4
XFILLER_28_518 VDD VDD VSS VSS gf180mcu_fd_sc_mcu7t5v0__fillcap_4
X_3115_ _3115_/D _3285_/CLK _3115_/Q VDD VDD VSS VSS gf180mcu_fd_sc_mcu7t5v0__dffq_1
X_3046_ _3046_/D _3303_/RN _3308_/CLK _3046_/Q VDD VDD VSS VSS gf180mcu_fd_sc_mcu7t5v0__dffrnq_1
XFILLER_23_212 VDD VDD VSS VSS gf180mcu_fd_sc_mcu7t5v0__fillcap_4
XFILLER_63_381 VDD VDD VSS VSS gf180mcu_fd_sc_mcu7t5v0__fillcap_32
Xclkbuf_leaf_53_clk_i clkbuf_leaf_5_clk_i/I _3276_/CLK VDD VDD VSS VSS gf180mcu_fd_sc_mcu7t5v0__clkbuf_4
XFILLER_23_26 VDD VDD VSS VSS gf180mcu_fd_sc_mcu7t5v0__fillcap_4
XTAP_TAPCELL_ROW_21_457 VDD VSS gf180mcu_fd_sc_mcu7t5v0__filltie
XFILLER_48_34 VDD VDD VSS VSS gf180mcu_fd_sc_mcu7t5v0__fill_1
XFILLER_59_632 VDD VDD VSS VSS gf180mcu_fd_sc_mcu7t5v0__fillcap_4
XFILLER_48_67 VDD VDD VSS VSS gf180mcu_fd_sc_mcu7t5v0__fillcap_4
XFILLER_59_698 VDD VDD VSS VSS gf180mcu_fd_sc_mcu7t5v0__fill_2
XTAP_TAPCELL_ROW_29_535 VDD VSS gf180mcu_fd_sc_mcu7t5v0__filltie
XTAP_TAPCELL_ROW_57_833 VDD VSS gf180mcu_fd_sc_mcu7t5v0__filltie
XFILLER_27_562 VDD VDD VSS VSS gf180mcu_fd_sc_mcu7t5v0__fillcap_8
XFILLER_73_156 VDD VDD VSS VSS gf180mcu_fd_sc_mcu7t5v0__fillcap_4
XTAP_TAPCELL_ROW_103_1316 VDD VSS gf180mcu_fd_sc_mcu7t5v0__filltie
XFILLER_89_52 VDD VDD VSS VSS gf180mcu_fd_sc_mcu7t5v0__fillcap_8
XFILLER_2_683 VDD VDD VSS VSS gf180mcu_fd_sc_mcu7t5v0__fill_1
XFILLER_64_101 VDD VDD VSS VSS gf180mcu_fd_sc_mcu7t5v0__fillcap_4
XFILLER_37_326 VDD VDD VSS VSS gf180mcu_fd_sc_mcu7t5v0__fillcap_16
XFILLER_92_465 VDD VDD VSS VSS gf180mcu_fd_sc_mcu7t5v0__fill_2
XFILLER_92_454 VDD VDD VSS VSS gf180mcu_fd_sc_mcu7t5v0__fill_1
XFILLER_18_584 VDD VDD VSS VSS gf180mcu_fd_sc_mcu7t5v0__fillcap_8
X_1994_ _3113_/Q _3009_/Q _1999_/S _3009_/D VDD VDD VSS VSS gf180mcu_fd_sc_mcu7t5v0__mux2_2
XFILLER_60_384 VDD VDD VSS VSS gf180mcu_fd_sc_mcu7t5v0__fill_1
X_2615_ _3016_/Q _3008_/Q _3000_/Q _2992_/Q _2673_/S0 _2673_/S1 _2615_/Z VDD VDD VSS
+ VSS gf180mcu_fd_sc_mcu7t5v0__mux4_1
Xclkload41 _3022_/CLK clkload41/Z VDD VDD VSS VSS gf180mcu_fd_sc_mcu7t5v0__clkbuf_4
Xclkload52 _2858_/CLK clkload52/ZN VDD VDD VSS VSS gf180mcu_fd_sc_mcu7t5v0__inv_4
Xclkload30 _3308_/CLK clkload30/ZN VDD VDD VSS VSS gf180mcu_fd_sc_mcu7t5v0__clkinv_2
Xclkload63 _2828_/CLK clkload63/ZN VDD VDD VSS VSS gf180mcu_fd_sc_mcu7t5v0__clkinv_4
X_2546_ _3169_/Q _2569_/S _2547_/B VDD VDD VSS VSS gf180mcu_fd_sc_mcu7t5v0__nor2_1
XFILLER_88_727 VDD VDD VSS VSS gf180mcu_fd_sc_mcu7t5v0__fillcap_8
X_2477_ _3152_/Q _3153_/Q _2480_/S _3153_/D VDD VDD VSS VSS gf180mcu_fd_sc_mcu7t5v0__mux2_2
X_1428_ _3119_/Q _2245_/A1 VDD VDD VSS VSS gf180mcu_fd_sc_mcu7t5v0__clkinv_1
XFILLER_68_451 VDD VDD VSS VSS gf180mcu_fd_sc_mcu7t5v0__fillcap_4
XFILLER_95_270 VDD VDD VSS VSS gf180mcu_fd_sc_mcu7t5v0__fill_2
XFILLER_28_337 VDD VDD VSS VSS gf180mcu_fd_sc_mcu7t5v0__fill_1
XTAP_TAPCELL_ROW_54_803 VDD VSS gf180mcu_fd_sc_mcu7t5v0__filltie
X_3029_ _3029_/D _3416_/RN _3416_/CLK _3029_/Q VDD VDD VSS VSS gf180mcu_fd_sc_mcu7t5v0__dffrnq_1
XTAP_TAPCELL_ROW_26_505 VDD VSS gf180mcu_fd_sc_mcu7t5v0__filltie
XFILLER_36_381 VDD VDD VSS VSS gf180mcu_fd_sc_mcu7t5v0__fillcap_4
XTAP_TAPCELL_ROW_34_593 VDD VSS gf180mcu_fd_sc_mcu7t5v0__filltie
XTAP_TAPCELL_ROW_62_880 VDD VSS gf180mcu_fd_sc_mcu7t5v0__filltie
XFILLER_20_760 VDD VDD VSS VSS gf180mcu_fd_sc_mcu7t5v0__fillcap_4
Xclkload2 clkload2/I clkload2/ZN VDD VDD VSS VSS gf180mcu_fd_sc_mcu7t5v0__clkinv_4
XFILLER_105_331 VDD VDD VSS VSS gf180mcu_fd_sc_mcu7t5v0__fill_1
XFILLER_79_738 VDD VDD VSS VSS gf180mcu_fd_sc_mcu7t5v0__fill_2
XFILLER_59_44 VDD VDD VSS VSS gf180mcu_fd_sc_mcu7t5v0__fillcap_8
XFILLER_19_348 VDD VDD VSS VSS gf180mcu_fd_sc_mcu7t5v0__fill_2
XTAP_TAPCELL_ROW_6_296 VDD VSS gf180mcu_fd_sc_mcu7t5v0__filltie
Xload_slew25 _2404_/S0 _2400_/S0 VDD VDD VSS VSS gf180mcu_fd_sc_mcu7t5v0__buf_4
XFILLER_74_454 VDD VDD VSS VSS gf180mcu_fd_sc_mcu7t5v0__fill_1
Xload_slew36 _3303_/RN _3328_/RN VDD VDD VSS VSS gf180mcu_fd_sc_mcu7t5v0__buf_20
XFILLER_15_521 VDD VDD VSS VSS gf180mcu_fd_sc_mcu7t5v0__fillcap_8
XFILLER_55_690 VDD VDD VSS VSS gf180mcu_fd_sc_mcu7t5v0__fillcap_8
XFILLER_70_682 VDD VDD VSS VSS gf180mcu_fd_sc_mcu7t5v0__fillcap_16
XFILLER_30_524 VDD VDD VSS VSS gf180mcu_fd_sc_mcu7t5v0__fill_1
XFILLER_11_760 VDD VDD VSS VSS gf180mcu_fd_sc_mcu7t5v0__fillcap_4
XFILLER_7_753 VDD VDD VSS VSS gf180mcu_fd_sc_mcu7t5v0__fillcap_8
X_2400_ _2893_/Q _2885_/Q _2877_/Q _2869_/Q _2400_/S0 _2404_/S1 _2400_/Z VDD VDD VSS
+ VSS gf180mcu_fd_sc_mcu7t5v0__mux4_1
X_3380_ _3380_/D input1/Z _3398_/CLK _3380_/Q VDD VDD VSS VSS gf180mcu_fd_sc_mcu7t5v0__dffsnq_1
X_2331_ _2409_/A1 _2331_/A2 _2331_/B _3133_/D VDD VDD VSS VSS gf180mcu_fd_sc_mcu7t5v0__oai21_1
XFILLER_69_204 VDD VDD VSS VSS gf180mcu_fd_sc_mcu7t5v0__fillcap_4
XFILLER_97_568 VDD VDD VSS VSS gf180mcu_fd_sc_mcu7t5v0__fill_1
XFILLER_97_557 VDD VDD VSS VSS gf180mcu_fd_sc_mcu7t5v0__fill_2
X_2262_ _2263_/A1 _3097_/Q _3102_/Q _2262_/B2 _2262_/C _2263_/C VDD VDD VSS VSS gf180mcu_fd_sc_mcu7t5v0__oai221_1
X_2193_ _1686_/B _2315_/A2 _2314_/A1 VDD VDD VSS VSS gf180mcu_fd_sc_mcu7t5v0__nor2_1
XFILLER_38_679 VDD VDD VSS VSS gf180mcu_fd_sc_mcu7t5v0__fill_2
XFILLER_1_84 VDD VDD VSS VSS gf180mcu_fd_sc_mcu7t5v0__fill_2
XFILLER_52_104 VDD VDD VSS VSS gf180mcu_fd_sc_mcu7t5v0__fill_1
XFILLER_80_457 VDD VDD VSS VSS gf180mcu_fd_sc_mcu7t5v0__fillcap_8
XFILLER_80_435 VDD VDD VSS VSS gf180mcu_fd_sc_mcu7t5v0__fillcap_4
XFILLER_18_381 VDD VDD VSS VSS gf180mcu_fd_sc_mcu7t5v0__fillcap_4
XFILLER_21_524 VDD VDD VSS VSS gf180mcu_fd_sc_mcu7t5v0__fillcap_4
XFILLER_33_384 VDD VDD VSS VSS gf180mcu_fd_sc_mcu7t5v0__fillcap_16
XFILLER_61_693 VDD VDD VSS VSS gf180mcu_fd_sc_mcu7t5v0__fillcap_4
X_1977_ _2994_/Q _3114_/Q _1981_/S _2994_/D VDD VDD VSS VSS gf180mcu_fd_sc_mcu7t5v0__mux2_2
XTAP_TAPCELL_ROW_31_563 VDD VSS gf180mcu_fd_sc_mcu7t5v0__filltie
XFILLER_20_16 VDD VDD VSS VSS gf180mcu_fd_sc_mcu7t5v0__fill_1
X_2529_ _3192_/Q _3184_/Q _2539_/S _3192_/D VDD VDD VSS VSS gf180mcu_fd_sc_mcu7t5v0__mux2_2
XFILLER_102_378 VDD VDD VSS VSS gf180mcu_fd_sc_mcu7t5v0__fillcap_4
XFILLER_75_218 VDD VDD VSS VSS gf180mcu_fd_sc_mcu7t5v0__fill_1
XFILLER_29_36 VDD VDD VSS VSS gf180mcu_fd_sc_mcu7t5v0__fillcap_32
Xhold47 hold47/I hold47/Z VDD VDD VSS VSS gf180mcu_fd_sc_mcu7t5v0__dlyc_1
Xhold58 hold58/I hold58/Z VDD VDD VSS VSS gf180mcu_fd_sc_mcu7t5v0__dlyc_1
XFILLER_84_730 VDD VDD VSS VSS gf180mcu_fd_sc_mcu7t5v0__fillcap_4
XFILLER_28_123 VDD VDD VSS VSS gf180mcu_fd_sc_mcu7t5v0__fillcap_8
XFILLER_28_101 VDD VDD VSS VSS gf180mcu_fd_sc_mcu7t5v0__fillcap_4
XTAP_TAPCELL_ROW_3_266 VDD VSS gf180mcu_fd_sc_mcu7t5v0__filltie
XTAP_TAPCELL_ROW_39_641 VDD VSS gf180mcu_fd_sc_mcu7t5v0__filltie
XFILLER_43_104 VDD VDD VSS VSS gf180mcu_fd_sc_mcu7t5v0__fill_2
XFILLER_56_476 VDD VDD VSS VSS gf180mcu_fd_sc_mcu7t5v0__fillcap_8
XFILLER_43_159 VDD VDD VSS VSS gf180mcu_fd_sc_mcu7t5v0__fillcap_8
XFILLER_45_68 VDD VDD VSS VSS gf180mcu_fd_sc_mcu7t5v0__fill_2
XFILLER_71_457 VDD VDD VSS VSS gf180mcu_fd_sc_mcu7t5v0__fill_2
Xclkbuf_3_6__f_clk_i clkbuf_0_clk_i/Z clkload5/I VDD VDD VSS VSS gf180mcu_fd_sc_mcu7t5v0__clkbuf_16
XFILLER_61_78 VDD VDD VSS VSS gf180mcu_fd_sc_mcu7t5v0__fill_1
XFILLER_3_200 VDD VDD VSS VSS gf180mcu_fd_sc_mcu7t5v0__fillcap_8
XFILLER_4_723 VDD VDD VSS VSS gf180mcu_fd_sc_mcu7t5v0__fillcap_8
XFILLER_3_266 VDD VDD VSS VSS gf180mcu_fd_sc_mcu7t5v0__fillcap_8
XFILLER_10_93 VDD VDD VSS VSS gf180mcu_fd_sc_mcu7t5v0__fillcap_8
XFILLER_94_527 VDD VDD VSS VSS gf180mcu_fd_sc_mcu7t5v0__fillcap_8
XFILLER_86_53 VDD VDD VSS VSS gf180mcu_fd_sc_mcu7t5v0__fill_2
XFILLER_66_229 VDD VDD VSS VSS gf180mcu_fd_sc_mcu7t5v0__fill_1
XFILLER_19_189 VDD VDD VSS VSS gf180mcu_fd_sc_mcu7t5v0__fillcap_16
XFILLER_34_104 VDD VDD VSS VSS gf180mcu_fd_sc_mcu7t5v0__fill_1
XFILLER_47_487 VDD VDD VSS VSS gf180mcu_fd_sc_mcu7t5v0__fill_2
XFILLER_62_457 VDD VDD VSS VSS gf180mcu_fd_sc_mcu7t5v0__fillcap_64
XTAP_TAPCELL_ROW_73_997 VDD VSS gf180mcu_fd_sc_mcu7t5v0__filltie
X_2880_ _2880_/D _2894_/CLK _2880_/Q VDD VDD VSS VSS gf180mcu_fd_sc_mcu7t5v0__dffq_1
X_1900_ _2927_/Q _3111_/Q _1907_/S _2927_/D VDD VDD VSS VSS gf180mcu_fd_sc_mcu7t5v0__mux2_2
X_1831_ _3286_/Q _2869_/Q _1832_/S _2869_/D VDD VDD VSS VSS gf180mcu_fd_sc_mcu7t5v0__mux2_2
XFILLER_42_192 VDD VDD VSS VSS gf180mcu_fd_sc_mcu7t5v0__fillcap_8
XFILLER_30_387 VDD VDD VSS VSS gf180mcu_fd_sc_mcu7t5v0__fillcap_8
X_1762_ _3282_/Q _2809_/Q _1767_/S _2809_/D VDD VDD VSS VSS gf180mcu_fd_sc_mcu7t5v0__mux2_2
X_1693_ _2278_/A1 _2278_/A2 _3140_/Q _1694_/A3 VDD VDD VSS VSS gf180mcu_fd_sc_mcu7t5v0__oai21_1
XTAP_TAPCELL_ROW_77_1045 VDD VSS gf180mcu_fd_sc_mcu7t5v0__filltie
X_3363_ _3363_/D _3369_/RN _3369_/CLK _3363_/Q VDD VDD VSS VSS gf180mcu_fd_sc_mcu7t5v0__dffrnq_1
X_2314_ _2314_/A1 _2314_/A2 _2314_/B1 _2314_/B2 _3131_/D VDD VDD VSS VSS gf180mcu_fd_sc_mcu7t5v0__oai22_1
X_3294_ _3294_/D _3303_/RN _3302_/CLK _3294_/Q VDD VDD VSS VSS gf180mcu_fd_sc_mcu7t5v0__dffrnq_1
X_2245_ _2245_/A1 _2218_/B _2271_/A2 _3142_/Q _3119_/D VDD VDD VSS VSS gf180mcu_fd_sc_mcu7t5v0__oai22_1
X_2176_ _3101_/Q _3219_/Q _2178_/S _3101_/D VDD VDD VSS VSS gf180mcu_fd_sc_mcu7t5v0__mux2_2
XTAP_TAPCELL_ROW_88_1163 VDD VSS gf180mcu_fd_sc_mcu7t5v0__filltie
XTAP_TAPCELL_ROW_0_225 VDD VSS gf180mcu_fd_sc_mcu7t5v0__filltie
XTAP_TAPCELL_ROW_0_236 VDD VSS gf180mcu_fd_sc_mcu7t5v0__filltie
XTAP_TAPCELL_ROW_36_611 VDD VSS gf180mcu_fd_sc_mcu7t5v0__filltie
XFILLER_25_137 VDD VDD VSS VSS gf180mcu_fd_sc_mcu7t5v0__fill_2
XFILLER_53_446 VDD VDD VSS VSS gf180mcu_fd_sc_mcu7t5v0__fillcap_4
XFILLER_40_107 VDD VDD VSS VSS gf180mcu_fd_sc_mcu7t5v0__fillcap_32
XFILLER_53_479 VDD VDD VSS VSS gf180mcu_fd_sc_mcu7t5v0__fillcap_8
XFILLER_21_343 VDD VDD VSS VSS gf180mcu_fd_sc_mcu7t5v0__fillcap_4
XFILLER_31_26 VDD VDD VSS VSS gf180mcu_fd_sc_mcu7t5v0__fillcap_4
XTAP_TAPCELL_ROW_99_1270 VDD VSS gf180mcu_fd_sc_mcu7t5v0__filltie
XPHY_EDGE_ROW_1_Right_1 VDD VSS gf180mcu_fd_sc_mcu7t5v0__endcap
XTAP_TAPCELL_ROW_8_314 VDD VSS gf180mcu_fd_sc_mcu7t5v0__filltie
XFILLER_103_698 VDD VDD VSS VSS gf180mcu_fd_sc_mcu7t5v0__fill_2
XFILLER_88_387 VDD VDD VSS VSS gf180mcu_fd_sc_mcu7t5v0__fillcap_4
XFILLER_91_508 VDD VDD VSS VSS gf180mcu_fd_sc_mcu7t5v0__fillcap_8
XFILLER_56_34 VDD VDD VSS VSS gf180mcu_fd_sc_mcu7t5v0__fill_1
XFILLER_57_763 VDD VDD VSS VSS gf180mcu_fd_sc_mcu7t5v0__fill_2
XFILLER_84_560 VDD VDD VSS VSS gf180mcu_fd_sc_mcu7t5v0__fill_1
XFILLER_17_627 VDD VDD VSS VSS gf180mcu_fd_sc_mcu7t5v0__fill_2
Xclkbuf_4_4_0_host_clk_i clkbuf_0_host_clk_i/Z _3352_/CLK VDD VDD VSS VSS gf180mcu_fd_sc_mcu7t5v0__clkbuf_4
XFILLER_56_262 VDD VDD VSS VSS gf180mcu_fd_sc_mcu7t5v0__fillcap_16
XFILLER_44_457 VDD VDD VSS VSS gf180mcu_fd_sc_mcu7t5v0__fillcap_8
XFILLER_71_232 VDD VDD VSS VSS gf180mcu_fd_sc_mcu7t5v0__fill_1
XFILLER_31_129 VDD VDD VSS VSS gf180mcu_fd_sc_mcu7t5v0__fillcap_8
XTAP_TAPCELL_ROW_70_967 VDD VSS gf180mcu_fd_sc_mcu7t5v0__filltie
XFILLER_72_99 VDD VDD VSS VSS gf180mcu_fd_sc_mcu7t5v0__fillcap_4
XFILLER_12_387 VDD VDD VSS VSS gf180mcu_fd_sc_mcu7t5v0__fillcap_64
XFILLER_12_376 VDD VDD VSS VSS gf180mcu_fd_sc_mcu7t5v0__fill_1
XFILLER_98_107 VDD VDD VSS VSS gf180mcu_fd_sc_mcu7t5v0__fill_2
XFILLER_4_597 VDD VDD VSS VSS gf180mcu_fd_sc_mcu7t5v0__fillcap_4
X_2030_ _3028_/Q _2023_/B _2030_/A3 _2032_/B VDD VDD VSS VSS gf180mcu_fd_sc_mcu7t5v0__nand3_1
XFILLER_35_413 VDD VDD VSS VSS gf180mcu_fd_sc_mcu7t5v0__fillcap_4
XFILLER_47_262 VDD VDD VSS VSS gf180mcu_fd_sc_mcu7t5v0__fillcap_16
XFILLER_35_424 VDD VDD VSS VSS gf180mcu_fd_sc_mcu7t5v0__fill_1
XFILLER_22_107 VDD VDD VSS VSS gf180mcu_fd_sc_mcu7t5v0__fillcap_8
X_2932_ _2932_/D _3324_/CLK _2932_/Q VDD VDD VSS VSS gf180mcu_fd_sc_mcu7t5v0__dffq_1
XFILLER_50_438 VDD VDD VSS VSS gf180mcu_fd_sc_mcu7t5v0__fillcap_16
X_2863_ _2863_/D _2894_/CLK _2863_/Q VDD VDD VSS VSS gf180mcu_fd_sc_mcu7t5v0__dffq_1
XFILLER_87_2 VDD VDD VSS VSS gf180mcu_fd_sc_mcu7t5v0__fill_1
X_1814_ _1851_/A1 _1786_/Z _1822_/S VDD VDD VSS VSS gf180mcu_fd_sc_mcu7t5v0__and2_1
XTAP_TAPCELL_ROW_13_371 VDD VSS gf180mcu_fd_sc_mcu7t5v0__filltie
X_2794_ _2794_/D _2828_/CLK _2794_/Q VDD VDD VSS VSS gf180mcu_fd_sc_mcu7t5v0__dffq_1
X_1745_ _3284_/Q _2795_/Q _1748_/S _2795_/D VDD VDD VSS VSS gf180mcu_fd_sc_mcu7t5v0__mux2_2
X_1676_ _3415_/D _1676_/A2 _2315_/A1 _2187_/A2 _2198_/B VDD VDD VSS VSS gf180mcu_fd_sc_mcu7t5v0__nor4_1
X_3415_ _3415_/D _3416_/RN _3424_/CLK _3415_/Q VDD VDD VSS VSS gf180mcu_fd_sc_mcu7t5v0__dffsnq_1
X_3346_ hold45/Z _3369_/RN _3358_/CLK _3346_/Q VDD VDD VSS VSS gf180mcu_fd_sc_mcu7t5v0__dffrnq_1
X_3277_ _3277_/D _3328_/RN _3326_/CLK _3277_/Q VDD VDD VSS VSS gf180mcu_fd_sc_mcu7t5v0__dffrnq_1
X_2228_ _2228_/A1 _2228_/A2 _2228_/Z VDD VDD VSS VSS gf180mcu_fd_sc_mcu7t5v0__and2_1
XFILLER_38_240 VDD VDD VSS VSS gf180mcu_fd_sc_mcu7t5v0__fillcap_4
X_2159_ _3238_/Q _3088_/Q _2166_/S _3088_/D VDD VDD VSS VSS gf180mcu_fd_sc_mcu7t5v0__mux2_2
XFILLER_26_457 VDD VDD VSS VSS gf180mcu_fd_sc_mcu7t5v0__fillcap_16
XFILLER_81_596 VDD VDD VSS VSS gf180mcu_fd_sc_mcu7t5v0__fill_1
XFILLER_41_438 VDD VDD VSS VSS gf180mcu_fd_sc_mcu7t5v0__fillcap_4
XFILLER_34_490 VDD VDD VSS VSS gf180mcu_fd_sc_mcu7t5v0__fill_1
XFILLER_17_402 VDD VDD VSS VSS gf180mcu_fd_sc_mcu7t5v0__fill_2
XTAP_TAPCELL_ROW_47_728 VDD VSS gf180mcu_fd_sc_mcu7t5v0__filltie
XFILLER_17_446 VDD VDD VSS VSS gf180mcu_fd_sc_mcu7t5v0__fillcap_4
XTAP_TAPCELL_ROW_106_1347 VDD VSS gf180mcu_fd_sc_mcu7t5v0__filltie
XFILLER_13_652 VDD VDD VSS VSS gf180mcu_fd_sc_mcu7t5v0__fillcap_4
XFILLER_32_449 VDD VDD VSS VSS gf180mcu_fd_sc_mcu7t5v0__fillcap_4
XFILLER_73_8 VDD VDD VSS VSS gf180mcu_fd_sc_mcu7t5v0__fill_1
XTAP_TAPCELL_ROW_10_341 VDD VSS gf180mcu_fd_sc_mcu7t5v0__filltie
XFILLER_8_188 VDD VDD VSS VSS gf180mcu_fd_sc_mcu7t5v0__fillcap_8
XFILLER_8_177 VDD VDD VSS VSS gf180mcu_fd_sc_mcu7t5v0__fillcap_4
XTAP_TAPCELL_ROW_74_1015 VDD VSS gf180mcu_fd_sc_mcu7t5v0__filltie
X_1530_ _2104_/A1 _3058_/Q _1546_/A3 _1561_/A1 VDD VDD VSS VSS gf180mcu_fd_sc_mcu7t5v0__nand3_1
X_1461_ _3404_/Q _1455_/I _1463_/A2 VDD VDD VSS VSS gf180mcu_fd_sc_mcu7t5v0__nor2_1
X_1392_ _3030_/Q _2039_/A1 VDD VDD VSS VSS gf180mcu_fd_sc_mcu7t5v0__clkinv_1
X_3200_ _3200_/D _3369_/RN _3329_/CLK _3200_/Q VDD VDD VSS VSS gf180mcu_fd_sc_mcu7t5v0__dffrnq_1
X_3131_ _3131_/D _3416_/RN _3131_/CLK _3131_/Q VDD VDD VSS VSS gf180mcu_fd_sc_mcu7t5v0__dffrnq_1
X_3062_ _3062_/D _3416_/RN _3311_/CLK _3062_/Q VDD VDD VSS VSS gf180mcu_fd_sc_mcu7t5v0__dffrnq_1
XTAP_TAPCELL_ROW_85_1122 VDD VSS gf180mcu_fd_sc_mcu7t5v0__filltie
X_2013_ _2013_/I _3023_/D VDD VDD VSS VSS gf180mcu_fd_sc_mcu7t5v0__clkinv_1
XFILLER_48_593 VDD VDD VSS VSS gf180mcu_fd_sc_mcu7t5v0__fill_2
XFILLER_90_382 VDD VDD VSS VSS gf180mcu_fd_sc_mcu7t5v0__fill_2
XFILLER_90_393 VDD VDD VSS VSS gf180mcu_fd_sc_mcu7t5v0__fill_1
XFILLER_31_460 VDD VDD VSS VSS gf180mcu_fd_sc_mcu7t5v0__fill_1
X_2915_ _2915_/D _2954_/CLK _2915_/Q VDD VDD VSS VSS gf180mcu_fd_sc_mcu7t5v0__dffq_1
X_2846_ _2846_/D _2892_/CLK _2846_/Q VDD VDD VSS VSS gf180mcu_fd_sc_mcu7t5v0__dffq_1
XTAP_TAPCELL_ROW_96_1240 VDD VSS gf180mcu_fd_sc_mcu7t5v0__filltie
X_2777_ _2777_/D _3406_/CLK _2777_/Q VDD VDD VSS VSS gf180mcu_fd_sc_mcu7t5v0__dffq_1
X_1728_ _2782_/Q _3287_/Q _1728_/S _2782_/D VDD VDD VSS VSS gf180mcu_fd_sc_mcu7t5v0__mux2_2
X_1659_ _2764_/Q _2765_/Q _2286_/B _1686_/B VDD VDD VSS VSS gf180mcu_fd_sc_mcu7t5v0__nor3_1
XFILLER_86_622 VDD VDD VSS VSS gf180mcu_fd_sc_mcu7t5v0__fillcap_16
XFILLER_58_313 VDD VDD VSS VSS gf180mcu_fd_sc_mcu7t5v0__fill_2
X_3329_ hold48/Z _3369_/RN _3329_/CLK _3329_/Q VDD VDD VSS VSS gf180mcu_fd_sc_mcu7t5v0__dffrnq_1
XFILLER_37_36 VDD VDD VSS VSS gf180mcu_fd_sc_mcu7t5v0__fillcap_32
XFILLER_27_744 VDD VDD VSS VSS gf180mcu_fd_sc_mcu7t5v0__fillcap_16
XTAP_TAPCELL_ROW_52_775 VDD VSS gf180mcu_fd_sc_mcu7t5v0__filltie
XTAP_TAPCELL_ROW_101_1299 VDD VSS gf180mcu_fd_sc_mcu7t5v0__filltie
XTAP_TAPCELL_ROW_24_488 VDD VSS gf180mcu_fd_sc_mcu7t5v0__filltie
XFILLER_5_136 VDD VDD VSS VSS gf180mcu_fd_sc_mcu7t5v0__fillcap_4
XFILLER_5_158 VDD VDD VSS VSS gf180mcu_fd_sc_mcu7t5v0__fill_1
XFILLER_78_87 VDD VDD VSS VSS gf180mcu_fd_sc_mcu7t5v0__fill_1
XFILLER_49_313 VDD VDD VSS VSS gf180mcu_fd_sc_mcu7t5v0__fill_1
XFILLER_76_132 VDD VDD VSS VSS gf180mcu_fd_sc_mcu7t5v0__fill_1
XFILLER_94_42 VDD VDD VSS VSS gf180mcu_fd_sc_mcu7t5v0__fillcap_32
XFILLER_77_699 VDD VDD VSS VSS gf180mcu_fd_sc_mcu7t5v0__fill_1
XFILLER_49_368 VDD VDD VSS VSS gf180mcu_fd_sc_mcu7t5v0__fillcap_4
XFILLER_17_276 VDD VDD VSS VSS gf180mcu_fd_sc_mcu7t5v0__fillcap_4
XFILLER_17_298 VDD VDD VSS VSS gf180mcu_fd_sc_mcu7t5v0__fillcap_8
XFILLER_72_393 VDD VDD VSS VSS gf180mcu_fd_sc_mcu7t5v0__fill_1
XFILLER_32_268 VDD VDD VSS VSS gf180mcu_fd_sc_mcu7t5v0__fillcap_8
XTAP_TAPCELL_ROW_80_1074 VDD VSS gf180mcu_fd_sc_mcu7t5v0__filltie
X_2700_ _2700_/I _3261_/D VDD VDD VSS VSS gf180mcu_fd_sc_mcu7t5v0__clkinv_1
X_2631_ _3353_/Q _2630_/Z _2634_/B VDD VDD VSS VSS gf180mcu_fd_sc_mcu7t5v0__nor2_1
X_2562_ _3180_/Q _3222_/Q _2569_/S _3222_/D VDD VDD VSS VSS gf180mcu_fd_sc_mcu7t5v0__mux2_2
X_1513_ _3108_/Q _1515_/A1 _1513_/B output8/I VDD VDD VSS VSS gf180mcu_fd_sc_mcu7t5v0__aoi21_1
XFILLER_87_419 VDD VDD VSS VSS gf180mcu_fd_sc_mcu7t5v0__fill_1
X_2493_ _2508_/A1 _2492_/Z _2493_/B _3161_/D VDD VDD VSS VSS gf180mcu_fd_sc_mcu7t5v0__oai21_1
X_1444_ _1442_/Z _1449_/A2 _3393_/D VDD VDD VSS VSS gf180mcu_fd_sc_mcu7t5v0__nor2_1
X_1375_ _3412_/Q _2266_/C VDD VDD VSS VSS gf180mcu_fd_sc_mcu7t5v0__clkinv_1
XTAP_TAPCELL_ROW_91_1192 VDD VSS gf180mcu_fd_sc_mcu7t5v0__filltie
XFILLER_82_102 VDD VDD VSS VSS gf180mcu_fd_sc_mcu7t5v0__fill_2
X_3114_ _3114_/D _3285_/CLK _3114_/Q VDD VDD VSS VSS gf180mcu_fd_sc_mcu7t5v0__dffq_1
XFILLER_55_349 VDD VDD VSS VSS gf180mcu_fd_sc_mcu7t5v0__fill_1
X_3045_ _3045_/D _3303_/RN _3302_/CLK _3045_/Q VDD VDD VSS VSS gf180mcu_fd_sc_mcu7t5v0__dffrnq_1
XFILLER_82_168 VDD VDD VSS VSS gf180mcu_fd_sc_mcu7t5v0__fill_2
XFILLER_70_308 VDD VDD VSS VSS gf180mcu_fd_sc_mcu7t5v0__fillcap_4
XFILLER_23_246 VDD VDD VSS VSS gf180mcu_fd_sc_mcu7t5v0__fillcap_16
XTAP_TAPCELL_ROW_21_458 VDD VSS gf180mcu_fd_sc_mcu7t5v0__filltie
X_2829_ _2829_/D _2893_/CLK _2829_/Q VDD VDD VSS VSS gf180mcu_fd_sc_mcu7t5v0__dffq_1
XFILLER_3_629 VDD VDD VSS VSS gf180mcu_fd_sc_mcu7t5v0__fill_1
XFILLER_101_763 VDD VDD VSS VSS gf180mcu_fd_sc_mcu7t5v0__fill_2
XTAP_TAPCELL_ROW_29_536 VDD VSS gf180mcu_fd_sc_mcu7t5v0__filltie
XFILLER_46_338 VDD VDD VSS VSS gf180mcu_fd_sc_mcu7t5v0__fill_2
XTAP_TAPCELL_ROW_57_834 VDD VSS gf180mcu_fd_sc_mcu7t5v0__filltie
XFILLER_64_34 VDD VDD VSS VSS gf180mcu_fd_sc_mcu7t5v0__fill_1
XTAP_TAPCELL_ROW_103_1317 VDD VSS gf180mcu_fd_sc_mcu7t5v0__filltie
XFILLER_54_371 VDD VDD VSS VSS gf180mcu_fd_sc_mcu7t5v0__fillcap_8
XFILLER_15_758 VDD VDD VSS VSS gf180mcu_fd_sc_mcu7t5v0__fillcap_4
XFILLER_6_434 VDD VDD VSS VSS gf180mcu_fd_sc_mcu7t5v0__fillcap_16
XFILLER_89_64 VDD VDD VSS VSS gf180mcu_fd_sc_mcu7t5v0__fill_1
XFILLER_97_706 VDD VDD VSS VSS gf180mcu_fd_sc_mcu7t5v0__fill_2
XFILLER_69_419 VDD VDD VSS VSS gf180mcu_fd_sc_mcu7t5v0__fill_1
XFILLER_77_430 VDD VDD VSS VSS gf180mcu_fd_sc_mcu7t5v0__fill_2
XFILLER_65_636 VDD VDD VSS VSS gf180mcu_fd_sc_mcu7t5v0__fill_2
XFILLER_64_146 VDD VDD VSS VSS gf180mcu_fd_sc_mcu7t5v0__fill_1
X_1993_ _3112_/Q _3008_/Q _1999_/S _3008_/D VDD VDD VSS VSS gf180mcu_fd_sc_mcu7t5v0__mux2_2
XFILLER_13_290 VDD VDD VSS VSS gf180mcu_fd_sc_mcu7t5v0__fillcap_4
Xclkload20 _3329_/CLK clkload20/ZN VDD VDD VSS VSS gf180mcu_fd_sc_mcu7t5v0__clkinv_2
Xclkload31 _3131_/CLK clkload31/ZN VDD VDD VSS VSS gf180mcu_fd_sc_mcu7t5v0__inv_3
Xclkload42 _2988_/CLK clkload42/Z VDD VDD VSS VSS gf180mcu_fd_sc_mcu7t5v0__clkbuf_1
X_2614_ _2952_/Q _2944_/Q _2936_/Q _2928_/Q _2672_/S0 _2675_/S1 _2614_/Z VDD VDD VSS
+ VSS gf180mcu_fd_sc_mcu7t5v0__mux4_1
Xclkload53 _3314_/CLK clkload53/ZN VDD VDD VSS VSS gf180mcu_fd_sc_mcu7t5v0__clkinv_8
XTAP_TAPCELL_ROW_93_1210 VDD VSS gf180mcu_fd_sc_mcu7t5v0__filltie
Xclkload64 _3407_/CLK clkload64/ZN VDD VDD VSS VSS gf180mcu_fd_sc_mcu7t5v0__inv_4
X_2545_ _3168_/Q _3208_/Q _2569_/S _3208_/D VDD VDD VSS VSS gf180mcu_fd_sc_mcu7t5v0__mux2_2
XFILLER_102_527 VDD VDD VSS VSS gf180mcu_fd_sc_mcu7t5v0__fillcap_8
XFILLER_88_739 VDD VDD VSS VSS gf180mcu_fd_sc_mcu7t5v0__fill_1
X_2476_ _3151_/Q _3152_/Q _2480_/S _3152_/D VDD VDD VSS VSS gf180mcu_fd_sc_mcu7t5v0__mux2_2
X_1427_ _3110_/Q _2231_/B2 VDD VDD VSS VSS gf180mcu_fd_sc_mcu7t5v0__clkinv_1
XFILLER_83_411 VDD VDD VSS VSS gf180mcu_fd_sc_mcu7t5v0__fillcap_8
XTAP_TAPCELL_ROW_54_804 VDD VSS gf180mcu_fd_sc_mcu7t5v0__filltie
XFILLER_56_658 VDD VDD VSS VSS gf180mcu_fd_sc_mcu7t5v0__fillcap_4
X_3028_ _3028_/D _3416_/RN _3416_/CLK _3028_/Q VDD VDD VSS VSS gf180mcu_fd_sc_mcu7t5v0__dffrnq_1
Xclkbuf_4_9_0_host_clk_i clkbuf_0_host_clk_i/Z _2893_/CLK VDD VDD VSS VSS gf180mcu_fd_sc_mcu7t5v0__clkbuf_4
XTAP_TAPCELL_ROW_26_506 VDD VSS gf180mcu_fd_sc_mcu7t5v0__filltie
XFILLER_43_319 VDD VDD VSS VSS gf180mcu_fd_sc_mcu7t5v0__fillcap_8
XFILLER_34_37 VDD VDD VSS VSS gf180mcu_fd_sc_mcu7t5v0__fill_1
XFILLER_51_352 VDD VDD VSS VSS gf180mcu_fd_sc_mcu7t5v0__fillcap_8
XFILLER_11_216 VDD VDD VSS VSS gf180mcu_fd_sc_mcu7t5v0__fill_2
XTAP_TAPCELL_ROW_34_594 VDD VSS gf180mcu_fd_sc_mcu7t5v0__filltie
XTAP_TAPCELL_ROW_62_881 VDD VSS gf180mcu_fd_sc_mcu7t5v0__filltie
XFILLER_7_209 VDD VDD VSS VSS gf180mcu_fd_sc_mcu7t5v0__fill_1
Xclkload3 clkload3/I clkload3/ZN VDD VDD VSS VSS gf180mcu_fd_sc_mcu7t5v0__clkinv_4
XFILLER_50_14 VDD VDD VSS VSS gf180mcu_fd_sc_mcu7t5v0__fill_1
XFILLER_78_216 VDD VDD VSS VSS gf180mcu_fd_sc_mcu7t5v0__fillcap_8
XTAP_TAPCELL_ROW_6_297 VDD VSS gf180mcu_fd_sc_mcu7t5v0__filltie
XFILLER_47_636 VDD VDD VSS VSS gf180mcu_fd_sc_mcu7t5v0__fill_2
Xload_slew26 _2388_/S0 _2404_/S0 VDD VDD VSS VSS gf180mcu_fd_sc_mcu7t5v0__buf_4
Xload_slew37 _3369_/RN _3303_/RN VDD VDD VSS VSS gf180mcu_fd_sc_mcu7t5v0__buf_20
XFILLER_27_360 VDD VDD VSS VSS gf180mcu_fd_sc_mcu7t5v0__fill_2
XFILLER_61_138 VDD VDD VSS VSS gf180mcu_fd_sc_mcu7t5v0__fill_2
XFILLER_15_566 VDD VDD VSS VSS gf180mcu_fd_sc_mcu7t5v0__fill_2
XFILLER_91_87 VDD VDD VSS VSS gf180mcu_fd_sc_mcu7t5v0__fillcap_8
XFILLER_24_81 VDD VDD VSS VSS gf180mcu_fd_sc_mcu7t5v0__fillcap_16
XFILLER_7_721 VDD VDD VSS VSS gf180mcu_fd_sc_mcu7t5v0__fillcap_32
XFILLER_6_297 VDD VDD VSS VSS gf180mcu_fd_sc_mcu7t5v0__fill_1
XFILLER_41_6 VDD VDD VSS VSS gf180mcu_fd_sc_mcu7t5v0__fill_2
X_2330_ _3132_/Q _2407_/B _2330_/B _2331_/A2 VDD VDD VSS VSS gf180mcu_fd_sc_mcu7t5v0__oai21_1
X_2261_ _3132_/Q _3096_/Q _2262_/C VDD VDD VSS VSS gf180mcu_fd_sc_mcu7t5v0__xnor2_1
XFILLER_69_238 VDD VDD VSS VSS gf180mcu_fd_sc_mcu7t5v0__fill_1
Xclkbuf_leaf_52_clk_i clkbuf_leaf_5_clk_i/I _3271_/CLK VDD VDD VSS VSS gf180mcu_fd_sc_mcu7t5v0__clkbuf_4
X_2192_ _2202_/A1 _2766_/Q _2315_/A2 VDD VDD VSS VSS gf180mcu_fd_sc_mcu7t5v0__nor2_1
XFILLER_77_282 VDD VDD VSS VSS gf180mcu_fd_sc_mcu7t5v0__fillcap_16
XFILLER_37_124 VDD VDD VSS VSS gf180mcu_fd_sc_mcu7t5v0__fillcap_16
XFILLER_38_658 VDD VDD VSS VSS gf180mcu_fd_sc_mcu7t5v0__fillcap_4
XFILLER_33_352 VDD VDD VSS VSS gf180mcu_fd_sc_mcu7t5v0__fillcap_32
XFILLER_61_672 VDD VDD VSS VSS gf180mcu_fd_sc_mcu7t5v0__fillcap_4
XFILLER_21_558 VDD VDD VSS VSS gf180mcu_fd_sc_mcu7t5v0__fill_2
X_1976_ _2993_/Q _3113_/Q _1981_/S _2993_/D VDD VDD VSS VSS gf180mcu_fd_sc_mcu7t5v0__mux2_2
XFILLER_60_193 VDD VDD VSS VSS gf180mcu_fd_sc_mcu7t5v0__fillcap_8
XTAP_TAPCELL_ROW_31_564 VDD VSS gf180mcu_fd_sc_mcu7t5v0__filltie
XFILLER_106_107 VDD VDD VSS VSS gf180mcu_fd_sc_mcu7t5v0__fillcap_16
XFILLER_88_503 VDD VDD VSS VSS gf180mcu_fd_sc_mcu7t5v0__fillcap_16
X_2528_ _3191_/Q _3183_/Q _2540_/S _3191_/D VDD VDD VSS VSS gf180mcu_fd_sc_mcu7t5v0__mux2_2
XFILLER_76_709 VDD VDD VSS VSS gf180mcu_fd_sc_mcu7t5v0__fillcap_16
X_2459_ _3250_/Q _1617_/Z _2466_/B1 _3274_/Q _2443_/Z _3266_/Q _2462_/A2 VDD VDD VSS
+ VSS gf180mcu_fd_sc_mcu7t5v0__aoi222_1
Xhold59 hold59/I hold59/Z VDD VDD VSS VSS gf180mcu_fd_sc_mcu7t5v0__dlyc_1
Xhold48 hold48/I hold48/Z VDD VDD VSS VSS gf180mcu_fd_sc_mcu7t5v0__dlyc_1
XFILLER_29_636 VDD VDD VSS VSS gf180mcu_fd_sc_mcu7t5v0__fill_1
XFILLER_84_764 VDD VDD VSS VSS gf180mcu_fd_sc_mcu7t5v0__fill_1
XTAP_TAPCELL_ROW_3_267 VDD VSS gf180mcu_fd_sc_mcu7t5v0__filltie
XTAP_TAPCELL_ROW_39_642 VDD VSS gf180mcu_fd_sc_mcu7t5v0__filltie
XTAP_TAPCELL_ROW_67_940 VDD VSS gf180mcu_fd_sc_mcu7t5v0__filltie
XFILLER_44_639 VDD VDD VSS VSS gf180mcu_fd_sc_mcu7t5v0__fillcap_16
XFILLER_61_57 VDD VDD VSS VSS gf180mcu_fd_sc_mcu7t5v0__fillcap_4
XFILLER_3_212 VDD VDD VSS VSS gf180mcu_fd_sc_mcu7t5v0__fillcap_4
XFILLER_3_278 VDD VDD VSS VSS gf180mcu_fd_sc_mcu7t5v0__fill_2
XFILLER_94_539 VDD VDD VSS VSS gf180mcu_fd_sc_mcu7t5v0__fill_2
XFILLER_86_98 VDD VDD VSS VSS gf180mcu_fd_sc_mcu7t5v0__fillcap_4
XFILLER_47_422 VDD VDD VSS VSS gf180mcu_fd_sc_mcu7t5v0__fillcap_16
XFILLER_59_282 VDD VDD VSS VSS gf180mcu_fd_sc_mcu7t5v0__fillcap_32
XFILLER_74_263 VDD VDD VSS VSS gf180mcu_fd_sc_mcu7t5v0__fillcap_4
XFILLER_15_352 VDD VDD VSS VSS gf180mcu_fd_sc_mcu7t5v0__fillcap_4
XTAP_TAPCELL_ROW_73_998 VDD VSS gf180mcu_fd_sc_mcu7t5v0__filltie
X_1830_ _3285_/Q _2868_/Q _1832_/S _2868_/D VDD VDD VSS VSS gf180mcu_fd_sc_mcu7t5v0__mux2_2
X_1761_ _3281_/Q _2808_/Q _1767_/S _2808_/D VDD VDD VSS VSS gf180mcu_fd_sc_mcu7t5v0__mux2_2
XFILLER_11_591 VDD VDD VSS VSS gf180mcu_fd_sc_mcu7t5v0__fillcap_32
X_1692_ _2263_/A1 _3139_/Q _2278_/A2 VDD VDD VSS VSS gf180mcu_fd_sc_mcu7t5v0__nand2_1
XTAP_TAPCELL_ROW_77_1046 VDD VSS gf180mcu_fd_sc_mcu7t5v0__filltie
XFILLER_7_562 VDD VDD VSS VSS gf180mcu_fd_sc_mcu7t5v0__fillcap_16
X_3362_ _3362_/D input1/Z _3367_/CLK _3362_/Q VDD VDD VSS VSS gf180mcu_fd_sc_mcu7t5v0__dffrnq_1
X_2313_ _2313_/A1 _2313_/A2 _3131_/Q _2314_/B1 VDD VDD VSS VSS gf180mcu_fd_sc_mcu7t5v0__oai21_1
XFILLER_97_344 VDD VDD VSS VSS gf180mcu_fd_sc_mcu7t5v0__fillcap_4
XFILLER_32_2 VDD VDD VSS VSS gf180mcu_fd_sc_mcu7t5v0__fillcap_16
X_3293_ _3293_/D _3303_/RN _3293_/CLK _3293_/Q VDD VDD VSS VSS gf180mcu_fd_sc_mcu7t5v0__dffrnq_1
XFILLER_57_208 VDD VDD VSS VSS gf180mcu_fd_sc_mcu7t5v0__fill_2
XFILLER_97_388 VDD VDD VSS VSS gf180mcu_fd_sc_mcu7t5v0__fill_2
X_2244_ _2262_/B2 _2242_/S _2244_/B _3118_/D VDD VDD VSS VSS gf180mcu_fd_sc_mcu7t5v0__oai21_1
X_2175_ _2255_/A2 _2178_/S _2175_/B _3100_/D VDD VDD VSS VSS gf180mcu_fd_sc_mcu7t5v0__oai21_1
XFILLER_66_753 VDD VDD VSS VSS gf180mcu_fd_sc_mcu7t5v0__fillcap_8
XTAP_TAPCELL_ROW_88_1153 VDD VSS gf180mcu_fd_sc_mcu7t5v0__filltie
XTAP_TAPCELL_ROW_0_226 VDD VSS gf180mcu_fd_sc_mcu7t5v0__filltie
XFILLER_25_105 VDD VDD VSS VSS gf180mcu_fd_sc_mcu7t5v0__fillcap_32
XTAP_TAPCELL_ROW_64_910 VDD VSS gf180mcu_fd_sc_mcu7t5v0__filltie
XFILLER_93_594 VDD VDD VSS VSS gf180mcu_fd_sc_mcu7t5v0__fillcap_4
XTAP_TAPCELL_ROW_0_237 VDD VSS gf180mcu_fd_sc_mcu7t5v0__filltie
XTAP_TAPCELL_ROW_36_612 VDD VSS gf180mcu_fd_sc_mcu7t5v0__filltie
XFILLER_80_255 VDD VDD VSS VSS gf180mcu_fd_sc_mcu7t5v0__fillcap_4
XFILLER_34_683 VDD VDD VSS VSS gf180mcu_fd_sc_mcu7t5v0__fill_1
XTAP_TAPCELL_ROW_99_1271 VDD VSS gf180mcu_fd_sc_mcu7t5v0__filltie
X_1959_ _3115_/Q _2979_/Q _1962_/S _2979_/D VDD VDD VSS VSS gf180mcu_fd_sc_mcu7t5v0__mux2_2
XTAP_TAPCELL_ROW_8_315 VDD VSS gf180mcu_fd_sc_mcu7t5v0__filltie
XFILLER_102_143 VDD VDD VSS VSS gf180mcu_fd_sc_mcu7t5v0__fill_2
XFILLER_88_377 VDD VDD VSS VSS gf180mcu_fd_sc_mcu7t5v0__fillcap_8
XFILLER_76_506 VDD VDD VSS VSS gf180mcu_fd_sc_mcu7t5v0__fillcap_16
XFILLER_29_422 VDD VDD VSS VSS gf180mcu_fd_sc_mcu7t5v0__fillcap_4
XFILLER_57_720 VDD VDD VSS VSS gf180mcu_fd_sc_mcu7t5v0__fill_1
XFILLER_29_488 VDD VDD VSS VSS gf180mcu_fd_sc_mcu7t5v0__fill_2
XFILLER_84_594 VDD VDD VSS VSS gf180mcu_fd_sc_mcu7t5v0__fill_1
XFILLER_16_127 VDD VDD VSS VSS gf180mcu_fd_sc_mcu7t5v0__fillcap_8
XFILLER_44_469 VDD VDD VSS VSS gf180mcu_fd_sc_mcu7t5v0__fill_2
XFILLER_72_34 VDD VDD VSS VSS gf180mcu_fd_sc_mcu7t5v0__fill_1
XFILLER_25_694 VDD VDD VSS VSS gf180mcu_fd_sc_mcu7t5v0__fillcap_4
XFILLER_72_67 VDD VDD VSS VSS gf180mcu_fd_sc_mcu7t5v0__fillcap_32
XFILLER_52_491 VDD VDD VSS VSS gf180mcu_fd_sc_mcu7t5v0__fill_1
XTAP_TAPCELL_ROW_70_968 VDD VSS gf180mcu_fd_sc_mcu7t5v0__filltie
XFILLER_40_675 VDD VDD VSS VSS gf180mcu_fd_sc_mcu7t5v0__fillcap_4
XFILLER_79_300 VDD VDD VSS VSS gf180mcu_fd_sc_mcu7t5v0__fill_2
XFILLER_97_97 VDD VDD VSS VSS gf180mcu_fd_sc_mcu7t5v0__fill_1
XFILLER_94_325 VDD VDD VSS VSS gf180mcu_fd_sc_mcu7t5v0__fill_2
XFILLER_94_314 VDD VDD VSS VSS gf180mcu_fd_sc_mcu7t5v0__fill_1
XFILLER_67_517 VDD VDD VSS VSS gf180mcu_fd_sc_mcu7t5v0__fillcap_16
XFILLER_48_731 VDD VDD VSS VSS gf180mcu_fd_sc_mcu7t5v0__fillcap_4
XFILLER_48_764 VDD VDD VSS VSS gf180mcu_fd_sc_mcu7t5v0__fill_1
XFILLER_90_597 VDD VDD VSS VSS gf180mcu_fd_sc_mcu7t5v0__fillcap_4
X_2931_ _2931_/D _3253_/CLK _2931_/Q VDD VDD VSS VSS gf180mcu_fd_sc_mcu7t5v0__dffq_1
XFILLER_15_160 VDD VDD VSS VSS gf180mcu_fd_sc_mcu7t5v0__fill_1
X_2862_ _2862_/D _2892_/CLK _2862_/Q VDD VDD VSS VSS gf180mcu_fd_sc_mcu7t5v0__dffq_1
X_1813_ _3287_/Q _2854_/Q _1813_/S _2854_/D VDD VDD VSS VSS gf180mcu_fd_sc_mcu7t5v0__mux2_2
XTAP_TAPCELL_ROW_13_372 VDD VSS gf180mcu_fd_sc_mcu7t5v0__filltie
XFILLER_30_174 VDD VDD VSS VSS gf180mcu_fd_sc_mcu7t5v0__fill_1
XFILLER_30_185 VDD VDD VSS VSS gf180mcu_fd_sc_mcu7t5v0__fill_1
X_2793_ _2793_/D _3409_/CLK _2793_/Q VDD VDD VSS VSS gf180mcu_fd_sc_mcu7t5v0__dffq_1
X_1744_ _3283_/Q _2794_/Q _1748_/S _2794_/D VDD VDD VSS VSS gf180mcu_fd_sc_mcu7t5v0__mux2_2
X_3414_ _3414_/D _3416_/RN _3423_/CLK _3415_/D VDD VDD VSS VSS gf180mcu_fd_sc_mcu7t5v0__dffsnq_1
X_1675_ _2413_/A1 _1701_/B _2434_/A1 VDD VDD VSS VSS gf180mcu_fd_sc_mcu7t5v0__nand2_1
XFILLER_98_642 VDD VDD VSS VSS gf180mcu_fd_sc_mcu7t5v0__fill_2
XPHY_EDGE_ROW_15_Right_15 VDD VSS gf180mcu_fd_sc_mcu7t5v0__endcap
XFILLER_97_152 VDD VDD VSS VSS gf180mcu_fd_sc_mcu7t5v0__fill_1
X_3345_ _3368_/Q _3369_/RN _3352_/CLK hold46/I VDD VDD VSS VSS gf180mcu_fd_sc_mcu7t5v0__dffrnq_1
X_3276_ _3276_/D _3328_/RN _3276_/CLK _3276_/Q VDD VDD VSS VSS gf180mcu_fd_sc_mcu7t5v0__dffrnq_1
X_2227_ _3131_/Q _2227_/A2 _2227_/B _2228_/A2 VDD VDD VSS VSS gf180mcu_fd_sc_mcu7t5v0__oai21_1
XFILLER_85_358 VDD VDD VSS VSS gf180mcu_fd_sc_mcu7t5v0__fill_1
X_2158_ _3237_/Q _3087_/Q _2165_/S _3087_/D VDD VDD VSS VSS gf180mcu_fd_sc_mcu7t5v0__mux2_2
XPHY_EDGE_ROW_24_Right_24 VDD VSS gf180mcu_fd_sc_mcu7t5v0__endcap
XFILLER_53_266 VDD VDD VSS VSS gf180mcu_fd_sc_mcu7t5v0__fillcap_8
X_2089_ _2407_/A2 _2091_/B _2089_/B1 _2089_/B2 _3048_/D VDD VDD VSS VSS gf180mcu_fd_sc_mcu7t5v0__aoi22_1
XFILLER_41_417 VDD VDD VSS VSS gf180mcu_fd_sc_mcu7t5v0__fill_2
XFILLER_22_664 VDD VDD VSS VSS gf180mcu_fd_sc_mcu7t5v0__fill_1
XFILLER_42_37 VDD VDD VSS VSS gf180mcu_fd_sc_mcu7t5v0__fillcap_64
XFILLER_108_758 VDD VDD VSS VSS gf180mcu_fd_sc_mcu7t5v0__fillcap_4
XFILLER_107_279 VDD VDD VSS VSS gf180mcu_fd_sc_mcu7t5v0__fill_1
XPHY_EDGE_ROW_33_Right_33 VDD VSS gf180mcu_fd_sc_mcu7t5v0__endcap
XFILLER_88_141 VDD VDD VSS VSS gf180mcu_fd_sc_mcu7t5v0__fillcap_8
XFILLER_67_12 VDD VDD VSS VSS gf180mcu_fd_sc_mcu7t5v0__fill_1
XFILLER_88_174 VDD VDD VSS VSS gf180mcu_fd_sc_mcu7t5v0__fill_1
XFILLER_88_185 VDD VDD VSS VSS gf180mcu_fd_sc_mcu7t5v0__fillcap_4
XFILLER_67_78 VDD VDD VSS VSS gf180mcu_fd_sc_mcu7t5v0__fill_1
XTAP_TAPCELL_ROW_47_729 VDD VSS gf180mcu_fd_sc_mcu7t5v0__filltie
XFILLER_29_296 VDD VDD VSS VSS gf180mcu_fd_sc_mcu7t5v0__fillcap_32
XPHY_EDGE_ROW_42_Right_42 VDD VSS gf180mcu_fd_sc_mcu7t5v0__endcap
XTAP_TAPCELL_ROW_106_1348 VDD VSS gf180mcu_fd_sc_mcu7t5v0__filltie
XFILLER_32_406 VDD VDD VSS VSS gf180mcu_fd_sc_mcu7t5v0__fillcap_4
XFILLER_44_255 VDD VDD VSS VSS gf180mcu_fd_sc_mcu7t5v0__fill_1
XFILLER_32_417 VDD VDD VSS VSS gf180mcu_fd_sc_mcu7t5v0__fillcap_32
XFILLER_60_737 VDD VDD VSS VSS gf180mcu_fd_sc_mcu7t5v0__fill_2
XPHY_EDGE_ROW_17_Left_126 VDD VSS gf180mcu_fd_sc_mcu7t5v0__endcap
XTAP_TAPCELL_ROW_10_342 VDD VSS gf180mcu_fd_sc_mcu7t5v0__filltie
XFILLER_32_92 VDD VDD VSS VSS gf180mcu_fd_sc_mcu7t5v0__fillcap_8
XPHY_EDGE_ROW_51_Right_51 VDD VSS gf180mcu_fd_sc_mcu7t5v0__endcap
XFILLER_99_417 VDD VDD VSS VSS gf180mcu_fd_sc_mcu7t5v0__fill_2
XTAP_TAPCELL_ROW_74_1016 VDD VSS gf180mcu_fd_sc_mcu7t5v0__filltie
XFILLER_99_439 VDD VDD VSS VSS gf180mcu_fd_sc_mcu7t5v0__fillcap_4
X_1460_ _1458_/Z _1466_/A2 _3405_/D VDD VDD VSS VSS gf180mcu_fd_sc_mcu7t5v0__nor2_1
XFILLER_4_384 VDD VDD VSS VSS gf180mcu_fd_sc_mcu7t5v0__fill_1
XPHY_EDGE_ROW_26_Left_135 VDD VSS gf180mcu_fd_sc_mcu7t5v0__endcap
X_1391_ _3033_/Q _2050_/A1 VDD VDD VSS VSS gf180mcu_fd_sc_mcu7t5v0__clkinv_1
X_3130_ _3130_/D _3416_/RN _3423_/CLK _3130_/Q VDD VDD VSS VSS gf180mcu_fd_sc_mcu7t5v0__dffrnq_1
XFILLER_95_612 VDD VDD VSS VSS gf180mcu_fd_sc_mcu7t5v0__fill_2
XFILLER_67_325 VDD VDD VSS VSS gf180mcu_fd_sc_mcu7t5v0__fill_1
XFILLER_94_177 VDD VDD VSS VSS gf180mcu_fd_sc_mcu7t5v0__fillcap_4
XPHY_EDGE_ROW_60_Right_60 VDD VSS gf180mcu_fd_sc_mcu7t5v0__endcap
X_3061_ _3061_/D _3416_/RN _3425_/CLK _3061_/Q VDD VDD VSS VSS gf180mcu_fd_sc_mcu7t5v0__dffrnq_1
XFILLER_94_199 VDD VDD VSS VSS gf180mcu_fd_sc_mcu7t5v0__fillcap_16
XTAP_TAPCELL_ROW_85_1123 VDD VSS gf180mcu_fd_sc_mcu7t5v0__filltie
X_2012_ _2051_/A1 _2010_/Z _3023_/Q _2013_/I VDD VDD VSS VSS gf180mcu_fd_sc_mcu7t5v0__mux2_2
XTAP_TAPCELL_ROW_18_420 VDD VSS gf180mcu_fd_sc_mcu7t5v0__filltie
XPHY_EDGE_ROW_35_Left_144 VDD VSS gf180mcu_fd_sc_mcu7t5v0__endcap
XFILLER_50_247 VDD VDD VSS VSS gf180mcu_fd_sc_mcu7t5v0__fillcap_4
X_2914_ _2914_/D _3286_/CLK _2914_/Q VDD VDD VSS VSS gf180mcu_fd_sc_mcu7t5v0__dffq_1
X_2845_ _2845_/D _2858_/CLK _2845_/Q VDD VDD VSS VSS gf180mcu_fd_sc_mcu7t5v0__dffq_1
XTAP_TAPCELL_ROW_96_1241 VDD VSS gf180mcu_fd_sc_mcu7t5v0__filltie
X_2776_ _2776_/D _2828_/CLK _2776_/Q VDD VDD VSS VSS gf180mcu_fd_sc_mcu7t5v0__dffq_1
XPHY_EDGE_ROW_103_Right_103 VDD VSS gf180mcu_fd_sc_mcu7t5v0__endcap
XPHY_EDGE_ROW_44_Left_153 VDD VSS gf180mcu_fd_sc_mcu7t5v0__endcap
X_1727_ _2781_/Q _3286_/Q _1728_/S _2781_/D VDD VDD VSS VSS gf180mcu_fd_sc_mcu7t5v0__mux2_2
X_1658_ _2218_/B _1708_/A1 _1658_/Z VDD VDD VSS VSS gf180mcu_fd_sc_mcu7t5v0__and2_1
X_1589_ _3379_/Q _3408_/D _1596_/A1 VDD VDD VSS VSS gf180mcu_fd_sc_mcu7t5v0__xnor2_1
X_3328_ spi_sclk_i _3328_/RN _3328_/CLK hold48/I VDD VDD VSS VSS gf180mcu_fd_sc_mcu7t5v0__dffrnq_1
X_3259_ _3259_/D _3328_/RN _3271_/CLK _3259_/Q VDD VDD VSS VSS gf180mcu_fd_sc_mcu7t5v0__dffrnq_1
XFILLER_58_369 VDD VDD VSS VSS gf180mcu_fd_sc_mcu7t5v0__fill_1
XFILLER_39_594 VDD VDD VSS VSS gf180mcu_fd_sc_mcu7t5v0__fillcap_8
XPHY_EDGE_ROW_53_Left_162 VDD VSS gf180mcu_fd_sc_mcu7t5v0__endcap
XFILLER_73_328 VDD VDD VSS VSS gf180mcu_fd_sc_mcu7t5v0__fillcap_8
XFILLER_26_244 VDD VDD VSS VSS gf180mcu_fd_sc_mcu7t5v0__fill_1
XFILLER_54_564 VDD VDD VSS VSS gf180mcu_fd_sc_mcu7t5v0__fillcap_16
XFILLER_54_597 VDD VDD VSS VSS gf180mcu_fd_sc_mcu7t5v0__fillcap_8
XFILLER_53_69 VDD VDD VSS VSS gf180mcu_fd_sc_mcu7t5v0__fill_1
XFILLER_41_258 VDD VDD VSS VSS gf180mcu_fd_sc_mcu7t5v0__fillcap_16
XTAP_TAPCELL_ROW_52_776 VDD VSS gf180mcu_fd_sc_mcu7t5v0__filltie
XTAP_TAPCELL_ROW_24_489 VDD VSS gf180mcu_fd_sc_mcu7t5v0__filltie
XPHY_EDGE_ROW_62_Left_171 VDD VSS gf180mcu_fd_sc_mcu7t5v0__endcap
XFILLER_104_761 VDD VDD VSS VSS gf180mcu_fd_sc_mcu7t5v0__fillcap_4
XFILLER_94_10 VDD VDD VSS VSS gf180mcu_fd_sc_mcu7t5v0__fillcap_4
XFILLER_77_689 VDD VDD VSS VSS gf180mcu_fd_sc_mcu7t5v0__fillcap_8
XFILLER_64_317 VDD VDD VSS VSS gf180mcu_fd_sc_mcu7t5v0__fillcap_32
XPHY_EDGE_ROW_71_Left_180 VDD VSS gf180mcu_fd_sc_mcu7t5v0__endcap
XFILLER_76_177 VDD VDD VSS VSS gf180mcu_fd_sc_mcu7t5v0__fillcap_32
XFILLER_18_734 VDD VDD VSS VSS gf180mcu_fd_sc_mcu7t5v0__fill_1
XFILLER_17_200 VDD VDD VSS VSS gf180mcu_fd_sc_mcu7t5v0__fillcap_8
XFILLER_94_98 VDD VDD VSS VSS gf180mcu_fd_sc_mcu7t5v0__fillcap_4
XFILLER_72_383 VDD VDD VSS VSS gf180mcu_fd_sc_mcu7t5v0__fill_2
XFILLER_32_247 VDD VDD VSS VSS gf180mcu_fd_sc_mcu7t5v0__fillcap_4
XTAP_TAPCELL_ROW_80_1075 VDD VSS gf180mcu_fd_sc_mcu7t5v0__filltie
X_2630_ _3018_/Q _3010_/Q _3002_/Q _2994_/Q _3351_/Q _3352_/Q _2630_/Z VDD VDD VSS
+ VSS gf180mcu_fd_sc_mcu7t5v0__mux4_1
XFILLER_9_498 VDD VDD VSS VSS gf180mcu_fd_sc_mcu7t5v0__fill_1
X_2561_ _3179_/Q _3221_/Q _2569_/S _3221_/D VDD VDD VSS VSS gf180mcu_fd_sc_mcu7t5v0__mux2_2
XFILLER_57_4 VDD VDD VSS VSS gf180mcu_fd_sc_mcu7t5v0__fill_1
XFILLER_99_236 VDD VDD VSS VSS gf180mcu_fd_sc_mcu7t5v0__fill_1
X_2492_ _2492_/A1 _3160_/Q _2492_/Z VDD VDD VSS VSS gf180mcu_fd_sc_mcu7t5v0__xor2_1
X_1512_ _2107_/S _3310_/D VDD VDD VSS VSS gf180mcu_fd_sc_mcu7t5v0__clkinv_1
XFILLER_99_269 VDD VDD VSS VSS gf180mcu_fd_sc_mcu7t5v0__fill_2
XFILLER_99_247 VDD VDD VSS VSS gf180mcu_fd_sc_mcu7t5v0__fillcap_4
X_1443_ _3392_/Q _1436_/Z _3393_/Q _1449_/A2 VDD VDD VSS VSS gf180mcu_fd_sc_mcu7t5v0__aoi21_1
XFILLER_87_409 VDD VDD VSS VSS gf180mcu_fd_sc_mcu7t5v0__fillcap_8
XFILLER_4_192 VDD VDD VSS VSS gf180mcu_fd_sc_mcu7t5v0__fillcap_8
XFILLER_95_442 VDD VDD VSS VSS gf180mcu_fd_sc_mcu7t5v0__fill_1
XTAP_TAPCELL_ROW_91_1193 VDD VSS gf180mcu_fd_sc_mcu7t5v0__filltie
X_1374_ _2766_/Q _2286_/B VDD VDD VSS VSS gf180mcu_fd_sc_mcu7t5v0__clkinv_1
X_3113_ _3113_/D _3288_/CLK _3113_/Q VDD VDD VSS VSS gf180mcu_fd_sc_mcu7t5v0__dffq_1
XFILLER_68_667 VDD VDD VSS VSS gf180mcu_fd_sc_mcu7t5v0__fillcap_16
X_3044_ _3044_/D _3416_/RN _3425_/CLK _3044_/Q VDD VDD VSS VSS gf180mcu_fd_sc_mcu7t5v0__dffrnq_1
XFILLER_24_737 VDD VDD VSS VSS gf180mcu_fd_sc_mcu7t5v0__fillcap_16
XFILLER_36_597 VDD VDD VSS VSS gf180mcu_fd_sc_mcu7t5v0__fillcap_4
XTAP_TAPCELL_ROW_21_459 VDD VSS gf180mcu_fd_sc_mcu7t5v0__filltie
X_2828_ _2828_/D _2828_/CLK _2828_/Q VDD VDD VSS VSS gf180mcu_fd_sc_mcu7t5v0__dffq_1
XFILLER_3_619 VDD VDD VSS VSS gf180mcu_fd_sc_mcu7t5v0__fillcap_8
X_2759_ _3217_/Q _3299_/Q _2763_/S _3299_/D VDD VDD VSS VSS gf180mcu_fd_sc_mcu7t5v0__mux2_2
XFILLER_2_107 VDD VDD VSS VSS gf180mcu_fd_sc_mcu7t5v0__fillcap_16
XFILLER_105_558 VDD VDD VSS VSS gf180mcu_fd_sc_mcu7t5v0__fill_2
XTAP_TAPCELL_ROW_29_537 VDD VSS gf180mcu_fd_sc_mcu7t5v0__filltie
XFILLER_46_317 VDD VDD VSS VSS gf180mcu_fd_sc_mcu7t5v0__fillcap_8
XTAP_TAPCELL_ROW_57_835 VDD VSS gf180mcu_fd_sc_mcu7t5v0__filltie
XFILLER_58_177 VDD VDD VSS VSS gf180mcu_fd_sc_mcu7t5v0__fillcap_4
XTAP_TAPCELL_ROW_103_1318 VDD VSS gf180mcu_fd_sc_mcu7t5v0__filltie
XFILLER_42_523 VDD VDD VSS VSS gf180mcu_fd_sc_mcu7t5v0__fill_2
XFILLER_54_383 VDD VDD VSS VSS gf180mcu_fd_sc_mcu7t5v0__fill_2
XFILLER_80_34 VDD VDD VSS VSS gf180mcu_fd_sc_mcu7t5v0__fill_1
XFILLER_13_72 VDD VDD VSS VSS gf180mcu_fd_sc_mcu7t5v0__fillcap_64
XFILLER_6_457 VDD VDD VSS VSS gf180mcu_fd_sc_mcu7t5v0__fillcap_64
XFILLER_96_228 VDD VDD VSS VSS gf180mcu_fd_sc_mcu7t5v0__fillcap_16
XFILLER_92_467 VDD VDD VSS VSS gf180mcu_fd_sc_mcu7t5v0__fill_1
XFILLER_80_629 VDD VDD VSS VSS gf180mcu_fd_sc_mcu7t5v0__fillcap_16
XFILLER_18_597 VDD VDD VSS VSS gf180mcu_fd_sc_mcu7t5v0__fillcap_8
XFILLER_73_692 VDD VDD VSS VSS gf180mcu_fd_sc_mcu7t5v0__fillcap_8
X_1992_ _3111_/Q _3007_/Q _1999_/S _3007_/D VDD VDD VSS VSS gf180mcu_fd_sc_mcu7t5v0__mux2_2
XFILLER_9_240 VDD VDD VSS VSS gf180mcu_fd_sc_mcu7t5v0__fillcap_4
Xclkload10 _3292_/CLK clkload10/Z VDD VDD VSS VSS gf180mcu_fd_sc_mcu7t5v0__clkbuf_1
Xclkload32 _3148_/CLK clkload32/Z VDD VDD VSS VSS gf180mcu_fd_sc_mcu7t5v0__clkbuf_1
Xclkload43 _3287_/CLK clkload43/ZN VDD VDD VSS VSS gf180mcu_fd_sc_mcu7t5v0__inv_4
X_2613_ _2920_/Q _2912_/Q _2904_/Q _2896_/Q _2674_/S0 _2674_/S1 _2613_/Z VDD VDD VSS
+ VSS gf180mcu_fd_sc_mcu7t5v0__mux4_1
Xclkload21 _3302_/CLK clkload21/Z VDD VDD VSS VSS gf180mcu_fd_sc_mcu7t5v0__clkbuf_1
XFILLER_62_2 VDD VDD VSS VSS gf180mcu_fd_sc_mcu7t5v0__fillcap_8
Xclkload65 _2887_/CLK clkload65/ZN VDD VDD VSS VSS gf180mcu_fd_sc_mcu7t5v0__inv_3
XTAP_TAPCELL_ROW_93_1211 VDD VSS gf180mcu_fd_sc_mcu7t5v0__filltie
X_2544_ _3167_/Q _3207_/Q _2569_/S _3207_/D VDD VDD VSS VSS gf180mcu_fd_sc_mcu7t5v0__mux2_2
Xclkload54 _3315_/CLK clkload54/ZN VDD VDD VSS VSS gf180mcu_fd_sc_mcu7t5v0__inv_8
X_2475_ _3150_/Q _3151_/Q _2480_/S _3151_/D VDD VDD VSS VSS gf180mcu_fd_sc_mcu7t5v0__mux2_2
X_1426_ _3413_/D _2185_/A1 VDD VDD VSS VSS gf180mcu_fd_sc_mcu7t5v0__clkinv_1
XFILLER_87_228 VDD VDD VSS VSS gf180mcu_fd_sc_mcu7t5v0__fillcap_8
XFILLER_68_464 VDD VDD VSS VSS gf180mcu_fd_sc_mcu7t5v0__fillcap_16
XFILLER_28_317 VDD VDD VSS VSS gf180mcu_fd_sc_mcu7t5v0__fillcap_8
XFILLER_83_467 VDD VDD VSS VSS gf180mcu_fd_sc_mcu7t5v0__fillcap_8
XFILLER_55_158 VDD VDD VSS VSS gf180mcu_fd_sc_mcu7t5v0__fillcap_8
X_3027_ _3027_/D _3416_/RN _3416_/CLK _3027_/Q VDD VDD VSS VSS gf180mcu_fd_sc_mcu7t5v0__dffrnq_1
XTAP_TAPCELL_ROW_26_507 VDD VSS gf180mcu_fd_sc_mcu7t5v0__filltie
XTAP_TAPCELL_ROW_54_805 VDD VSS gf180mcu_fd_sc_mcu7t5v0__filltie
XFILLER_71_629 VDD VDD VSS VSS gf180mcu_fd_sc_mcu7t5v0__fill_1
XFILLER_24_523 VDD VDD VSS VSS gf180mcu_fd_sc_mcu7t5v0__fill_2
XFILLER_12_718 VDD VDD VSS VSS gf180mcu_fd_sc_mcu7t5v0__fill_2
XFILLER_24_556 VDD VDD VSS VSS gf180mcu_fd_sc_mcu7t5v0__fillcap_4
XFILLER_51_364 VDD VDD VSS VSS gf180mcu_fd_sc_mcu7t5v0__fill_1
XTAP_TAPCELL_ROW_34_595 VDD VSS gf180mcu_fd_sc_mcu7t5v0__filltie
XTAP_TAPCELL_ROW_62_882 VDD VSS gf180mcu_fd_sc_mcu7t5v0__filltie
Xclkload4 clkload4/I clkload4/ZN VDD VDD VSS VSS gf180mcu_fd_sc_mcu7t5v0__inv_4
XFILLER_50_37 VDD VDD VSS VSS gf180mcu_fd_sc_mcu7t5v0__fillcap_16
XFILLER_3_416 VDD VDD VSS VSS gf180mcu_fd_sc_mcu7t5v0__fillcap_4
XTAP_TAPCELL_ROW_6_298 VDD VSS gf180mcu_fd_sc_mcu7t5v0__filltie
Xload_slew27 _1439_/B _2388_/S0 VDD VDD VSS VSS gf180mcu_fd_sc_mcu7t5v0__buf_4
Xload_slew38 input1/Z _3369_/RN VDD VDD VSS VSS gf180mcu_fd_sc_mcu7t5v0__buf_20
XFILLER_27_372 VDD VDD VSS VSS gf180mcu_fd_sc_mcu7t5v0__fillcap_32
XFILLER_91_44 VDD VDD VSS VSS gf180mcu_fd_sc_mcu7t5v0__fillcap_16
XFILLER_6_221 VDD VDD VSS VSS gf180mcu_fd_sc_mcu7t5v0__fill_1
XFILLER_97_504 VDD VDD VSS VSS gf180mcu_fd_sc_mcu7t5v0__fill_2
XFILLER_97_559 VDD VDD VSS VSS gf180mcu_fd_sc_mcu7t5v0__fill_1
X_2260_ _3137_/Q _3101_/Q _2263_/B VDD VDD VSS VSS gf180mcu_fd_sc_mcu7t5v0__xor2_1
XFILLER_69_228 VDD VDD VSS VSS gf180mcu_fd_sc_mcu7t5v0__fillcap_8
XFILLER_78_762 VDD VDD VSS VSS gf180mcu_fd_sc_mcu7t5v0__fill_2
X_2191_ _2764_/Q _2286_/B _2199_/A1 VDD VDD VSS VSS gf180mcu_fd_sc_mcu7t5v0__nand2_1
XPHY_EDGE_ROW_9_Left_118 VDD VSS gf180mcu_fd_sc_mcu7t5v0__endcap
XFILLER_1_86 VDD VDD VSS VSS gf180mcu_fd_sc_mcu7t5v0__fill_1
XFILLER_52_139 VDD VDD VSS VSS gf180mcu_fd_sc_mcu7t5v0__fillcap_16
X_1975_ _2992_/Q _3112_/Q _1981_/S _2992_/D VDD VDD VSS VSS gf180mcu_fd_sc_mcu7t5v0__mux2_2
X_2527_ _3190_/Q _3182_/Q _2540_/S _3190_/D VDD VDD VSS VSS gf180mcu_fd_sc_mcu7t5v0__mux2_2
XFILLER_88_559 VDD VDD VSS VSS gf180mcu_fd_sc_mcu7t5v0__fillcap_8
X_2458_ _3258_/Q _2467_/B1 _2458_/B _2462_/A1 VDD VDD VSS VSS gf180mcu_fd_sc_mcu7t5v0__aoi21_1
XPHY_EDGE_ROW_89_Right_89 VDD VSS gf180mcu_fd_sc_mcu7t5v0__endcap
X_1409_ _3306_/Q _1525_/B2 VDD VDD VSS VSS gf180mcu_fd_sc_mcu7t5v0__clkinv_1
XFILLER_96_581 VDD VDD VSS VSS gf180mcu_fd_sc_mcu7t5v0__fillcap_4
X_2389_ _3394_/Q _2388_/Z _2392_/A2 VDD VDD VSS VSS gf180mcu_fd_sc_mcu7t5v0__nand2_1
XFILLER_29_615 VDD VDD VSS VSS gf180mcu_fd_sc_mcu7t5v0__fillcap_8
Xhold49 hold49/I hold49/Z VDD VDD VSS VSS gf180mcu_fd_sc_mcu7t5v0__dlyc_1
XTAP_TAPCELL_ROW_3_268 VDD VSS gf180mcu_fd_sc_mcu7t5v0__filltie
XTAP_TAPCELL_ROW_39_643 VDD VSS gf180mcu_fd_sc_mcu7t5v0__filltie
XTAP_TAPCELL_ROW_67_941 VDD VSS gf180mcu_fd_sc_mcu7t5v0__filltie
XFILLER_16_309 VDD VDD VSS VSS gf180mcu_fd_sc_mcu7t5v0__fill_1
XFILLER_71_426 VDD VDD VSS VSS gf180mcu_fd_sc_mcu7t5v0__fill_2
XPHY_EDGE_ROW_98_Right_98 VDD VSS gf180mcu_fd_sc_mcu7t5v0__endcap
XFILLER_12_548 VDD VDD VSS VSS gf180mcu_fd_sc_mcu7t5v0__fill_2
XFILLER_61_36 VDD VDD VSS VSS gf180mcu_fd_sc_mcu7t5v0__fillcap_16
XFILLER_106_664 VDD VDD VSS VSS gf180mcu_fd_sc_mcu7t5v0__fill_1
XFILLER_87_570 VDD VDD VSS VSS gf180mcu_fd_sc_mcu7t5v0__fillcap_4
XFILLER_75_710 VDD VDD VSS VSS gf180mcu_fd_sc_mcu7t5v0__fillcap_8
XFILLER_59_250 VDD VDD VSS VSS gf180mcu_fd_sc_mcu7t5v0__fill_1
XFILLER_47_489 VDD VDD VSS VSS gf180mcu_fd_sc_mcu7t5v0__fill_1
XFILLER_62_448 VDD VDD VSS VSS gf180mcu_fd_sc_mcu7t5v0__fillcap_4
XFILLER_42_172 VDD VDD VSS VSS gf180mcu_fd_sc_mcu7t5v0__fill_2
XTAP_TAPCELL_ROW_73_999 VDD VSS gf180mcu_fd_sc_mcu7t5v0__filltie
XFILLER_15_397 VDD VDD VSS VSS gf180mcu_fd_sc_mcu7t5v0__fillcap_8
X_1760_ _3280_/Q _2807_/Q _1767_/S _2807_/D VDD VDD VSS VSS gf180mcu_fd_sc_mcu7t5v0__mux2_2
X_1691_ _3136_/Q _3138_/Q _1690_/Z _2278_/A1 VDD VDD VSS VSS gf180mcu_fd_sc_mcu7t5v0__nand3_1
XTAP_TAPCELL_ROW_77_1047 VDD VSS gf180mcu_fd_sc_mcu7t5v0__filltie
X_3361_ _3361_/D input1/Z _3367_/CLK _3361_/Q VDD VDD VSS VSS gf180mcu_fd_sc_mcu7t5v0__dffrnq_1
X_2312_ _2312_/A1 _2312_/A2 _2314_/A2 VDD VDD VSS VSS gf180mcu_fd_sc_mcu7t5v0__nand2_1
XFILLER_97_312 VDD VDD VSS VSS gf180mcu_fd_sc_mcu7t5v0__fill_2
X_3292_ _3292_/D _3303_/RN _3292_/CLK _3292_/Q VDD VDD VSS VSS gf180mcu_fd_sc_mcu7t5v0__dffrnq_1
XFILLER_25_2 VDD VDD VSS VSS gf180mcu_fd_sc_mcu7t5v0__fill_2
X_2243_ _3118_/Q _2242_/S _2244_/B VDD VDD VSS VSS gf180mcu_fd_sc_mcu7t5v0__nand2_1
XFILLER_38_445 VDD VDD VSS VSS gf180mcu_fd_sc_mcu7t5v0__fillcap_8
X_2174_ _3218_/Q _2178_/S _2175_/B VDD VDD VSS VSS gf180mcu_fd_sc_mcu7t5v0__nand2_1
XFILLER_65_220 VDD VDD VSS VSS gf180mcu_fd_sc_mcu7t5v0__fillcap_4
XFILLER_66_743 VDD VDD VSS VSS gf180mcu_fd_sc_mcu7t5v0__fill_2
XFILLER_93_562 VDD VDD VSS VSS gf180mcu_fd_sc_mcu7t5v0__fillcap_32
XTAP_TAPCELL_ROW_88_1154 VDD VSS gf180mcu_fd_sc_mcu7t5v0__filltie
XFILLER_81_702 VDD VDD VSS VSS gf180mcu_fd_sc_mcu7t5v0__fillcap_16
XTAP_TAPCELL_ROW_0_227 VDD VSS gf180mcu_fd_sc_mcu7t5v0__filltie
XFILLER_38_489 VDD VDD VSS VSS gf180mcu_fd_sc_mcu7t5v0__fillcap_16
XTAP_TAPCELL_ROW_64_911 VDD VSS gf180mcu_fd_sc_mcu7t5v0__filltie
XTAP_TAPCELL_ROW_0_238 VDD VSS gf180mcu_fd_sc_mcu7t5v0__filltie
XFILLER_25_139 VDD VDD VSS VSS gf180mcu_fd_sc_mcu7t5v0__fill_1
XTAP_TAPCELL_ROW_36_613 VDD VSS gf180mcu_fd_sc_mcu7t5v0__filltie
XFILLER_33_150 VDD VDD VSS VSS gf180mcu_fd_sc_mcu7t5v0__fill_1
XFILLER_61_492 VDD VDD VSS VSS gf180mcu_fd_sc_mcu7t5v0__fillcap_16
X_1958_ _3114_/Q _2978_/Q _1962_/S _2978_/D VDD VDD VSS VSS gf180mcu_fd_sc_mcu7t5v0__mux2_2
XTAP_TAPCELL_ROW_99_1272 VDD VSS gf180mcu_fd_sc_mcu7t5v0__filltie
X_1889_ _3366_/Q _3367_/Q _2000_/A1 _1897_/S VDD VDD VSS VSS gf180mcu_fd_sc_mcu7t5v0__nand3_1
XFILLER_107_439 VDD VDD VSS VSS gf180mcu_fd_sc_mcu7t5v0__fillcap_32
XTAP_TAPCELL_ROW_8_316 VDD VSS gf180mcu_fd_sc_mcu7t5v0__filltie
XFILLER_88_312 VDD VDD VSS VSS gf180mcu_fd_sc_mcu7t5v0__fill_2
XFILLER_103_678 VDD VDD VSS VSS gf180mcu_fd_sc_mcu7t5v0__fillcap_16
XFILLER_88_345 VDD VDD VSS VSS gf180mcu_fd_sc_mcu7t5v0__fillcap_32
XFILLER_102_177 VDD VDD VSS VSS gf180mcu_fd_sc_mcu7t5v0__fillcap_64
XFILLER_29_401 VDD VDD VSS VSS gf180mcu_fd_sc_mcu7t5v0__fillcap_4
XFILLER_69_570 VDD VDD VSS VSS gf180mcu_fd_sc_mcu7t5v0__fill_1
XFILLER_17_629 VDD VDD VSS VSS gf180mcu_fd_sc_mcu7t5v0__fill_1
XFILLER_29_467 VDD VDD VSS VSS gf180mcu_fd_sc_mcu7t5v0__fillcap_4
XFILLER_56_242 VDD VDD VSS VSS gf180mcu_fd_sc_mcu7t5v0__fill_2
XFILLER_71_212 VDD VDD VSS VSS gf180mcu_fd_sc_mcu7t5v0__fillcap_16
XFILLER_71_267 VDD VDD VSS VSS gf180mcu_fd_sc_mcu7t5v0__fillcap_8
XFILLER_12_312 VDD VDD VSS VSS gf180mcu_fd_sc_mcu7t5v0__fill_2
XTAP_TAPCELL_ROW_70_969 VDD VSS gf180mcu_fd_sc_mcu7t5v0__filltie
XFILLER_8_327 VDD VDD VSS VSS gf180mcu_fd_sc_mcu7t5v0__fillcap_4
Xclkbuf_leaf_51_clk_i clkload0/I _3329_/CLK VDD VDD VSS VSS gf180mcu_fd_sc_mcu7t5v0__clkbuf_4
XFILLER_21_72 VDD VDD VSS VSS gf180mcu_fd_sc_mcu7t5v0__fillcap_4
XFILLER_97_10 VDD VDD VSS VSS gf180mcu_fd_sc_mcu7t5v0__fill_1
XFILLER_0_750 VDD VDD VSS VSS gf180mcu_fd_sc_mcu7t5v0__fillcap_8
XFILLER_94_348 VDD VDD VSS VSS gf180mcu_fd_sc_mcu7t5v0__fillcap_4
XFILLER_47_220 VDD VDD VSS VSS gf180mcu_fd_sc_mcu7t5v0__fill_2
XFILLER_75_562 VDD VDD VSS VSS gf180mcu_fd_sc_mcu7t5v0__fillcap_64
XFILLER_63_702 VDD VDD VSS VSS gf180mcu_fd_sc_mcu7t5v0__fill_1
XFILLER_90_543 VDD VDD VSS VSS gf180mcu_fd_sc_mcu7t5v0__fillcap_8
XFILLER_90_587 VDD VDD VSS VSS gf180mcu_fd_sc_mcu7t5v0__fillcap_8
XFILLER_16_684 VDD VDD VSS VSS gf180mcu_fd_sc_mcu7t5v0__fillcap_32
XFILLER_16_662 VDD VDD VSS VSS gf180mcu_fd_sc_mcu7t5v0__fill_2
X_2930_ _2930_/D _3313_/CLK _2930_/Q VDD VDD VSS VSS gf180mcu_fd_sc_mcu7t5v0__dffq_1
XFILLER_50_418 VDD VDD VSS VSS gf180mcu_fd_sc_mcu7t5v0__fillcap_4
XPHY_EDGE_ROW_99_Left_208 VDD VSS gf180mcu_fd_sc_mcu7t5v0__endcap
XFILLER_43_492 VDD VDD VSS VSS gf180mcu_fd_sc_mcu7t5v0__fillcap_8
Xclkbuf_leaf_19_clk_i clkload1/I _3306_/CLK VDD VDD VSS VSS gf180mcu_fd_sc_mcu7t5v0__clkbuf_4
XFILLER_31_676 VDD VDD VSS VSS gf180mcu_fd_sc_mcu7t5v0__fillcap_16
XTAP_TAPCELL_ROW_41_660 VDD VSS gf180mcu_fd_sc_mcu7t5v0__filltie
X_2861_ _2861_/D _3314_/CLK _2861_/Q VDD VDD VSS VSS gf180mcu_fd_sc_mcu7t5v0__dffq_1
XTAP_TAPCELL_ROW_13_373 VDD VSS gf180mcu_fd_sc_mcu7t5v0__filltie
X_1812_ _3286_/Q _2853_/Q _1813_/S _2853_/D VDD VDD VSS VSS gf180mcu_fd_sc_mcu7t5v0__mux2_2
X_2792_ _2792_/D _2796_/CLK _2792_/Q VDD VDD VSS VSS gf180mcu_fd_sc_mcu7t5v0__dffq_1
X_1743_ _3282_/Q _2793_/Q _1748_/S _2793_/D VDD VDD VSS VSS gf180mcu_fd_sc_mcu7t5v0__mux2_2
X_1674_ _2286_/B _2249_/B _1681_/A1 VDD VDD VSS VSS gf180mcu_fd_sc_mcu7t5v0__nand2_1
X_3413_ _3413_/D _3416_/RN _3423_/CLK _3414_/D VDD VDD VSS VSS gf180mcu_fd_sc_mcu7t5v0__dffsnq_1
XFILLER_97_142 VDD VDD VSS VSS gf180mcu_fd_sc_mcu7t5v0__fillcap_8
X_3344_ _3363_/Q _3369_/RN _3352_/CLK hold49/I VDD VDD VSS VSS gf180mcu_fd_sc_mcu7t5v0__dffrnq_1
XFILLER_85_304 VDD VDD VSS VSS gf180mcu_fd_sc_mcu7t5v0__fillcap_4
X_3275_ _3275_/D _3328_/RN _3276_/CLK _3275_/Q VDD VDD VSS VSS gf180mcu_fd_sc_mcu7t5v0__dffrnq_1
X_2226_ _1679_/C _2315_/B _2226_/A3 _2251_/C _2229_/S VDD VDD VSS VSS gf180mcu_fd_sc_mcu7t5v0__nor4_1
XFILLER_85_348 VDD VDD VSS VSS gf180mcu_fd_sc_mcu7t5v0__fill_2
X_2157_ _3236_/Q _3086_/Q _2165_/S _3086_/D VDD VDD VSS VSS gf180mcu_fd_sc_mcu7t5v0__mux2_2
XFILLER_53_212 VDD VDD VSS VSS gf180mcu_fd_sc_mcu7t5v0__fillcap_16
X_2088_ _3051_/Q _2076_/C _2091_/A2 _3302_/Q _2090_/A2 _3294_/Q _2089_/B2 VDD VDD
+ VSS VSS gf180mcu_fd_sc_mcu7t5v0__aoi222_1
XFILLER_53_278 VDD VDD VSS VSS gf180mcu_fd_sc_mcu7t5v0__fill_2
XFILLER_21_120 VDD VDD VSS VSS gf180mcu_fd_sc_mcu7t5v0__fill_1
XFILLER_21_142 VDD VDD VSS VSS gf180mcu_fd_sc_mcu7t5v0__fillcap_8
XFILLER_89_632 VDD VDD VSS VSS gf180mcu_fd_sc_mcu7t5v0__fillcap_16
XFILLER_1_536 VDD VDD VSS VSS gf180mcu_fd_sc_mcu7t5v0__fillcap_16
XFILLER_88_164 VDD VDD VSS VSS gf180mcu_fd_sc_mcu7t5v0__fillcap_8
XFILLER_76_304 VDD VDD VSS VSS gf180mcu_fd_sc_mcu7t5v0__fillcap_4
XFILLER_49_507 VDD VDD VSS VSS gf180mcu_fd_sc_mcu7t5v0__fill_2
XFILLER_67_68 VDD VDD VSS VSS gf180mcu_fd_sc_mcu7t5v0__fill_2
XFILLER_17_404 VDD VDD VSS VSS gf180mcu_fd_sc_mcu7t5v0__fill_1
XFILLER_45_702 VDD VDD VSS VSS gf180mcu_fd_sc_mcu7t5v0__fill_2
XFILLER_29_286 VDD VDD VSS VSS gf180mcu_fd_sc_mcu7t5v0__fill_2
XFILLER_72_521 VDD VDD VSS VSS gf180mcu_fd_sc_mcu7t5v0__fillcap_4
XTAP_TAPCELL_ROW_106_1349 VDD VSS gf180mcu_fd_sc_mcu7t5v0__filltie
XFILLER_83_45 VDD VDD VSS VSS gf180mcu_fd_sc_mcu7t5v0__fillcap_8
XFILLER_72_543 VDD VDD VSS VSS gf180mcu_fd_sc_mcu7t5v0__fillcap_16
XFILLER_25_470 VDD VDD VSS VSS gf180mcu_fd_sc_mcu7t5v0__fillcap_4
XFILLER_13_632 VDD VDD VSS VSS gf180mcu_fd_sc_mcu7t5v0__fillcap_4
XFILLER_25_492 VDD VDD VSS VSS gf180mcu_fd_sc_mcu7t5v0__fillcap_8
XFILLER_8_102 VDD VDD VSS VSS gf180mcu_fd_sc_mcu7t5v0__fill_2
XFILLER_40_451 VDD VDD VSS VSS gf180mcu_fd_sc_mcu7t5v0__fillcap_4
XFILLER_13_687 VDD VDD VSS VSS gf180mcu_fd_sc_mcu7t5v0__fillcap_8
XFILLER_9_647 VDD VDD VSS VSS gf180mcu_fd_sc_mcu7t5v0__fillcap_4
XTAP_TAPCELL_ROW_10_343 VDD VSS gf180mcu_fd_sc_mcu7t5v0__filltie
XFILLER_8_146 VDD VDD VSS VSS gf180mcu_fd_sc_mcu7t5v0__fillcap_4
XTAP_TAPCELL_ROW_74_1006 VDD VSS gf180mcu_fd_sc_mcu7t5v0__filltie
XFILLER_4_374 VDD VDD VSS VSS gf180mcu_fd_sc_mcu7t5v0__fillcap_8
X_1390_ _3034_/Q _1606_/C VDD VDD VSS VSS gf180mcu_fd_sc_mcu7t5v0__clkinv_1
XFILLER_79_142 VDD VDD VSS VSS gf180mcu_fd_sc_mcu7t5v0__fillcap_64
X_3060_ _3060_/D _3416_/RN _3425_/CLK _3060_/Q VDD VDD VSS VSS gf180mcu_fd_sc_mcu7t5v0__dffrnq_1
XFILLER_0_580 VDD VDD VSS VSS gf180mcu_fd_sc_mcu7t5v0__fillcap_32
X_2011_ _2015_/B _2031_/A2 _2051_/A1 VDD VDD VSS VSS gf180mcu_fd_sc_mcu7t5v0__nand2_1
XFILLER_82_307 VDD VDD VSS VSS gf180mcu_fd_sc_mcu7t5v0__fillcap_8
XFILLER_82_329 VDD VDD VSS VSS gf180mcu_fd_sc_mcu7t5v0__fill_1
XFILLER_35_212 VDD VDD VSS VSS gf180mcu_fd_sc_mcu7t5v0__fillcap_16
XTAP_TAPCELL_ROW_85_1124 VDD VSS gf180mcu_fd_sc_mcu7t5v0__filltie
XTAP_TAPCELL_ROW_18_421 VDD VSS gf180mcu_fd_sc_mcu7t5v0__filltie
XFILLER_90_384 VDD VDD VSS VSS gf180mcu_fd_sc_mcu7t5v0__fill_1
XFILLER_35_267 VDD VDD VSS VSS gf180mcu_fd_sc_mcu7t5v0__fill_2
XFILLER_92_2 VDD VDD VSS VSS gf180mcu_fd_sc_mcu7t5v0__fillcap_8
XFILLER_50_237 VDD VDD VSS VSS gf180mcu_fd_sc_mcu7t5v0__fillcap_8
X_2913_ _2913_/D _2958_/CLK _2913_/Q VDD VDD VSS VSS gf180mcu_fd_sc_mcu7t5v0__dffq_1
X_2844_ _2844_/D _3315_/CLK _2844_/Q VDD VDD VSS VSS gf180mcu_fd_sc_mcu7t5v0__dffq_1
XTAP_TAPCELL_ROW_96_1242 VDD VSS gf180mcu_fd_sc_mcu7t5v0__filltie
X_2775_ _2775_/D _2796_/CLK _2775_/Q VDD VDD VSS VSS gf180mcu_fd_sc_mcu7t5v0__dffq_1
XFILLER_105_718 VDD VDD VSS VSS gf180mcu_fd_sc_mcu7t5v0__fillcap_8
XFILLER_7_190 VDD VDD VSS VSS gf180mcu_fd_sc_mcu7t5v0__fillcap_8
X_1726_ _2780_/Q _3285_/Q _1728_/S _2780_/D VDD VDD VSS VSS gf180mcu_fd_sc_mcu7t5v0__mux2_2
X_1657_ _3418_/Q _2266_/C _2315_/A1 VDD VDD VSS VSS gf180mcu_fd_sc_mcu7t5v0__nand2_1
X_1588_ _1582_/Z _1588_/A2 _1587_/Z _3340_/D VDD VDD VSS VSS gf180mcu_fd_sc_mcu7t5v0__nor3_1
X_3327_ _3329_/Q _3369_/RN _3327_/CLK _3327_/Q VDD VDD VSS VSS gf180mcu_fd_sc_mcu7t5v0__dffrnq_1
X_3258_ _3258_/D _3328_/RN _3325_/CLK _3258_/Q VDD VDD VSS VSS gf180mcu_fd_sc_mcu7t5v0__dffrnq_1
XFILLER_27_702 VDD VDD VSS VSS gf180mcu_fd_sc_mcu7t5v0__fillcap_8
XFILLER_39_562 VDD VDD VSS VSS gf180mcu_fd_sc_mcu7t5v0__fillcap_32
XFILLER_100_489 VDD VDD VSS VSS gf180mcu_fd_sc_mcu7t5v0__fillcap_16
XFILLER_85_189 VDD VDD VSS VSS gf180mcu_fd_sc_mcu7t5v0__fillcap_8
X_2209_ _3394_/Q _2208_/Z _2212_/B1 VDD VDD VSS VSS gf180mcu_fd_sc_mcu7t5v0__nand2_1
X_3189_ _3189_/D _3328_/RN _3273_/CLK _3189_/Q VDD VDD VSS VSS gf180mcu_fd_sc_mcu7t5v0__dffrnq_1
XFILLER_26_201 VDD VDD VSS VSS gf180mcu_fd_sc_mcu7t5v0__fill_2
XFILLER_14_429 VDD VDD VSS VSS gf180mcu_fd_sc_mcu7t5v0__fillcap_16
XFILLER_26_267 VDD VDD VSS VSS gf180mcu_fd_sc_mcu7t5v0__fill_2
XFILLER_53_26 VDD VDD VSS VSS gf180mcu_fd_sc_mcu7t5v0__fillcap_4
XTAP_TAPCELL_ROW_52_777 VDD VSS gf180mcu_fd_sc_mcu7t5v0__filltie
XFILLER_10_613 VDD VDD VSS VSS gf180mcu_fd_sc_mcu7t5v0__fillcap_8
XFILLER_108_512 VDD VDD VSS VSS gf180mcu_fd_sc_mcu7t5v0__fillcap_32
XFILLER_78_34 VDD VDD VSS VSS gf180mcu_fd_sc_mcu7t5v0__fill_1
XFILLER_89_451 VDD VDD VSS VSS gf180mcu_fd_sc_mcu7t5v0__fill_1
XFILLER_94_33 VDD VDD VSS VSS gf180mcu_fd_sc_mcu7t5v0__fill_2
XFILLER_92_605 VDD VDD VSS VSS gf180mcu_fd_sc_mcu7t5v0__fill_2
XFILLER_17_212 VDD VDD VSS VSS gf180mcu_fd_sc_mcu7t5v0__fillcap_8
XFILLER_60_535 VDD VDD VSS VSS gf180mcu_fd_sc_mcu7t5v0__fillcap_4
XFILLER_60_568 VDD VDD VSS VSS gf180mcu_fd_sc_mcu7t5v0__fillcap_8
XTAP_TAPCELL_ROW_80_1076 VDD VSS gf180mcu_fd_sc_mcu7t5v0__filltie
X_2560_ _3178_/Q _3220_/Q _2569_/S _3220_/D VDD VDD VSS VSS gf180mcu_fd_sc_mcu7t5v0__mux2_2
X_1511_ _3120_/Q _3121_/Q _3308_/Q _2414_/B _2107_/S VDD VDD VSS VSS gf180mcu_fd_sc_mcu7t5v0__nand4_1
X_2491_ _3161_/Q _2491_/A2 _2493_/B VDD VDD VSS VSS gf180mcu_fd_sc_mcu7t5v0__nand2_1
XFILLER_5_661 VDD VDD VSS VSS gf180mcu_fd_sc_mcu7t5v0__fillcap_8
X_1442_ _2390_/S1 _3393_/Q _1436_/Z _1442_/Z VDD VDD VSS VSS gf180mcu_fd_sc_mcu7t5v0__and3_1
XFILLER_4_171 VDD VDD VSS VSS gf180mcu_fd_sc_mcu7t5v0__fillcap_4
XTAP_TAPCELL_ROW_91_1194 VDD VSS gf180mcu_fd_sc_mcu7t5v0__filltie
X_1373_ _2765_/Q _2202_/A2 VDD VDD VSS VSS gf180mcu_fd_sc_mcu7t5v0__clkinv_1
X_3112_ _3112_/D _3288_/CLK _3112_/Q VDD VDD VSS VSS gf180mcu_fd_sc_mcu7t5v0__dffq_1
XFILLER_83_627 VDD VDD VSS VSS gf180mcu_fd_sc_mcu7t5v0__fill_2
XFILLER_82_104 VDD VDD VSS VSS gf180mcu_fd_sc_mcu7t5v0__fill_1
XFILLER_36_521 VDD VDD VSS VSS gf180mcu_fd_sc_mcu7t5v0__fillcap_4
X_3043_ _3043_/D _3303_/RN _3308_/CLK _3043_/Q VDD VDD VSS VSS gf180mcu_fd_sc_mcu7t5v0__dffrnq_1
XFILLER_91_682 VDD VDD VSS VSS gf180mcu_fd_sc_mcu7t5v0__fillcap_16
XFILLER_23_18 VDD VDD VSS VSS gf180mcu_fd_sc_mcu7t5v0__fillcap_8
X_2827_ _2827_/D _2887_/CLK _2827_/Q VDD VDD VSS VSS gf180mcu_fd_sc_mcu7t5v0__dffq_1
X_2758_ _3216_/Q _3298_/Q _2763_/S _3298_/D VDD VDD VSS VSS gf180mcu_fd_sc_mcu7t5v0__mux2_2
X_1709_ _2267_/C _1709_/A2 _1710_/I0 VDD VDD VSS VSS gf180mcu_fd_sc_mcu7t5v0__nor2_1
X_2689_ _2689_/A1 _2687_/Z _2689_/A3 _3256_/D VDD VDD VSS VSS gf180mcu_fd_sc_mcu7t5v0__nand3_1
XFILLER_58_101 VDD VDD VSS VSS gf180mcu_fd_sc_mcu7t5v0__fillcap_4
XFILLER_86_465 VDD VDD VSS VSS gf180mcu_fd_sc_mcu7t5v0__fill_2
XFILLER_58_156 VDD VDD VSS VSS gf180mcu_fd_sc_mcu7t5v0__fillcap_16
XFILLER_74_649 VDD VDD VSS VSS gf180mcu_fd_sc_mcu7t5v0__fillcap_16
XTAP_TAPCELL_ROW_57_836 VDD VSS gf180mcu_fd_sc_mcu7t5v0__filltie
XTAP_TAPCELL_ROW_29_538 VDD VSS gf180mcu_fd_sc_mcu7t5v0__filltie
XFILLER_82_660 VDD VDD VSS VSS gf180mcu_fd_sc_mcu7t5v0__fillcap_4
XTAP_TAPCELL_ROW_103_1319 VDD VSS gf180mcu_fd_sc_mcu7t5v0__filltie
XFILLER_42_535 VDD VDD VSS VSS gf180mcu_fd_sc_mcu7t5v0__fillcap_4
XFILLER_23_760 VDD VDD VSS VSS gf180mcu_fd_sc_mcu7t5v0__fillcap_4
XFILLER_108_342 VDD VDD VSS VSS gf180mcu_fd_sc_mcu7t5v0__fillcap_32
XFILLER_2_620 VDD VDD VSS VSS gf180mcu_fd_sc_mcu7t5v0__fillcap_4
XFILLER_2_664 VDD VDD VSS VSS gf180mcu_fd_sc_mcu7t5v0__fill_1
XFILLER_77_487 VDD VDD VSS VSS gf180mcu_fd_sc_mcu7t5v0__fill_2
XFILLER_37_318 VDD VDD VSS VSS gf180mcu_fd_sc_mcu7t5v0__fill_1
XFILLER_65_638 VDD VDD VSS VSS gf180mcu_fd_sc_mcu7t5v0__fill_1
XFILLER_92_457 VDD VDD VSS VSS gf180mcu_fd_sc_mcu7t5v0__fillcap_8
XFILLER_33_557 VDD VDD VSS VSS gf180mcu_fd_sc_mcu7t5v0__fill_2
X_1991_ _1991_/A1 _2000_/A2 _1999_/S VDD VDD VSS VSS gf180mcu_fd_sc_mcu7t5v0__nand2_1
XFILLER_60_387 VDD VDD VSS VSS gf180mcu_fd_sc_mcu7t5v0__fillcap_16
X_2612_ _3247_/Q _2680_/C _2732_/A3 _2612_/B2 _2619_/A1 VDD VDD VSS VSS gf180mcu_fd_sc_mcu7t5v0__aoi22_1
Xclkload11 _3271_/CLK clkload11/Z VDD VDD VSS VSS gf180mcu_fd_sc_mcu7t5v0__clkbuf_1
XFILLER_9_296 VDD VDD VSS VSS gf180mcu_fd_sc_mcu7t5v0__fillcap_8
Xclkload44 _3286_/CLK clkload44/ZN VDD VDD VSS VSS gf180mcu_fd_sc_mcu7t5v0__inv_2
Xclkload22 _3410_/CLK clkload22/ZN VDD VDD VSS VSS gf180mcu_fd_sc_mcu7t5v0__clkinv_2
Xclkload33 _3285_/CLK clkload33/ZN VDD VDD VSS VSS gf180mcu_fd_sc_mcu7t5v0__clkinv_2
Xclkload66 _3408_/CLK clkload66/ZN VDD VDD VSS VSS gf180mcu_fd_sc_mcu7t5v0__inv_2
XTAP_TAPCELL_ROW_93_1212 VDD VSS gf180mcu_fd_sc_mcu7t5v0__filltie
X_2543_ _3166_/Q _3206_/Q _2569_/S _3206_/D VDD VDD VSS VSS gf180mcu_fd_sc_mcu7t5v0__mux2_2
XFILLER_55_2 VDD VDD VSS VSS gf180mcu_fd_sc_mcu7t5v0__fillcap_4
Xclkload55 _2796_/CLK clkload55/ZN VDD VDD VSS VSS gf180mcu_fd_sc_mcu7t5v0__clkinv_8
X_2474_ _3324_/Q _3150_/Q _2480_/S _3150_/D VDD VDD VSS VSS gf180mcu_fd_sc_mcu7t5v0__mux2_2
X_1425_ _3417_/D _2182_/A1 VDD VDD VSS VSS gf180mcu_fd_sc_mcu7t5v0__clkinv_1
XFILLER_96_741 VDD VDD VSS VSS gf180mcu_fd_sc_mcu7t5v0__fill_2
XFILLER_56_605 VDD VDD VSS VSS gf180mcu_fd_sc_mcu7t5v0__fill_2
XFILLER_18_18 VDD VDD VSS VSS gf180mcu_fd_sc_mcu7t5v0__fill_2
XFILLER_28_329 VDD VDD VSS VSS gf180mcu_fd_sc_mcu7t5v0__fill_2
X_3026_ _3026_/D _3416_/RN _3419_/CLK _3026_/Q VDD VDD VSS VSS gf180mcu_fd_sc_mcu7t5v0__dffrnq_1
XTAP_TAPCELL_ROW_26_508 VDD VSS gf180mcu_fd_sc_mcu7t5v0__filltie
XTAP_TAPCELL_ROW_54_806 VDD VSS gf180mcu_fd_sc_mcu7t5v0__filltie
XFILLER_70_107 VDD VDD VSS VSS gf180mcu_fd_sc_mcu7t5v0__fill_1
XFILLER_36_373 VDD VDD VSS VSS gf180mcu_fd_sc_mcu7t5v0__fillcap_8
XPHY_EDGE_ROW_90_Left_199 VDD VSS gf180mcu_fd_sc_mcu7t5v0__endcap
XTAP_TAPCELL_ROW_62_883 VDD VSS gf180mcu_fd_sc_mcu7t5v0__filltie
XFILLER_20_752 VDD VDD VSS VSS gf180mcu_fd_sc_mcu7t5v0__fillcap_8
XTAP_TAPCELL_ROW_34_596 VDD VSS gf180mcu_fd_sc_mcu7t5v0__filltie
Xclkload5 clkload5/I clkload5/ZN VDD VDD VSS VSS gf180mcu_fd_sc_mcu7t5v0__clkinv_8
XFILLER_59_69 VDD VDD VSS VSS gf180mcu_fd_sc_mcu7t5v0__fill_1
XFILLER_47_605 VDD VDD VSS VSS gf180mcu_fd_sc_mcu7t5v0__fillcap_16
XFILLER_101_562 VDD VDD VSS VSS gf180mcu_fd_sc_mcu7t5v0__fillcap_64
XTAP_TAPCELL_ROW_6_299 VDD VSS gf180mcu_fd_sc_mcu7t5v0__filltie
XFILLER_46_104 VDD VDD VSS VSS gf180mcu_fd_sc_mcu7t5v0__fill_1
XFILLER_47_638 VDD VDD VSS VSS gf180mcu_fd_sc_mcu7t5v0__fill_1
Xload_slew39 input1/Z _3416_/RN VDD VDD VSS VSS gf180mcu_fd_sc_mcu7t5v0__buf_20
Xload_slew28 _3391_/Q _1439_/B VDD VDD VSS VSS gf180mcu_fd_sc_mcu7t5v0__buf_4
XFILLER_75_57 VDD VDD VSS VSS gf180mcu_fd_sc_mcu7t5v0__fill_2
XFILLER_74_457 VDD VDD VSS VSS gf180mcu_fd_sc_mcu7t5v0__fillcap_4
XFILLER_27_362 VDD VDD VSS VSS gf180mcu_fd_sc_mcu7t5v0__fill_1
XFILLER_15_568 VDD VDD VSS VSS gf180mcu_fd_sc_mcu7t5v0__fill_1
XFILLER_70_663 VDD VDD VSS VSS gf180mcu_fd_sc_mcu7t5v0__fill_2
XFILLER_30_527 VDD VDD VSS VSS gf180mcu_fd_sc_mcu7t5v0__fillcap_4
XFILLER_6_244 VDD VDD VSS VSS gf180mcu_fd_sc_mcu7t5v0__fill_1
XFILLER_108_172 VDD VDD VSS VSS gf180mcu_fd_sc_mcu7t5v0__fillcap_32
X_2190_ _2424_/A1 _2434_/B _2224_/B _3107_/Q _2190_/C _2196_/A1 VDD VDD VSS VSS gf180mcu_fd_sc_mcu7t5v0__oai221_1
XFILLER_77_262 VDD VDD VSS VSS gf180mcu_fd_sc_mcu7t5v0__fillcap_4
XFILLER_65_402 VDD VDD VSS VSS gf180mcu_fd_sc_mcu7t5v0__fillcap_16
XFILLER_92_221 VDD VDD VSS VSS gf180mcu_fd_sc_mcu7t5v0__fillcap_8
XFILLER_18_362 VDD VDD VSS VSS gf180mcu_fd_sc_mcu7t5v0__fillcap_4
XFILLER_52_107 VDD VDD VSS VSS gf180mcu_fd_sc_mcu7t5v0__fillcap_32
XFILLER_92_287 VDD VDD VSS VSS gf180mcu_fd_sc_mcu7t5v0__fillcap_8
XFILLER_18_373 VDD VDD VSS VSS gf180mcu_fd_sc_mcu7t5v0__fillcap_8
XFILLER_60_173 VDD VDD VSS VSS gf180mcu_fd_sc_mcu7t5v0__fill_2
X_1974_ _2991_/Q _3111_/Q _1981_/S _2991_/D VDD VDD VSS VSS gf180mcu_fd_sc_mcu7t5v0__mux2_2
XTAP_TAPCELL_ROW_31_555 VDD VSS gf180mcu_fd_sc_mcu7t5v0__filltie
X_2526_ _3189_/Q _3181_/Q _2534_/S _3189_/D VDD VDD VSS VSS gf180mcu_fd_sc_mcu7t5v0__mux2_2
XFILLER_102_304 VDD VDD VSS VSS gf180mcu_fd_sc_mcu7t5v0__fill_1
XFILLER_88_527 VDD VDD VSS VSS gf180mcu_fd_sc_mcu7t5v0__fillcap_32
X_2457_ _2468_/B _2457_/A2 _2457_/A3 _2457_/Z VDD VDD VSS VSS gf180mcu_fd_sc_mcu7t5v0__and3_1
X_1408_ _3126_/Q _2289_/B2 VDD VDD VSS VSS gf180mcu_fd_sc_mcu7t5v0__clkinv_1
XFILLER_69_763 VDD VDD VSS VSS gf180mcu_fd_sc_mcu7t5v0__fill_2
X_2388_ _2828_/Q _2820_/Q _2812_/Q _2804_/Q _2388_/S0 _2388_/S1 _2388_/Z VDD VDD VSS
+ VSS gf180mcu_fd_sc_mcu7t5v0__mux4_1
XFILLER_29_627 VDD VDD VSS VSS gf180mcu_fd_sc_mcu7t5v0__fill_2
XTAP_TAPCELL_ROW_3_269 VDD VSS gf180mcu_fd_sc_mcu7t5v0__filltie
XTAP_TAPCELL_ROW_39_644 VDD VSS gf180mcu_fd_sc_mcu7t5v0__filltie
XFILLER_56_457 VDD VDD VSS VSS gf180mcu_fd_sc_mcu7t5v0__fillcap_4
XTAP_TAPCELL_ROW_67_942 VDD VSS gf180mcu_fd_sc_mcu7t5v0__filltie
XFILLER_44_608 VDD VDD VSS VSS gf180mcu_fd_sc_mcu7t5v0__fill_2
XFILLER_83_298 VDD VDD VSS VSS gf180mcu_fd_sc_mcu7t5v0__fillcap_8
X_3009_ _3009_/D _3022_/CLK _3009_/Q VDD VDD VSS VSS gf180mcu_fd_sc_mcu7t5v0__dffq_1
XFILLER_36_170 VDD VDD VSS VSS gf180mcu_fd_sc_mcu7t5v0__fillcap_4
XFILLER_37_671 VDD VDD VSS VSS gf180mcu_fd_sc_mcu7t5v0__fillcap_16
XFILLER_52_663 VDD VDD VSS VSS gf180mcu_fd_sc_mcu7t5v0__fill_2
XFILLER_101_66 VDD VDD VSS VSS gf180mcu_fd_sc_mcu7t5v0__fillcap_4
XFILLER_12_527 VDD VDD VSS VSS gf180mcu_fd_sc_mcu7t5v0__fill_2
XFILLER_12_505 VDD VDD VSS VSS gf180mcu_fd_sc_mcu7t5v0__fillcap_16
XFILLER_20_593 VDD VDD VSS VSS gf180mcu_fd_sc_mcu7t5v0__fill_2
XFILLER_4_737 VDD VDD VSS VSS gf180mcu_fd_sc_mcu7t5v0__fillcap_16
XFILLER_105_142 VDD VDD VSS VSS gf180mcu_fd_sc_mcu7t5v0__fillcap_32
XFILLER_10_52 VDD VDD VSS VSS gf180mcu_fd_sc_mcu7t5v0__fillcap_4
XFILLER_87_582 VDD VDD VSS VSS gf180mcu_fd_sc_mcu7t5v0__fillcap_8
XFILLER_19_72 VDD VDD VSS VSS gf180mcu_fd_sc_mcu7t5v0__fillcap_16
XFILLER_28_671 VDD VDD VSS VSS gf180mcu_fd_sc_mcu7t5v0__fill_1
XFILLER_30_313 VDD VDD VSS VSS gf180mcu_fd_sc_mcu7t5v0__fill_2
XFILLER_70_482 VDD VDD VSS VSS gf180mcu_fd_sc_mcu7t5v0__fill_2
XFILLER_30_357 VDD VDD VSS VSS gf180mcu_fd_sc_mcu7t5v0__fillcap_4
XFILLER_7_553 VDD VDD VSS VSS gf180mcu_fd_sc_mcu7t5v0__fillcap_4
X_1690_ _3134_/Q _3135_/Q _3137_/Q _1690_/Z VDD VDD VSS VSS gf180mcu_fd_sc_mcu7t5v0__and3_1
XFILLER_7_586 VDD VDD VSS VSS gf180mcu_fd_sc_mcu7t5v0__fill_1
X_3360_ _3360_/D _3369_/RN _3369_/CLK _3360_/Q VDD VDD VSS VSS gf180mcu_fd_sc_mcu7t5v0__dffrnq_1
X_2311_ _2424_/A1 _2316_/A2 _2313_/A1 _2314_/B2 VDD VDD VSS VSS gf180mcu_fd_sc_mcu7t5v0__nor3_1
X_3291_ _3291_/D _3303_/RN clkload9/I _3291_/Q VDD VDD VSS VSS gf180mcu_fd_sc_mcu7t5v0__dffrnq_1
X_2242_ _3137_/Q _3117_/Q _2242_/S _3117_/D VDD VDD VSS VSS gf180mcu_fd_sc_mcu7t5v0__mux2_2
XFILLER_78_593 VDD VDD VSS VSS gf180mcu_fd_sc_mcu7t5v0__fill_2
XFILLER_18_2 VDD VDD VSS VSS gf180mcu_fd_sc_mcu7t5v0__fillcap_16
X_2173_ _3099_/Q _3217_/Q _2178_/S _3099_/D VDD VDD VSS VSS gf180mcu_fd_sc_mcu7t5v0__mux2_2
XTAP_TAPCELL_ROW_88_1155 VDD VSS gf180mcu_fd_sc_mcu7t5v0__filltie
XFILLER_38_457 VDD VDD VSS VSS gf180mcu_fd_sc_mcu7t5v0__fillcap_16
XTAP_TAPCELL_ROW_64_901 VDD VSS gf180mcu_fd_sc_mcu7t5v0__filltie
XFILLER_80_202 VDD VDD VSS VSS gf180mcu_fd_sc_mcu7t5v0__fillcap_16
XTAP_TAPCELL_ROW_0_228 VDD VSS gf180mcu_fd_sc_mcu7t5v0__filltie
XTAP_TAPCELL_ROW_0_239 VDD VSS gf180mcu_fd_sc_mcu7t5v0__filltie
XTAP_TAPCELL_ROW_36_614 VDD VSS gf180mcu_fd_sc_mcu7t5v0__filltie
XFILLER_53_438 VDD VDD VSS VSS gf180mcu_fd_sc_mcu7t5v0__fillcap_8
XFILLER_65_276 VDD VDD VSS VSS gf180mcu_fd_sc_mcu7t5v0__fillcap_4
XFILLER_34_641 VDD VDD VSS VSS gf180mcu_fd_sc_mcu7t5v0__fillcap_16
XFILLER_61_460 VDD VDD VSS VSS gf180mcu_fd_sc_mcu7t5v0__fill_1
XFILLER_21_335 VDD VDD VSS VSS gf180mcu_fd_sc_mcu7t5v0__fillcap_8
XTAP_TAPCELL_ROW_44_691 VDD VSS gf180mcu_fd_sc_mcu7t5v0__filltie
X_1957_ _3113_/Q _2977_/Q _1962_/S _2977_/D VDD VDD VSS VSS gf180mcu_fd_sc_mcu7t5v0__mux2_2
XFILLER_31_18 VDD VDD VSS VSS gf180mcu_fd_sc_mcu7t5v0__fillcap_8
XTAP_TAPCELL_ROW_99_1273 VDD VSS gf180mcu_fd_sc_mcu7t5v0__filltie
X_1888_ _3365_/Q _3364_/Q _2245_/A1 _3369_/Q _2000_/A1 VDD VDD VSS VSS gf180mcu_fd_sc_mcu7t5v0__nor4_1
XTAP_TAPCELL_ROW_8_317 VDD VSS gf180mcu_fd_sc_mcu7t5v0__filltie
XFILLER_103_613 VDD VDD VSS VSS gf180mcu_fd_sc_mcu7t5v0__fill_2
XFILLER_102_101 VDD VDD VSS VSS gf180mcu_fd_sc_mcu7t5v0__fillcap_4
XFILLER_0_206 VDD VDD VSS VSS gf180mcu_fd_sc_mcu7t5v0__fillcap_32
X_2509_ _3172_/Q _3324_/Q _2534_/S _3172_/D VDD VDD VSS VSS gf180mcu_fd_sc_mcu7t5v0__mux2_2
XFILLER_102_145 VDD VDD VSS VSS gf180mcu_fd_sc_mcu7t5v0__fill_1
XFILLER_56_37 VDD VDD VSS VSS gf180mcu_fd_sc_mcu7t5v0__fillcap_16
XFILLER_57_755 VDD VDD VSS VSS gf180mcu_fd_sc_mcu7t5v0__fillcap_8
XTAP_TAPCELL_ROW_108_1380 VDD VSS gf180mcu_fd_sc_mcu7t5v0__filltie
XFILLER_71_279 VDD VDD VSS VSS gf180mcu_fd_sc_mcu7t5v0__fill_1
XFILLER_12_357 VDD VDD VSS VSS gf180mcu_fd_sc_mcu7t5v0__fillcap_4
XFILLER_8_317 VDD VDD VSS VSS gf180mcu_fd_sc_mcu7t5v0__fill_1
XFILLER_4_523 VDD VDD VSS VSS gf180mcu_fd_sc_mcu7t5v0__fill_2
XFILLER_21_51 VDD VDD VSS VSS gf180mcu_fd_sc_mcu7t5v0__fillcap_16
XFILLER_106_440 VDD VDD VSS VSS gf180mcu_fd_sc_mcu7t5v0__fillcap_8
XFILLER_79_302 VDD VDD VSS VSS gf180mcu_fd_sc_mcu7t5v0__fill_1
XFILLER_97_77 VDD VDD VSS VSS gf180mcu_fd_sc_mcu7t5v0__fill_1
XFILLER_0_762 VDD VDD VSS VSS gf180mcu_fd_sc_mcu7t5v0__fill_2
XFILLER_48_711 VDD VDD VSS VSS gf180mcu_fd_sc_mcu7t5v0__fill_1
XFILLER_94_327 VDD VDD VSS VSS gf180mcu_fd_sc_mcu7t5v0__fill_1
XFILLER_35_405 VDD VDD VSS VSS gf180mcu_fd_sc_mcu7t5v0__fillcap_8
XFILLER_47_243 VDD VDD VSS VSS gf180mcu_fd_sc_mcu7t5v0__fillcap_4
XFILLER_90_500 VDD VDD VSS VSS gf180mcu_fd_sc_mcu7t5v0__fillcap_16
XFILLER_63_747 VDD VDD VSS VSS gf180mcu_fd_sc_mcu7t5v0__fillcap_16
XFILLER_90_555 VDD VDD VSS VSS gf180mcu_fd_sc_mcu7t5v0__fill_2
XFILLER_62_279 VDD VDD VSS VSS gf180mcu_fd_sc_mcu7t5v0__fillcap_4
XFILLER_30_121 VDD VDD VSS VSS gf180mcu_fd_sc_mcu7t5v0__fill_1
XFILLER_31_644 VDD VDD VSS VSS gf180mcu_fd_sc_mcu7t5v0__fillcap_32
X_2860_ _2860_/D _3315_/CLK _2860_/Q VDD VDD VSS VSS gf180mcu_fd_sc_mcu7t5v0__dffq_1
X_1811_ _3285_/Q _2852_/Q _1813_/S _2852_/D VDD VDD VSS VSS gf180mcu_fd_sc_mcu7t5v0__mux2_2
XTAP_TAPCELL_ROW_13_374 VDD VSS gf180mcu_fd_sc_mcu7t5v0__filltie
XTAP_TAPCELL_ROW_41_661 VDD VSS gf180mcu_fd_sc_mcu7t5v0__filltie
X_2791_ _2791_/D _3406_/CLK _2791_/Q VDD VDD VSS VSS gf180mcu_fd_sc_mcu7t5v0__dffq_1
XFILLER_11_390 VDD VDD VSS VSS gf180mcu_fd_sc_mcu7t5v0__fill_1
X_1742_ _3281_/Q _2792_/Q _1748_/S _2792_/D VDD VDD VSS VSS gf180mcu_fd_sc_mcu7t5v0__mux2_2
X_1673_ _2766_/Q _2222_/B2 _2426_/A1 VDD VDD VSS VSS gf180mcu_fd_sc_mcu7t5v0__nor2_1
X_3412_ _3418_/Q _3416_/RN _3423_/CLK _3412_/Q VDD VDD VSS VSS gf180mcu_fd_sc_mcu7t5v0__dffsnq_1
XFILLER_98_644 VDD VDD VSS VSS gf180mcu_fd_sc_mcu7t5v0__fill_1
X_3343_ _3362_/Q input1/Z _3352_/CLK hold47/I VDD VDD VSS VSS gf180mcu_fd_sc_mcu7t5v0__dffrnq_1
X_3274_ _3274_/D _3328_/RN _3329_/CLK _3274_/Q VDD VDD VSS VSS gf180mcu_fd_sc_mcu7t5v0__dffrnq_1
XFILLER_58_508 VDD VDD VSS VSS gf180mcu_fd_sc_mcu7t5v0__fill_2
X_2225_ _1679_/C _2226_/A3 _2251_/C _2230_/S VDD VDD VSS VSS gf180mcu_fd_sc_mcu7t5v0__nor3_1
XFILLER_38_232 VDD VDD VSS VSS gf180mcu_fd_sc_mcu7t5v0__fillcap_8
XTAP_TAPCELL_ROW_49_750 VDD VSS gf180mcu_fd_sc_mcu7t5v0__filltie
XFILLER_66_563 VDD VDD VSS VSS gf180mcu_fd_sc_mcu7t5v0__fillcap_32
XFILLER_93_360 VDD VDD VSS VSS gf180mcu_fd_sc_mcu7t5v0__fill_1
X_2156_ _3235_/Q _3085_/Q _2165_/S _3085_/D VDD VDD VSS VSS gf180mcu_fd_sc_mcu7t5v0__mux2_2
XPHY_EDGE_ROW_5_Right_5 VDD VSS gf180mcu_fd_sc_mcu7t5v0__endcap
X_2087_ _2394_/A2 _2091_/B _2087_/B1 _2087_/B2 _3047_/D VDD VDD VSS VSS gf180mcu_fd_sc_mcu7t5v0__aoi22_1
XFILLER_41_419 VDD VDD VSS VSS gf180mcu_fd_sc_mcu7t5v0__fill_1
XFILLER_21_154 VDD VDD VSS VSS gf180mcu_fd_sc_mcu7t5v0__fill_1
XFILLER_61_290 VDD VDD VSS VSS gf180mcu_fd_sc_mcu7t5v0__fillcap_4
X_2989_ _2989_/D _3020_/CLK _2989_/Q VDD VDD VSS VSS gf180mcu_fd_sc_mcu7t5v0__dffq_1
XFILLER_108_716 VDD VDD VSS VSS gf180mcu_fd_sc_mcu7t5v0__fillcap_32
XFILLER_107_259 VDD VDD VSS VSS gf180mcu_fd_sc_mcu7t5v0__fillcap_16
XFILLER_103_487 VDD VDD VSS VSS gf180mcu_fd_sc_mcu7t5v0__fill_2
XFILLER_29_221 VDD VDD VSS VSS gf180mcu_fd_sc_mcu7t5v0__fillcap_16
XFILLER_84_382 VDD VDD VSS VSS gf180mcu_fd_sc_mcu7t5v0__fill_2
XFILLER_84_371 VDD VDD VSS VSS gf180mcu_fd_sc_mcu7t5v0__fill_2
XFILLER_57_585 VDD VDD VSS VSS gf180mcu_fd_sc_mcu7t5v0__fillcap_4
XFILLER_83_57 VDD VDD VSS VSS gf180mcu_fd_sc_mcu7t5v0__fill_2
XFILLER_17_438 VDD VDD VSS VSS gf180mcu_fd_sc_mcu7t5v0__fillcap_8
XFILLER_60_739 VDD VDD VSS VSS gf180mcu_fd_sc_mcu7t5v0__fill_1
XFILLER_12_143 VDD VDD VSS VSS gf180mcu_fd_sc_mcu7t5v0__fill_2
XFILLER_13_699 VDD VDD VSS VSS gf180mcu_fd_sc_mcu7t5v0__fill_1
XTAP_TAPCELL_ROW_10_344 VDD VSS gf180mcu_fd_sc_mcu7t5v0__filltie
XTAP_TAPCELL_ROW_74_1007 VDD VSS gf180mcu_fd_sc_mcu7t5v0__filltie
XFILLER_99_419 VDD VDD VSS VSS gf180mcu_fd_sc_mcu7t5v0__fill_1
XFILLER_79_121 VDD VDD VSS VSS gf180mcu_fd_sc_mcu7t5v0__fillcap_16
XFILLER_94_102 VDD VDD VSS VSS gf180mcu_fd_sc_mcu7t5v0__fill_2
XFILLER_0_570 VDD VDD VSS VSS gf180mcu_fd_sc_mcu7t5v0__fillcap_8
X_2010_ _3039_/Q _2031_/A2 _2267_/C _2010_/Z VDD VDD VSS VSS gf180mcu_fd_sc_mcu7t5v0__or3_1
XFILLER_75_382 VDD VDD VSS VSS gf180mcu_fd_sc_mcu7t5v0__fill_2
XFILLER_48_585 VDD VDD VSS VSS gf180mcu_fd_sc_mcu7t5v0__fillcap_8
XFILLER_63_500 VDD VDD VSS VSS gf180mcu_fd_sc_mcu7t5v0__fill_2
XTAP_TAPCELL_ROW_85_1125 VDD VSS gf180mcu_fd_sc_mcu7t5v0__filltie
XTAP_TAPCELL_ROW_18_422 VDD VSS gf180mcu_fd_sc_mcu7t5v0__filltie
XTAP_TAPCELL_ROW_46_720 VDD VSS gf180mcu_fd_sc_mcu7t5v0__filltie
XFILLER_63_533 VDD VDD VSS VSS gf180mcu_fd_sc_mcu7t5v0__fill_2
XFILLER_90_374 VDD VDD VSS VSS gf180mcu_fd_sc_mcu7t5v0__fillcap_8
XFILLER_51_706 VDD VDD VSS VSS gf180mcu_fd_sc_mcu7t5v0__fill_1
X_2912_ _2912_/D _2926_/CLK _2912_/Q VDD VDD VSS VSS gf180mcu_fd_sc_mcu7t5v0__dffq_1
XFILLER_85_2 VDD VDD VSS VSS gf180mcu_fd_sc_mcu7t5v0__fillcap_4
X_2843_ _2843_/D _2892_/CLK _2843_/Q VDD VDD VSS VSS gf180mcu_fd_sc_mcu7t5v0__dffq_1
X_2774_ _2774_/D _2828_/CLK _2774_/Q VDD VDD VSS VSS gf180mcu_fd_sc_mcu7t5v0__dffq_1
XTAP_TAPCELL_ROW_96_1243 VDD VSS gf180mcu_fd_sc_mcu7t5v0__filltie
X_1725_ _2779_/Q _3284_/Q _1728_/S _2779_/D VDD VDD VSS VSS gf180mcu_fd_sc_mcu7t5v0__mux2_2
X_1656_ _1646_/Z _1656_/A2 _2218_/B _2429_/B VDD VDD VSS VSS gf180mcu_fd_sc_mcu7t5v0__oai21_1
X_1587_ _3349_/Q _3359_/D _1587_/Z VDD VDD VSS VSS gf180mcu_fd_sc_mcu7t5v0__xor2_1
X_3326_ _3326_/D _3369_/RN _3326_/CLK _3326_/Q VDD VDD VSS VSS gf180mcu_fd_sc_mcu7t5v0__dffrnq_1
XFILLER_85_124 VDD VDD VSS VSS gf180mcu_fd_sc_mcu7t5v0__fill_1
XFILLER_58_349 VDD VDD VSS VSS gf180mcu_fd_sc_mcu7t5v0__fillcap_16
XFILLER_100_457 VDD VDD VSS VSS gf180mcu_fd_sc_mcu7t5v0__fillcap_32
Xclkbuf_leaf_50_clk_i clkload0/I _3327_/CLK VDD VDD VSS VSS gf180mcu_fd_sc_mcu7t5v0__clkbuf_4
X_3257_ _3257_/D _3328_/RN _3257_/CLK _3257_/Q VDD VDD VSS VSS gf180mcu_fd_sc_mcu7t5v0__dffrnq_1
XFILLER_39_541 VDD VDD VSS VSS gf180mcu_fd_sc_mcu7t5v0__fill_1
X_2208_ _2798_/Q _2790_/Q _2782_/Q _2774_/Q _2388_/S0 _2388_/S1 _2208_/Z VDD VDD VSS
+ VSS gf180mcu_fd_sc_mcu7t5v0__mux4_1
X_3188_ _3188_/D _3369_/RN _3327_/CLK _3188_/Q VDD VDD VSS VSS gf180mcu_fd_sc_mcu7t5v0__dffrnq_1
X_2139_ _3218_/Q _3068_/Q _2166_/S _3068_/D VDD VDD VSS VSS gf180mcu_fd_sc_mcu7t5v0__mux2_2
XFILLER_54_588 VDD VDD VSS VSS gf180mcu_fd_sc_mcu7t5v0__fillcap_4
XFILLER_22_430 VDD VDD VSS VSS gf180mcu_fd_sc_mcu7t5v0__fillcap_8
XTAP_TAPCELL_ROW_52_778 VDD VSS gf180mcu_fd_sc_mcu7t5v0__filltie
XFILLER_10_658 VDD VDD VSS VSS gf180mcu_fd_sc_mcu7t5v0__fillcap_4
XFILLER_1_345 VDD VDD VSS VSS gf180mcu_fd_sc_mcu7t5v0__fillcap_4
XFILLER_49_305 VDD VDD VSS VSS gf180mcu_fd_sc_mcu7t5v0__fillcap_8
XFILLER_77_636 VDD VDD VSS VSS gf180mcu_fd_sc_mcu7t5v0__fill_2
Xclkbuf_leaf_18_clk_i clkload1/I _3424_/CLK VDD VDD VSS VSS gf180mcu_fd_sc_mcu7t5v0__clkbuf_4
XFILLER_49_349 VDD VDD VSS VSS gf180mcu_fd_sc_mcu7t5v0__fill_1
XFILLER_45_500 VDD VDD VSS VSS gf180mcu_fd_sc_mcu7t5v0__fillcap_4
XFILLER_27_61 VDD VDD VSS VSS gf180mcu_fd_sc_mcu7t5v0__fillcap_8
XFILLER_27_72 VDD VDD VSS VSS gf180mcu_fd_sc_mcu7t5v0__fillcap_16
XFILLER_45_577 VDD VDD VSS VSS gf180mcu_fd_sc_mcu7t5v0__fill_2
XFILLER_9_401 VDD VDD VSS VSS gf180mcu_fd_sc_mcu7t5v0__fillcap_4
XTAP_TAPCELL_ROW_80_1077 VDD VSS gf180mcu_fd_sc_mcu7t5v0__filltie
XFILLER_9_467 VDD VDD VSS VSS gf180mcu_fd_sc_mcu7t5v0__fillcap_8
XTAP_TAPCELL_ROW_23_480 VDD VSS gf180mcu_fd_sc_mcu7t5v0__filltie
X_2490_ _3160_/Q _2508_/A1 _2490_/B _3160_/D VDD VDD VSS VSS gf180mcu_fd_sc_mcu7t5v0__oai21_1
X_1510_ _3308_/Q _2414_/B _1569_/B VDD VDD VSS VSS gf180mcu_fd_sc_mcu7t5v0__nand2_1
X_1441_ _3392_/Q _1441_/A2 _3396_/D VDD VDD VSS VSS gf180mcu_fd_sc_mcu7t5v0__xnor2_1
XFILLER_95_422 VDD VDD VSS VSS gf180mcu_fd_sc_mcu7t5v0__fillcap_16
X_1372_ _2764_/Q _2202_/A1 VDD VDD VSS VSS gf180mcu_fd_sc_mcu7t5v0__clkinv_1
X_3111_ _3111_/D _3297_/CLK _3111_/Q VDD VDD VSS VSS gf180mcu_fd_sc_mcu7t5v0__dffq_1
XFILLER_67_135 VDD VDD VSS VSS gf180mcu_fd_sc_mcu7t5v0__fillcap_4
XFILLER_68_658 VDD VDD VSS VSS gf180mcu_fd_sc_mcu7t5v0__fillcap_4
X_3042_ _3042_/D _3303_/RN _3308_/CLK _3042_/Q VDD VDD VSS VSS gf180mcu_fd_sc_mcu7t5v0__dffrnq_1
XFILLER_82_149 VDD VDD VSS VSS gf180mcu_fd_sc_mcu7t5v0__fillcap_4
XFILLER_23_216 VDD VDD VSS VSS gf180mcu_fd_sc_mcu7t5v0__fill_1
XFILLER_90_193 VDD VDD VSS VSS gf180mcu_fd_sc_mcu7t5v0__fillcap_8
XFILLER_32_750 VDD VDD VSS VSS gf180mcu_fd_sc_mcu7t5v0__fillcap_8
XFILLER_51_558 VDD VDD VSS VSS gf180mcu_fd_sc_mcu7t5v0__fill_2
X_2826_ _2826_/D _2894_/CLK _2826_/Q VDD VDD VSS VSS gf180mcu_fd_sc_mcu7t5v0__dffq_1
XFILLER_31_282 VDD VDD VSS VSS gf180mcu_fd_sc_mcu7t5v0__fillcap_16
XTAP_TAPCELL_ROW_100_1280 VDD VSS gf180mcu_fd_sc_mcu7t5v0__filltie
X_2757_ _3215_/Q _3297_/Q _2760_/S _3297_/D VDD VDD VSS VSS gf180mcu_fd_sc_mcu7t5v0__mux2_2
X_1708_ _1708_/A1 _2214_/A2 _1708_/A3 _2298_/B _1709_/A2 VDD VDD VSS VSS gf180mcu_fd_sc_mcu7t5v0__nor4_1
X_2688_ _3142_/Q _2732_/A3 _2603_/Z _2689_/A3 VDD VDD VSS VSS gf180mcu_fd_sc_mcu7t5v0__nand3_1
X_1639_ _2424_/A1 _1637_/Z _2188_/C VDD VDD VSS VSS gf180mcu_fd_sc_mcu7t5v0__nand2_1
XFILLER_86_411 VDD VDD VSS VSS gf180mcu_fd_sc_mcu7t5v0__fill_2
XFILLER_59_636 VDD VDD VSS VSS gf180mcu_fd_sc_mcu7t5v0__fill_1
XFILLER_101_755 VDD VDD VSS VSS gf180mcu_fd_sc_mcu7t5v0__fillcap_8
X_3309_ _3309_/D _3416_/RN _3311_/CLK _3309_/Q VDD VDD VSS VSS gf180mcu_fd_sc_mcu7t5v0__dffrnq_1
XPHY_EDGE_ROW_100_Left_209 VDD VSS gf180mcu_fd_sc_mcu7t5v0__endcap
XFILLER_39_360 VDD VDD VSS VSS gf180mcu_fd_sc_mcu7t5v0__fillcap_8
XTAP_TAPCELL_ROW_57_837 VDD VSS gf180mcu_fd_sc_mcu7t5v0__filltie
XFILLER_73_105 VDD VDD VSS VSS gf180mcu_fd_sc_mcu7t5v0__fillcap_4
XTAP_TAPCELL_ROW_29_539 VDD VSS gf180mcu_fd_sc_mcu7t5v0__filltie
XFILLER_67_691 VDD VDD VSS VSS gf180mcu_fd_sc_mcu7t5v0__fillcap_8
XFILLER_73_127 VDD VDD VSS VSS gf180mcu_fd_sc_mcu7t5v0__fillcap_4
XFILLER_15_717 VDD VDD VSS VSS gf180mcu_fd_sc_mcu7t5v0__fillcap_4
XFILLER_64_37 VDD VDD VSS VSS gf180mcu_fd_sc_mcu7t5v0__fillcap_64
XFILLER_108_376 VDD VDD VSS VSS gf180mcu_fd_sc_mcu7t5v0__fillcap_4
XFILLER_1_142 VDD VDD VSS VSS gf180mcu_fd_sc_mcu7t5v0__fillcap_16
XFILLER_104_560 VDD VDD VSS VSS gf180mcu_fd_sc_mcu7t5v0__fillcap_4
XFILLER_77_422 VDD VDD VSS VSS gf180mcu_fd_sc_mcu7t5v0__fillcap_8
XFILLER_49_135 VDD VDD VSS VSS gf180mcu_fd_sc_mcu7t5v0__fillcap_4
XFILLER_92_403 VDD VDD VSS VSS gf180mcu_fd_sc_mcu7t5v0__fill_2
XFILLER_77_477 VDD VDD VSS VSS gf180mcu_fd_sc_mcu7t5v0__fill_1
XFILLER_45_352 VDD VDD VSS VSS gf180mcu_fd_sc_mcu7t5v0__fill_2
X_1990_ _3118_/Q _3006_/Q _1990_/S _3006_/D VDD VDD VSS VSS gf180mcu_fd_sc_mcu7t5v0__mux2_2
XFILLER_54_92 VDD VDD VSS VSS gf180mcu_fd_sc_mcu7t5v0__fillcap_8
XFILLER_60_344 VDD VDD VSS VSS gf180mcu_fd_sc_mcu7t5v0__fillcap_4
XFILLER_14_761 VDD VDD VSS VSS gf180mcu_fd_sc_mcu7t5v0__fillcap_4
XFILLER_13_282 VDD VDD VSS VSS gf180mcu_fd_sc_mcu7t5v0__fillcap_8
Xclkload34 _2984_/CLK clkload34/ZN VDD VDD VSS VSS gf180mcu_fd_sc_mcu7t5v0__inv_2
Xclkload12 _3276_/CLK clkload12/Z VDD VDD VSS VSS gf180mcu_fd_sc_mcu7t5v0__clkbuf_1
X_2611_ _2663_/B _2611_/A2 _2612_/B2 VDD VDD VSS VSS gf180mcu_fd_sc_mcu7t5v0__nand2_1
Xclkload23 _3425_/CLK clkload23/Z VDD VDD VSS VSS gf180mcu_fd_sc_mcu7t5v0__clkbuf_1
XTAP_TAPCELL_ROW_93_1213 VDD VSS gf180mcu_fd_sc_mcu7t5v0__filltie
X_2542_ _3165_/Q _3205_/Q _2569_/S _3205_/D VDD VDD VSS VSS gf180mcu_fd_sc_mcu7t5v0__mux2_2
Xclkload56 _3352_/CLK clkload56/ZN VDD VDD VSS VSS gf180mcu_fd_sc_mcu7t5v0__clkinv_8
Xclkload45 _2926_/CLK clkload45/Z VDD VDD VSS VSS gf180mcu_fd_sc_mcu7t5v0__clkbuf_1
XFILLER_5_492 VDD VDD VSS VSS gf180mcu_fd_sc_mcu7t5v0__fillcap_8
X_2473_ _2473_/A1 _2481_/A1 _2480_/S VDD VDD VSS VSS gf180mcu_fd_sc_mcu7t5v0__nand2_1
XFILLER_48_2 VDD VDD VSS VSS gf180mcu_fd_sc_mcu7t5v0__fillcap_32
XFILLER_96_720 VDD VDD VSS VSS gf180mcu_fd_sc_mcu7t5v0__fillcap_8
X_1424_ _3049_/Q _2092_/A1 VDD VDD VSS VSS gf180mcu_fd_sc_mcu7t5v0__clkinv_1
XFILLER_96_764 VDD VDD VSS VSS gf180mcu_fd_sc_mcu7t5v0__fill_1
XFILLER_68_488 VDD VDD VSS VSS gf180mcu_fd_sc_mcu7t5v0__fill_2
X_3025_ _3025_/D _3416_/RN _3416_/CLK _3025_/Q VDD VDD VSS VSS gf180mcu_fd_sc_mcu7t5v0__dffrnq_1
XFILLER_49_691 VDD VDD VSS VSS gf180mcu_fd_sc_mcu7t5v0__fill_1
XFILLER_24_503 VDD VDD VSS VSS gf180mcu_fd_sc_mcu7t5v0__fillcap_16
XTAP_TAPCELL_ROW_26_509 VDD VSS gf180mcu_fd_sc_mcu7t5v0__filltie
XFILLER_51_344 VDD VDD VSS VSS gf180mcu_fd_sc_mcu7t5v0__fillcap_4
XTAP_TAPCELL_ROW_34_586 VDD VSS gf180mcu_fd_sc_mcu7t5v0__filltie
XTAP_TAPCELL_ROW_62_884 VDD VSS gf180mcu_fd_sc_mcu7t5v0__filltie
XFILLER_20_731 VDD VDD VSS VSS gf180mcu_fd_sc_mcu7t5v0__fillcap_4
XFILLER_51_399 VDD VDD VSS VSS gf180mcu_fd_sc_mcu7t5v0__fillcap_4
XFILLER_20_764 VDD VDD VSS VSS gf180mcu_fd_sc_mcu7t5v0__fill_1
Xclkload6 clkload6/I clkload6/ZN VDD VDD VSS VSS gf180mcu_fd_sc_mcu7t5v0__inv_4
X_2809_ _2809_/D _2887_/CLK _2809_/Q VDD VDD VSS VSS gf180mcu_fd_sc_mcu7t5v0__dffq_1
XFILLER_105_368 VDD VDD VSS VSS gf180mcu_fd_sc_mcu7t5v0__fillcap_8
XFILLER_105_346 VDD VDD VSS VSS gf180mcu_fd_sc_mcu7t5v0__fillcap_4
XFILLER_59_422 VDD VDD VSS VSS gf180mcu_fd_sc_mcu7t5v0__fillcap_4
XFILLER_59_444 VDD VDD VSS VSS gf180mcu_fd_sc_mcu7t5v0__fill_2
Xload_slew29 _2673_/S1 _2675_/S1 VDD VDD VSS VSS gf180mcu_fd_sc_mcu7t5v0__buf_4
XFILLER_27_352 VDD VDD VSS VSS gf180mcu_fd_sc_mcu7t5v0__fillcap_8
XFILLER_42_311 VDD VDD VSS VSS gf180mcu_fd_sc_mcu7t5v0__fillcap_4
XFILLER_15_558 VDD VDD VSS VSS gf180mcu_fd_sc_mcu7t5v0__fill_2
XFILLER_42_333 VDD VDD VSS VSS gf180mcu_fd_sc_mcu7t5v0__fill_2
XFILLER_91_68 VDD VDD VSS VSS gf180mcu_fd_sc_mcu7t5v0__fill_2
XFILLER_11_764 VDD VDD VSS VSS gf180mcu_fd_sc_mcu7t5v0__fill_1
XFILLER_7_702 VDD VDD VSS VSS gf180mcu_fd_sc_mcu7t5v0__fillcap_4
XFILLER_10_263 VDD VDD VSS VSS gf180mcu_fd_sc_mcu7t5v0__fillcap_4
XFILLER_10_296 VDD VDD VSS VSS gf180mcu_fd_sc_mcu7t5v0__fillcap_8
XFILLER_6_289 VDD VDD VSS VSS gf180mcu_fd_sc_mcu7t5v0__fillcap_8
XFILLER_69_208 VDD VDD VSS VSS gf180mcu_fd_sc_mcu7t5v0__fill_2
XFILLER_78_764 VDD VDD VSS VSS gf180mcu_fd_sc_mcu7t5v0__fill_1
XFILLER_77_274 VDD VDD VSS VSS gf180mcu_fd_sc_mcu7t5v0__fillcap_4
XFILLER_92_233 VDD VDD VSS VSS gf180mcu_fd_sc_mcu7t5v0__fill_1
XFILLER_92_255 VDD VDD VSS VSS gf180mcu_fd_sc_mcu7t5v0__fillcap_32
XFILLER_92_244 VDD VDD VSS VSS gf180mcu_fd_sc_mcu7t5v0__fill_1
XFILLER_1_66 VDD VDD VSS VSS gf180mcu_fd_sc_mcu7t5v0__fillcap_4
XFILLER_80_439 VDD VDD VSS VSS gf180mcu_fd_sc_mcu7t5v0__fill_2
XFILLER_61_664 VDD VDD VSS VSS gf180mcu_fd_sc_mcu7t5v0__fillcap_8
XFILLER_21_528 VDD VDD VSS VSS gf180mcu_fd_sc_mcu7t5v0__fill_1
XFILLER_61_697 VDD VDD VSS VSS gf180mcu_fd_sc_mcu7t5v0__fill_2
X_1973_ _1490_/Z _2000_/A2 _1981_/S VDD VDD VSS VSS gf180mcu_fd_sc_mcu7t5v0__and2_1
XTAP_TAPCELL_ROW_31_556 VDD VSS gf180mcu_fd_sc_mcu7t5v0__filltie
X_2525_ _3188_/Q _3180_/Q _2539_/S _3188_/D VDD VDD VSS VSS gf180mcu_fd_sc_mcu7t5v0__mux2_2
X_2456_ _2458_/B _2456_/A2 _2456_/A3 _2457_/A3 VDD VDD VSS VSS gf180mcu_fd_sc_mcu7t5v0__nand3_1
X_1407_ _3162_/Q _2445_/A3 VDD VDD VSS VSS gf180mcu_fd_sc_mcu7t5v0__clkinv_1
XFILLER_96_550 VDD VDD VSS VSS gf180mcu_fd_sc_mcu7t5v0__fill_2
XFILLER_56_403 VDD VDD VSS VSS gf180mcu_fd_sc_mcu7t5v0__fill_2
X_2387_ _2385_/Z _2386_/Z _2405_/S _2387_/Z VDD VDD VSS VSS gf180mcu_fd_sc_mcu7t5v0__mux2_2
XFILLER_84_734 VDD VDD VSS VSS gf180mcu_fd_sc_mcu7t5v0__fill_1
XTAP_TAPCELL_ROW_39_645 VDD VSS gf180mcu_fd_sc_mcu7t5v0__filltie
X_3008_ _3008_/D _3016_/CLK _3008_/Q VDD VDD VSS VSS gf180mcu_fd_sc_mcu7t5v0__dffq_1
XFILLER_36_193 VDD VDD VSS VSS gf180mcu_fd_sc_mcu7t5v0__fill_2
XFILLER_87_550 VDD VDD VSS VSS gf180mcu_fd_sc_mcu7t5v0__fillcap_8
XFILLER_19_40 VDD VDD VSS VSS gf180mcu_fd_sc_mcu7t5v0__fillcap_16
XFILLER_19_116 VDD VDD VSS VSS gf180mcu_fd_sc_mcu7t5v0__fillcap_16
XFILLER_35_94 VDD VDD VSS VSS gf180mcu_fd_sc_mcu7t5v0__fillcap_4
XFILLER_35_72 VDD VDD VSS VSS gf180mcu_fd_sc_mcu7t5v0__fillcap_4
XFILLER_43_664 VDD VDD VSS VSS gf180mcu_fd_sc_mcu7t5v0__fillcap_16
XFILLER_70_461 VDD VDD VSS VSS gf180mcu_fd_sc_mcu7t5v0__fill_2
XFILLER_42_174 VDD VDD VSS VSS gf180mcu_fd_sc_mcu7t5v0__fill_1
XTAP_TAPCELL_ROW_77_1038 VDD VSS gf180mcu_fd_sc_mcu7t5v0__filltie
X_2310_ _2310_/A1 _2310_/A2 _3130_/D VDD VDD VSS VSS gf180mcu_fd_sc_mcu7t5v0__nor2_1
XFILLER_97_314 VDD VDD VSS VSS gf180mcu_fd_sc_mcu7t5v0__fill_1
X_3290_ _3290_/D _3303_/RN _3410_/CLK _3290_/Q VDD VDD VSS VSS gf180mcu_fd_sc_mcu7t5v0__dffrnq_1
XFILLER_97_336 VDD VDD VSS VSS gf180mcu_fd_sc_mcu7t5v0__fillcap_8
X_2241_ _3136_/Q _3116_/Q _2242_/S _3116_/D VDD VDD VSS VSS gf180mcu_fd_sc_mcu7t5v0__mux2_2
X_2172_ _3098_/Q _3216_/Q _2178_/S _3098_/D VDD VDD VSS VSS gf180mcu_fd_sc_mcu7t5v0__mux2_2
XTAP_TAPCELL_ROW_88_1156 VDD VSS gf180mcu_fd_sc_mcu7t5v0__filltie
XTAP_TAPCELL_ROW_0_218 VDD VSS gf180mcu_fd_sc_mcu7t5v0__filltie
XTAP_TAPCELL_ROW_64_902 VDD VSS gf180mcu_fd_sc_mcu7t5v0__filltie
XFILLER_81_726 VDD VDD VSS VSS gf180mcu_fd_sc_mcu7t5v0__fill_2
XTAP_TAPCELL_ROW_0_229 VDD VSS gf180mcu_fd_sc_mcu7t5v0__filltie
XTAP_TAPCELL_ROW_36_615 VDD VSS gf180mcu_fd_sc_mcu7t5v0__filltie
XFILLER_80_247 VDD VDD VSS VSS gf180mcu_fd_sc_mcu7t5v0__fillcap_8
XFILLER_33_185 VDD VDD VSS VSS gf180mcu_fd_sc_mcu7t5v0__fillcap_16
XTAP_TAPCELL_ROW_44_692 VDD VSS gf180mcu_fd_sc_mcu7t5v0__filltie
XTAP_TAPCELL_ROW_72_990 VDD VSS gf180mcu_fd_sc_mcu7t5v0__filltie
X_1956_ _3112_/Q _2976_/Q _1962_/S _2976_/D VDD VDD VSS VSS gf180mcu_fd_sc_mcu7t5v0__mux2_2
XFILLER_21_347 VDD VDD VSS VSS gf180mcu_fd_sc_mcu7t5v0__fill_2
XFILLER_107_419 VDD VDD VSS VSS gf180mcu_fd_sc_mcu7t5v0__fill_1
XTAP_TAPCELL_ROW_99_1274 VDD VSS gf180mcu_fd_sc_mcu7t5v0__filltie
X_1887_ _2918_/Q _3118_/Q _1887_/S _2918_/D VDD VDD VSS VSS gf180mcu_fd_sc_mcu7t5v0__mux2_2
XTAP_TAPCELL_ROW_8_318 VDD VSS gf180mcu_fd_sc_mcu7t5v0__filltie
XFILLER_88_314 VDD VDD VSS VSS gf180mcu_fd_sc_mcu7t5v0__fill_1
X_2508_ _2508_/A1 _2508_/A2 _2539_/S VDD VDD VSS VSS gf180mcu_fd_sc_mcu7t5v0__nor2_2
XFILLER_103_647 VDD VDD VSS VSS gf180mcu_fd_sc_mcu7t5v0__fill_2
XFILLER_102_168 VDD VDD VSS VSS gf180mcu_fd_sc_mcu7t5v0__fillcap_4
X_2439_ _2439_/A1 _2439_/A2 _3148_/D VDD VDD VSS VSS gf180mcu_fd_sc_mcu7t5v0__nor2_1
XFILLER_56_244 VDD VDD VSS VSS gf180mcu_fd_sc_mcu7t5v0__fill_1
XFILLER_72_737 VDD VDD VSS VSS gf180mcu_fd_sc_mcu7t5v0__fillcap_16
XTAP_TAPCELL_ROW_108_1381 VDD VSS gf180mcu_fd_sc_mcu7t5v0__filltie
XTAP_TAPCELL_ROW_108_1370 VDD VSS gf180mcu_fd_sc_mcu7t5v0__filltie
XFILLER_25_686 VDD VDD VSS VSS gf180mcu_fd_sc_mcu7t5v0__fillcap_8
XFILLER_72_37 VDD VDD VSS VSS gf180mcu_fd_sc_mcu7t5v0__fillcap_16
XFILLER_12_314 VDD VDD VSS VSS gf180mcu_fd_sc_mcu7t5v0__fill_1
XFILLER_24_174 VDD VDD VSS VSS gf180mcu_fd_sc_mcu7t5v0__fill_1
XFILLER_8_307 VDD VDD VSS VSS gf180mcu_fd_sc_mcu7t5v0__fillcap_8
XFILLER_40_667 VDD VDD VSS VSS gf180mcu_fd_sc_mcu7t5v0__fillcap_8
XFILLER_106_452 VDD VDD VSS VSS gf180mcu_fd_sc_mcu7t5v0__fill_2
XFILLER_4_546 VDD VDD VSS VSS gf180mcu_fd_sc_mcu7t5v0__fillcap_4
XFILLER_4_579 VDD VDD VSS VSS gf180mcu_fd_sc_mcu7t5v0__fill_2
XFILLER_94_317 VDD VDD VSS VSS gf180mcu_fd_sc_mcu7t5v0__fillcap_8
XFILLER_47_222 VDD VDD VSS VSS gf180mcu_fd_sc_mcu7t5v0__fill_1
XFILLER_35_417 VDD VDD VSS VSS gf180mcu_fd_sc_mcu7t5v0__fill_2
XFILLER_16_642 VDD VDD VSS VSS gf180mcu_fd_sc_mcu7t5v0__fill_1
XFILLER_62_247 VDD VDD VSS VSS gf180mcu_fd_sc_mcu7t5v0__fillcap_16
XFILLER_16_664 VDD VDD VSS VSS gf180mcu_fd_sc_mcu7t5v0__fill_1
X_1810_ _3284_/Q _2851_/Q _1813_/S _2851_/D VDD VDD VSS VSS gf180mcu_fd_sc_mcu7t5v0__mux2_2
X_2790_ _2790_/D _2828_/CLK _2790_/Q VDD VDD VSS VSS gf180mcu_fd_sc_mcu7t5v0__dffq_1
XTAP_TAPCELL_ROW_13_375 VDD VSS gf180mcu_fd_sc_mcu7t5v0__filltie
XFILLER_30_177 VDD VDD VSS VSS gf180mcu_fd_sc_mcu7t5v0__fillcap_8
XTAP_TAPCELL_ROW_41_662 VDD VSS gf180mcu_fd_sc_mcu7t5v0__filltie
X_1741_ _3280_/Q _2791_/Q _1748_/S _2791_/D VDD VDD VSS VSS gf180mcu_fd_sc_mcu7t5v0__mux2_2
X_1672_ _2413_/A1 _1637_/Z _1672_/B _1672_/C _1677_/C VDD VDD VSS VSS gf180mcu_fd_sc_mcu7t5v0__aoi211_1
XFILLER_7_384 VDD VDD VSS VSS gf180mcu_fd_sc_mcu7t5v0__fillcap_16
XFILLER_7_87 VDD VDD VSS VSS gf180mcu_fd_sc_mcu7t5v0__fill_2
X_3411_ _3411_/D _3416_/RN _3425_/CLK _3411_/Q VDD VDD VSS VSS gf180mcu_fd_sc_mcu7t5v0__dffrnq_1
XFILLER_98_612 VDD VDD VSS VSS gf180mcu_fd_sc_mcu7t5v0__fill_1
X_3342_ _3361_/Q input1/Z _3352_/CLK hold50/I VDD VDD VSS VSS gf180mcu_fd_sc_mcu7t5v0__dffrnq_1
XFILLER_30_2 VDD VDD VSS VSS gf180mcu_fd_sc_mcu7t5v0__fillcap_32
XFILLER_85_317 VDD VDD VSS VSS gf180mcu_fd_sc_mcu7t5v0__fillcap_4
X_3273_ _3273_/D _3328_/RN _3273_/CLK _3273_/Q VDD VDD VSS VSS gf180mcu_fd_sc_mcu7t5v0__dffrnq_1
X_2224_ _2224_/A1 _2431_/B _2224_/B _2267_/C _2251_/C VDD VDD VSS VSS gf180mcu_fd_sc_mcu7t5v0__aoi211_1
XFILLER_85_328 VDD VDD VSS VSS gf180mcu_fd_sc_mcu7t5v0__fillcap_16
X_2155_ _3234_/Q _3084_/Q _2165_/S _3084_/D VDD VDD VSS VSS gf180mcu_fd_sc_mcu7t5v0__mux2_2
XFILLER_38_244 VDD VDD VSS VSS gf180mcu_fd_sc_mcu7t5v0__fill_1
XTAP_TAPCELL_ROW_49_751 VDD VSS gf180mcu_fd_sc_mcu7t5v0__filltie
XFILLER_66_531 VDD VDD VSS VSS gf180mcu_fd_sc_mcu7t5v0__fill_2
XFILLER_38_288 VDD VDD VSS VSS gf180mcu_fd_sc_mcu7t5v0__fillcap_16
XFILLER_54_715 VDD VDD VSS VSS gf180mcu_fd_sc_mcu7t5v0__fillcap_16
XFILLER_54_737 VDD VDD VSS VSS gf180mcu_fd_sc_mcu7t5v0__fillcap_16
XFILLER_66_597 VDD VDD VSS VSS gf180mcu_fd_sc_mcu7t5v0__fill_1
XFILLER_81_556 VDD VDD VSS VSS gf180mcu_fd_sc_mcu7t5v0__fillcap_4
X_2086_ _3301_/Q _2091_/A2 _2090_/A2 _3293_/Q _2087_/B2 VDD VDD VSS VSS gf180mcu_fd_sc_mcu7t5v0__aoi22_1
XFILLER_34_472 VDD VDD VSS VSS gf180mcu_fd_sc_mcu7t5v0__fillcap_16
XFILLER_21_133 VDD VDD VSS VSS gf180mcu_fd_sc_mcu7t5v0__fillcap_4
XFILLER_22_667 VDD VDD VSS VSS gf180mcu_fd_sc_mcu7t5v0__fillcap_16
X_2988_ _2988_/D _2988_/CLK _2988_/Q VDD VDD VSS VSS gf180mcu_fd_sc_mcu7t5v0__dffq_1
X_1939_ _2961_/Q _3113_/Q _1944_/S _2961_/D VDD VDD VSS VSS gf180mcu_fd_sc_mcu7t5v0__mux2_2
XFILLER_107_227 VDD VDD VSS VSS gf180mcu_fd_sc_mcu7t5v0__fillcap_32
XFILLER_89_623 VDD VDD VSS VSS gf180mcu_fd_sc_mcu7t5v0__fillcap_4
XFILLER_107_66 VDD VDD VSS VSS gf180mcu_fd_sc_mcu7t5v0__fillcap_4
XFILLER_103_422 VDD VDD VSS VSS gf180mcu_fd_sc_mcu7t5v0__fill_2
XFILLER_88_177 VDD VDD VSS VSS gf180mcu_fd_sc_mcu7t5v0__fillcap_8
XFILLER_44_247 VDD VDD VSS VSS gf180mcu_fd_sc_mcu7t5v0__fillcap_8
XFILLER_60_729 VDD VDD VSS VSS gf180mcu_fd_sc_mcu7t5v0__fillcap_4
XPHY_EDGE_ROW_11_Right_11 VDD VSS gf180mcu_fd_sc_mcu7t5v0__endcap
XFILLER_13_656 VDD VDD VSS VSS gf180mcu_fd_sc_mcu7t5v0__fill_2
XFILLER_12_177 VDD VDD VSS VSS gf180mcu_fd_sc_mcu7t5v0__fillcap_64
XFILLER_12_155 VDD VDD VSS VSS gf180mcu_fd_sc_mcu7t5v0__fillcap_16
XFILLER_9_627 VDD VDD VSS VSS gf180mcu_fd_sc_mcu7t5v0__fill_2
XFILLER_8_104 VDD VDD VSS VSS gf180mcu_fd_sc_mcu7t5v0__fill_1
XTAP_TAPCELL_ROW_10_334 VDD VSS gf180mcu_fd_sc_mcu7t5v0__filltie
XTAP_TAPCELL_ROW_74_1008 VDD VSS gf180mcu_fd_sc_mcu7t5v0__filltie
XFILLER_4_387 VDD VDD VSS VSS gf180mcu_fd_sc_mcu7t5v0__fillcap_16
XPHY_EDGE_ROW_20_Right_20 VDD VSS gf180mcu_fd_sc_mcu7t5v0__endcap
XFILLER_67_339 VDD VDD VSS VSS gf180mcu_fd_sc_mcu7t5v0__fill_2
XFILLER_36_737 VDD VDD VSS VSS gf180mcu_fd_sc_mcu7t5v0__fillcap_16
XFILLER_48_564 VDD VDD VSS VSS gf180mcu_fd_sc_mcu7t5v0__fillcap_4
XFILLER_48_597 VDD VDD VSS VSS gf180mcu_fd_sc_mcu7t5v0__fillcap_8
XTAP_TAPCELL_ROW_85_1126 VDD VSS gf180mcu_fd_sc_mcu7t5v0__filltie
XTAP_TAPCELL_ROW_18_423 VDD VSS gf180mcu_fd_sc_mcu7t5v0__filltie
XTAP_TAPCELL_ROW_46_721 VDD VSS gf180mcu_fd_sc_mcu7t5v0__filltie
XFILLER_35_269 VDD VDD VSS VSS gf180mcu_fd_sc_mcu7t5v0__fill_1
XFILLER_63_578 VDD VDD VSS VSS gf180mcu_fd_sc_mcu7t5v0__fill_2
XFILLER_16_472 VDD VDD VSS VSS gf180mcu_fd_sc_mcu7t5v0__fillcap_4
X_2911_ _2911_/D _3369_/CLK _2911_/Q VDD VDD VSS VSS gf180mcu_fd_sc_mcu7t5v0__dffq_1
XFILLER_73_80 VDD VDD VSS VSS gf180mcu_fd_sc_mcu7t5v0__fill_2
X_2842_ _2842_/D _2858_/CLK _2842_/Q VDD VDD VSS VSS gf180mcu_fd_sc_mcu7t5v0__dffq_1
XFILLER_78_2 VDD VDD VSS VSS gf180mcu_fd_sc_mcu7t5v0__fillcap_32
X_2773_ _2773_/D _2893_/CLK _2773_/Q VDD VDD VSS VSS gf180mcu_fd_sc_mcu7t5v0__dffq_1
X_1724_ _2778_/Q _3283_/Q _1728_/S _2778_/D VDD VDD VSS VSS gf180mcu_fd_sc_mcu7t5v0__mux2_2
XTAP_TAPCELL_ROW_96_1244 VDD VSS gf180mcu_fd_sc_mcu7t5v0__filltie
X_1655_ _3128_/Q _1632_/Z _2277_/A2 _2224_/A1 _1656_/A2 VDD VDD VSS VSS gf180mcu_fd_sc_mcu7t5v0__aoi22_1
X_1586_ _1586_/A1 _1586_/A2 _1586_/A3 _1588_/A2 VDD VDD VSS VSS gf180mcu_fd_sc_mcu7t5v0__nand3_1
XFILLER_98_453 VDD VDD VSS VSS gf180mcu_fd_sc_mcu7t5v0__fill_2
XPHY_EDGE_ROW_13_Left_122 VDD VSS gf180mcu_fd_sc_mcu7t5v0__endcap
X_3325_ _3325_/D _3369_/RN _3325_/CLK _3325_/Q VDD VDD VSS VSS gf180mcu_fd_sc_mcu7t5v0__dffrnq_1
X_3256_ _3256_/D _3328_/RN _3257_/CLK _3256_/Q VDD VDD VSS VSS gf180mcu_fd_sc_mcu7t5v0__dffrnq_1
XFILLER_58_317 VDD VDD VSS VSS gf180mcu_fd_sc_mcu7t5v0__fillcap_32
X_2207_ _2405_/S _2206_/Z _3393_/Q _2212_/A2 VDD VDD VSS VSS gf180mcu_fd_sc_mcu7t5v0__aoi21_1
XFILLER_26_203 VDD VDD VSS VSS gf180mcu_fd_sc_mcu7t5v0__fill_1
X_3187_ _3187_/D _3303_/RN clkload8/I _3187_/Q VDD VDD VSS VSS gf180mcu_fd_sc_mcu7t5v0__dffrnq_1
X_2138_ _3217_/Q _3067_/Q _2166_/S _3067_/D VDD VDD VSS VSS gf180mcu_fd_sc_mcu7t5v0__mux2_2
XFILLER_54_523 VDD VDD VSS VSS gf180mcu_fd_sc_mcu7t5v0__fill_2
XTAP_TAPCELL_ROW_105_1340 VDD VSS gf180mcu_fd_sc_mcu7t5v0__filltie
XFILLER_26_247 VDD VDD VSS VSS gf180mcu_fd_sc_mcu7t5v0__fillcap_16
XFILLER_26_269 VDD VDD VSS VSS gf180mcu_fd_sc_mcu7t5v0__fill_1
X_2069_ _2091_/B _2069_/A2 _2085_/B1 VDD VDD VSS VSS gf180mcu_fd_sc_mcu7t5v0__nor2_1
XPHY_EDGE_ROW_22_Left_131 VDD VSS gf180mcu_fd_sc_mcu7t5v0__endcap
XFILLER_22_486 VDD VDD VSS VSS gf180mcu_fd_sc_mcu7t5v0__fillcap_4
XTAP_TAPCELL_ROW_52_779 VDD VSS gf180mcu_fd_sc_mcu7t5v0__filltie
XFILLER_1_302 VDD VDD VSS VSS gf180mcu_fd_sc_mcu7t5v0__fill_1
XPHY_EDGE_ROW_31_Left_140 VDD VSS gf180mcu_fd_sc_mcu7t5v0__endcap
XFILLER_104_753 VDD VDD VSS VSS gf180mcu_fd_sc_mcu7t5v0__fillcap_8
XFILLER_103_230 VDD VDD VSS VSS gf180mcu_fd_sc_mcu7t5v0__fill_1
XFILLER_78_69 VDD VDD VSS VSS gf180mcu_fd_sc_mcu7t5v0__fillcap_16
XFILLER_76_114 VDD VDD VSS VSS gf180mcu_fd_sc_mcu7t5v0__fillcap_16
XFILLER_92_607 VDD VDD VSS VSS gf180mcu_fd_sc_mcu7t5v0__fill_1
XFILLER_57_372 VDD VDD VSS VSS gf180mcu_fd_sc_mcu7t5v0__fill_2
XFILLER_18_737 VDD VDD VSS VSS gf180mcu_fd_sc_mcu7t5v0__fillcap_16
XFILLER_32_228 VDD VDD VSS VSS gf180mcu_fd_sc_mcu7t5v0__fillcap_16
XFILLER_72_375 VDD VDD VSS VSS gf180mcu_fd_sc_mcu7t5v0__fillcap_8
XTAP_TAPCELL_ROW_80_1078 VDD VSS gf180mcu_fd_sc_mcu7t5v0__filltie
XFILLER_13_486 VDD VDD VSS VSS gf180mcu_fd_sc_mcu7t5v0__fillcap_4
XFILLER_40_261 VDD VDD VSS VSS gf180mcu_fd_sc_mcu7t5v0__fill_1
XFILLER_43_72 VDD VDD VSS VSS gf180mcu_fd_sc_mcu7t5v0__fillcap_32
X_1440_ _1436_/Z _1441_/A2 _3391_/D VDD VDD VSS VSS gf180mcu_fd_sc_mcu7t5v0__nor2_1
X_1371_ _3418_/Q _2197_/A1 VDD VDD VSS VSS gf180mcu_fd_sc_mcu7t5v0__clkinv_1
XTAP_TAPCELL_ROW_91_1185 VDD VSS gf180mcu_fd_sc_mcu7t5v0__filltie
X_3110_ _3110_/D _3369_/RN _3131_/CLK _3110_/Q VDD VDD VSS VSS gf180mcu_fd_sc_mcu7t5v0__dffrnq_1
XFILLER_68_626 VDD VDD VSS VSS gf180mcu_fd_sc_mcu7t5v0__fillcap_32
XFILLER_83_629 VDD VDD VSS VSS gf180mcu_fd_sc_mcu7t5v0__fill_1
XFILLER_55_309 VDD VDD VSS VSS gf180mcu_fd_sc_mcu7t5v0__fillcap_32
X_3041_ _3041_/D _3416_/RN _3425_/CLK _3041_/Q VDD VDD VSS VSS gf180mcu_fd_sc_mcu7t5v0__dffrnq_1
XFILLER_76_681 VDD VDD VSS VSS gf180mcu_fd_sc_mcu7t5v0__fill_1
XFILLER_48_383 VDD VDD VSS VSS gf180mcu_fd_sc_mcu7t5v0__fill_2
XFILLER_32_762 VDD VDD VSS VSS gf180mcu_fd_sc_mcu7t5v0__fill_2
X_2825_ _2825_/D _2887_/CLK _2825_/Q VDD VDD VSS VSS gf180mcu_fd_sc_mcu7t5v0__dffq_1
XTAP_TAPCELL_ROW_100_1281 VDD VSS gf180mcu_fd_sc_mcu7t5v0__filltie
X_2756_ _3214_/Q _3296_/Q _2760_/S _3296_/D VDD VDD VSS VSS gf180mcu_fd_sc_mcu7t5v0__mux2_2
X_1707_ _2431_/B _1707_/A2 _2298_/B VDD VDD VSS VSS gf180mcu_fd_sc_mcu7t5v0__nor2_1
X_2687_ _3206_/Q _2687_/A2 _2607_/Z _2687_/Z VDD VDD VSS VSS gf180mcu_fd_sc_mcu7t5v0__or3_1
X_1638_ _2765_/Q _2289_/A1 _1702_/C VDD VDD VSS VSS gf180mcu_fd_sc_mcu7t5v0__nand2_1
X_1569_ _3120_/Q _3121_/Q _1569_/B _2111_/A2 VDD VDD VSS VSS gf180mcu_fd_sc_mcu7t5v0__aoi21_1
X_3308_ _3308_/D _3416_/RN _3308_/CLK _3308_/Q VDD VDD VSS VSS gf180mcu_fd_sc_mcu7t5v0__dffsnq_1
XFILLER_104_34 VDD VDD VSS VSS gf180mcu_fd_sc_mcu7t5v0__fill_1
Xclkbuf_4_14_0_host_clk_i clkbuf_0_host_clk_i/Z _2887_/CLK VDD VDD VSS VSS gf180mcu_fd_sc_mcu7t5v0__clkbuf_4
XFILLER_74_629 VDD VDD VSS VSS gf180mcu_fd_sc_mcu7t5v0__fillcap_16
X_3239_ _3239_/D _3328_/RN _3271_/CLK _3239_/Q VDD VDD VSS VSS gf180mcu_fd_sc_mcu7t5v0__dffrnq_1
XFILLER_27_556 VDD VDD VSS VSS gf180mcu_fd_sc_mcu7t5v0__fillcap_4
XFILLER_81_183 VDD VDD VSS VSS gf180mcu_fd_sc_mcu7t5v0__fill_2
XFILLER_14_228 VDD VDD VSS VSS gf180mcu_fd_sc_mcu7t5v0__fillcap_4
XFILLER_42_515 VDD VDD VSS VSS gf180mcu_fd_sc_mcu7t5v0__fillcap_8
XFILLER_80_37 VDD VDD VSS VSS gf180mcu_fd_sc_mcu7t5v0__fillcap_64
XFILLER_22_294 VDD VDD VSS VSS gf180mcu_fd_sc_mcu7t5v0__fillcap_4
XFILLER_13_53 VDD VDD VSS VSS gf180mcu_fd_sc_mcu7t5v0__fillcap_16
XTAP_TAPCELL_ROW_20_440 VDD VSS gf180mcu_fd_sc_mcu7t5v0__filltie
XFILLER_108_399 VDD VDD VSS VSS gf180mcu_fd_sc_mcu7t5v0__fillcap_8
XFILLER_89_79 VDD VDD VSS VSS gf180mcu_fd_sc_mcu7t5v0__fillcap_32
XFILLER_8_2 VDD VDD VSS VSS gf180mcu_fd_sc_mcu7t5v0__fillcap_32
XFILLER_1_121 VDD VDD VSS VSS gf180mcu_fd_sc_mcu7t5v0__fillcap_16
XFILLER_89_272 VDD VDD VSS VSS gf180mcu_fd_sc_mcu7t5v0__fill_2
XFILLER_2_699 VDD VDD VSS VSS gf180mcu_fd_sc_mcu7t5v0__fillcap_32
XFILLER_104_594 VDD VDD VSS VSS gf180mcu_fd_sc_mcu7t5v0__fill_1
XFILLER_77_489 VDD VDD VSS VSS gf180mcu_fd_sc_mcu7t5v0__fill_1
XFILLER_18_567 VDD VDD VSS VSS gf180mcu_fd_sc_mcu7t5v0__fill_2
XFILLER_33_537 VDD VDD VSS VSS gf180mcu_fd_sc_mcu7t5v0__fillcap_16
XFILLER_45_397 VDD VDD VSS VSS gf180mcu_fd_sc_mcu7t5v0__fillcap_4
XFILLER_60_301 VDD VDD VSS VSS gf180mcu_fd_sc_mcu7t5v0__fill_1
XFILLER_72_150 VDD VDD VSS VSS gf180mcu_fd_sc_mcu7t5v0__fill_2
XFILLER_33_559 VDD VDD VSS VSS gf180mcu_fd_sc_mcu7t5v0__fill_1
XFILLER_60_378 VDD VDD VSS VSS gf180mcu_fd_sc_mcu7t5v0__fillcap_4
XFILLER_13_294 VDD VDD VSS VSS gf180mcu_fd_sc_mcu7t5v0__fill_1
XFILLER_13_272 VDD VDD VSS VSS gf180mcu_fd_sc_mcu7t5v0__fill_2
XFILLER_9_221 VDD VDD VSS VSS gf180mcu_fd_sc_mcu7t5v0__fill_1
Xclkload24 _3311_/CLK clkload24/Z VDD VDD VSS VSS gf180mcu_fd_sc_mcu7t5v0__clkbuf_1
Xclkload35 _3253_/CLK clkload35/Z VDD VDD VSS VSS gf180mcu_fd_sc_mcu7t5v0__clkbuf_4
Xclkload13 _3264_/CLK clkload13/ZN VDD VDD VSS VSS gf180mcu_fd_sc_mcu7t5v0__inv_2
X_2610_ _3065_/Q _2132_/I _2664_/B1 _3097_/Q _2765_/Q _2603_/Z _2611_/A2 VDD VDD VSS
+ VSS gf180mcu_fd_sc_mcu7t5v0__aoi222_1
XTAP_TAPCELL_ROW_93_1214 VDD VSS gf180mcu_fd_sc_mcu7t5v0__filltie
Xclkload46 _2958_/CLK clkload46/ZN VDD VDD VSS VSS gf180mcu_fd_sc_mcu7t5v0__clkinv_1
X_2541_ _3164_/Q _3204_/Q _2569_/S _3204_/D VDD VDD VSS VSS gf180mcu_fd_sc_mcu7t5v0__mux2_2
Xclkload57 _3358_/CLK clkload57/ZN VDD VDD VSS VSS gf180mcu_fd_sc_mcu7t5v0__inv_3
X_2472_ _2472_/A1 _2472_/A2 _2472_/B _3149_/D VDD VDD VSS VSS gf180mcu_fd_sc_mcu7t5v0__oai21_1
XFILLER_87_209 VDD VDD VSS VSS gf180mcu_fd_sc_mcu7t5v0__fill_1
X_1423_ _3254_/Q _2681_/A1 VDD VDD VSS VSS gf180mcu_fd_sc_mcu7t5v0__clkinv_1
XFILLER_96_732 VDD VDD VSS VSS gf180mcu_fd_sc_mcu7t5v0__fill_2
XFILLER_96_743 VDD VDD VSS VSS gf180mcu_fd_sc_mcu7t5v0__fill_1
XFILLER_95_242 VDD VDD VSS VSS gf180mcu_fd_sc_mcu7t5v0__fillcap_8
XFILLER_28_309 VDD VDD VSS VSS gf180mcu_fd_sc_mcu7t5v0__fillcap_4
XFILLER_56_607 VDD VDD VSS VSS gf180mcu_fd_sc_mcu7t5v0__fill_1
XFILLER_95_297 VDD VDD VSS VSS gf180mcu_fd_sc_mcu7t5v0__fill_1
X_3024_ _3024_/D _3416_/RN _3416_/CLK _3024_/Q VDD VDD VSS VSS gf180mcu_fd_sc_mcu7t5v0__dffrnq_1
XFILLER_55_139 VDD VDD VSS VSS gf180mcu_fd_sc_mcu7t5v0__fill_1
XFILLER_51_301 VDD VDD VSS VSS gf180mcu_fd_sc_mcu7t5v0__fill_1
XTAP_TAPCELL_ROW_102_1310 VDD VSS gf180mcu_fd_sc_mcu7t5v0__filltie
XFILLER_91_492 VDD VDD VSS VSS gf180mcu_fd_sc_mcu7t5v0__fillcap_16
XFILLER_11_209 VDD VDD VSS VSS gf180mcu_fd_sc_mcu7t5v0__fill_1
XTAP_TAPCELL_ROW_62_885 VDD VSS gf180mcu_fd_sc_mcu7t5v0__filltie
XTAP_TAPCELL_ROW_34_587 VDD VSS gf180mcu_fd_sc_mcu7t5v0__filltie
Xclkbuf_leaf_17_clk_i clkload1/I _3419_/CLK VDD VDD VSS VSS gf180mcu_fd_sc_mcu7t5v0__clkbuf_4
Xclkload7 clkload7/I clkload7/ZN VDD VDD VSS VSS gf180mcu_fd_sc_mcu7t5v0__clkinv_2
X_2808_ _2808_/D _2887_/CLK _2808_/Q VDD VDD VSS VSS gf180mcu_fd_sc_mcu7t5v0__dffq_1
X_2739_ _3214_/Q _3280_/Q _2746_/S _3280_/D VDD VDD VSS VSS gf180mcu_fd_sc_mcu7t5v0__mux2_2
XFILLER_86_253 VDD VDD VSS VSS gf180mcu_fd_sc_mcu7t5v0__fillcap_4
XFILLER_47_629 VDD VDD VSS VSS gf180mcu_fd_sc_mcu7t5v0__fill_1
XFILLER_59_478 VDD VDD VSS VSS gf180mcu_fd_sc_mcu7t5v0__fill_2
XFILLER_75_59 VDD VDD VSS VSS gf180mcu_fd_sc_mcu7t5v0__fill_1
XFILLER_74_448 VDD VDD VSS VSS gf180mcu_fd_sc_mcu7t5v0__fillcap_4
XFILLER_70_698 VDD VDD VSS VSS gf180mcu_fd_sc_mcu7t5v0__fill_2
XFILLER_11_710 VDD VDD VSS VSS gf180mcu_fd_sc_mcu7t5v0__fillcap_4
XFILLER_77_220 VDD VDD VSS VSS gf180mcu_fd_sc_mcu7t5v0__fill_2
XTAP_TAPCELL_ROW_5_290 VDD VSS gf180mcu_fd_sc_mcu7t5v0__filltie
XFILLER_65_437 VDD VDD VSS VSS gf180mcu_fd_sc_mcu7t5v0__fillcap_4
XFILLER_46_640 VDD VDD VSS VSS gf180mcu_fd_sc_mcu7t5v0__fillcap_16
XFILLER_65_81 VDD VDD VSS VSS gf180mcu_fd_sc_mcu7t5v0__fillcap_16
XFILLER_61_632 VDD VDD VSS VSS gf180mcu_fd_sc_mcu7t5v0__fillcap_32
XFILLER_73_492 VDD VDD VSS VSS gf180mcu_fd_sc_mcu7t5v0__fillcap_64
XFILLER_61_676 VDD VDD VSS VSS gf180mcu_fd_sc_mcu7t5v0__fill_2
XFILLER_14_592 VDD VDD VSS VSS gf180mcu_fd_sc_mcu7t5v0__fill_2
X_1972_ _3366_/Q _3367_/Q _2000_/A2 VDD VDD VSS VSS gf180mcu_fd_sc_mcu7t5v0__nor2_1
XTAP_TAPCELL_ROW_31_557 VDD VSS gf180mcu_fd_sc_mcu7t5v0__filltie
XFILLER_60_2 VDD VDD VSS VSS gf180mcu_fd_sc_mcu7t5v0__fillcap_8
XPHY_EDGE_ROW_49_Right_49 VDD VSS gf180mcu_fd_sc_mcu7t5v0__endcap
X_2524_ _3187_/Q _3179_/Q _2540_/S _3187_/D VDD VDD VSS VSS gf180mcu_fd_sc_mcu7t5v0__mux2_2
X_2455_ _3157_/Q _2455_/A2 _2455_/A3 _2457_/A2 VDD VDD VSS VSS gf180mcu_fd_sc_mcu7t5v0__nand3_1
X_1406_ _3161_/Q _2492_/A1 VDD VDD VSS VSS gf180mcu_fd_sc_mcu7t5v0__clkinv_1
X_2386_ _2860_/Q _2852_/Q _2844_/Q _2836_/Q _3391_/Q _2388_/S1 _2386_/Z VDD VDD VSS
+ VSS gf180mcu_fd_sc_mcu7t5v0__mux4_1
XFILLER_29_629 VDD VDD VSS VSS gf180mcu_fd_sc_mcu7t5v0__fill_1
XFILLER_83_212 VDD VDD VSS VSS gf180mcu_fd_sc_mcu7t5v0__fillcap_16
XTAP_TAPCELL_ROW_67_933 VDD VSS gf180mcu_fd_sc_mcu7t5v0__filltie
XFILLER_83_256 VDD VDD VSS VSS gf180mcu_fd_sc_mcu7t5v0__fillcap_16
XTAP_TAPCELL_ROW_39_646 VDD VSS gf180mcu_fd_sc_mcu7t5v0__filltie
XFILLER_45_18 VDD VDD VSS VSS gf180mcu_fd_sc_mcu7t5v0__fillcap_4
XPHY_EDGE_ROW_58_Right_58 VDD VSS gf180mcu_fd_sc_mcu7t5v0__endcap
X_3007_ _3007_/D _3021_/CLK _3007_/Q VDD VDD VSS VSS gf180mcu_fd_sc_mcu7t5v0__dffq_1
XFILLER_51_142 VDD VDD VSS VSS gf180mcu_fd_sc_mcu7t5v0__fill_1
XPHY_EDGE_ROW_67_Right_67 VDD VSS gf180mcu_fd_sc_mcu7t5v0__endcap
XFILLER_106_612 VDD VDD VSS VSS gf180mcu_fd_sc_mcu7t5v0__fillcap_4
XFILLER_3_216 VDD VDD VSS VSS gf180mcu_fd_sc_mcu7t5v0__fill_1
XFILLER_106_667 VDD VDD VSS VSS gf180mcu_fd_sc_mcu7t5v0__fillcap_64
XPHY_EDGE_ROW_5_Left_114 VDD VSS gf180mcu_fd_sc_mcu7t5v0__endcap
XFILLER_87_562 VDD VDD VSS VSS gf180mcu_fd_sc_mcu7t5v0__fillcap_8
XPHY_EDGE_ROW_76_Right_76 VDD VSS gf180mcu_fd_sc_mcu7t5v0__endcap
XTAP_TAPCELL_ROW_2_260 VDD VSS gf180mcu_fd_sc_mcu7t5v0__filltie
XFILLER_74_267 VDD VDD VSS VSS gf180mcu_fd_sc_mcu7t5v0__fill_2
XFILLER_43_632 VDD VDD VSS VSS gf180mcu_fd_sc_mcu7t5v0__fillcap_4
XFILLER_43_643 VDD VDD VSS VSS gf180mcu_fd_sc_mcu7t5v0__fillcap_4
XFILLER_55_492 VDD VDD VSS VSS gf180mcu_fd_sc_mcu7t5v0__fillcap_8
XFILLER_30_337 VDD VDD VSS VSS gf180mcu_fd_sc_mcu7t5v0__fill_2
XFILLER_70_484 VDD VDD VSS VSS gf180mcu_fd_sc_mcu7t5v0__fill_1
XPHY_EDGE_ROW_85_Right_85 VDD VSS gf180mcu_fd_sc_mcu7t5v0__endcap
XTAP_TAPCELL_ROW_77_1039 VDD VSS gf180mcu_fd_sc_mcu7t5v0__filltie
XFILLER_97_348 VDD VDD VSS VSS gf180mcu_fd_sc_mcu7t5v0__fill_2
X_2240_ _3135_/Q _3115_/Q _2242_/S _3115_/D VDD VDD VSS VSS gf180mcu_fd_sc_mcu7t5v0__mux2_2
XPHY_EDGE_ROW_94_Right_94 VDD VSS gf180mcu_fd_sc_mcu7t5v0__endcap
X_2171_ _3097_/Q _3215_/Q _2178_/S _3097_/D VDD VDD VSS VSS gf180mcu_fd_sc_mcu7t5v0__mux2_2
XFILLER_65_212 VDD VDD VSS VSS gf180mcu_fd_sc_mcu7t5v0__fillcap_8
XTAP_TAPCELL_ROW_88_1157 VDD VSS gf180mcu_fd_sc_mcu7t5v0__filltie
XFILLER_93_598 VDD VDD VSS VSS gf180mcu_fd_sc_mcu7t5v0__fill_1
XTAP_TAPCELL_ROW_0_219 VDD VSS gf180mcu_fd_sc_mcu7t5v0__filltie
XTAP_TAPCELL_ROW_36_616 VDD VSS gf180mcu_fd_sc_mcu7t5v0__filltie
XTAP_TAPCELL_ROW_64_903 VDD VSS gf180mcu_fd_sc_mcu7t5v0__filltie
XPHY_EDGE_ROW_69_Left_178 VDD VSS gf180mcu_fd_sc_mcu7t5v0__endcap
XFILLER_80_226 VDD VDD VSS VSS gf180mcu_fd_sc_mcu7t5v0__fill_2
XFILLER_80_259 VDD VDD VSS VSS gf180mcu_fd_sc_mcu7t5v0__fill_1
XFILLER_33_142 VDD VDD VSS VSS gf180mcu_fd_sc_mcu7t5v0__fillcap_8
XTAP_TAPCELL_ROW_44_693 VDD VSS gf180mcu_fd_sc_mcu7t5v0__filltie
XFILLER_61_484 VDD VDD VSS VSS gf180mcu_fd_sc_mcu7t5v0__fillcap_4
XTAP_TAPCELL_ROW_72_991 VDD VSS gf180mcu_fd_sc_mcu7t5v0__filltie
X_1955_ _3111_/Q _2975_/Q _1962_/S _2975_/D VDD VDD VSS VSS gf180mcu_fd_sc_mcu7t5v0__mux2_2
XTAP_TAPCELL_ROW_99_1275 VDD VSS gf180mcu_fd_sc_mcu7t5v0__filltie
XPHY_EDGE_ROW_78_Left_187 VDD VSS gf180mcu_fd_sc_mcu7t5v0__endcap
X_1886_ _2917_/Q _3117_/Q _1886_/S _2917_/D VDD VDD VSS VSS gf180mcu_fd_sc_mcu7t5v0__mux2_2
XTAP_TAPCELL_ROW_8_319 VDD VSS gf180mcu_fd_sc_mcu7t5v0__filltie
X_2507_ _3171_/Q _3156_/Q wire13/Z _3171_/D VDD VDD VSS VSS gf180mcu_fd_sc_mcu7t5v0__mux2_2
X_2438_ _3148_/Q _2438_/A2 _2218_/B _2438_/B2 _2439_/A2 VDD VDD VSS VSS gf180mcu_fd_sc_mcu7t5v0__aoi22_1
XFILLER_57_702 VDD VDD VSS VSS gf180mcu_fd_sc_mcu7t5v0__fillcap_16
XFILLER_69_562 VDD VDD VSS VSS gf180mcu_fd_sc_mcu7t5v0__fillcap_8
XFILLER_29_426 VDD VDD VSS VSS gf180mcu_fd_sc_mcu7t5v0__fill_1
XFILLER_56_201 VDD VDD VSS VSS gf180mcu_fd_sc_mcu7t5v0__fillcap_4
X_2369_ _3135_/Q _2407_/B _2369_/B _2370_/A2 VDD VDD VSS VSS gf180mcu_fd_sc_mcu7t5v0__oai21_1
XPHY_EDGE_ROW_87_Left_196 VDD VSS gf180mcu_fd_sc_mcu7t5v0__endcap
XFILLER_29_459 VDD VDD VSS VSS gf180mcu_fd_sc_mcu7t5v0__fillcap_8
XFILLER_56_278 VDD VDD VSS VSS gf180mcu_fd_sc_mcu7t5v0__fill_2
XTAP_TAPCELL_ROW_108_1382 VDD VSS gf180mcu_fd_sc_mcu7t5v0__filltie
XTAP_TAPCELL_ROW_108_1371 VDD VSS gf180mcu_fd_sc_mcu7t5v0__filltie
XFILLER_25_632 VDD VDD VSS VSS gf180mcu_fd_sc_mcu7t5v0__fillcap_4
XFILLER_37_492 VDD VDD VSS VSS gf180mcu_fd_sc_mcu7t5v0__fillcap_4
XFILLER_12_304 VDD VDD VSS VSS gf180mcu_fd_sc_mcu7t5v0__fillcap_8
XFILLER_25_698 VDD VDD VSS VSS gf180mcu_fd_sc_mcu7t5v0__fill_2
XFILLER_40_613 VDD VDD VSS VSS gf180mcu_fd_sc_mcu7t5v0__fillcap_4
XFILLER_40_657 VDD VDD VSS VSS gf180mcu_fd_sc_mcu7t5v0__fillcap_8
XFILLER_40_679 VDD VDD VSS VSS gf180mcu_fd_sc_mcu7t5v0__fill_1
XFILLER_20_381 VDD VDD VSS VSS gf180mcu_fd_sc_mcu7t5v0__fillcap_4
XFILLER_108_2 VDD VDD VSS VSS gf180mcu_fd_sc_mcu7t5v0__fillcap_32
XFILLER_97_57 VDD VDD VSS VSS gf180mcu_fd_sc_mcu7t5v0__fill_2
XFILLER_79_348 VDD VDD VSS VSS gf180mcu_fd_sc_mcu7t5v0__fill_2
XFILLER_79_359 VDD VDD VSS VSS gf180mcu_fd_sc_mcu7t5v0__fillcap_32
XFILLER_0_764 VDD VDD VSS VSS gf180mcu_fd_sc_mcu7t5v0__fill_1
XFILLER_47_212 VDD VDD VSS VSS gf180mcu_fd_sc_mcu7t5v0__fillcap_8
XFILLER_90_524 VDD VDD VSS VSS gf180mcu_fd_sc_mcu7t5v0__fill_1
XFILLER_47_278 VDD VDD VSS VSS gf180mcu_fd_sc_mcu7t5v0__fill_2
XFILLER_90_557 VDD VDD VSS VSS gf180mcu_fd_sc_mcu7t5v0__fill_1
XFILLER_62_226 VDD VDD VSS VSS gf180mcu_fd_sc_mcu7t5v0__fillcap_4
XFILLER_15_142 VDD VDD VSS VSS gf180mcu_fd_sc_mcu7t5v0__fill_2
XFILLER_15_175 VDD VDD VSS VSS gf180mcu_fd_sc_mcu7t5v0__fill_1
XTAP_TAPCELL_ROW_41_663 VDD VSS gf180mcu_fd_sc_mcu7t5v0__filltie
X_1740_ _3406_/Q _3407_/Q _1851_/A1 _1748_/S VDD VDD VSS VSS gf180mcu_fd_sc_mcu7t5v0__nand3_1
XFILLER_7_330 VDD VDD VSS VSS gf180mcu_fd_sc_mcu7t5v0__fill_2
X_1671_ _2286_/B _1671_/A2 _1672_/C VDD VDD VSS VSS gf180mcu_fd_sc_mcu7t5v0__nand2_1
XFILLER_7_352 VDD VDD VSS VSS gf180mcu_fd_sc_mcu7t5v0__fillcap_32
X_3410_ _3410_/D _3416_/RN _3410_/CLK _3410_/Q VDD VDD VSS VSS gf180mcu_fd_sc_mcu7t5v0__dffrnq_1
X_3341_ _3360_/Q _3369_/RN _3352_/CLK hold45/I VDD VDD VSS VSS gf180mcu_fd_sc_mcu7t5v0__dffrnq_1
XFILLER_98_657 VDD VDD VSS VSS gf180mcu_fd_sc_mcu7t5v0__fill_2
X_3272_ _3272_/D _3328_/RN _3273_/CLK _3272_/Q VDD VDD VSS VSS gf180mcu_fd_sc_mcu7t5v0__dffrnq_1
XFILLER_39_702 VDD VDD VSS VSS gf180mcu_fd_sc_mcu7t5v0__fill_2
XFILLER_97_189 VDD VDD VSS VSS gf180mcu_fd_sc_mcu7t5v0__fillcap_16
X_2223_ _2223_/A1 _2223_/A2 _2267_/C _2226_/A3 VDD VDD VSS VSS gf180mcu_fd_sc_mcu7t5v0__aoi21_1
XFILLER_78_381 VDD VDD VSS VSS gf180mcu_fd_sc_mcu7t5v0__fillcap_4
XFILLER_23_2 VDD VDD VSS VSS gf180mcu_fd_sc_mcu7t5v0__fillcap_16
XFILLER_93_340 VDD VDD VSS VSS gf180mcu_fd_sc_mcu7t5v0__fill_2
X_2154_ _3233_/Q _3083_/Q _2165_/S _3083_/D VDD VDD VSS VSS gf180mcu_fd_sc_mcu7t5v0__mux2_2
XFILLER_38_256 VDD VDD VSS VSS gf180mcu_fd_sc_mcu7t5v0__fillcap_32
XTAP_TAPCELL_ROW_49_752 VDD VSS gf180mcu_fd_sc_mcu7t5v0__filltie
XFILLER_93_395 VDD VDD VSS VSS gf180mcu_fd_sc_mcu7t5v0__fillcap_16
XFILLER_19_492 VDD VDD VSS VSS gf180mcu_fd_sc_mcu7t5v0__fillcap_8
X_2085_ _2381_/A2 _2091_/B _2085_/B1 _2085_/B2 _3046_/D VDD VDD VSS VSS gf180mcu_fd_sc_mcu7t5v0__aoi22_1
X_2987_ _2987_/D _2988_/CLK _2987_/Q VDD VDD VSS VSS gf180mcu_fd_sc_mcu7t5v0__dffq_1
X_1938_ _2960_/Q _3112_/Q _1944_/S _2960_/D VDD VDD VSS VSS gf180mcu_fd_sc_mcu7t5v0__mux2_2
X_1869_ _3364_/Q _1869_/A2 _1879_/A3 _1876_/S VDD VDD VSS VSS gf180mcu_fd_sc_mcu7t5v0__nor3_1
XPHY_EDGE_ROW_95_Left_204 VDD VSS gf180mcu_fd_sc_mcu7t5v0__endcap
XFILLER_103_489 VDD VDD VSS VSS gf180mcu_fd_sc_mcu7t5v0__fill_1
XFILLER_88_189 VDD VDD VSS VSS gf180mcu_fd_sc_mcu7t5v0__fill_1
XFILLER_29_245 VDD VDD VSS VSS gf180mcu_fd_sc_mcu7t5v0__fill_1
XFILLER_84_373 VDD VDD VSS VSS gf180mcu_fd_sc_mcu7t5v0__fill_1
XFILLER_84_384 VDD VDD VSS VSS gf180mcu_fd_sc_mcu7t5v0__fill_1
XFILLER_83_59 VDD VDD VSS VSS gf180mcu_fd_sc_mcu7t5v0__fill_1
XFILLER_16_53 VDD VDD VSS VSS gf180mcu_fd_sc_mcu7t5v0__fill_2
XFILLER_52_270 VDD VDD VSS VSS gf180mcu_fd_sc_mcu7t5v0__fill_1
XFILLER_12_145 VDD VDD VSS VSS gf180mcu_fd_sc_mcu7t5v0__fill_1
XFILLER_40_443 VDD VDD VSS VSS gf180mcu_fd_sc_mcu7t5v0__fillcap_8
XFILLER_32_52 VDD VDD VSS VSS gf180mcu_fd_sc_mcu7t5v0__fillcap_4
XTAP_TAPCELL_ROW_10_335 VDD VSS gf180mcu_fd_sc_mcu7t5v0__filltie
XFILLER_4_333 VDD VDD VSS VSS gf180mcu_fd_sc_mcu7t5v0__fillcap_4
XTAP_TAPCELL_ROW_74_1009 VDD VSS gf180mcu_fd_sc_mcu7t5v0__filltie
XFILLER_95_638 VDD VDD VSS VSS gf180mcu_fd_sc_mcu7t5v0__fillcap_32
XFILLER_94_104 VDD VDD VSS VSS gf180mcu_fd_sc_mcu7t5v0__fill_1
XFILLER_48_510 VDD VDD VSS VSS gf180mcu_fd_sc_mcu7t5v0__fill_1
XTAP_TAPCELL_ROW_85_1127 VDD VSS gf180mcu_fd_sc_mcu7t5v0__filltie
XTAP_TAPCELL_ROW_18_424 VDD VSS gf180mcu_fd_sc_mcu7t5v0__filltie
XTAP_TAPCELL_ROW_46_722 VDD VSS gf180mcu_fd_sc_mcu7t5v0__filltie
XFILLER_90_387 VDD VDD VSS VSS gf180mcu_fd_sc_mcu7t5v0__fillcap_4
X_2910_ _2910_/D _2926_/CLK _2910_/Q VDD VDD VSS VSS gf180mcu_fd_sc_mcu7t5v0__dffq_1
X_2841_ _2841_/D _3406_/CLK _2841_/Q VDD VDD VSS VSS gf180mcu_fd_sc_mcu7t5v0__dffq_1
X_2772_ _2772_/D _3315_/CLK _2772_/Q VDD VDD VSS VSS gf180mcu_fd_sc_mcu7t5v0__dffq_1
X_1723_ _2777_/Q _3282_/Q _1728_/S _2777_/D VDD VDD VSS VSS gf180mcu_fd_sc_mcu7t5v0__mux2_2
XTAP_TAPCELL_ROW_96_1245 VDD VSS gf180mcu_fd_sc_mcu7t5v0__filltie
X_1654_ _2224_/A1 _2431_/B _2190_/C VDD VDD VSS VSS gf180mcu_fd_sc_mcu7t5v0__nand2_1
X_1585_ _3348_/Q _3358_/D _1586_/A3 VDD VDD VSS VSS gf180mcu_fd_sc_mcu7t5v0__xnor2_1
XFILLER_86_605 VDD VDD VSS VSS gf180mcu_fd_sc_mcu7t5v0__fill_2
X_3324_ hold41/Z _3369_/RN _3324_/CLK _3324_/Q VDD VDD VSS VSS gf180mcu_fd_sc_mcu7t5v0__dffrnq_1
XFILLER_98_476 VDD VDD VSS VSS gf180mcu_fd_sc_mcu7t5v0__fillcap_4
X_3255_ _3255_/D _3369_/RN _3325_/CLK _3255_/Q VDD VDD VSS VSS gf180mcu_fd_sc_mcu7t5v0__dffrnq_1
X_2206_ _2894_/Q _2886_/Q _2878_/Q _2870_/Q _2400_/S0 _2390_/S1 _2206_/Z VDD VDD VSS
+ VSS gf180mcu_fd_sc_mcu7t5v0__mux4_1
X_3186_ _3186_/D _3328_/RN _3240_/CLK _3186_/Q VDD VDD VSS VSS gf180mcu_fd_sc_mcu7t5v0__dffrnq_1
X_2137_ _3216_/Q _3066_/Q _2166_/S _3066_/D VDD VDD VSS VSS gf180mcu_fd_sc_mcu7t5v0__mux2_2
XFILLER_53_18 VDD VDD VSS VSS gf180mcu_fd_sc_mcu7t5v0__fillcap_8
X_2068_ _2111_/A1 _2068_/A2 _2069_/A2 VDD VDD VSS VSS gf180mcu_fd_sc_mcu7t5v0__nor2_1
XTAP_TAPCELL_ROW_105_1341 VDD VSS gf180mcu_fd_sc_mcu7t5v0__filltie
XFILLER_34_292 VDD VDD VSS VSS gf180mcu_fd_sc_mcu7t5v0__fill_2
XFILLER_78_37 VDD VDD VSS VSS gf180mcu_fd_sc_mcu7t5v0__fillcap_32
XFILLER_77_638 VDD VDD VSS VSS gf180mcu_fd_sc_mcu7t5v0__fill_1
XFILLER_49_329 VDD VDD VSS VSS gf180mcu_fd_sc_mcu7t5v0__fillcap_16
XFILLER_94_14 VDD VDD VSS VSS gf180mcu_fd_sc_mcu7t5v0__fill_1
XFILLER_45_535 VDD VDD VSS VSS gf180mcu_fd_sc_mcu7t5v0__fillcap_16
XFILLER_45_579 VDD VDD VSS VSS gf180mcu_fd_sc_mcu7t5v0__fill_1
XFILLER_60_505 VDD VDD VSS VSS gf180mcu_fd_sc_mcu7t5v0__fillcap_4
XFILLER_26_760 VDD VDD VSS VSS gf180mcu_fd_sc_mcu7t5v0__fillcap_4
XFILLER_60_527 VDD VDD VSS VSS gf180mcu_fd_sc_mcu7t5v0__fillcap_8
XFILLER_72_387 VDD VDD VSS VSS gf180mcu_fd_sc_mcu7t5v0__fillcap_4
XFILLER_41_741 VDD VDD VSS VSS gf180mcu_fd_sc_mcu7t5v0__fill_2
XTAP_TAPCELL_ROW_80_1079 VDD VSS gf180mcu_fd_sc_mcu7t5v0__filltie
XTAP_TAPCELL_ROW_23_471 VDD VSS gf180mcu_fd_sc_mcu7t5v0__filltie
XFILLER_4_34 VDD VDD VSS VSS gf180mcu_fd_sc_mcu7t5v0__fill_1
XFILLER_4_163 VDD VDD VSS VSS gf180mcu_fd_sc_mcu7t5v0__fillcap_8
X_1370_ _3415_/D _2413_/A1 VDD VDD VSS VSS gf180mcu_fd_sc_mcu7t5v0__clkinv_1
XFILLER_95_402 VDD VDD VSS VSS gf180mcu_fd_sc_mcu7t5v0__fill_2
XTAP_TAPCELL_ROW_91_1186 VDD VSS gf180mcu_fd_sc_mcu7t5v0__filltie
XFILLER_82_107 VDD VDD VSS VSS gf180mcu_fd_sc_mcu7t5v0__fill_1
XFILLER_36_502 VDD VDD VSS VSS gf180mcu_fd_sc_mcu7t5v0__fillcap_4
XFILLER_48_351 VDD VDD VSS VSS gf180mcu_fd_sc_mcu7t5v0__fillcap_32
X_3040_ _3040_/D _3416_/RN _3410_/CLK _3040_/Q VDD VDD VSS VSS gf180mcu_fd_sc_mcu7t5v0__dffrnq_1
XFILLER_90_173 VDD VDD VSS VSS gf180mcu_fd_sc_mcu7t5v0__fill_2
XFILLER_32_730 VDD VDD VSS VSS gf180mcu_fd_sc_mcu7t5v0__fillcap_4
XFILLER_90_2 VDD VDD VSS VSS gf180mcu_fd_sc_mcu7t5v0__fillcap_32
XFILLER_31_262 VDD VDD VSS VSS gf180mcu_fd_sc_mcu7t5v0__fillcap_4
X_2824_ _2824_/D _2887_/CLK _2824_/Q VDD VDD VSS VSS gf180mcu_fd_sc_mcu7t5v0__dffq_1
XTAP_TAPCELL_ROW_100_1282 VDD VSS gf180mcu_fd_sc_mcu7t5v0__filltie
X_2755_ _3229_/Q _3295_/Q _2763_/S _3295_/D VDD VDD VSS VSS gf180mcu_fd_sc_mcu7t5v0__mux2_2
X_1706_ _3142_/Q _2431_/B _1706_/Z VDD VDD VSS VSS gf180mcu_fd_sc_mcu7t5v0__or2_1
X_2686_ _3256_/Q _2680_/C _2731_/B1 _3074_/Q _2689_/A1 VDD VDD VSS VSS gf180mcu_fd_sc_mcu7t5v0__aoi22_1
X_1637_ _2765_/Q _2289_/A1 _1637_/Z VDD VDD VSS VSS gf180mcu_fd_sc_mcu7t5v0__and2_1
XFILLER_101_702 VDD VDD VSS VSS gf180mcu_fd_sc_mcu7t5v0__fill_2
XFILLER_86_413 VDD VDD VSS VSS gf180mcu_fd_sc_mcu7t5v0__fill_1
X_1568_ _3307_/Q _1568_/A2 _1568_/B _1570_/A2 VDD VDD VSS VSS gf180mcu_fd_sc_mcu7t5v0__aoi21_1
X_3307_ _3307_/D _3416_/RN _3311_/CLK _3307_/Q VDD VDD VSS VSS gf180mcu_fd_sc_mcu7t5v0__dffsnq_1
XFILLER_86_457 VDD VDD VSS VSS gf180mcu_fd_sc_mcu7t5v0__fillcap_8
X_1499_ _3366_/Q _3367_/Q _1879_/A3 VDD VDD VSS VSS gf180mcu_fd_sc_mcu7t5v0__nand2_1
X_3238_ _3238_/D _3369_/RN _3327_/CLK _3238_/Q VDD VDD VSS VSS gf180mcu_fd_sc_mcu7t5v0__dffrnq_1
XTAP_TAPCELL_ROW_57_828 VDD VSS gf180mcu_fd_sc_mcu7t5v0__filltie
X_3169_ _3169_/D _3328_/RN clkload7/I _3169_/Q VDD VDD VSS VSS gf180mcu_fd_sc_mcu7t5v0__dffrnq_1
XFILLER_82_652 VDD VDD VSS VSS gf180mcu_fd_sc_mcu7t5v0__fillcap_8
XFILLER_42_527 VDD VDD VSS VSS gf180mcu_fd_sc_mcu7t5v0__fillcap_8
XFILLER_23_730 VDD VDD VSS VSS gf180mcu_fd_sc_mcu7t5v0__fill_1
XFILLER_50_593 VDD VDD VSS VSS gf180mcu_fd_sc_mcu7t5v0__fill_2
XTAP_TAPCELL_ROW_20_441 VDD VSS gf180mcu_fd_sc_mcu7t5v0__filltie
XFILLER_89_36 VDD VDD VSS VSS gf180mcu_fd_sc_mcu7t5v0__fillcap_16
XFILLER_2_612 VDD VDD VSS VSS gf180mcu_fd_sc_mcu7t5v0__fillcap_8
XFILLER_2_656 VDD VDD VSS VSS gf180mcu_fd_sc_mcu7t5v0__fillcap_8
XFILLER_2_667 VDD VDD VSS VSS gf180mcu_fd_sc_mcu7t5v0__fillcap_16
XFILLER_1_166 VDD VDD VSS VSS gf180mcu_fd_sc_mcu7t5v0__fill_2
XFILLER_89_295 VDD VDD VSS VSS gf180mcu_fd_sc_mcu7t5v0__fill_2
XFILLER_92_405 VDD VDD VSS VSS gf180mcu_fd_sc_mcu7t5v0__fill_1
XFILLER_64_107 VDD VDD VSS VSS gf180mcu_fd_sc_mcu7t5v0__fillcap_4
XFILLER_58_671 VDD VDD VSS VSS gf180mcu_fd_sc_mcu7t5v0__fill_1
XTAP_TAPCELL_ROW_28_530 VDD VSS gf180mcu_fd_sc_mcu7t5v0__filltie
XFILLER_72_173 VDD VDD VSS VSS gf180mcu_fd_sc_mcu7t5v0__fill_2
XFILLER_26_590 VDD VDD VSS VSS gf180mcu_fd_sc_mcu7t5v0__fillcap_4
XFILLER_13_240 VDD VDD VSS VSS gf180mcu_fd_sc_mcu7t5v0__fill_2
XFILLER_9_244 VDD VDD VSS VSS gf180mcu_fd_sc_mcu7t5v0__fill_2
Xclkload25 _3416_/CLK clkload25/Z VDD VDD VSS VSS gf180mcu_fd_sc_mcu7t5v0__clkbuf_1
Xclkload14 _3273_/CLK clkload14/Z VDD VDD VSS VSS gf180mcu_fd_sc_mcu7t5v0__clkbuf_1
Xclkload47 _3399_/CLK clkload47/Z VDD VDD VSS VSS gf180mcu_fd_sc_mcu7t5v0__clkbuf_1
XTAP_TAPCELL_ROW_93_1215 VDD VSS gf180mcu_fd_sc_mcu7t5v0__filltie
Xclkload36 _2982_/CLK clkload36/ZN VDD VDD VSS VSS gf180mcu_fd_sc_mcu7t5v0__inv_2
X_2540_ _3203_/Q _3195_/Q _2540_/S _3203_/D VDD VDD VSS VSS gf180mcu_fd_sc_mcu7t5v0__mux2_2
Xclkload58 _3406_/CLK clkload58/ZN VDD VDD VSS VSS gf180mcu_fd_sc_mcu7t5v0__clkinv_8
X_2471_ _3158_/Q _2471_/A2 _2457_/Z _2471_/B _2472_/A2 VDD VDD VSS VSS gf180mcu_fd_sc_mcu7t5v0__oai31_1
XFILLER_79_80 VDD VDD VSS VSS gf180mcu_fd_sc_mcu7t5v0__fillcap_4
X_1422_ _3253_/Q _2678_/A1 VDD VDD VSS VSS gf180mcu_fd_sc_mcu7t5v0__clkinv_1
Xclkbuf_0_clk_i clk_i clkbuf_0_clk_i/Z VDD VDD VSS VSS gf180mcu_fd_sc_mcu7t5v0__clkbuf_16
XPHY_EDGE_ROW_50_Left_159 VDD VSS gf180mcu_fd_sc_mcu7t5v0__endcap
XFILLER_68_457 VDD VDD VSS VSS gf180mcu_fd_sc_mcu7t5v0__fill_2
X_3023_ _3023_/D _3416_/RN _3416_/CLK _3023_/Q VDD VDD VSS VSS gf180mcu_fd_sc_mcu7t5v0__dffrnq_1
XFILLER_36_321 VDD VDD VSS VSS gf180mcu_fd_sc_mcu7t5v0__fill_1
XFILLER_36_365 VDD VDD VSS VSS gf180mcu_fd_sc_mcu7t5v0__fill_2
XFILLER_36_387 VDD VDD VSS VSS gf180mcu_fd_sc_mcu7t5v0__fillcap_16
XFILLER_64_696 VDD VDD VSS VSS gf180mcu_fd_sc_mcu7t5v0__fillcap_8
XTAP_TAPCELL_ROW_102_1300 VDD VSS gf180mcu_fd_sc_mcu7t5v0__filltie
XFILLER_32_593 VDD VDD VSS VSS gf180mcu_fd_sc_mcu7t5v0__fill_2
XTAP_TAPCELL_ROW_34_588 VDD VSS gf180mcu_fd_sc_mcu7t5v0__filltie
XTAP_TAPCELL_ROW_62_886 VDD VSS gf180mcu_fd_sc_mcu7t5v0__filltie
Xclkload8 clkload8/I clkload8/ZN VDD VDD VSS VSS gf180mcu_fd_sc_mcu7t5v0__clkinv_2
X_2807_ _2807_/D _3408_/CLK _2807_/Q VDD VDD VSS VSS gf180mcu_fd_sc_mcu7t5v0__dffq_1
X_2738_ _3317_/D _2746_/S _3279_/D VDD VDD VSS VSS gf180mcu_fd_sc_mcu7t5v0__xnor2_1
X_2669_ _2668_/Z _2667_/Z _2665_/Z _2666_/Z _3353_/Q _3354_/Q _2669_/Z VDD VDD VSS
+ VSS gf180mcu_fd_sc_mcu7t5v0__mux4_1
XFILLER_86_210 VDD VDD VSS VSS gf180mcu_fd_sc_mcu7t5v0__fill_2
XFILLER_86_265 VDD VDD VSS VSS gf180mcu_fd_sc_mcu7t5v0__fillcap_4
XFILLER_39_170 VDD VDD VSS VSS gf180mcu_fd_sc_mcu7t5v0__fill_2
XFILLER_46_107 VDD VDD VSS VSS gf180mcu_fd_sc_mcu7t5v0__fillcap_64
XFILLER_39_192 VDD VDD VSS VSS gf180mcu_fd_sc_mcu7t5v0__fill_2
XTAP_TAPCELL_ROW_25_500 VDD VSS gf180mcu_fd_sc_mcu7t5v0__filltie
XFILLER_54_140 VDD VDD VSS VSS gf180mcu_fd_sc_mcu7t5v0__fill_1
XFILLER_55_674 VDD VDD VSS VSS gf180mcu_fd_sc_mcu7t5v0__fillcap_16
XFILLER_91_37 VDD VDD VSS VSS gf180mcu_fd_sc_mcu7t5v0__fill_2
XFILLER_82_482 VDD VDD VSS VSS gf180mcu_fd_sc_mcu7t5v0__fillcap_16
XFILLER_70_655 VDD VDD VSS VSS gf180mcu_fd_sc_mcu7t5v0__fillcap_8
XFILLER_11_744 VDD VDD VSS VSS gf180mcu_fd_sc_mcu7t5v0__fillcap_16
XFILLER_24_97 VDD VDD VSS VSS gf180mcu_fd_sc_mcu7t5v0__fillcap_8
XFILLER_6_247 VDD VDD VSS VSS gf180mcu_fd_sc_mcu7t5v0__fillcap_8
XFILLER_40_41 VDD VDD VSS VSS gf180mcu_fd_sc_mcu7t5v0__fill_1
XFILLER_104_381 VDD VDD VSS VSS gf180mcu_fd_sc_mcu7t5v0__fillcap_4
XFILLER_77_254 VDD VDD VSS VSS gf180mcu_fd_sc_mcu7t5v0__fillcap_8
XFILLER_77_298 VDD VDD VSS VSS gf180mcu_fd_sc_mcu7t5v0__fill_2
XTAP_TAPCELL_ROW_5_291 VDD VSS gf180mcu_fd_sc_mcu7t5v0__filltie
XFILLER_80_419 VDD VDD VSS VSS gf180mcu_fd_sc_mcu7t5v0__fillcap_16
XFILLER_18_354 VDD VDD VSS VSS gf180mcu_fd_sc_mcu7t5v0__fillcap_8
XFILLER_61_600 VDD VDD VSS VSS gf180mcu_fd_sc_mcu7t5v0__fill_2
XFILLER_18_387 VDD VDD VSS VSS gf180mcu_fd_sc_mcu7t5v0__fillcap_16
XFILLER_33_346 VDD VDD VSS VSS gf180mcu_fd_sc_mcu7t5v0__fillcap_4
X_1971_ _3118_/Q _2990_/Q _1971_/S _2990_/D VDD VDD VSS VSS gf180mcu_fd_sc_mcu7t5v0__mux2_2
XFILLER_61_699 VDD VDD VSS VSS gf180mcu_fd_sc_mcu7t5v0__fill_1
XFILLER_81_92 VDD VDD VSS VSS gf180mcu_fd_sc_mcu7t5v0__fill_2
XTAP_TAPCELL_ROW_31_558 VDD VSS gf180mcu_fd_sc_mcu7t5v0__filltie
X_2523_ _3186_/Q _3178_/Q _2534_/S _3186_/D VDD VDD VSS VSS gf180mcu_fd_sc_mcu7t5v0__mux2_2
XFILLER_53_2 VDD VDD VSS VSS gf180mcu_fd_sc_mcu7t5v0__fillcap_16
XFILLER_88_519 VDD VDD VSS VSS gf180mcu_fd_sc_mcu7t5v0__fillcap_4
X_2454_ _3277_/Q _2466_/B1 _2467_/B1 _3261_/Q _2456_/A3 VDD VDD VSS VSS gf180mcu_fd_sc_mcu7t5v0__aoi22_1
X_1405_ _3157_/Q _2458_/B VDD VDD VSS VSS gf180mcu_fd_sc_mcu7t5v0__clkinv_1
X_2385_ _2796_/Q _2788_/Q _2780_/Q _2772_/Q _3391_/Q _2388_/S1 _2385_/Z VDD VDD VSS
+ VSS gf180mcu_fd_sc_mcu7t5v0__mux4_1
XFILLER_84_714 VDD VDD VSS VSS gf180mcu_fd_sc_mcu7t5v0__fillcap_16
XFILLER_56_405 VDD VDD VSS VSS gf180mcu_fd_sc_mcu7t5v0__fill_1
XFILLER_68_243 VDD VDD VSS VSS gf180mcu_fd_sc_mcu7t5v0__fill_2
XFILLER_96_585 VDD VDD VSS VSS gf180mcu_fd_sc_mcu7t5v0__fill_2
Xinput1 input1/I input1/Z VDD VDD VSS VSS gf180mcu_fd_sc_mcu7t5v0__buf_8
XFILLER_28_107 VDD VDD VSS VSS gf180mcu_fd_sc_mcu7t5v0__fillcap_16
XTAP_TAPCELL_ROW_67_934 VDD VSS gf180mcu_fd_sc_mcu7t5v0__filltie
XTAP_TAPCELL_ROW_39_647 VDD VSS gf180mcu_fd_sc_mcu7t5v0__filltie
XFILLER_24_302 VDD VDD VSS VSS gf180mcu_fd_sc_mcu7t5v0__fill_1
X_3006_ _3006_/D _3366_/CLK _3006_/Q VDD VDD VSS VSS gf180mcu_fd_sc_mcu7t5v0__dffq_1
XFILLER_24_313 VDD VDD VSS VSS gf180mcu_fd_sc_mcu7t5v0__fill_2
XFILLER_20_585 VDD VDD VSS VSS gf180mcu_fd_sc_mcu7t5v0__fillcap_8
XFILLER_86_37 VDD VDD VSS VSS gf180mcu_fd_sc_mcu7t5v0__fillcap_16
XFILLER_87_574 VDD VDD VSS VSS gf180mcu_fd_sc_mcu7t5v0__fill_2
XFILLER_19_64 VDD VDD VSS VSS gf180mcu_fd_sc_mcu7t5v0__fillcap_4
XFILLER_47_416 VDD VDD VSS VSS gf180mcu_fd_sc_mcu7t5v0__fillcap_4
XFILLER_47_438 VDD VDD VSS VSS gf180mcu_fd_sc_mcu7t5v0__fill_2
XFILLER_28_630 VDD VDD VSS VSS gf180mcu_fd_sc_mcu7t5v0__fill_1
XTAP_TAPCELL_ROW_2_250 VDD VSS gf180mcu_fd_sc_mcu7t5v0__filltie
XFILLER_62_408 VDD VDD VSS VSS gf180mcu_fd_sc_mcu7t5v0__fillcap_32
XPHY_EDGE_ROW_106_Left_215 VDD VSS gf180mcu_fd_sc_mcu7t5v0__endcap
XFILLER_70_463 VDD VDD VSS VSS gf180mcu_fd_sc_mcu7t5v0__fill_1
XFILLER_70_474 VDD VDD VSS VSS gf180mcu_fd_sc_mcu7t5v0__fillcap_8
XFILLER_51_40 VDD VDD VSS VSS gf180mcu_fd_sc_mcu7t5v0__fillcap_16
XFILLER_7_545 VDD VDD VSS VSS gf180mcu_fd_sc_mcu7t5v0__fillcap_8
XFILLER_51_95 VDD VDD VSS VSS gf180mcu_fd_sc_mcu7t5v0__fill_2
XFILLER_7_578 VDD VDD VSS VSS gf180mcu_fd_sc_mcu7t5v0__fillcap_8
XFILLER_3_762 VDD VDD VSS VSS gf180mcu_fd_sc_mcu7t5v0__fill_2
XFILLER_78_585 VDD VDD VSS VSS gf180mcu_fd_sc_mcu7t5v0__fillcap_8
XFILLER_38_427 VDD VDD VSS VSS gf180mcu_fd_sc_mcu7t5v0__fill_2
X_2170_ _3096_/Q _3214_/Q _2178_/S _3096_/D VDD VDD VSS VSS gf180mcu_fd_sc_mcu7t5v0__mux2_2
Xclkbuf_leaf_16_clk_i clkload1/I _3416_/CLK VDD VDD VSS VSS gf180mcu_fd_sc_mcu7t5v0__clkbuf_4
XFILLER_65_224 VDD VDD VSS VSS gf180mcu_fd_sc_mcu7t5v0__fill_2
XTAP_TAPCELL_ROW_88_1158 VDD VSS gf180mcu_fd_sc_mcu7t5v0__filltie
XFILLER_81_728 VDD VDD VSS VSS gf180mcu_fd_sc_mcu7t5v0__fill_1
XFILLER_19_663 VDD VDD VSS VSS gf180mcu_fd_sc_mcu7t5v0__fillcap_4
XTAP_TAPCELL_ROW_36_617 VDD VSS gf180mcu_fd_sc_mcu7t5v0__filltie
XTAP_TAPCELL_ROW_64_904 VDD VSS gf180mcu_fd_sc_mcu7t5v0__filltie
XTAP_TAPCELL_ROW_72_992 VDD VSS gf180mcu_fd_sc_mcu7t5v0__filltie
XFILLER_21_349 VDD VDD VSS VSS gf180mcu_fd_sc_mcu7t5v0__fill_1
X_1954_ _1991_/A1 _1935_/Z _1962_/S VDD VDD VSS VSS gf180mcu_fd_sc_mcu7t5v0__nand2_1
XTAP_TAPCELL_ROW_44_694 VDD VSS gf180mcu_fd_sc_mcu7t5v0__filltie
XTAP_TAPCELL_ROW_99_1276 VDD VSS gf180mcu_fd_sc_mcu7t5v0__filltie
X_1885_ _2916_/Q _3116_/Q _1886_/S _2916_/D VDD VDD VSS VSS gf180mcu_fd_sc_mcu7t5v0__mux2_2
X_2506_ _3170_/Q _3155_/Q wire13/Z _3170_/D VDD VDD VSS VSS gf180mcu_fd_sc_mcu7t5v0__mux2_2
X_2437_ _3148_/Q _3147_/Q _2439_/A1 VDD VDD VSS VSS gf180mcu_fd_sc_mcu7t5v0__nor2_1
XFILLER_96_382 VDD VDD VSS VSS gf180mcu_fd_sc_mcu7t5v0__fill_2
XFILLER_84_522 VDD VDD VSS VSS gf180mcu_fd_sc_mcu7t5v0__fill_2
XFILLER_56_18 VDD VDD VSS VSS gf180mcu_fd_sc_mcu7t5v0__fill_1
X_2368_ _2407_/A1 _2368_/A2 _2407_/B _2368_/C _2369_/B VDD VDD VSS VSS gf180mcu_fd_sc_mcu7t5v0__oai211_1
X_2299_ _2190_/C _2316_/A2 _2297_/Z _2299_/B _2300_/B2 VDD VDD VSS VSS gf180mcu_fd_sc_mcu7t5v0__oai31_1
XTAP_TAPCELL_ROW_108_1383 VDD VSS gf180mcu_fd_sc_mcu7t5v0__filltie
XTAP_TAPCELL_ROW_108_1372 VDD VSS gf180mcu_fd_sc_mcu7t5v0__filltie
XFILLER_25_622 VDD VDD VSS VSS gf180mcu_fd_sc_mcu7t5v0__fillcap_8
XFILLER_40_625 VDD VDD VSS VSS gf180mcu_fd_sc_mcu7t5v0__fillcap_32
XFILLER_52_463 VDD VDD VSS VSS gf180mcu_fd_sc_mcu7t5v0__fillcap_16
XFILLER_12_349 VDD VDD VSS VSS gf180mcu_fd_sc_mcu7t5v0__fillcap_8
XFILLER_20_360 VDD VDD VSS VSS gf180mcu_fd_sc_mcu7t5v0__fill_2
XFILLER_106_410 VDD VDD VSS VSS gf180mcu_fd_sc_mcu7t5v0__fill_1
XFILLER_21_76 VDD VDD VSS VSS gf180mcu_fd_sc_mcu7t5v0__fill_1
XFILLER_106_454 VDD VDD VSS VSS gf180mcu_fd_sc_mcu7t5v0__fill_1
XFILLER_94_308 VDD VDD VSS VSS gf180mcu_fd_sc_mcu7t5v0__fillcap_4
XFILLER_48_758 VDD VDD VSS VSS gf180mcu_fd_sc_mcu7t5v0__fillcap_4
XFILLER_35_419 VDD VDD VSS VSS gf180mcu_fd_sc_mcu7t5v0__fill_1
XFILLER_46_84 VDD VDD VSS VSS gf180mcu_fd_sc_mcu7t5v0__fillcap_16
XFILLER_55_290 VDD VDD VSS VSS gf180mcu_fd_sc_mcu7t5v0__fillcap_4
XFILLER_43_474 VDD VDD VSS VSS gf180mcu_fd_sc_mcu7t5v0__fill_1
XFILLER_62_61 VDD VDD VSS VSS gf180mcu_fd_sc_mcu7t5v0__fill_1
XTAP_TAPCELL_ROW_13_366 VDD VSS gf180mcu_fd_sc_mcu7t5v0__filltie
XTAP_TAPCELL_ROW_41_664 VDD VSS gf180mcu_fd_sc_mcu7t5v0__filltie
XFILLER_7_34 VDD VDD VSS VSS gf180mcu_fd_sc_mcu7t5v0__fill_2
X_1670_ _1702_/C _1701_/B _1672_/B VDD VDD VSS VSS gf180mcu_fd_sc_mcu7t5v0__nor2_1
XFILLER_7_89 VDD VDD VSS VSS gf180mcu_fd_sc_mcu7t5v0__fill_1
X_3340_ _3340_/D input1/Z _3358_/CLK _3340_/Q VDD VDD VSS VSS gf180mcu_fd_sc_mcu7t5v0__dffsnq_1
XFILLER_3_570 VDD VDD VSS VSS gf180mcu_fd_sc_mcu7t5v0__fill_2
XFILLER_85_308 VDD VDD VSS VSS gf180mcu_fd_sc_mcu7t5v0__fill_1
X_3271_ _3271_/D _3328_/RN _3271_/CLK _3271_/Q VDD VDD VSS VSS gf180mcu_fd_sc_mcu7t5v0__dffrnq_1
X_2222_ _2426_/A1 _2222_/A2 _2227_/B _2222_/B2 _2223_/A2 VDD VDD VSS VSS gf180mcu_fd_sc_mcu7t5v0__aoi22_1
XFILLER_16_2 VDD VDD VSS VSS gf180mcu_fd_sc_mcu7t5v0__fillcap_32
X_2153_ _3232_/Q _3082_/Q _2165_/S _3082_/D VDD VDD VSS VSS gf180mcu_fd_sc_mcu7t5v0__mux2_2
XFILLER_66_522 VDD VDD VSS VSS gf180mcu_fd_sc_mcu7t5v0__fill_2
XFILLER_66_533 VDD VDD VSS VSS gf180mcu_fd_sc_mcu7t5v0__fill_1
XFILLER_93_352 VDD VDD VSS VSS gf180mcu_fd_sc_mcu7t5v0__fillcap_8
XTAP_TAPCELL_ROW_49_753 VDD VSS gf180mcu_fd_sc_mcu7t5v0__filltie
XFILLER_53_205 VDD VDD VSS VSS gf180mcu_fd_sc_mcu7t5v0__fillcap_4
X_2084_ _3300_/Q _2091_/A2 _2090_/A2 _3292_/Q _2085_/B2 VDD VDD VSS VSS gf180mcu_fd_sc_mcu7t5v0__aoi22_1
XFILLER_34_430 VDD VDD VSS VSS gf180mcu_fd_sc_mcu7t5v0__fillcap_16
XFILLER_22_658 VDD VDD VSS VSS gf180mcu_fd_sc_mcu7t5v0__fillcap_4
XFILLER_61_282 VDD VDD VSS VSS gf180mcu_fd_sc_mcu7t5v0__fillcap_8
X_2986_ _2986_/D _3016_/CLK _2986_/Q VDD VDD VSS VSS gf180mcu_fd_sc_mcu7t5v0__dffq_1
X_1937_ _2959_/Q _3111_/Q _1944_/S _2959_/D VDD VDD VSS VSS gf180mcu_fd_sc_mcu7t5v0__mux2_2
X_1868_ _3364_/Q _1869_/A2 _1982_/A1 VDD VDD VSS VSS gf180mcu_fd_sc_mcu7t5v0__nor2_1
X_1799_ _3282_/Q _2841_/Q _1804_/S _2841_/D VDD VDD VSS VSS gf180mcu_fd_sc_mcu7t5v0__mux2_2
XFILLER_76_308 VDD VDD VSS VSS gf180mcu_fd_sc_mcu7t5v0__fill_1
XFILLER_57_511 VDD VDD VSS VSS gf180mcu_fd_sc_mcu7t5v0__fill_2
XFILLER_69_371 VDD VDD VSS VSS gf180mcu_fd_sc_mcu7t5v0__fillcap_8
XFILLER_97_691 VDD VDD VSS VSS gf180mcu_fd_sc_mcu7t5v0__fillcap_8
XFILLER_84_363 VDD VDD VSS VSS gf180mcu_fd_sc_mcu7t5v0__fillcap_8
XFILLER_57_577 VDD VDD VSS VSS gf180mcu_fd_sc_mcu7t5v0__fillcap_8
XFILLER_53_761 VDD VDD VSS VSS gf180mcu_fd_sc_mcu7t5v0__fillcap_4
XFILLER_25_474 VDD VDD VSS VSS gf180mcu_fd_sc_mcu7t5v0__fill_1
XFILLER_13_636 VDD VDD VSS VSS gf180mcu_fd_sc_mcu7t5v0__fill_1
XFILLER_9_629 VDD VDD VSS VSS gf180mcu_fd_sc_mcu7t5v0__fill_1
XFILLER_21_680 VDD VDD VSS VSS gf180mcu_fd_sc_mcu7t5v0__fillcap_4
XTAP_TAPCELL_ROW_10_336 VDD VSS gf180mcu_fd_sc_mcu7t5v0__filltie
XFILLER_107_730 VDD VDD VSS VSS gf180mcu_fd_sc_mcu7t5v0__fill_1
XFILLER_75_341 VDD VDD VSS VSS gf180mcu_fd_sc_mcu7t5v0__fill_1
XFILLER_57_72 VDD VDD VSS VSS gf180mcu_fd_sc_mcu7t5v0__fillcap_32
XFILLER_90_311 VDD VDD VSS VSS gf180mcu_fd_sc_mcu7t5v0__fillcap_4
XTAP_TAPCELL_ROW_85_1128 VDD VSS gf180mcu_fd_sc_mcu7t5v0__filltie
XTAP_TAPCELL_ROW_18_425 VDD VSS gf180mcu_fd_sc_mcu7t5v0__filltie
XTAP_TAPCELL_ROW_46_712 VDD VSS gf180mcu_fd_sc_mcu7t5v0__filltie
XFILLER_63_558 VDD VDD VSS VSS gf180mcu_fd_sc_mcu7t5v0__fill_2
XFILLER_31_422 VDD VDD VSS VSS gf180mcu_fd_sc_mcu7t5v0__fillcap_16
XFILLER_43_282 VDD VDD VSS VSS gf180mcu_fd_sc_mcu7t5v0__fillcap_16
X_2840_ _2840_/D _2892_/CLK _2840_/Q VDD VDD VSS VSS gf180mcu_fd_sc_mcu7t5v0__dffq_1
X_2771_ _2771_/D _2893_/CLK _2771_/Q VDD VDD VSS VSS gf180mcu_fd_sc_mcu7t5v0__dffq_1
XFILLER_8_662 VDD VDD VSS VSS gf180mcu_fd_sc_mcu7t5v0__fill_2
X_1722_ _2776_/Q _3281_/Q _1728_/S _2776_/D VDD VDD VSS VSS gf180mcu_fd_sc_mcu7t5v0__mux2_2
XTAP_TAPCELL_ROW_96_1246 VDD VSS gf180mcu_fd_sc_mcu7t5v0__filltie
X_1653_ _2202_/A1 _2765_/Q _2766_/Q _2431_/B VDD VDD VSS VSS gf180mcu_fd_sc_mcu7t5v0__nand3_1
XPHY_EDGE_ROW_9_Right_9 VDD VSS gf180mcu_fd_sc_mcu7t5v0__endcap
X_1584_ _3347_/Q _3357_/D _1586_/A2 VDD VDD VSS VSS gf180mcu_fd_sc_mcu7t5v0__xnor2_1
X_3323_ input5/Z _3369_/RN _3327_/CLK hold41/I VDD VDD VSS VSS gf180mcu_fd_sc_mcu7t5v0__dffrnq_1
XPHY_EDGE_ROW_107_Right_107 VDD VSS gf180mcu_fd_sc_mcu7t5v0__endcap
X_3254_ _3254_/D _3328_/RN _3326_/CLK _3254_/Q VDD VDD VSS VSS gf180mcu_fd_sc_mcu7t5v0__dffrnq_1
X_2205_ _3394_/Q _2204_/Z _2212_/A1 VDD VDD VSS VSS gf180mcu_fd_sc_mcu7t5v0__nand2_1
XFILLER_85_149 VDD VDD VSS VSS gf180mcu_fd_sc_mcu7t5v0__fillcap_4
XFILLER_85_138 VDD VDD VSS VSS gf180mcu_fd_sc_mcu7t5v0__fill_2
X_3185_ _3185_/D _3328_/RN _3240_/CLK _3185_/Q VDD VDD VSS VSS gf180mcu_fd_sc_mcu7t5v0__dffrnq_1
XFILLER_94_683 VDD VDD VSS VSS gf180mcu_fd_sc_mcu7t5v0__fillcap_4
X_2136_ _3215_/Q _3065_/Q _2166_/S _3065_/D VDD VDD VSS VSS gf180mcu_fd_sc_mcu7t5v0__mux2_2
XFILLER_81_333 VDD VDD VSS VSS gf180mcu_fd_sc_mcu7t5v0__fillcap_4
XFILLER_26_238 VDD VDD VSS VSS gf180mcu_fd_sc_mcu7t5v0__fillcap_4
X_2067_ _3060_/Q _3061_/Q _3062_/Q _3059_/Q _2068_/A2 VDD VDD VSS VSS gf180mcu_fd_sc_mcu7t5v0__aoi211_1
XFILLER_62_591 VDD VDD VSS VSS gf180mcu_fd_sc_mcu7t5v0__fillcap_4
X_2969_ _2969_/D _3020_/CLK _2969_/Q VDD VDD VSS VSS gf180mcu_fd_sc_mcu7t5v0__dffq_1
XFILLER_1_337 VDD VDD VSS VSS gf180mcu_fd_sc_mcu7t5v0__fillcap_8
XFILLER_77_628 VDD VDD VSS VSS gf180mcu_fd_sc_mcu7t5v0__fill_2
XFILLER_57_352 VDD VDD VSS VSS gf180mcu_fd_sc_mcu7t5v0__fillcap_16
XFILLER_85_694 VDD VDD VSS VSS gf180mcu_fd_sc_mcu7t5v0__fillcap_4
XFILLER_18_728 VDD VDD VSS VSS gf180mcu_fd_sc_mcu7t5v0__fillcap_4
XFILLER_57_374 VDD VDD VSS VSS gf180mcu_fd_sc_mcu7t5v0__fill_1
XFILLER_84_193 VDD VDD VSS VSS gf180mcu_fd_sc_mcu7t5v0__fillcap_8
XFILLER_13_422 VDD VDD VSS VSS gf180mcu_fd_sc_mcu7t5v0__fillcap_64
XFILLER_25_282 VDD VDD VSS VSS gf180mcu_fd_sc_mcu7t5v0__fillcap_8
XTAP_TAPCELL_ROW_80_1069 VDD VSS gf180mcu_fd_sc_mcu7t5v0__filltie
XFILLER_43_52 VDD VDD VSS VSS gf180mcu_fd_sc_mcu7t5v0__fill_2
XTAP_TAPCELL_ROW_23_472 VDD VSS gf180mcu_fd_sc_mcu7t5v0__filltie
XFILLER_40_296 VDD VDD VSS VSS gf180mcu_fd_sc_mcu7t5v0__fillcap_16
XTAP_TAPCELL_ROW_51_770 VDD VSS gf180mcu_fd_sc_mcu7t5v0__filltie
XFILLER_5_698 VDD VDD VSS VSS gf180mcu_fd_sc_mcu7t5v0__fill_2
XTAP_TAPCELL_ROW_91_1187 VDD VSS gf180mcu_fd_sc_mcu7t5v0__filltie
XFILLER_76_694 VDD VDD VSS VSS gf180mcu_fd_sc_mcu7t5v0__fill_2
XFILLER_32_764 VDD VDD VSS VSS gf180mcu_fd_sc_mcu7t5v0__fill_1
X_2823_ _2823_/D _3408_/CLK _2823_/Q VDD VDD VSS VSS gf180mcu_fd_sc_mcu7t5v0__dffq_1
XFILLER_83_2 VDD VDD VSS VSS gf180mcu_fd_sc_mcu7t5v0__fill_2
XTAP_TAPCELL_ROW_100_1283 VDD VSS gf180mcu_fd_sc_mcu7t5v0__filltie
X_2754_ _3228_/Q _3294_/Q _2763_/S _3294_/D VDD VDD VSS VSS gf180mcu_fd_sc_mcu7t5v0__mux2_2
X_1705_ _3142_/Q _2096_/A1 _2406_/C _1705_/C _1707_/A2 VDD VDD VSS VSS gf180mcu_fd_sc_mcu7t5v0__aoi211_1
X_2685_ _2685_/A1 _2607_/Z _2731_/B1 VDD VDD VSS VSS gf180mcu_fd_sc_mcu7t5v0__nor2_1
X_1636_ _2202_/A1 _2765_/Q _2277_/A2 VDD VDD VSS VSS gf180mcu_fd_sc_mcu7t5v0__nand2_1
X_1567_ _3310_/Q _1567_/A2 _1571_/A3 VDD VDD VSS VSS gf180mcu_fd_sc_mcu7t5v0__nand2_1
X_3306_ _3306_/D _3416_/RN _3306_/CLK _3306_/Q VDD VDD VSS VSS gf180mcu_fd_sc_mcu7t5v0__dffrnq_1
XFILLER_86_403 VDD VDD VSS VSS gf180mcu_fd_sc_mcu7t5v0__fillcap_8
X_1498_ _3366_/Q _1498_/A2 _3361_/D VDD VDD VSS VSS gf180mcu_fd_sc_mcu7t5v0__xnor2_1
X_3237_ _3237_/D _3328_/RN _3240_/CLK _3237_/Q VDD VDD VSS VSS gf180mcu_fd_sc_mcu7t5v0__dffrnq_1
XFILLER_82_620 VDD VDD VSS VSS gf180mcu_fd_sc_mcu7t5v0__fillcap_8
X_3168_ _3168_/D _3328_/RN _3257_/CLK _3168_/Q VDD VDD VSS VSS gf180mcu_fd_sc_mcu7t5v0__dffrnq_1
XTAP_TAPCELL_ROW_57_829 VDD VSS gf180mcu_fd_sc_mcu7t5v0__filltie
XFILLER_73_119 VDD VDD VSS VSS gf180mcu_fd_sc_mcu7t5v0__fillcap_8
XFILLER_82_664 VDD VDD VSS VSS gf180mcu_fd_sc_mcu7t5v0__fill_1
X_2119_ _2108_/B _2119_/A2 _2122_/A2 _2119_/Z VDD VDD VSS VSS gf180mcu_fd_sc_mcu7t5v0__or3_1
XFILLER_54_333 VDD VDD VSS VSS gf180mcu_fd_sc_mcu7t5v0__fillcap_4
X_3099_ _3099_/D _3303_/RN _3288_/CLK _3099_/Q VDD VDD VSS VSS gf180mcu_fd_sc_mcu7t5v0__dffrnq_1
XFILLER_42_539 VDD VDD VSS VSS gf180mcu_fd_sc_mcu7t5v0__fill_2
XFILLER_23_764 VDD VDD VSS VSS gf180mcu_fd_sc_mcu7t5v0__fill_1
XTAP_TAPCELL_ROW_20_442 VDD VSS gf180mcu_fd_sc_mcu7t5v0__filltie
XFILLER_2_624 VDD VDD VSS VSS gf180mcu_fd_sc_mcu7t5v0__fill_2
XTAP_TAPCELL_ROW_28_531 VDD VSS gf180mcu_fd_sc_mcu7t5v0__filltie
XFILLER_72_185 VDD VDD VSS VSS gf180mcu_fd_sc_mcu7t5v0__fillcap_4
XFILLER_14_753 VDD VDD VSS VSS gf180mcu_fd_sc_mcu7t5v0__fillcap_8
XFILLER_13_252 VDD VDD VSS VSS gf180mcu_fd_sc_mcu7t5v0__fillcap_16
XFILLER_13_274 VDD VDD VSS VSS gf180mcu_fd_sc_mcu7t5v0__fill_1
Xclkload26 _3419_/CLK clkload26/ZN VDD VDD VSS VSS gf180mcu_fd_sc_mcu7t5v0__clkinv_2
Xclkload15 _3257_/CLK clkload15/Z VDD VDD VSS VSS gf180mcu_fd_sc_mcu7t5v0__clkbuf_1
Xclkload37 _2954_/CLK clkload37/Z VDD VDD VSS VSS gf180mcu_fd_sc_mcu7t5v0__clkbuf_2
Xclkload59 _3409_/CLK clkload59/ZN VDD VDD VSS VSS gf180mcu_fd_sc_mcu7t5v0__inv_4
Xclkload48 _3387_/CLK clkload48/ZN VDD VDD VSS VSS gf180mcu_fd_sc_mcu7t5v0__inv_2
X_2470_ _3329_/Q _3163_/Q _2470_/A3 _2471_/B VDD VDD VSS VSS gf180mcu_fd_sc_mcu7t5v0__nor3_1
XFILLER_55_6 VDD VDD VSS VSS gf180mcu_fd_sc_mcu7t5v0__fill_1
XFILLER_5_484 VDD VDD VSS VSS gf180mcu_fd_sc_mcu7t5v0__fillcap_4
X_1421_ _3048_/Q _2407_/A2 VDD VDD VSS VSS gf180mcu_fd_sc_mcu7t5v0__clkinv_1
XFILLER_96_734 VDD VDD VSS VSS gf180mcu_fd_sc_mcu7t5v0__fill_1
XFILLER_95_266 VDD VDD VSS VSS gf180mcu_fd_sc_mcu7t5v0__fillcap_4
X_3022_ _3022_/D _3022_/CLK _3022_/Q VDD VDD VSS VSS gf180mcu_fd_sc_mcu7t5v0__dffq_1
XTAP_TAPCELL_ROW_102_1301 VDD VSS gf180mcu_fd_sc_mcu7t5v0__filltie
XFILLER_17_591 VDD VDD VSS VSS gf180mcu_fd_sc_mcu7t5v0__fillcap_4
XFILLER_51_336 VDD VDD VSS VSS gf180mcu_fd_sc_mcu7t5v0__fillcap_8
XFILLER_63_174 VDD VDD VSS VSS gf180mcu_fd_sc_mcu7t5v0__fill_2
XTAP_TAPCELL_ROW_34_589 VDD VSS gf180mcu_fd_sc_mcu7t5v0__filltie
XTAP_TAPCELL_ROW_62_887 VDD VSS gf180mcu_fd_sc_mcu7t5v0__filltie
Xclkload9 clkload9/I clkload9/Z VDD VDD VSS VSS gf180mcu_fd_sc_mcu7t5v0__clkbuf_1
X_2806_ _2806_/D _2887_/CLK _2806_/Q VDD VDD VSS VSS gf180mcu_fd_sc_mcu7t5v0__dffq_1
X_2737_ _2737_/A1 _2736_/Z _2746_/S VDD VDD VSS VSS gf180mcu_fd_sc_mcu7t5v0__nand2_1
X_2668_ _3021_/Q _3013_/Q _3005_/Q _2997_/Q _3351_/Q _3352_/Q _2668_/Z VDD VDD VSS
+ VSS gf180mcu_fd_sc_mcu7t5v0__mux4_1
X_1619_ _2508_/A1 _1619_/A2 _3325_/D VDD VDD VSS VSS gf180mcu_fd_sc_mcu7t5v0__nor2_1
X_2599_ _3208_/Q _2602_/A2 _2601_/A3 VDD VDD VSS VSS gf180mcu_fd_sc_mcu7t5v0__nand2_1
XTAP_TAPCELL_ROW_25_501 VDD VSS gf180mcu_fd_sc_mcu7t5v0__filltie
XFILLER_42_325 VDD VDD VSS VSS gf180mcu_fd_sc_mcu7t5v0__fillcap_8
Xclkbuf_4_0_0_host_clk_i clkbuf_0_host_clk_i/Z _2858_/CLK VDD VDD VSS VSS gf180mcu_fd_sc_mcu7t5v0__clkbuf_4
XFILLER_10_244 VDD VDD VSS VSS gf180mcu_fd_sc_mcu7t5v0__fill_1
XFILLER_10_277 VDD VDD VSS VSS gf180mcu_fd_sc_mcu7t5v0__fill_2
XTAP_TAPCELL_ROW_79_1060 VDD VSS gf180mcu_fd_sc_mcu7t5v0__filltie
XFILLER_40_31 VDD VDD VSS VSS gf180mcu_fd_sc_mcu7t5v0__fillcap_4
XFILLER_2_454 VDD VDD VSS VSS gf180mcu_fd_sc_mcu7t5v0__fill_1
XFILLER_2_465 VDD VDD VSS VSS gf180mcu_fd_sc_mcu7t5v0__fillcap_4
XFILLER_78_734 VDD VDD VSS VSS gf180mcu_fd_sc_mcu7t5v0__fill_1
XFILLER_77_222 VDD VDD VSS VSS gf180mcu_fd_sc_mcu7t5v0__fill_1
XFILLER_38_609 VDD VDD VSS VSS gf180mcu_fd_sc_mcu7t5v0__fill_2
XFILLER_49_95 VDD VDD VSS VSS gf180mcu_fd_sc_mcu7t5v0__fillcap_4
XFILLER_93_715 VDD VDD VSS VSS gf180mcu_fd_sc_mcu7t5v0__fill_2
XFILLER_18_366 VDD VDD VSS VSS gf180mcu_fd_sc_mcu7t5v0__fill_2
XFILLER_46_664 VDD VDD VSS VSS gf180mcu_fd_sc_mcu7t5v0__fill_1
XFILLER_45_174 VDD VDD VSS VSS gf180mcu_fd_sc_mcu7t5v0__fill_1
X_1970_ _3117_/Q _2989_/Q _1971_/S _2989_/D VDD VDD VSS VSS gf180mcu_fd_sc_mcu7t5v0__mux2_2
XFILLER_60_177 VDD VDD VSS VSS gf180mcu_fd_sc_mcu7t5v0__fillcap_16
XFILLER_14_594 VDD VDD VSS VSS gf180mcu_fd_sc_mcu7t5v0__fill_1
XTAP_TAPCELL_ROW_31_559 VDD VSS gf180mcu_fd_sc_mcu7t5v0__filltie
X_2522_ _3185_/Q _3177_/Q _2540_/S _3185_/D VDD VDD VSS VSS gf180mcu_fd_sc_mcu7t5v0__mux2_2
XFILLER_5_270 VDD VDD VSS VSS gf180mcu_fd_sc_mcu7t5v0__fillcap_8
X_2453_ _3253_/Q _1617_/Z _2443_/Z _3269_/Q _2456_/A2 VDD VDD VSS VSS gf180mcu_fd_sc_mcu7t5v0__aoi22_1
XFILLER_46_2 VDD VDD VSS VSS gf180mcu_fd_sc_mcu7t5v0__fillcap_8
X_1404_ _3158_/Q _2469_/B VDD VDD VSS VSS gf180mcu_fd_sc_mcu7t5v0__clkinv_1
X_2384_ _3138_/Q _2409_/A1 _2396_/B VDD VDD VSS VSS gf180mcu_fd_sc_mcu7t5v0__nand2_1
XFILLER_96_542 VDD VDD VSS VSS gf180mcu_fd_sc_mcu7t5v0__fillcap_8
XFILLER_68_255 VDD VDD VSS VSS gf180mcu_fd_sc_mcu7t5v0__fillcap_4
Xinput2 scl_pad_i input2/Z VDD VDD VSS VSS gf180mcu_fd_sc_mcu7t5v0__dlyb_1
XFILLER_96_597 VDD VDD VSS VSS gf180mcu_fd_sc_mcu7t5v0__fillcap_8
XTAP_TAPCELL_ROW_67_935 VDD VSS gf180mcu_fd_sc_mcu7t5v0__filltie
XFILLER_68_266 VDD VDD VSS VSS gf180mcu_fd_sc_mcu7t5v0__fill_2
XFILLER_83_236 VDD VDD VSS VSS gf180mcu_fd_sc_mcu7t5v0__fill_2
X_3005_ _3005_/D _3366_/CLK _3005_/Q VDD VDD VSS VSS gf180mcu_fd_sc_mcu7t5v0__dffq_1
XTAP_TAPCELL_ROW_39_648 VDD VSS gf180mcu_fd_sc_mcu7t5v0__filltie
XFILLER_49_480 VDD VDD VSS VSS gf180mcu_fd_sc_mcu7t5v0__fillcap_8
XFILLER_37_653 VDD VDD VSS VSS gf180mcu_fd_sc_mcu7t5v0__fillcap_4
XFILLER_36_174 VDD VDD VSS VSS gf180mcu_fd_sc_mcu7t5v0__fill_1
XFILLER_52_645 VDD VDD VSS VSS gf180mcu_fd_sc_mcu7t5v0__fill_1
XFILLER_51_177 VDD VDD VSS VSS gf180mcu_fd_sc_mcu7t5v0__fill_2
XFILLER_20_564 VDD VDD VSS VSS gf180mcu_fd_sc_mcu7t5v0__fillcap_4
XFILLER_20_597 VDD VDD VSS VSS gf180mcu_fd_sc_mcu7t5v0__fillcap_4
XFILLER_10_34 VDD VDD VSS VSS gf180mcu_fd_sc_mcu7t5v0__fill_1
XFILLER_10_56 VDD VDD VSS VSS gf180mcu_fd_sc_mcu7t5v0__fill_2
XFILLER_59_244 VDD VDD VSS VSS gf180mcu_fd_sc_mcu7t5v0__fillcap_4
XFILLER_74_247 VDD VDD VSS VSS gf180mcu_fd_sc_mcu7t5v0__fillcap_16
XTAP_TAPCELL_ROW_2_251 VDD VSS gf180mcu_fd_sc_mcu7t5v0__filltie
XFILLER_15_347 VDD VDD VSS VSS gf180mcu_fd_sc_mcu7t5v0__fill_2
XFILLER_30_317 VDD VDD VSS VSS gf180mcu_fd_sc_mcu7t5v0__fillcap_8
XFILLER_7_557 VDD VDD VSS VSS gf180mcu_fd_sc_mcu7t5v0__fill_2
XFILLER_65_203 VDD VDD VSS VSS gf180mcu_fd_sc_mcu7t5v0__fillcap_4
XFILLER_66_726 VDD VDD VSS VSS gf180mcu_fd_sc_mcu7t5v0__fill_2
XFILLER_93_556 VDD VDD VSS VSS gf180mcu_fd_sc_mcu7t5v0__fillcap_4
Xclkbuf_3_2__f_clk_i clkbuf_0_clk_i/Z clkload1/I VDD VDD VSS VSS gf180mcu_fd_sc_mcu7t5v0__clkbuf_16
XFILLER_19_620 VDD VDD VSS VSS gf180mcu_fd_sc_mcu7t5v0__fillcap_8
XTAP_TAPCELL_ROW_88_1159 VDD VSS gf180mcu_fd_sc_mcu7t5v0__filltie
XFILLER_81_718 VDD VDD VSS VSS gf180mcu_fd_sc_mcu7t5v0__fillcap_8
XTAP_TAPCELL_ROW_36_607 VDD VSS gf180mcu_fd_sc_mcu7t5v0__filltie
XTAP_TAPCELL_ROW_64_905 VDD VSS gf180mcu_fd_sc_mcu7t5v0__filltie
XFILLER_80_228 VDD VDD VSS VSS gf180mcu_fd_sc_mcu7t5v0__fill_1
XFILLER_18_185 VDD VDD VSS VSS gf180mcu_fd_sc_mcu7t5v0__fillcap_4
XFILLER_18_196 VDD VDD VSS VSS gf180mcu_fd_sc_mcu7t5v0__fillcap_32
XTAP_TAPCELL_ROW_72_993 VDD VSS gf180mcu_fd_sc_mcu7t5v0__filltie
XTAP_TAPCELL_ROW_16_397 VDD VSS gf180mcu_fd_sc_mcu7t5v0__filltie
X_1953_ _3118_/Q _2974_/Q _1953_/S _2974_/D VDD VDD VSS VSS gf180mcu_fd_sc_mcu7t5v0__mux2_2
XTAP_TAPCELL_ROW_44_695 VDD VSS gf180mcu_fd_sc_mcu7t5v0__filltie
X_1884_ _2915_/Q _3115_/Q _1886_/S _2915_/D VDD VDD VSS VSS gf180mcu_fd_sc_mcu7t5v0__mux2_2
XTAP_TAPCELL_ROW_99_1277 VDD VSS gf180mcu_fd_sc_mcu7t5v0__filltie
X_2505_ _3169_/Q _3154_/Q wire13/Z _3169_/D VDD VDD VSS VSS gf180mcu_fd_sc_mcu7t5v0__mux2_2
X_2436_ _2436_/A1 _2436_/A2 _3147_/D VDD VDD VSS VSS gf180mcu_fd_sc_mcu7t5v0__nand2_1
XFILLER_96_350 VDD VDD VSS VSS gf180mcu_fd_sc_mcu7t5v0__fillcap_32
X_2367_ _3393_/Q _2361_/Z _2367_/B _2368_/C VDD VDD VSS VSS gf180mcu_fd_sc_mcu7t5v0__oai21_1
X_2298_ _2424_/A1 _2190_/C _2298_/B _2299_/B VDD VDD VSS VSS gf180mcu_fd_sc_mcu7t5v0__aoi21_1
XFILLER_84_556 VDD VDD VSS VSS gf180mcu_fd_sc_mcu7t5v0__fillcap_4
XTAP_TAPCELL_ROW_108_1373 VDD VSS gf180mcu_fd_sc_mcu7t5v0__filltie
XFILLER_71_228 VDD VDD VSS VSS gf180mcu_fd_sc_mcu7t5v0__fillcap_4
XTAP_TAPCELL_ROW_108_1384 VDD VSS gf180mcu_fd_sc_mcu7t5v0__filltie
XFILLER_80_762 VDD VDD VSS VSS gf180mcu_fd_sc_mcu7t5v0__fill_2
XFILLER_12_317 VDD VDD VSS VSS gf180mcu_fd_sc_mcu7t5v0__fillcap_32
XFILLER_24_177 VDD VDD VSS VSS gf180mcu_fd_sc_mcu7t5v0__fillcap_32
XFILLER_20_372 VDD VDD VSS VSS gf180mcu_fd_sc_mcu7t5v0__fillcap_4
XTAP_TAPCELL_ROW_76_1030 VDD VSS gf180mcu_fd_sc_mcu7t5v0__filltie
XFILLER_4_527 VDD VDD VSS VSS gf180mcu_fd_sc_mcu7t5v0__fillcap_4
XTAP_TAPCELL_ROW_7_310 VDD VSS gf180mcu_fd_sc_mcu7t5v0__filltie
XFILLER_0_711 VDD VDD VSS VSS gf180mcu_fd_sc_mcu7t5v0__fill_2
XFILLER_102_683 VDD VDD VSS VSS gf180mcu_fd_sc_mcu7t5v0__fillcap_4
XFILLER_75_556 VDD VDD VSS VSS gf180mcu_fd_sc_mcu7t5v0__fillcap_4
Xmax_cap20 _2585_/S _2569_/S VDD VDD VSS VSS gf180mcu_fd_sc_mcu7t5v0__buf_12
XFILLER_46_52 VDD VDD VSS VSS gf180mcu_fd_sc_mcu7t5v0__fillcap_32
XFILLER_16_667 VDD VDD VSS VSS gf180mcu_fd_sc_mcu7t5v0__fill_2
XFILLER_15_144 VDD VDD VSS VSS gf180mcu_fd_sc_mcu7t5v0__fill_1
XFILLER_30_103 VDD VDD VSS VSS gf180mcu_fd_sc_mcu7t5v0__fill_2
XTAP_TAPCELL_ROW_13_367 VDD VSS gf180mcu_fd_sc_mcu7t5v0__filltie
XTAP_TAPCELL_ROW_41_665 VDD VSS gf180mcu_fd_sc_mcu7t5v0__filltie
XFILLER_7_332 VDD VDD VSS VSS gf180mcu_fd_sc_mcu7t5v0__fill_1
X_3270_ _3270_/D _3369_/RN _3270_/CLK _3270_/Q VDD VDD VSS VSS gf180mcu_fd_sc_mcu7t5v0__dffrnq_1
X_2221_ _1637_/Z _2221_/A2 _2223_/A1 VDD VDD VSS VSS gf180mcu_fd_sc_mcu7t5v0__nand2_1
X_2152_ _3231_/Q _3081_/Q _2165_/S _3081_/D VDD VDD VSS VSS gf180mcu_fd_sc_mcu7t5v0__mux2_2
XFILLER_38_247 VDD VDD VSS VSS gf180mcu_fd_sc_mcu7t5v0__fill_1
X_2083_ _2368_/A2 _2091_/B _2083_/B1 _2083_/B2 _3045_/D VDD VDD VSS VSS gf180mcu_fd_sc_mcu7t5v0__aoi22_1
XFILLER_19_472 VDD VDD VSS VSS gf180mcu_fd_sc_mcu7t5v0__fill_2
XFILLER_53_228 VDD VDD VSS VSS gf180mcu_fd_sc_mcu7t5v0__fillcap_4
XFILLER_62_751 VDD VDD VSS VSS gf180mcu_fd_sc_mcu7t5v0__fillcap_8
XFILLER_22_626 VDD VDD VSS VSS gf180mcu_fd_sc_mcu7t5v0__fillcap_32
XFILLER_61_261 VDD VDD VSS VSS gf180mcu_fd_sc_mcu7t5v0__fill_2
XFILLER_21_114 VDD VDD VSS VSS gf180mcu_fd_sc_mcu7t5v0__fillcap_4
XFILLER_21_125 VDD VDD VSS VSS gf180mcu_fd_sc_mcu7t5v0__fillcap_8
XFILLER_61_294 VDD VDD VSS VSS gf180mcu_fd_sc_mcu7t5v0__fill_2
X_2985_ _2985_/D _3366_/CLK _2985_/Q VDD VDD VSS VSS gf180mcu_fd_sc_mcu7t5v0__dffq_1
X_1936_ _1490_/Z _1935_/Z _1944_/S VDD VDD VSS VSS gf180mcu_fd_sc_mcu7t5v0__and2_1
XFILLER_107_219 VDD VDD VSS VSS gf180mcu_fd_sc_mcu7t5v0__fillcap_4
X_1867_ _2902_/Q _3118_/Q _1867_/S _2902_/D VDD VDD VSS VSS gf180mcu_fd_sc_mcu7t5v0__mux2_2
X_1798_ _3281_/Q _2840_/Q _1804_/S _2840_/D VDD VDD VSS VSS gf180mcu_fd_sc_mcu7t5v0__mux2_2
XFILLER_89_648 VDD VDD VSS VSS gf180mcu_fd_sc_mcu7t5v0__fillcap_8
XFILLER_89_615 VDD VDD VSS VSS gf180mcu_fd_sc_mcu7t5v0__fillcap_8
XFILLER_88_103 VDD VDD VSS VSS gf180mcu_fd_sc_mcu7t5v0__fill_2
X_3399_ _3399_/D input1/Z _3399_/CLK _3399_/Q VDD VDD VSS VSS gf180mcu_fd_sc_mcu7t5v0__dffrnq_1
X_2419_ _2420_/B _2419_/A2 _2424_/C _2421_/S VDD VDD VSS VSS gf180mcu_fd_sc_mcu7t5v0__oai21_1
XFILLER_69_383 VDD VDD VSS VSS gf180mcu_fd_sc_mcu7t5v0__fill_2
XFILLER_45_729 VDD VDD VSS VSS gf180mcu_fd_sc_mcu7t5v0__fill_2
XFILLER_57_589 VDD VDD VSS VSS gf180mcu_fd_sc_mcu7t5v0__fill_1
XFILLER_72_559 VDD VDD VSS VSS gf180mcu_fd_sc_mcu7t5v0__fill_2
XFILLER_16_55 VDD VDD VSS VSS gf180mcu_fd_sc_mcu7t5v0__fill_1
XFILLER_13_626 VDD VDD VSS VSS gf180mcu_fd_sc_mcu7t5v0__fillcap_4
XFILLER_80_581 VDD VDD VSS VSS gf180mcu_fd_sc_mcu7t5v0__fillcap_8
XFILLER_12_103 VDD VDD VSS VSS gf180mcu_fd_sc_mcu7t5v0__fill_2
XFILLER_8_107 VDD VDD VSS VSS gf180mcu_fd_sc_mcu7t5v0__fillcap_8
XTAP_TAPCELL_ROW_10_337 VDD VSS gf180mcu_fd_sc_mcu7t5v0__filltie
Xclkbuf_leaf_15_clk_i clkload1/I _3311_/CLK VDD VDD VSS VSS gf180mcu_fd_sc_mcu7t5v0__clkbuf_4
XFILLER_95_629 VDD VDD VSS VSS gf180mcu_fd_sc_mcu7t5v0__fill_1
XFILLER_48_556 VDD VDD VSS VSS gf180mcu_fd_sc_mcu7t5v0__fillcap_8
XTAP_TAPCELL_ROW_85_1129 VDD VSS gf180mcu_fd_sc_mcu7t5v0__filltie
XFILLER_35_228 VDD VDD VSS VSS gf180mcu_fd_sc_mcu7t5v0__fill_1
XTAP_TAPCELL_ROW_46_713 VDD VSS gf180mcu_fd_sc_mcu7t5v0__filltie
XTAP_TAPCELL_ROW_18_426 VDD VSS gf180mcu_fd_sc_mcu7t5v0__filltie
XFILLER_16_431 VDD VDD VSS VSS gf180mcu_fd_sc_mcu7t5v0__fillcap_8
XFILLER_73_72 VDD VDD VSS VSS gf180mcu_fd_sc_mcu7t5v0__fillcap_8
XFILLER_31_412 VDD VDD VSS VSS gf180mcu_fd_sc_mcu7t5v0__fillcap_8
XFILLER_85_6 VDD VDD VSS VSS gf180mcu_fd_sc_mcu7t5v0__fill_1
XFILLER_31_456 VDD VDD VSS VSS gf180mcu_fd_sc_mcu7t5v0__fillcap_4
X_2770_ _2770_/D _2893_/CLK _2770_/Q VDD VDD VSS VSS gf180mcu_fd_sc_mcu7t5v0__dffq_1
X_1721_ _2775_/Q _3280_/Q _1728_/S _2775_/D VDD VDD VSS VSS gf180mcu_fd_sc_mcu7t5v0__mux2_2
XTAP_TAPCELL_ROW_96_1247 VDD VSS gf180mcu_fd_sc_mcu7t5v0__filltie
X_1652_ _2286_/B _2277_/A2 _2434_/B VDD VDD VSS VSS gf180mcu_fd_sc_mcu7t5v0__nor2_1
X_1583_ _3346_/Q _3356_/D _1586_/A1 VDD VDD VSS VSS gf180mcu_fd_sc_mcu7t5v0__xnor2_1
X_3322_ _3322_/D _3369_/RN _3327_/CLK _3322_/Q VDD VDD VSS VSS gf180mcu_fd_sc_mcu7t5v0__dffsnq_1
X_3253_ _3253_/D _3369_/RN _3253_/CLK _3253_/Q VDD VDD VSS VSS gf180mcu_fd_sc_mcu7t5v0__dffrnq_1
XFILLER_58_309 VDD VDD VSS VSS gf180mcu_fd_sc_mcu7t5v0__fillcap_4
X_2204_ _2830_/Q _2822_/Q _2814_/Q _2806_/Q _2388_/S0 _2373_/S1 _2204_/Z VDD VDD VSS
+ VSS gf180mcu_fd_sc_mcu7t5v0__mux4_1
X_3184_ _3184_/D _3328_/RN _3257_/CLK _3184_/Q VDD VDD VSS VSS gf180mcu_fd_sc_mcu7t5v0__dffrnq_1
XFILLER_39_523 VDD VDD VSS VSS gf180mcu_fd_sc_mcu7t5v0__fillcap_16
XFILLER_39_512 VDD VDD VSS VSS gf180mcu_fd_sc_mcu7t5v0__fill_2
XFILLER_94_662 VDD VDD VSS VSS gf180mcu_fd_sc_mcu7t5v0__fill_2
X_2135_ _3214_/Q _3064_/Q _2166_/S _3064_/D VDD VDD VSS VSS gf180mcu_fd_sc_mcu7t5v0__mux2_2
X_2066_ _3061_/Q _3062_/Q _2066_/Z VDD VDD VSS VSS gf180mcu_fd_sc_mcu7t5v0__or2_1
XTAP_TAPCELL_ROW_105_1332 VDD VSS gf180mcu_fd_sc_mcu7t5v0__filltie
XFILLER_35_762 VDD VDD VSS VSS gf180mcu_fd_sc_mcu7t5v0__fill_2
X_2968_ _2968_/D _2984_/CLK _2968_/Q VDD VDD VSS VSS gf180mcu_fd_sc_mcu7t5v0__dffq_1
X_1919_ _3112_/Q _2944_/Q _1925_/S _2944_/D VDD VDD VSS VSS gf180mcu_fd_sc_mcu7t5v0__mux2_2
Xclkbuf_4_5_0_host_clk_i clkbuf_0_host_clk_i/Z _3358_/CLK VDD VDD VSS VSS gf180mcu_fd_sc_mcu7t5v0__clkbuf_4
X_2899_ _2899_/D _3313_/CLK _2899_/Q VDD VDD VSS VSS gf180mcu_fd_sc_mcu7t5v0__dffq_1
XTAP_TAPCELL_ROW_73_1000 VDD VSS gf180mcu_fd_sc_mcu7t5v0__filltie
XFILLER_89_445 VDD VDD VSS VSS gf180mcu_fd_sc_mcu7t5v0__fillcap_4
XFILLER_1_349 VDD VDD VSS VSS gf180mcu_fd_sc_mcu7t5v0__fill_1
XFILLER_89_489 VDD VDD VSS VSS gf180mcu_fd_sc_mcu7t5v0__fill_1
XFILLER_103_277 VDD VDD VSS VSS gf180mcu_fd_sc_mcu7t5v0__fill_2
XFILLER_69_180 VDD VDD VSS VSS gf180mcu_fd_sc_mcu7t5v0__fillcap_16
XFILLER_85_640 VDD VDD VSS VSS gf180mcu_fd_sc_mcu7t5v0__fillcap_4
XFILLER_27_10 VDD VDD VSS VSS gf180mcu_fd_sc_mcu7t5v0__fill_1
XFILLER_84_172 VDD VDD VSS VSS gf180mcu_fd_sc_mcu7t5v0__fill_2
XFILLER_45_504 VDD VDD VSS VSS gf180mcu_fd_sc_mcu7t5v0__fill_2
XFILLER_72_312 VDD VDD VSS VSS gf180mcu_fd_sc_mcu7t5v0__fill_2
XFILLER_45_559 VDD VDD VSS VSS gf180mcu_fd_sc_mcu7t5v0__fill_1
XTAP_TAPCELL_ROW_23_473 VDD VSS gf180mcu_fd_sc_mcu7t5v0__filltie
XTAP_TAPCELL_ROW_51_771 VDD VSS gf180mcu_fd_sc_mcu7t5v0__filltie
XFILLER_95_404 VDD VDD VSS VSS gf180mcu_fd_sc_mcu7t5v0__fill_1
XTAP_TAPCELL_ROW_91_1188 VDD VSS gf180mcu_fd_sc_mcu7t5v0__filltie
XFILLER_67_139 VDD VDD VSS VSS gf180mcu_fd_sc_mcu7t5v0__fill_1
XFILLER_76_662 VDD VDD VSS VSS gf180mcu_fd_sc_mcu7t5v0__fill_2
XFILLER_91_632 VDD VDD VSS VSS gf180mcu_fd_sc_mcu7t5v0__fillcap_4
XFILLER_91_698 VDD VDD VSS VSS gf180mcu_fd_sc_mcu7t5v0__fill_2
XFILLER_23_209 VDD VDD VSS VSS gf180mcu_fd_sc_mcu7t5v0__fill_1
X_2822_ _2822_/D _3408_/CLK _2822_/Q VDD VDD VSS VSS gf180mcu_fd_sc_mcu7t5v0__dffq_1
XTAP_TAPCELL_ROW_100_1284 VDD VSS gf180mcu_fd_sc_mcu7t5v0__filltie
XFILLER_76_2 VDD VDD VSS VSS gf180mcu_fd_sc_mcu7t5v0__fillcap_16
X_2753_ _3227_/Q _3293_/Q _2763_/S _3293_/D VDD VDD VSS VSS gf180mcu_fd_sc_mcu7t5v0__mux2_2
X_1704_ _3142_/Q _2096_/A1 _2420_/A2 VDD VDD VSS VSS gf180mcu_fd_sc_mcu7t5v0__nand2_1
X_2684_ _2607_/Z _2684_/A2 _2684_/B _3255_/D VDD VDD VSS VSS gf180mcu_fd_sc_mcu7t5v0__oai21_1
X_1635_ _2764_/Q _2766_/Q _2289_/A1 VDD VDD VSS VSS gf180mcu_fd_sc_mcu7t5v0__nor2_1
X_1566_ _1566_/A1 _1566_/A2 _1566_/B _3309_/D VDD VDD VSS VSS gf180mcu_fd_sc_mcu7t5v0__oai21_1
XFILLER_101_704 VDD VDD VSS VSS gf180mcu_fd_sc_mcu7t5v0__fill_1
X_3305_ _3305_/D _3416_/RN _3311_/CLK _3305_/Q VDD VDD VSS VSS gf180mcu_fd_sc_mcu7t5v0__dffrnq_1
XFILLER_98_286 VDD VDD VSS VSS gf180mcu_fd_sc_mcu7t5v0__fillcap_16
XFILLER_86_437 VDD VDD VSS VSS gf180mcu_fd_sc_mcu7t5v0__fill_2
X_1497_ _3366_/Q _1490_/Z _3366_/D VDD VDD VSS VSS gf180mcu_fd_sc_mcu7t5v0__xor2_1
X_3236_ _3236_/D _3328_/RN _3328_/CLK _3236_/Q VDD VDD VSS VSS gf180mcu_fd_sc_mcu7t5v0__dffrnq_1
XFILLER_39_331 VDD VDD VSS VSS gf180mcu_fd_sc_mcu7t5v0__fillcap_16
XFILLER_104_37 VDD VDD VSS VSS gf180mcu_fd_sc_mcu7t5v0__fillcap_64
X_3167_ _3167_/D _3303_/RN _3292_/CLK _3167_/Q VDD VDD VSS VSS gf180mcu_fd_sc_mcu7t5v0__dffrnq_1
XFILLER_54_312 VDD VDD VSS VSS gf180mcu_fd_sc_mcu7t5v0__fill_2
XFILLER_73_109 VDD VDD VSS VSS gf180mcu_fd_sc_mcu7t5v0__fill_2
X_3098_ _3098_/D _3303_/RN _3222_/CLK _3098_/Q VDD VDD VSS VSS gf180mcu_fd_sc_mcu7t5v0__dffrnq_1
X_2118_ _2118_/A1 _2118_/A2 _2122_/A2 VDD VDD VSS VSS gf180mcu_fd_sc_mcu7t5v0__nor2_1
X_2049_ _2061_/A2 _2055_/A4 _2050_/B VDD VDD VSS VSS gf180mcu_fd_sc_mcu7t5v0__nor2_1
XFILLER_81_142 VDD VDD VSS VSS gf180mcu_fd_sc_mcu7t5v0__fillcap_4
XFILLER_23_710 VDD VDD VSS VSS gf180mcu_fd_sc_mcu7t5v0__fill_2
XTAP_TAPCELL_ROW_20_443 VDD VSS gf180mcu_fd_sc_mcu7t5v0__filltie
XFILLER_104_564 VDD VDD VSS VSS gf180mcu_fd_sc_mcu7t5v0__fill_1
XFILLER_89_264 VDD VDD VSS VSS gf180mcu_fd_sc_mcu7t5v0__fillcap_8
XFILLER_89_297 VDD VDD VSS VSS gf180mcu_fd_sc_mcu7t5v0__fill_1
XFILLER_89_286 VDD VDD VSS VSS gf180mcu_fd_sc_mcu7t5v0__fill_2
XFILLER_1_168 VDD VDD VSS VSS gf180mcu_fd_sc_mcu7t5v0__fill_1
XFILLER_49_139 VDD VDD VSS VSS gf180mcu_fd_sc_mcu7t5v0__fill_1
XFILLER_73_621 VDD VDD VSS VSS gf180mcu_fd_sc_mcu7t5v0__fillcap_8
XFILLER_85_481 VDD VDD VSS VSS gf180mcu_fd_sc_mcu7t5v0__fill_2
XFILLER_18_559 VDD VDD VSS VSS gf180mcu_fd_sc_mcu7t5v0__fillcap_8
XTAP_TAPCELL_ROW_28_532 VDD VSS gf180mcu_fd_sc_mcu7t5v0__filltie
XFILLER_72_131 VDD VDD VSS VSS gf180mcu_fd_sc_mcu7t5v0__fill_2
XFILLER_73_632 VDD VDD VSS VSS gf180mcu_fd_sc_mcu7t5v0__fill_2
XFILLER_73_687 VDD VDD VSS VSS gf180mcu_fd_sc_mcu7t5v0__fill_1
XFILLER_60_348 VDD VDD VSS VSS gf180mcu_fd_sc_mcu7t5v0__fill_2
XFILLER_41_562 VDD VDD VSS VSS gf180mcu_fd_sc_mcu7t5v0__fillcap_4
XFILLER_41_595 VDD VDD VSS VSS gf180mcu_fd_sc_mcu7t5v0__fillcap_16
Xclkload16 _3215_/CLK clkload16/Z VDD VDD VSS VSS gf180mcu_fd_sc_mcu7t5v0__clkbuf_1
XFILLER_70_95 VDD VDD VSS VSS gf180mcu_fd_sc_mcu7t5v0__fill_1
XTAP_TAPCELL_ROW_93_1206 VDD VSS gf180mcu_fd_sc_mcu7t5v0__filltie
Xclkload27 _3306_/CLK clkload27/ZN VDD VDD VSS VSS gf180mcu_fd_sc_mcu7t5v0__inv_2
Xclkload38 _3313_/CLK clkload38/ZN VDD VDD VSS VSS gf180mcu_fd_sc_mcu7t5v0__inv_2
Xclkload49 _3367_/CLK clkload49/ZN VDD VDD VSS VSS gf180mcu_fd_sc_mcu7t5v0__clkinv_2
X_1420_ _3047_/Q _2394_/A2 VDD VDD VSS VSS gf180mcu_fd_sc_mcu7t5v0__clkinv_1
XFILLER_95_212 VDD VDD VSS VSS gf180mcu_fd_sc_mcu7t5v0__fillcap_16
X_3021_ _3021_/D _3021_/CLK _3021_/Q VDD VDD VSS VSS gf180mcu_fd_sc_mcu7t5v0__dffq_1
XFILLER_36_312 VDD VDD VSS VSS gf180mcu_fd_sc_mcu7t5v0__fill_2
XFILLER_63_120 VDD VDD VSS VSS gf180mcu_fd_sc_mcu7t5v0__fillcap_4
XFILLER_91_451 VDD VDD VSS VSS gf180mcu_fd_sc_mcu7t5v0__fillcap_16
XFILLER_36_367 VDD VDD VSS VSS gf180mcu_fd_sc_mcu7t5v0__fill_1
XFILLER_63_142 VDD VDD VSS VSS gf180mcu_fd_sc_mcu7t5v0__fillcap_32
XTAP_TAPCELL_ROW_102_1302 VDD VSS gf180mcu_fd_sc_mcu7t5v0__filltie
XFILLER_51_348 VDD VDD VSS VSS gf180mcu_fd_sc_mcu7t5v0__fill_2
XTAP_TAPCELL_ROW_62_888 VDD VSS gf180mcu_fd_sc_mcu7t5v0__filltie
X_2805_ _2805_/D _2893_/CLK _2805_/Q VDD VDD VSS VSS gf180mcu_fd_sc_mcu7t5v0__dffq_1
X_2736_ _3320_/Q _3212_/Q _3213_/Q _2736_/A4 _2736_/Z VDD VDD VSS VSS gf180mcu_fd_sc_mcu7t5v0__and4_1
X_2667_ _2989_/Q _2981_/Q _2973_/Q _2965_/Q _2672_/S0 _2675_/S1 _2667_/Z VDD VDD VSS
+ VSS gf180mcu_fd_sc_mcu7t5v0__mux4_1
X_1618_ _3163_/Q _1617_/Z _1618_/B _1619_/A2 VDD VDD VSS VSS gf180mcu_fd_sc_mcu7t5v0__aoi21_1
XFILLER_87_702 VDD VDD VSS VSS gf180mcu_fd_sc_mcu7t5v0__fillcap_16
X_2598_ _3213_/Q _2126_/B _2598_/A3 _2732_/A3 VDD VDD VSS VSS gf180mcu_fd_sc_mcu7t5v0__nor3_1
XFILLER_86_212 VDD VDD VSS VSS gf180mcu_fd_sc_mcu7t5v0__fill_1
XFILLER_59_426 VDD VDD VSS VSS gf180mcu_fd_sc_mcu7t5v0__fill_2
X_1549_ _1549_/A1 _1547_/B _2111_/A1 VDD VDD VSS VSS gf180mcu_fd_sc_mcu7t5v0__nand2_1
XFILLER_101_556 VDD VDD VSS VSS gf180mcu_fd_sc_mcu7t5v0__fillcap_4
XFILLER_86_278 VDD VDD VSS VSS gf180mcu_fd_sc_mcu7t5v0__fillcap_32
X_3219_ _3219_/D _3303_/RN _3293_/CLK _3219_/Q VDD VDD VSS VSS gf180mcu_fd_sc_mcu7t5v0__dffrnq_1
XFILLER_39_172 VDD VDD VSS VSS gf180mcu_fd_sc_mcu7t5v0__fill_1
XFILLER_39_194 VDD VDD VSS VSS gf180mcu_fd_sc_mcu7t5v0__fill_1
XFILLER_67_492 VDD VDD VSS VSS gf180mcu_fd_sc_mcu7t5v0__fillcap_8
XFILLER_82_473 VDD VDD VSS VSS gf180mcu_fd_sc_mcu7t5v0__fillcap_4
XFILLER_55_698 VDD VDD VSS VSS gf180mcu_fd_sc_mcu7t5v0__fill_2
XFILLER_11_702 VDD VDD VSS VSS gf180mcu_fd_sc_mcu7t5v0__fillcap_8
XFILLER_23_562 VDD VDD VSS VSS gf180mcu_fd_sc_mcu7t5v0__fillcap_4
XFILLER_10_212 VDD VDD VSS VSS gf180mcu_fd_sc_mcu7t5v0__fillcap_32
XFILLER_10_267 VDD VDD VSS VSS gf180mcu_fd_sc_mcu7t5v0__fill_2
XFILLER_40_10 VDD VDD VSS VSS gf180mcu_fd_sc_mcu7t5v0__fillcap_4
XTAP_TAPCELL_ROW_79_1061 VDD VSS gf180mcu_fd_sc_mcu7t5v0__filltie
XFILLER_40_65 VDD VDD VSS VSS gf180mcu_fd_sc_mcu7t5v0__fillcap_4
XFILLER_6_2 VDD VDD VSS VSS gf180mcu_fd_sc_mcu7t5v0__fillcap_32
XFILLER_77_212 VDD VDD VSS VSS gf180mcu_fd_sc_mcu7t5v0__fillcap_8
XFILLER_77_278 VDD VDD VSS VSS gf180mcu_fd_sc_mcu7t5v0__fill_2
XTAP_TAPCELL_ROW_5_282 VDD VSS gf180mcu_fd_sc_mcu7t5v0__filltie
XFILLER_65_418 VDD VDD VSS VSS gf180mcu_fd_sc_mcu7t5v0__fill_2
XFILLER_45_142 VDD VDD VSS VSS gf180mcu_fd_sc_mcu7t5v0__fillcap_32
XFILLER_61_602 VDD VDD VSS VSS gf180mcu_fd_sc_mcu7t5v0__fill_1
XFILLER_81_72 VDD VDD VSS VSS gf180mcu_fd_sc_mcu7t5v0__fillcap_16
XFILLER_6_761 VDD VDD VSS VSS gf180mcu_fd_sc_mcu7t5v0__fillcap_4
X_2521_ _3184_/Q _3176_/Q _2534_/S _3184_/D VDD VDD VSS VSS gf180mcu_fd_sc_mcu7t5v0__mux2_2
XFILLER_5_282 VDD VDD VSS VSS gf180mcu_fd_sc_mcu7t5v0__fill_2
X_2452_ _3252_/Q _1617_/Z _2443_/Z _3268_/Q _2455_/A3 VDD VDD VSS VSS gf180mcu_fd_sc_mcu7t5v0__aoi22_1
XFILLER_69_702 VDD VDD VSS VSS gf180mcu_fd_sc_mcu7t5v0__fillcap_16
XFILLER_96_521 VDD VDD VSS VSS gf180mcu_fd_sc_mcu7t5v0__fillcap_4
XPHY_EDGE_ROW_18_Right_18 VDD VSS gf180mcu_fd_sc_mcu7t5v0__endcap
X_1403_ _3159_/Q _2468_/B VDD VDD VSS VSS gf180mcu_fd_sc_mcu7t5v0__clkinv_1
XFILLER_68_201 VDD VDD VSS VSS gf180mcu_fd_sc_mcu7t5v0__fillcap_4
X_2383_ _2409_/A1 _2383_/A2 _2383_/B _3137_/D VDD VDD VSS VSS gf180mcu_fd_sc_mcu7t5v0__oai21_1
Xinput3 sda_pad_i input3/Z VDD VDD VSS VSS gf180mcu_fd_sc_mcu7t5v0__dlyb_1
X_3004_ _3004_/D _3016_/CLK _3004_/Q VDD VDD VSS VSS gf180mcu_fd_sc_mcu7t5v0__dffq_1
XFILLER_37_632 VDD VDD VSS VSS gf180mcu_fd_sc_mcu7t5v0__fill_2
XTAP_TAPCELL_ROW_67_936 VDD VSS gf180mcu_fd_sc_mcu7t5v0__filltie
XPHY_EDGE_ROW_27_Right_27 VDD VSS gf180mcu_fd_sc_mcu7t5v0__endcap
X_2719_ _3271_/Q _2680_/C _2729_/B1 _3089_/Q _2720_/A2 VDD VDD VSS VSS gf180mcu_fd_sc_mcu7t5v0__aoi22_1
XFILLER_3_208 VDD VDD VSS VSS gf180mcu_fd_sc_mcu7t5v0__fill_2
XFILLER_106_648 VDD VDD VSS VSS gf180mcu_fd_sc_mcu7t5v0__fillcap_16
XPHY_EDGE_ROW_36_Right_36 VDD VSS gf180mcu_fd_sc_mcu7t5v0__endcap
XFILLER_59_212 VDD VDD VSS VSS gf180mcu_fd_sc_mcu7t5v0__fillcap_32
XFILLER_87_532 VDD VDD VSS VSS gf180mcu_fd_sc_mcu7t5v0__fill_2
XFILLER_87_576 VDD VDD VSS VSS gf180mcu_fd_sc_mcu7t5v0__fill_1
XFILLER_19_88 VDD VDD VSS VSS gf180mcu_fd_sc_mcu7t5v0__fill_2
XFILLER_28_610 VDD VDD VSS VSS gf180mcu_fd_sc_mcu7t5v0__fillcap_16
XTAP_TAPCELL_ROW_2_252 VDD VSS gf180mcu_fd_sc_mcu7t5v0__filltie
XFILLER_42_101 VDD VDD VSS VSS gf180mcu_fd_sc_mcu7t5v0__fillcap_4
XPHY_EDGE_ROW_45_Right_45 VDD VSS gf180mcu_fd_sc_mcu7t5v0__endcap
XFILLER_82_292 VDD VDD VSS VSS gf180mcu_fd_sc_mcu7t5v0__fill_1
XFILLER_35_76 VDD VDD VSS VSS gf180mcu_fd_sc_mcu7t5v0__fill_2
XFILLER_35_98 VDD VDD VSS VSS gf180mcu_fd_sc_mcu7t5v0__fill_2
XFILLER_42_156 VDD VDD VSS VSS gf180mcu_fd_sc_mcu7t5v0__fillcap_16
XFILLER_30_329 VDD VDD VSS VSS gf180mcu_fd_sc_mcu7t5v0__fillcap_8
XFILLER_51_64 VDD VDD VSS VSS gf180mcu_fd_sc_mcu7t5v0__fillcap_4
XFILLER_51_97 VDD VDD VSS VSS gf180mcu_fd_sc_mcu7t5v0__fill_1
XPHY_EDGE_ROW_54_Right_54 VDD VSS gf180mcu_fd_sc_mcu7t5v0__endcap
XFILLER_3_764 VDD VDD VSS VSS gf180mcu_fd_sc_mcu7t5v0__fill_1
XPHY_EDGE_ROW_29_Left_138 VDD VSS gf180mcu_fd_sc_mcu7t5v0__endcap
XFILLER_2_296 VDD VDD VSS VSS gf180mcu_fd_sc_mcu7t5v0__fillcap_4
XFILLER_76_50 VDD VDD VSS VSS gf180mcu_fd_sc_mcu7t5v0__fillcap_4
XFILLER_38_429 VDD VDD VSS VSS gf180mcu_fd_sc_mcu7t5v0__fill_1
XFILLER_19_632 VDD VDD VSS VSS gf180mcu_fd_sc_mcu7t5v0__fill_2
XTAP_TAPCELL_ROW_36_608 VDD VSS gf180mcu_fd_sc_mcu7t5v0__filltie
XPHY_EDGE_ROW_63_Right_63 VDD VSS gf180mcu_fd_sc_mcu7t5v0__endcap
XTAP_TAPCELL_ROW_64_906 VDD VSS gf180mcu_fd_sc_mcu7t5v0__filltie
XFILLER_80_218 VDD VDD VSS VSS gf180mcu_fd_sc_mcu7t5v0__fillcap_8
XFILLER_19_698 VDD VDD VSS VSS gf180mcu_fd_sc_mcu7t5v0__fill_2
XFILLER_33_101 VDD VDD VSS VSS gf180mcu_fd_sc_mcu7t5v0__fillcap_16
XPHY_EDGE_ROW_1_Left_110 VDD VSS gf180mcu_fd_sc_mcu7t5v0__endcap
XFILLER_34_657 VDD VDD VSS VSS gf180mcu_fd_sc_mcu7t5v0__fillcap_8
XFILLER_61_454 VDD VDD VSS VSS gf180mcu_fd_sc_mcu7t5v0__fillcap_4
XPHY_EDGE_ROW_38_Left_147 VDD VSS gf180mcu_fd_sc_mcu7t5v0__endcap
XFILLER_61_476 VDD VDD VSS VSS gf180mcu_fd_sc_mcu7t5v0__fillcap_8
XTAP_TAPCELL_ROW_16_398 VDD VSS gf180mcu_fd_sc_mcu7t5v0__filltie
X_1952_ _3117_/Q _2973_/Q _1953_/S _2973_/D VDD VDD VSS VSS gf180mcu_fd_sc_mcu7t5v0__mux2_2
XTAP_TAPCELL_ROW_44_696 VDD VSS gf180mcu_fd_sc_mcu7t5v0__filltie
XTAP_TAPCELL_ROW_72_994 VDD VSS gf180mcu_fd_sc_mcu7t5v0__filltie
X_1883_ _2914_/Q _3114_/Q _1886_/S _2914_/D VDD VDD VSS VSS gf180mcu_fd_sc_mcu7t5v0__mux2_2
XTAP_TAPCELL_ROW_99_1278 VDD VSS gf180mcu_fd_sc_mcu7t5v0__filltie
XPHY_EDGE_ROW_72_Right_72 VDD VSS gf180mcu_fd_sc_mcu7t5v0__endcap
XFILLER_6_580 VDD VDD VSS VSS gf180mcu_fd_sc_mcu7t5v0__fill_1
XFILLER_6_591 VDD VDD VSS VSS gf180mcu_fd_sc_mcu7t5v0__fillcap_4
X_2504_ _3168_/Q _3153_/Q wire13/Z _3168_/D VDD VDD VSS VSS gf180mcu_fd_sc_mcu7t5v0__mux2_2
XPHY_EDGE_ROW_47_Left_156 VDD VSS gf180mcu_fd_sc_mcu7t5v0__endcap
X_2435_ _2298_/B _2435_/A2 _2435_/B _2436_/A2 VDD VDD VSS VSS gf180mcu_fd_sc_mcu7t5v0__oai21_1
XFILLER_102_139 VDD VDD VSS VSS gf180mcu_fd_sc_mcu7t5v0__fillcap_4
X_2366_ _2366_/A1 _2366_/A2 _2379_/B _2367_/B VDD VDD VSS VSS gf180mcu_fd_sc_mcu7t5v0__aoi21_1
XFILLER_96_384 VDD VDD VSS VSS gf180mcu_fd_sc_mcu7t5v0__fill_1
X_2297_ _3128_/Q _1632_/Z _2434_/A1 _2434_/A2 _2297_/Z VDD VDD VSS VSS gf180mcu_fd_sc_mcu7t5v0__and4_1
XFILLER_84_524 VDD VDD VSS VSS gf180mcu_fd_sc_mcu7t5v0__fill_1
XPHY_EDGE_ROW_81_Right_81 VDD VSS gf180mcu_fd_sc_mcu7t5v0__endcap
XFILLER_37_451 VDD VDD VSS VSS gf180mcu_fd_sc_mcu7t5v0__fillcap_8
XTAP_TAPCELL_ROW_108_1374 VDD VSS gf180mcu_fd_sc_mcu7t5v0__filltie
XTAP_TAPCELL_ROW_108_1363 VDD VSS gf180mcu_fd_sc_mcu7t5v0__filltie
XFILLER_80_730 VDD VDD VSS VSS gf180mcu_fd_sc_mcu7t5v0__fillcap_4
XFILLER_24_123 VDD VDD VSS VSS gf180mcu_fd_sc_mcu7t5v0__fill_2
XPHY_EDGE_ROW_56_Left_165 VDD VSS gf180mcu_fd_sc_mcu7t5v0__endcap
XFILLER_40_605 VDD VDD VSS VSS gf180mcu_fd_sc_mcu7t5v0__fill_2
XFILLER_52_487 VDD VDD VSS VSS gf180mcu_fd_sc_mcu7t5v0__fillcap_4
XPHY_EDGE_ROW_90_Right_90 VDD VSS gf180mcu_fd_sc_mcu7t5v0__endcap
XFILLER_20_395 VDD VDD VSS VSS gf180mcu_fd_sc_mcu7t5v0__fillcap_4
XTAP_TAPCELL_ROW_76_1031 VDD VSS gf180mcu_fd_sc_mcu7t5v0__filltie
XFILLER_21_67 VDD VDD VSS VSS gf180mcu_fd_sc_mcu7t5v0__fill_2
XPHY_EDGE_ROW_65_Left_174 VDD VSS gf180mcu_fd_sc_mcu7t5v0__endcap
XFILLER_97_49 VDD VDD VSS VSS gf180mcu_fd_sc_mcu7t5v0__fillcap_8
XTAP_TAPCELL_ROW_7_311 VDD VSS gf180mcu_fd_sc_mcu7t5v0__filltie
XFILLER_47_204 VDD VDD VSS VSS gf180mcu_fd_sc_mcu7t5v0__fillcap_4
Xmax_cap10 _2731_/B1 _2729_/B1 VDD VDD VSS VSS gf180mcu_fd_sc_mcu7t5v0__buf_4
XFILLER_90_527 VDD VDD VSS VSS gf180mcu_fd_sc_mcu7t5v0__fillcap_16
XFILLER_90_516 VDD VDD VSS VSS gf180mcu_fd_sc_mcu7t5v0__fillcap_8
XFILLER_43_410 VDD VDD VSS VSS gf180mcu_fd_sc_mcu7t5v0__fillcap_8
XPHY_EDGE_ROW_74_Left_183 VDD VSS gf180mcu_fd_sc_mcu7t5v0__endcap
XFILLER_15_134 VDD VDD VSS VSS gf180mcu_fd_sc_mcu7t5v0__fillcap_4
XFILLER_71_741 VDD VDD VSS VSS gf180mcu_fd_sc_mcu7t5v0__fillcap_16
XFILLER_31_605 VDD VDD VSS VSS gf180mcu_fd_sc_mcu7t5v0__fillcap_8
XFILLER_30_115 VDD VDD VSS VSS gf180mcu_fd_sc_mcu7t5v0__fillcap_4
XTAP_TAPCELL_ROW_41_666 VDD VSS gf180mcu_fd_sc_mcu7t5v0__filltie
XFILLER_62_96 VDD VDD VSS VSS gf180mcu_fd_sc_mcu7t5v0__fillcap_8
XTAP_TAPCELL_ROW_13_368 VDD VSS gf180mcu_fd_sc_mcu7t5v0__filltie
XPHY_EDGE_ROW_83_Left_192 VDD VSS gf180mcu_fd_sc_mcu7t5v0__endcap
X_2220_ _2300_/A1 _1632_/Z _2278_/B _2221_/A2 VDD VDD VSS VSS gf180mcu_fd_sc_mcu7t5v0__nand3_1
X_2151_ _3230_/Q _3080_/Q _2166_/S _3080_/D VDD VDD VSS VSS gf180mcu_fd_sc_mcu7t5v0__mux2_2
XFILLER_66_524 VDD VDD VSS VSS gf180mcu_fd_sc_mcu7t5v0__fill_1
XTAP_TAPCELL_ROW_49_744 VDD VSS gf180mcu_fd_sc_mcu7t5v0__filltie
X_2082_ _3051_/Q _2076_/C _2090_/A2 _3291_/Q _2091_/B _2083_/B2 VDD VDD VSS VSS gf180mcu_fd_sc_mcu7t5v0__aoi221_1
XFILLER_74_590 VDD VDD VSS VSS gf180mcu_fd_sc_mcu7t5v0__fillcap_4
XFILLER_34_454 VDD VDD VSS VSS gf180mcu_fd_sc_mcu7t5v0__fill_1
XFILLER_62_763 VDD VDD VSS VSS gf180mcu_fd_sc_mcu7t5v0__fill_2
X_2984_ _2984_/D _2984_/CLK _2984_/Q VDD VDD VSS VSS gf180mcu_fd_sc_mcu7t5v0__dffq_1
XFILLER_21_137 VDD VDD VSS VSS gf180mcu_fd_sc_mcu7t5v0__fill_2
X_1935_ _3366_/Q _1935_/A2 _1935_/Z VDD VDD VSS VSS gf180mcu_fd_sc_mcu7t5v0__and2_1
X_1866_ _2901_/Q _3117_/Q _1867_/S _2901_/D VDD VDD VSS VSS gf180mcu_fd_sc_mcu7t5v0__mux2_2
X_1797_ _3280_/Q _2839_/Q _1804_/S _2839_/D VDD VDD VSS VSS gf180mcu_fd_sc_mcu7t5v0__mux2_2
XFILLER_89_627 VDD VDD VSS VSS gf180mcu_fd_sc_mcu7t5v0__fill_2
X_3398_ _3398_/D _3416_/RN _3398_/CLK _3398_/Q VDD VDD VSS VSS gf180mcu_fd_sc_mcu7t5v0__dffrnq_1
X_2418_ _2424_/A1 _2434_/B _2418_/B _2418_/C _2419_/A2 VDD VDD VSS VSS gf180mcu_fd_sc_mcu7t5v0__aoi211_1
XFILLER_96_170 VDD VDD VSS VSS gf180mcu_fd_sc_mcu7t5v0__fill_1
X_2349_ _2825_/Q _2817_/Q _2809_/Q _2801_/Q _2388_/S0 _2388_/S1 _2349_/Z VDD VDD VSS
+ VSS gf180mcu_fd_sc_mcu7t5v0__mux4_1
XFILLER_29_237 VDD VDD VSS VSS gf180mcu_fd_sc_mcu7t5v0__fillcap_8
XFILLER_72_527 VDD VDD VSS VSS gf180mcu_fd_sc_mcu7t5v0__fill_1
XFILLER_16_34 VDD VDD VSS VSS gf180mcu_fd_sc_mcu7t5v0__fill_1
XPHY_EDGE_ROW_0_Right_0 VDD VSS gf180mcu_fd_sc_mcu7t5v0__endcap
XFILLER_25_454 VDD VDD VSS VSS gf180mcu_fd_sc_mcu7t5v0__fillcap_16
XFILLER_52_262 VDD VDD VSS VSS gf180mcu_fd_sc_mcu7t5v0__fillcap_8
XFILLER_80_593 VDD VDD VSS VSS gf180mcu_fd_sc_mcu7t5v0__fill_2
XTAP_TAPCELL_ROW_82_1090 VDD VSS gf180mcu_fd_sc_mcu7t5v0__filltie
XFILLER_40_457 VDD VDD VSS VSS gf180mcu_fd_sc_mcu7t5v0__fillcap_4
XTAP_TAPCELL_ROW_10_338 VDD VSS gf180mcu_fd_sc_mcu7t5v0__filltie
XFILLER_106_2 VDD VDD VSS VSS gf180mcu_fd_sc_mcu7t5v0__fillcap_32
XFILLER_79_137 VDD VDD VSS VSS gf180mcu_fd_sc_mcu7t5v0__fill_2
XFILLER_94_107 VDD VDD VSS VSS gf180mcu_fd_sc_mcu7t5v0__fillcap_64
XFILLER_88_660 VDD VDD VSS VSS gf180mcu_fd_sc_mcu7t5v0__fillcap_4
XFILLER_48_502 VDD VDD VSS VSS gf180mcu_fd_sc_mcu7t5v0__fillcap_8
XFILLER_48_568 VDD VDD VSS VSS gf180mcu_fd_sc_mcu7t5v0__fill_2
XTAP_TAPCELL_ROW_46_714 VDD VSS gf180mcu_fd_sc_mcu7t5v0__filltie
XTAP_TAPCELL_ROW_18_427 VDD VSS gf180mcu_fd_sc_mcu7t5v0__filltie
XFILLER_28_270 VDD VDD VSS VSS gf180mcu_fd_sc_mcu7t5v0__fillcap_8
XFILLER_28_292 VDD VDD VSS VSS gf180mcu_fd_sc_mcu7t5v0__fill_2
XFILLER_16_476 VDD VDD VSS VSS gf180mcu_fd_sc_mcu7t5v0__fill_2
XFILLER_44_763 VDD VDD VSS VSS gf180mcu_fd_sc_mcu7t5v0__fill_2
XFILLER_73_62 VDD VDD VSS VSS gf180mcu_fd_sc_mcu7t5v0__fillcap_8
XFILLER_73_51 VDD VDD VSS VSS gf180mcu_fd_sc_mcu7t5v0__fill_2
XFILLER_31_446 VDD VDD VSS VSS gf180mcu_fd_sc_mcu7t5v0__fill_2
XPHY_EDGE_ROW_91_Left_200 VDD VSS gf180mcu_fd_sc_mcu7t5v0__endcap
XFILLER_12_682 VDD VDD VSS VSS gf180mcu_fd_sc_mcu7t5v0__fill_2
X_1720_ _3406_/Q _3407_/Q _1833_/A1 _1728_/S VDD VDD VSS VSS gf180mcu_fd_sc_mcu7t5v0__and3_1
XFILLER_8_664 VDD VDD VSS VSS gf180mcu_fd_sc_mcu7t5v0__fill_1
XTAP_TAPCELL_ROW_96_1237 VDD VSS gf180mcu_fd_sc_mcu7t5v0__filltie
X_1651_ _2764_/Q _2202_/A2 _2766_/Q _2224_/A1 VDD VDD VSS VSS gf180mcu_fd_sc_mcu7t5v0__nand3_1
XFILLER_7_174 VDD VDD VSS VSS gf180mcu_fd_sc_mcu7t5v0__fillcap_16
X_3321_ input4/Z _3369_/RN _3327_/CLK _3322_/D VDD VDD VSS VSS gf180mcu_fd_sc_mcu7t5v0__dffsnq_1
X_1582_ _3350_/Q _3355_/D _1582_/Z VDD VDD VSS VSS gf180mcu_fd_sc_mcu7t5v0__xor2_1
XFILLER_98_457 VDD VDD VSS VSS gf180mcu_fd_sc_mcu7t5v0__fillcap_4
XFILLER_79_660 VDD VDD VSS VSS gf180mcu_fd_sc_mcu7t5v0__fillcap_16
X_3252_ _3252_/D _3369_/RN _3253_/CLK _3252_/Q VDD VDD VSS VSS gf180mcu_fd_sc_mcu7t5v0__dffrnq_1
X_2203_ _3148_/Q _1686_/B _2438_/B2 VDD VDD VSS VSS gf180mcu_fd_sc_mcu7t5v0__nand2_1
XFILLER_78_170 VDD VDD VSS VSS gf180mcu_fd_sc_mcu7t5v0__fillcap_4
X_3183_ _3183_/D _3303_/RN _3293_/CLK _3183_/Q VDD VDD VSS VSS gf180mcu_fd_sc_mcu7t5v0__dffrnq_1
XFILLER_78_181 VDD VDD VSS VSS gf180mcu_fd_sc_mcu7t5v0__fill_1
X_2134_ _3320_/Q _3212_/Q _3213_/Q _2132_/I _2166_/S VDD VDD VSS VSS gf180mcu_fd_sc_mcu7t5v0__nand4_2
XFILLER_54_527 VDD VDD VSS VSS gf180mcu_fd_sc_mcu7t5v0__fill_2
XFILLER_66_387 VDD VDD VSS VSS gf180mcu_fd_sc_mcu7t5v0__fillcap_16
XFILLER_81_324 VDD VDD VSS VSS gf180mcu_fd_sc_mcu7t5v0__fillcap_4
X_2065_ _3311_/Q _3123_/Q _2414_/B _2091_/B VDD VDD VSS VSS gf180mcu_fd_sc_mcu7t5v0__nand3_1
XTAP_TAPCELL_ROW_105_1333 VDD VSS gf180mcu_fd_sc_mcu7t5v0__filltie
XFILLER_34_251 VDD VDD VSS VSS gf180mcu_fd_sc_mcu7t5v0__fill_2
XFILLER_34_284 VDD VDD VSS VSS gf180mcu_fd_sc_mcu7t5v0__fillcap_8
XFILLER_50_733 VDD VDD VSS VSS gf180mcu_fd_sc_mcu7t5v0__fill_2
X_2967_ _2967_/D _2988_/CLK _2967_/Q VDD VDD VSS VSS gf180mcu_fd_sc_mcu7t5v0__dffq_1
X_1918_ _3111_/Q _2943_/Q _1925_/S _2943_/D VDD VDD VSS VSS gf180mcu_fd_sc_mcu7t5v0__mux2_2
X_2898_ _2898_/D _3286_/CLK _2898_/Q VDD VDD VSS VSS gf180mcu_fd_sc_mcu7t5v0__dffq_1
X_1849_ _3286_/Q _2885_/Q _1850_/S _2885_/D VDD VDD VSS VSS gf180mcu_fd_sc_mcu7t5v0__mux2_2
XFILLER_89_413 VDD VDD VSS VSS gf180mcu_fd_sc_mcu7t5v0__fillcap_4
XTAP_TAPCELL_ROW_73_1001 VDD VSS gf180mcu_fd_sc_mcu7t5v0__filltie
XFILLER_103_212 VDD VDD VSS VSS gf180mcu_fd_sc_mcu7t5v0__fillcap_16
XFILLER_103_245 VDD VDD VSS VSS gf180mcu_fd_sc_mcu7t5v0__fillcap_32
XFILLER_89_457 VDD VDD VSS VSS gf180mcu_fd_sc_mcu7t5v0__fillcap_32
XFILLER_26_752 VDD VDD VSS VSS gf180mcu_fd_sc_mcu7t5v0__fillcap_8
XFILLER_27_88 VDD VDD VSS VSS gf180mcu_fd_sc_mcu7t5v0__fillcap_4
XFILLER_25_295 VDD VDD VSS VSS gf180mcu_fd_sc_mcu7t5v0__fillcap_32
XFILLER_40_243 VDD VDD VSS VSS gf180mcu_fd_sc_mcu7t5v0__fill_2
XFILLER_43_54 VDD VDD VSS VSS gf180mcu_fd_sc_mcu7t5v0__fill_1
XTAP_TAPCELL_ROW_23_474 VDD VSS gf180mcu_fd_sc_mcu7t5v0__filltie
XTAP_TAPCELL_ROW_51_772 VDD VSS gf180mcu_fd_sc_mcu7t5v0__filltie
XFILLER_4_111 VDD VDD VSS VSS gf180mcu_fd_sc_mcu7t5v0__fill_2
XFILLER_107_562 VDD VDD VSS VSS gf180mcu_fd_sc_mcu7t5v0__fillcap_64
XFILLER_4_37 VDD VDD VSS VSS gf180mcu_fd_sc_mcu7t5v0__fillcap_64
XTAP_TAPCELL_ROW_91_1189 VDD VSS gf180mcu_fd_sc_mcu7t5v0__filltie
XFILLER_95_438 VDD VDD VSS VSS gf180mcu_fd_sc_mcu7t5v0__fillcap_4
XTAP_TAPCELL_ROW_59_850 VDD VSS gf180mcu_fd_sc_mcu7t5v0__filltie
XFILLER_76_696 VDD VDD VSS VSS gf180mcu_fd_sc_mcu7t5v0__fill_1
XFILLER_36_527 VDD VDD VSS VSS gf180mcu_fd_sc_mcu7t5v0__fillcap_4
XFILLER_48_387 VDD VDD VSS VSS gf180mcu_fd_sc_mcu7t5v0__fillcap_16
XFILLER_17_763 VDD VDD VSS VSS gf180mcu_fd_sc_mcu7t5v0__fill_2
XFILLER_44_593 VDD VDD VSS VSS gf180mcu_fd_sc_mcu7t5v0__fill_2
XFILLER_71_390 VDD VDD VSS VSS gf180mcu_fd_sc_mcu7t5v0__fill_1
X_2821_ _2821_/D _2893_/CLK _2821_/Q VDD VDD VSS VSS gf180mcu_fd_sc_mcu7t5v0__dffq_1
XTAP_TAPCELL_ROW_100_1285 VDD VSS gf180mcu_fd_sc_mcu7t5v0__filltie
XFILLER_31_298 VDD VDD VSS VSS gf180mcu_fd_sc_mcu7t5v0__fill_2
X_2752_ _3226_/Q _3292_/Q _2760_/S _3292_/D VDD VDD VSS VSS gf180mcu_fd_sc_mcu7t5v0__mux2_2
X_1703_ _3142_/Q _3305_/Q _1705_/C VDD VDD VSS VSS gf180mcu_fd_sc_mcu7t5v0__nor2_1
X_2683_ _3073_/Q _2132_/I _2603_/Z _3144_/Q _2683_/C _2684_/A2 VDD VDD VSS VSS gf180mcu_fd_sc_mcu7t5v0__aoi221_1
X_1634_ _3128_/Q _1632_/Z _2424_/A1 VDD VDD VSS VSS gf180mcu_fd_sc_mcu7t5v0__nand2_1
X_1565_ _3309_/Q _2414_/B _1565_/A3 _1566_/B VDD VDD VSS VSS gf180mcu_fd_sc_mcu7t5v0__nand3_1
XFILLER_98_254 VDD VDD VSS VSS gf180mcu_fd_sc_mcu7t5v0__fillcap_32
X_3304_ _3304_/D _3416_/RN _3311_/CLK _3304_/Q VDD VDD VSS VSS gf180mcu_fd_sc_mcu7t5v0__dffsnq_1
X_3235_ _3235_/D _3328_/RN _3328_/CLK _3235_/Q VDD VDD VSS VSS gf180mcu_fd_sc_mcu7t5v0__dffrnq_1
XFILLER_39_310 VDD VDD VSS VSS gf180mcu_fd_sc_mcu7t5v0__fill_1
X_1496_ _3366_/Q _1490_/Z _1503_/A2 VDD VDD VSS VSS gf180mcu_fd_sc_mcu7t5v0__nor2_1
XFILLER_58_107 VDD VDD VSS VSS gf180mcu_fd_sc_mcu7t5v0__fill_1
XFILLER_100_237 VDD VDD VSS VSS gf180mcu_fd_sc_mcu7t5v0__fillcap_8
X_3166_ _3166_/D _3328_/RN _3215_/CLK _3166_/Q VDD VDD VSS VSS gf180mcu_fd_sc_mcu7t5v0__dffrnq_1
XFILLER_66_151 VDD VDD VSS VSS gf180mcu_fd_sc_mcu7t5v0__fillcap_8
X_3097_ _3097_/D _3303_/RN _3288_/CLK _3097_/Q VDD VDD VSS VSS gf180mcu_fd_sc_mcu7t5v0__dffrnq_1
Xclkbuf_leaf_14_clk_i clkload1/I _3425_/CLK VDD VDD VSS VSS gf180mcu_fd_sc_mcu7t5v0__clkbuf_4
X_2117_ _2124_/A1 _2114_/Z _3061_/Q _2120_/B VDD VDD VSS VSS gf180mcu_fd_sc_mcu7t5v0__aoi21_1
X_2048_ _3032_/Q _3031_/Q _3033_/Q _2048_/A4 _2055_/A4 VDD VDD VSS VSS gf180mcu_fd_sc_mcu7t5v0__nand4_1
XFILLER_54_379 VDD VDD VSS VSS gf180mcu_fd_sc_mcu7t5v0__fillcap_4
XFILLER_22_243 VDD VDD VSS VSS gf180mcu_fd_sc_mcu7t5v0__fill_2
Xclkbuf_leaf_29_clk_i clkload5/I _2926_/CLK VDD VDD VSS VSS gf180mcu_fd_sc_mcu7t5v0__clkbuf_4
XFILLER_50_585 VDD VDD VSS VSS gf180mcu_fd_sc_mcu7t5v0__fillcap_8
XFILLER_22_298 VDD VDD VSS VSS gf180mcu_fd_sc_mcu7t5v0__fill_2
XTAP_TAPCELL_ROW_20_444 VDD VSS gf180mcu_fd_sc_mcu7t5v0__filltie
XFILLER_2_626 VDD VDD VSS VSS gf180mcu_fd_sc_mcu7t5v0__fill_1
XFILLER_1_158 VDD VDD VSS VSS gf180mcu_fd_sc_mcu7t5v0__fillcap_8
XFILLER_38_10 VDD VDD VSS VSS gf180mcu_fd_sc_mcu7t5v0__fillcap_4
XFILLER_38_87 VDD VDD VSS VSS gf180mcu_fd_sc_mcu7t5v0__fillcap_16
XFILLER_18_527 VDD VDD VSS VSS gf180mcu_fd_sc_mcu7t5v0__fillcap_32
XTAP_TAPCELL_ROW_28_533 VDD VSS gf180mcu_fd_sc_mcu7t5v0__filltie
XTAP_TAPCELL_ROW_56_820 VDD VSS gf180mcu_fd_sc_mcu7t5v0__filltie
XFILLER_45_346 VDD VDD VSS VSS gf180mcu_fd_sc_mcu7t5v0__fillcap_4
XFILLER_26_582 VDD VDD VSS VSS gf180mcu_fd_sc_mcu7t5v0__fillcap_8
XFILLER_54_53 VDD VDD VSS VSS gf180mcu_fd_sc_mcu7t5v0__fillcap_4
XFILLER_41_541 VDD VDD VSS VSS gf180mcu_fd_sc_mcu7t5v0__fillcap_4
Xclkload17 _3222_/CLK clkload17/Z VDD VDD VSS VSS gf180mcu_fd_sc_mcu7t5v0__clkbuf_1
XTAP_TAPCELL_ROW_93_1207 VDD VSS gf180mcu_fd_sc_mcu7t5v0__filltie
Xclkload39 _3270_/CLK clkload39/ZN VDD VDD VSS VSS gf180mcu_fd_sc_mcu7t5v0__inv_2
Xclkload28 _3288_/CLK clkload28/ZN VDD VDD VSS VSS gf180mcu_fd_sc_mcu7t5v0__clkinv_1
XFILLER_79_72 VDD VDD VSS VSS gf180mcu_fd_sc_mcu7t5v0__fillcap_8
XPHY_EDGE_ROW_10_Left_119 VDD VSS gf180mcu_fd_sc_mcu7t5v0__endcap
XFILLER_83_419 VDD VDD VSS VSS gf180mcu_fd_sc_mcu7t5v0__fill_1
X_3020_ _3020_/D _3020_/CLK _3020_/Q VDD VDD VSS VSS gf180mcu_fd_sc_mcu7t5v0__dffq_1
XFILLER_49_663 VDD VDD VSS VSS gf180mcu_fd_sc_mcu7t5v0__fillcap_16
XFILLER_48_173 VDD VDD VSS VSS gf180mcu_fd_sc_mcu7t5v0__fill_2
XFILLER_24_519 VDD VDD VSS VSS gf180mcu_fd_sc_mcu7t5v0__fillcap_4
XTAP_TAPCELL_ROW_102_1303 VDD VSS gf180mcu_fd_sc_mcu7t5v0__filltie
XTAP_TAPCELL_ROW_62_889 VDD VSS gf180mcu_fd_sc_mcu7t5v0__filltie
X_2804_ _2804_/D _2828_/CLK _2804_/Q VDD VDD VSS VSS gf180mcu_fd_sc_mcu7t5v0__dffq_1
X_2735_ _3314_/D _2735_/A2 _3278_/D VDD VDD VSS VSS gf180mcu_fd_sc_mcu7t5v0__xor2_1
X_2666_ _2925_/Q _2917_/Q _2909_/Q _2901_/Q _2674_/S0 _2675_/S1 _2666_/Z VDD VDD VSS
+ VSS gf180mcu_fd_sc_mcu7t5v0__mux4_1
XFILLER_105_329 VDD VDD VSS VSS gf180mcu_fd_sc_mcu7t5v0__fill_2
X_1617_ _2492_/A1 _3160_/Q _3162_/Q _1617_/Z VDD VDD VSS VSS gf180mcu_fd_sc_mcu7t5v0__and3_1
X_2597_ _3213_/Q _2126_/B _2680_/A1 VDD VDD VSS VSS gf180mcu_fd_sc_mcu7t5v0__nor2_1
XFILLER_99_585 VDD VDD VSS VSS gf180mcu_fd_sc_mcu7t5v0__fill_2
XFILLER_86_202 VDD VDD VSS VSS gf180mcu_fd_sc_mcu7t5v0__fillcap_8
X_1548_ _1549_/A1 _1547_/B _1548_/Z VDD VDD VSS VSS gf180mcu_fd_sc_mcu7t5v0__and2_1
XFILLER_86_257 VDD VDD VSS VSS gf180mcu_fd_sc_mcu7t5v0__fill_1
X_1479_ _1484_/A2 _1478_/Z _3353_/D VDD VDD VSS VSS gf180mcu_fd_sc_mcu7t5v0__nor2_1
XFILLER_74_408 VDD VDD VSS VSS gf180mcu_fd_sc_mcu7t5v0__fillcap_32
X_3218_ _3218_/D _3303_/RN _3292_/CLK _3218_/Q VDD VDD VSS VSS gf180mcu_fd_sc_mcu7t5v0__dffrnq_1
X_3149_ _3149_/D _3369_/RN _3329_/CLK _3149_/Q VDD VDD VSS VSS gf180mcu_fd_sc_mcu7t5v0__dffrnq_1
XFILLER_35_390 VDD VDD VSS VSS gf180mcu_fd_sc_mcu7t5v0__fill_2
XFILLER_42_349 VDD VDD VSS VSS gf180mcu_fd_sc_mcu7t5v0__fillcap_32
XFILLER_11_714 VDD VDD VSS VSS gf180mcu_fd_sc_mcu7t5v0__fill_1
XFILLER_24_34 VDD VDD VSS VSS gf180mcu_fd_sc_mcu7t5v0__fill_1
XFILLER_24_45 VDD VDD VSS VSS gf180mcu_fd_sc_mcu7t5v0__fill_2
XTAP_TAPCELL_ROW_33_580 VDD VSS gf180mcu_fd_sc_mcu7t5v0__filltie
XFILLER_50_371 VDD VDD VSS VSS gf180mcu_fd_sc_mcu7t5v0__fillcap_8
XFILLER_6_217 VDD VDD VSS VSS gf180mcu_fd_sc_mcu7t5v0__fillcap_4
XFILLER_6_228 VDD VDD VSS VSS gf180mcu_fd_sc_mcu7t5v0__fill_1
XTAP_TAPCELL_ROW_79_1062 VDD VSS gf180mcu_fd_sc_mcu7t5v0__filltie
XFILLER_93_717 VDD VDD VSS VSS gf180mcu_fd_sc_mcu7t5v0__fill_1
XTAP_TAPCELL_ROW_5_283 VDD VSS gf180mcu_fd_sc_mcu7t5v0__filltie
XFILLER_33_316 VDD VDD VSS VSS gf180mcu_fd_sc_mcu7t5v0__fill_2
XFILLER_61_625 VDD VDD VSS VSS gf180mcu_fd_sc_mcu7t5v0__fillcap_4
XFILLER_33_338 VDD VDD VSS VSS gf180mcu_fd_sc_mcu7t5v0__fillcap_8
X_2520_ _3183_/Q _3175_/Q _2540_/S _3183_/D VDD VDD VSS VSS gf180mcu_fd_sc_mcu7t5v0__mux2_2
X_2451_ _3276_/Q _2466_/B1 _2467_/B1 _3260_/Q _2455_/A2 VDD VDD VSS VSS gf180mcu_fd_sc_mcu7t5v0__aoi22_1
X_1402_ _3329_/Q _1609_/A2 VDD VDD VSS VSS gf180mcu_fd_sc_mcu7t5v0__clkinv_1
X_2382_ _3136_/Q _2407_/B _2382_/B _2383_/A2 VDD VDD VSS VSS gf180mcu_fd_sc_mcu7t5v0__oai21_1
X_3003_ _3003_/D _3020_/CLK _3003_/Q VDD VDD VSS VSS gf180mcu_fd_sc_mcu7t5v0__dffq_1
Xinput4 spi_cs_ni input4/Z VDD VDD VSS VSS gf180mcu_fd_sc_mcu7t5v0__dlyb_1
XTAP_TAPCELL_ROW_39_639 VDD VSS gf180mcu_fd_sc_mcu7t5v0__filltie
XTAP_TAPCELL_ROW_67_937 VDD VSS gf180mcu_fd_sc_mcu7t5v0__filltie
XFILLER_64_452 VDD VDD VSS VSS gf180mcu_fd_sc_mcu7t5v0__fill_2
XFILLER_91_282 VDD VDD VSS VSS gf180mcu_fd_sc_mcu7t5v0__fill_2
XFILLER_24_349 VDD VDD VSS VSS gf180mcu_fd_sc_mcu7t5v0__fill_2
XFILLER_51_179 VDD VDD VSS VSS gf180mcu_fd_sc_mcu7t5v0__fill_1
XTAP_TAPCELL_ROW_30_550 VDD VSS gf180mcu_fd_sc_mcu7t5v0__filltie
XFILLER_106_616 VDD VDD VSS VSS gf180mcu_fd_sc_mcu7t5v0__fill_2
X_2718_ _2718_/I _3270_/D VDD VDD VSS VSS gf180mcu_fd_sc_mcu7t5v0__clkinv_1
XFILLER_10_58 VDD VDD VSS VSS gf180mcu_fd_sc_mcu7t5v0__fill_1
X_2649_ _2687_/A2 _2649_/A2 _2650_/B1 VDD VDD VSS VSS gf180mcu_fd_sc_mcu7t5v0__nand2_1
XFILLER_99_360 VDD VDD VSS VSS gf180mcu_fd_sc_mcu7t5v0__fill_2
XFILLER_86_18 VDD VDD VSS VSS gf180mcu_fd_sc_mcu7t5v0__fillcap_4
XFILLER_99_382 VDD VDD VSS VSS gf180mcu_fd_sc_mcu7t5v0__fillcap_16
XFILLER_19_56 VDD VDD VSS VSS gf180mcu_fd_sc_mcu7t5v0__fillcap_8
XFILLER_47_408 VDD VDD VSS VSS gf180mcu_fd_sc_mcu7t5v0__fillcap_8
XTAP_TAPCELL_ROW_2_253 VDD VSS gf180mcu_fd_sc_mcu7t5v0__filltie
XFILLER_82_271 VDD VDD VSS VSS gf180mcu_fd_sc_mcu7t5v0__fill_1
XFILLER_15_305 VDD VDD VSS VSS gf180mcu_fd_sc_mcu7t5v0__fillcap_8
XFILLER_43_625 VDD VDD VSS VSS gf180mcu_fd_sc_mcu7t5v0__fillcap_4
XFILLER_15_349 VDD VDD VSS VSS gf180mcu_fd_sc_mcu7t5v0__fill_1
XFILLER_43_636 VDD VDD VSS VSS gf180mcu_fd_sc_mcu7t5v0__fill_1
XFILLER_51_87 VDD VDD VSS VSS gf180mcu_fd_sc_mcu7t5v0__fillcap_8
XFILLER_7_559 VDD VDD VSS VSS gf180mcu_fd_sc_mcu7t5v0__fill_1
XFILLER_3_710 VDD VDD VSS VSS gf180mcu_fd_sc_mcu7t5v0__fill_1
XFILLER_97_308 VDD VDD VSS VSS gf180mcu_fd_sc_mcu7t5v0__fillcap_4
XFILLER_38_419 VDD VDD VSS VSS gf180mcu_fd_sc_mcu7t5v0__fillcap_8
XFILLER_66_728 VDD VDD VSS VSS gf180mcu_fd_sc_mcu7t5v0__fill_1
XFILLER_74_761 VDD VDD VSS VSS gf180mcu_fd_sc_mcu7t5v0__fillcap_4
XTAP_TAPCELL_ROW_36_609 VDD VSS gf180mcu_fd_sc_mcu7t5v0__filltie
XFILLER_46_452 VDD VDD VSS VSS gf180mcu_fd_sc_mcu7t5v0__fill_2
XTAP_TAPCELL_ROW_64_907 VDD VSS gf180mcu_fd_sc_mcu7t5v0__filltie
XFILLER_61_422 VDD VDD VSS VSS gf180mcu_fd_sc_mcu7t5v0__fillcap_32
XFILLER_73_282 VDD VDD VSS VSS gf180mcu_fd_sc_mcu7t5v0__fillcap_4
XFILLER_61_488 VDD VDD VSS VSS gf180mcu_fd_sc_mcu7t5v0__fill_2
XTAP_TAPCELL_ROW_16_399 VDD VSS gf180mcu_fd_sc_mcu7t5v0__filltie
X_1951_ _3116_/Q _2972_/Q _1953_/S _2972_/D VDD VDD VSS VSS gf180mcu_fd_sc_mcu7t5v0__mux2_2
XTAP_TAPCELL_ROW_44_697 VDD VSS gf180mcu_fd_sc_mcu7t5v0__filltie
XTAP_TAPCELL_ROW_72_995 VDD VSS gf180mcu_fd_sc_mcu7t5v0__filltie
X_1882_ _2913_/Q _3113_/Q _1887_/S _2913_/D VDD VDD VSS VSS gf180mcu_fd_sc_mcu7t5v0__mux2_2
X_2503_ _3167_/Q _3152_/Q wire13/Z _3167_/D VDD VDD VSS VSS gf180mcu_fd_sc_mcu7t5v0__mux2_2
XFILLER_51_2 VDD VDD VSS VSS gf180mcu_fd_sc_mcu7t5v0__fillcap_4
XFILLER_102_107 VDD VDD VSS VSS gf180mcu_fd_sc_mcu7t5v0__fillcap_32
XPHY_EDGE_ROW_102_Left_211 VDD VSS gf180mcu_fd_sc_mcu7t5v0__endcap
X_2434_ _2434_/A1 _2434_/A2 _2434_/B _2435_/A2 VDD VDD VSS VSS gf180mcu_fd_sc_mcu7t5v0__aoi21_1
XFILLER_69_500 VDD VDD VSS VSS gf180mcu_fd_sc_mcu7t5v0__fill_1
X_2365_ _2405_/S _2364_/Z _2378_/B _2366_/A2 VDD VDD VSS VSS gf180mcu_fd_sc_mcu7t5v0__aoi21_1
XFILLER_96_341 VDD VDD VSS VSS gf180mcu_fd_sc_mcu7t5v0__fill_1
XFILLER_69_555 VDD VDD VSS VSS gf180mcu_fd_sc_mcu7t5v0__fillcap_4
X_2296_ _2300_/A1 _2296_/A2 _2300_/B1 VDD VDD VSS VSS gf180mcu_fd_sc_mcu7t5v0__nand2_1
XFILLER_56_205 VDD VDD VSS VSS gf180mcu_fd_sc_mcu7t5v0__fill_2
XTAP_TAPCELL_ROW_108_1364 VDD VSS gf180mcu_fd_sc_mcu7t5v0__filltie
XTAP_TAPCELL_ROW_108_1375 VDD VSS gf180mcu_fd_sc_mcu7t5v0__filltie
XFILLER_24_135 VDD VDD VSS VSS gf180mcu_fd_sc_mcu7t5v0__fillcap_4
XFILLER_25_636 VDD VDD VSS VSS gf180mcu_fd_sc_mcu7t5v0__fill_2
XFILLER_80_764 VDD VDD VSS VSS gf180mcu_fd_sc_mcu7t5v0__fill_1
XFILLER_106_402 VDD VDD VSS VSS gf180mcu_fd_sc_mcu7t5v0__fillcap_8
XTAP_TAPCELL_ROW_76_1032 VDD VSS gf180mcu_fd_sc_mcu7t5v0__filltie
XFILLER_106_457 VDD VDD VSS VSS gf180mcu_fd_sc_mcu7t5v0__fillcap_4
XFILLER_79_308 VDD VDD VSS VSS gf180mcu_fd_sc_mcu7t5v0__fillcap_32
XTAP_TAPCELL_ROW_7_312 VDD VSS gf180mcu_fd_sc_mcu7t5v0__filltie
XFILLER_0_713 VDD VDD VSS VSS gf180mcu_fd_sc_mcu7t5v0__fill_1
XPHY_EDGE_ROW_102_Right_102 VDD VSS gf180mcu_fd_sc_mcu7t5v0__endcap
XFILLER_102_663 VDD VDD VSS VSS gf180mcu_fd_sc_mcu7t5v0__fill_2
XFILLER_87_352 VDD VDD VSS VSS gf180mcu_fd_sc_mcu7t5v0__fillcap_16
Xmax_cap11 _2534_/S _2540_/S VDD VDD VSS VSS gf180mcu_fd_sc_mcu7t5v0__buf_8
XTAP_TAPCELL_ROW_87_1150 VDD VSS gf180mcu_fd_sc_mcu7t5v0__filltie
XFILLER_28_452 VDD VDD VSS VSS gf180mcu_fd_sc_mcu7t5v0__fill_2
XFILLER_56_761 VDD VDD VSS VSS gf180mcu_fd_sc_mcu7t5v0__fillcap_4
XFILLER_16_658 VDD VDD VSS VSS gf180mcu_fd_sc_mcu7t5v0__fillcap_4
XFILLER_55_282 VDD VDD VSS VSS gf180mcu_fd_sc_mcu7t5v0__fillcap_8
XFILLER_43_466 VDD VDD VSS VSS gf180mcu_fd_sc_mcu7t5v0__fillcap_8
XFILLER_31_628 VDD VDD VSS VSS gf180mcu_fd_sc_mcu7t5v0__fill_2
XFILLER_62_53 VDD VDD VSS VSS gf180mcu_fd_sc_mcu7t5v0__fillcap_8
XFILLER_23_190 VDD VDD VSS VSS gf180mcu_fd_sc_mcu7t5v0__fillcap_4
XTAP_TAPCELL_ROW_41_667 VDD VSS gf180mcu_fd_sc_mcu7t5v0__filltie
XTAP_TAPCELL_ROW_13_369 VDD VSS gf180mcu_fd_sc_mcu7t5v0__filltie
XFILLER_11_352 VDD VDD VSS VSS gf180mcu_fd_sc_mcu7t5v0__fill_2
XFILLER_3_562 VDD VDD VSS VSS gf180mcu_fd_sc_mcu7t5v0__fillcap_8
XFILLER_87_61 VDD VDD VSS VSS gf180mcu_fd_sc_mcu7t5v0__fill_1
X_2150_ _3229_/Q _3079_/Q _2165_/S _3079_/D VDD VDD VSS VSS gf180mcu_fd_sc_mcu7t5v0__mux2_2
XTAP_TAPCELL_ROW_49_745 VDD VSS gf180mcu_fd_sc_mcu7t5v0__filltie
X_2081_ _3299_/Q _2091_/A2 _2083_/B1 VDD VDD VSS VSS gf180mcu_fd_sc_mcu7t5v0__nand2_1
XFILLER_19_474 VDD VDD VSS VSS gf180mcu_fd_sc_mcu7t5v0__fill_1
XFILLER_99_2 VDD VDD VSS VSS gf180mcu_fd_sc_mcu7t5v0__fillcap_32
X_2983_ _2983_/D _3016_/CLK _2983_/Q VDD VDD VSS VSS gf180mcu_fd_sc_mcu7t5v0__dffq_1
XFILLER_34_488 VDD VDD VSS VSS gf180mcu_fd_sc_mcu7t5v0__fill_2
XFILLER_61_296 VDD VDD VSS VSS gf180mcu_fd_sc_mcu7t5v0__fill_1
X_1934_ _3118_/Q _2958_/Q _1934_/S _2958_/D VDD VDD VSS VSS gf180mcu_fd_sc_mcu7t5v0__mux2_2
X_1865_ _2900_/Q _3116_/Q _1867_/S _2900_/D VDD VDD VSS VSS gf180mcu_fd_sc_mcu7t5v0__mux2_2
X_1796_ _1833_/A1 _1786_/Z _1804_/S VDD VDD VSS VSS gf180mcu_fd_sc_mcu7t5v0__nand2_1
X_2417_ _2426_/A1 _2417_/A2 _2434_/B _2418_/C VDD VDD VSS VSS gf180mcu_fd_sc_mcu7t5v0__aoi21_1
XFILLER_88_149 VDD VDD VSS VSS gf180mcu_fd_sc_mcu7t5v0__fill_1
X_3397_ _3397_/D _3416_/RN _3398_/CLK _3397_/Q VDD VDD VSS VSS gf180mcu_fd_sc_mcu7t5v0__dffrnq_1
XFILLER_69_352 VDD VDD VSS VSS gf180mcu_fd_sc_mcu7t5v0__fill_1
XFILLER_69_330 VDD VDD VSS VSS gf180mcu_fd_sc_mcu7t5v0__fillcap_16
XFILLER_29_205 VDD VDD VSS VSS gf180mcu_fd_sc_mcu7t5v0__fill_1
X_2348_ _2346_/Z _2347_/Z _2405_/S _2348_/Z VDD VDD VSS VSS gf180mcu_fd_sc_mcu7t5v0__mux2_2
XFILLER_69_385 VDD VDD VSS VSS gf180mcu_fd_sc_mcu7t5v0__fill_1
X_2279_ _2431_/B _2434_/A2 _2280_/A4 VDD VDD VSS VSS gf180mcu_fd_sc_mcu7t5v0__nand2_1
XFILLER_38_750 VDD VDD VSS VSS gf180mcu_fd_sc_mcu7t5v0__fillcap_8
XFILLER_25_422 VDD VDD VSS VSS gf180mcu_fd_sc_mcu7t5v0__fillcap_32
XTAP_TAPCELL_ROW_82_1091 VDD VSS gf180mcu_fd_sc_mcu7t5v0__filltie
XFILLER_32_56 VDD VDD VSS VSS gf180mcu_fd_sc_mcu7t5v0__fill_2
XFILLER_32_34 VDD VDD VSS VSS gf180mcu_fd_sc_mcu7t5v0__fill_1
XTAP_TAPCELL_ROW_10_339 VDD VSS gf180mcu_fd_sc_mcu7t5v0__filltie
XFILLER_20_171 VDD VDD VSS VSS gf180mcu_fd_sc_mcu7t5v0__fillcap_4
XFILLER_4_337 VDD VDD VSS VSS gf180mcu_fd_sc_mcu7t5v0__fill_2
XFILLER_0_554 VDD VDD VSS VSS gf180mcu_fd_sc_mcu7t5v0__fill_1
XFILLER_57_64 VDD VDD VSS VSS gf180mcu_fd_sc_mcu7t5v0__fillcap_4
XFILLER_75_366 VDD VDD VSS VSS gf180mcu_fd_sc_mcu7t5v0__fillcap_16
XTAP_TAPCELL_ROW_46_715 VDD VSS gf180mcu_fd_sc_mcu7t5v0__filltie
XFILLER_63_517 VDD VDD VSS VSS gf180mcu_fd_sc_mcu7t5v0__fillcap_16
XTAP_TAPCELL_ROW_18_428 VDD VSS gf180mcu_fd_sc_mcu7t5v0__filltie
XFILLER_44_731 VDD VDD VSS VSS gf180mcu_fd_sc_mcu7t5v0__fillcap_4
XFILLER_56_591 VDD VDD VSS VSS gf180mcu_fd_sc_mcu7t5v0__fillcap_4
XFILLER_90_358 VDD VDD VSS VSS gf180mcu_fd_sc_mcu7t5v0__fillcap_16
XFILLER_73_96 VDD VDD VSS VSS gf180mcu_fd_sc_mcu7t5v0__fillcap_4
XTAP_TAPCELL_ROW_96_1238 VDD VSS gf180mcu_fd_sc_mcu7t5v0__filltie
X_1650_ _2286_/B _2222_/B2 _2267_/A2 VDD VDD VSS VSS gf180mcu_fd_sc_mcu7t5v0__nor2_1
XFILLER_11_193 VDD VDD VSS VSS gf180mcu_fd_sc_mcu7t5v0__fillcap_16
XFILLER_7_142 VDD VDD VSS VSS gf180mcu_fd_sc_mcu7t5v0__fillcap_32
X_1581_ _1581_/A1 _1581_/A2 _1581_/A3 _3369_/D VDD VDD VSS VSS gf180mcu_fd_sc_mcu7t5v0__nor3_1
X_3320_ _3320_/D _3369_/RN _3325_/CLK _3320_/Q VDD VDD VSS VSS gf180mcu_fd_sc_mcu7t5v0__dffrnq_1
X_3251_ _3251_/D _3369_/RN _3324_/CLK _3251_/Q VDD VDD VSS VSS gf180mcu_fd_sc_mcu7t5v0__dffrnq_1
X_2202_ _2202_/A1 _2202_/A2 _2766_/Q _3148_/Q _2407_/B VDD VDD VSS VSS gf180mcu_fd_sc_mcu7t5v0__and4_1
XFILLER_39_514 VDD VDD VSS VSS gf180mcu_fd_sc_mcu7t5v0__fill_1
X_3182_ _3182_/D _3303_/RN _3293_/CLK _3182_/Q VDD VDD VSS VSS gf180mcu_fd_sc_mcu7t5v0__dffrnq_1
XFILLER_14_2 VDD VDD VSS VSS gf180mcu_fd_sc_mcu7t5v0__fillcap_32
X_2133_ _3320_/Q _3212_/Q _2734_/A2 VDD VDD VSS VSS gf180mcu_fd_sc_mcu7t5v0__nand2_1
XFILLER_94_664 VDD VDD VSS VSS gf180mcu_fd_sc_mcu7t5v0__fill_1
XFILLER_81_303 VDD VDD VSS VSS gf180mcu_fd_sc_mcu7t5v0__fillcap_16
XFILLER_19_282 VDD VDD VSS VSS gf180mcu_fd_sc_mcu7t5v0__fillcap_16
X_2064_ _3041_/Q _3114_/Q _3411_/D _3041_/D VDD VDD VSS VSS gf180mcu_fd_sc_mcu7t5v0__mux2_2
XTAP_TAPCELL_ROW_105_1334 VDD VSS gf180mcu_fd_sc_mcu7t5v0__filltie
XFILLER_34_241 VDD VDD VSS VSS gf180mcu_fd_sc_mcu7t5v0__fillcap_4
XFILLER_35_764 VDD VDD VSS VSS gf180mcu_fd_sc_mcu7t5v0__fill_1
X_2966_ _2966_/D _2982_/CLK _2966_/Q VDD VDD VSS VSS gf180mcu_fd_sc_mcu7t5v0__dffq_1
X_1917_ _1991_/A1 _1926_/A2 _1925_/S VDD VDD VSS VSS gf180mcu_fd_sc_mcu7t5v0__nand2_1
X_2897_ _2897_/D _2958_/CLK _2897_/Q VDD VDD VSS VSS gf180mcu_fd_sc_mcu7t5v0__dffq_1
X_1848_ _3285_/Q _2884_/Q _1850_/S _2884_/D VDD VDD VSS VSS gf180mcu_fd_sc_mcu7t5v0__mux2_2
X_1779_ _2824_/Q _3281_/Q _1785_/S _2824_/D VDD VDD VSS VSS gf180mcu_fd_sc_mcu7t5v0__mux2_2
XTAP_TAPCELL_ROW_73_1002 VDD VSS gf180mcu_fd_sc_mcu7t5v0__filltie
XFILLER_103_279 VDD VDD VSS VSS gf180mcu_fd_sc_mcu7t5v0__fill_1
XFILLER_17_208 VDD VDD VSS VSS gf180mcu_fd_sc_mcu7t5v0__fill_2
XFILLER_84_174 VDD VDD VSS VSS gf180mcu_fd_sc_mcu7t5v0__fill_1
XFILLER_72_314 VDD VDD VSS VSS gf180mcu_fd_sc_mcu7t5v0__fill_1
XTAP_TAPCELL_ROW_84_1120 VDD VSS gf180mcu_fd_sc_mcu7t5v0__filltie
XFILLER_26_764 VDD VDD VSS VSS gf180mcu_fd_sc_mcu7t5v0__fill_1
XFILLER_60_509 VDD VDD VSS VSS gf180mcu_fd_sc_mcu7t5v0__fill_1
XFILLER_40_211 VDD VDD VSS VSS gf180mcu_fd_sc_mcu7t5v0__fillcap_16
XFILLER_40_255 VDD VDD VSS VSS gf180mcu_fd_sc_mcu7t5v0__fillcap_4
XTAP_TAPCELL_ROW_51_773 VDD VSS gf180mcu_fd_sc_mcu7t5v0__filltie
XTAP_TAPCELL_ROW_23_475 VDD VSS gf180mcu_fd_sc_mcu7t5v0__filltie
XFILLER_5_613 VDD VDD VSS VSS gf180mcu_fd_sc_mcu7t5v0__fillcap_16
XFILLER_4_101 VDD VDD VSS VSS gf180mcu_fd_sc_mcu7t5v0__fillcap_4
XFILLER_67_119 VDD VDD VSS VSS gf180mcu_fd_sc_mcu7t5v0__fillcap_16
XFILLER_75_130 VDD VDD VSS VSS gf180mcu_fd_sc_mcu7t5v0__fill_2
XFILLER_76_675 VDD VDD VSS VSS gf180mcu_fd_sc_mcu7t5v0__fillcap_4
XFILLER_76_664 VDD VDD VSS VSS gf180mcu_fd_sc_mcu7t5v0__fill_1
XTAP_TAPCELL_ROW_59_851 VDD VSS gf180mcu_fd_sc_mcu7t5v0__filltie
XFILLER_90_177 VDD VDD VSS VSS gf180mcu_fd_sc_mcu7t5v0__fillcap_16
XFILLER_32_734 VDD VDD VSS VSS gf180mcu_fd_sc_mcu7t5v0__fill_1
X_2820_ _2820_/D _2828_/CLK _2820_/Q VDD VDD VSS VSS gf180mcu_fd_sc_mcu7t5v0__dffq_1
XFILLER_31_266 VDD VDD VSS VSS gf180mcu_fd_sc_mcu7t5v0__fill_2
XFILLER_31_277 VDD VDD VSS VSS gf180mcu_fd_sc_mcu7t5v0__fill_2
XTAP_TAPCELL_ROW_100_1286 VDD VSS gf180mcu_fd_sc_mcu7t5v0__filltie
X_2751_ _3225_/Q _3291_/Q _2760_/S _3291_/D VDD VDD VSS VSS gf180mcu_fd_sc_mcu7t5v0__mux2_2
X_1702_ _3415_/D _1701_/B _1702_/B _1702_/C _1708_/A3 VDD VDD VSS VSS gf180mcu_fd_sc_mcu7t5v0__aoi211_1
X_2682_ _3255_/Q _2680_/C _2684_/B VDD VDD VSS VSS gf180mcu_fd_sc_mcu7t5v0__nand2_1
X_1633_ _2197_/A1 _3412_/Q _3131_/Q _1633_/A4 _2296_/A2 VDD VDD VSS VSS gf180mcu_fd_sc_mcu7t5v0__nand4_1
X_1564_ _3121_/Q _1564_/A2 _1565_/A3 VDD VDD VSS VSS gf180mcu_fd_sc_mcu7t5v0__nand2_1
X_1495_ _3365_/Q _1495_/A2 _3360_/D VDD VDD VSS VSS gf180mcu_fd_sc_mcu7t5v0__xnor2_1
X_3303_ _3303_/D _3303_/RN _3410_/CLK _3303_/Q VDD VDD VSS VSS gf180mcu_fd_sc_mcu7t5v0__dffrnq_1
XFILLER_101_739 VDD VDD VSS VSS gf180mcu_fd_sc_mcu7t5v0__fillcap_16
XFILLER_86_439 VDD VDD VSS VSS gf180mcu_fd_sc_mcu7t5v0__fill_1
X_3234_ _3234_/D _3328_/RN _3276_/CLK _3234_/Q VDD VDD VSS VSS gf180mcu_fd_sc_mcu7t5v0__dffrnq_1
X_3165_ _3165_/D _3328_/RN _3215_/CLK _3165_/Q VDD VDD VSS VSS gf180mcu_fd_sc_mcu7t5v0__dffrnq_1
XFILLER_67_675 VDD VDD VSS VSS gf180mcu_fd_sc_mcu7t5v0__fillcap_16
X_2116_ _2119_/A2 _2114_/Z _2116_/A3 _2124_/A1 _2118_/A1 _3060_/D VDD VDD VSS VSS
+ gf180mcu_fd_sc_mcu7t5v0__oai32_1
XFILLER_54_314 VDD VDD VSS VSS gf180mcu_fd_sc_mcu7t5v0__fill_1
X_3096_ _3096_/D _3303_/RN _3288_/CLK _3096_/Q VDD VDD VSS VSS gf180mcu_fd_sc_mcu7t5v0__dffrnq_1
X_2047_ _3032_/Q _3031_/Q _2010_/Z _2048_/A4 _2050_/A2 VDD VDD VSS VSS gf180mcu_fd_sc_mcu7t5v0__nand4_1
XFILLER_62_380 VDD VDD VSS VSS gf180mcu_fd_sc_mcu7t5v0__fillcap_4
XFILLER_62_391 VDD VDD VSS VSS gf180mcu_fd_sc_mcu7t5v0__fill_2
X_2949_ _2949_/D _3253_/CLK _2949_/Q VDD VDD VSS VSS gf180mcu_fd_sc_mcu7t5v0__dffq_1
XFILLER_13_69 VDD VDD VSS VSS gf180mcu_fd_sc_mcu7t5v0__fill_1
XTAP_TAPCELL_ROW_20_445 VDD VSS gf180mcu_fd_sc_mcu7t5v0__filltie
XFILLER_89_18 VDD VDD VSS VSS gf180mcu_fd_sc_mcu7t5v0__fillcap_8
XFILLER_1_137 VDD VDD VSS VSS gf180mcu_fd_sc_mcu7t5v0__fill_2
XFILLER_89_288 VDD VDD VSS VSS gf180mcu_fd_sc_mcu7t5v0__fill_1
XFILLER_38_33 VDD VDD VSS VSS gf180mcu_fd_sc_mcu7t5v0__fill_2
XFILLER_58_642 VDD VDD VSS VSS gf180mcu_fd_sc_mcu7t5v0__fillcap_8
XTAP_TAPCELL_ROW_28_523 VDD VSS gf180mcu_fd_sc_mcu7t5v0__filltie
XTAP_TAPCELL_ROW_56_821 VDD VSS gf180mcu_fd_sc_mcu7t5v0__filltie
XFILLER_72_133 VDD VDD VSS VSS gf180mcu_fd_sc_mcu7t5v0__fill_1
XFILLER_60_328 VDD VDD VSS VSS gf180mcu_fd_sc_mcu7t5v0__fillcap_16
XFILLER_72_177 VDD VDD VSS VSS gf180mcu_fd_sc_mcu7t5v0__fillcap_8
XFILLER_26_594 VDD VDD VSS VSS gf180mcu_fd_sc_mcu7t5v0__fill_1
Xclkload18 _3326_/CLK clkload18/ZN VDD VDD VSS VSS gf180mcu_fd_sc_mcu7t5v0__clkinv_2
Xclkload29 _3297_/CLK clkload29/Z VDD VDD VSS VSS gf180mcu_fd_sc_mcu7t5v0__clkbuf_2
XTAP_TAPCELL_ROW_93_1208 VDD VSS gf180mcu_fd_sc_mcu7t5v0__filltie
XFILLER_96_704 VDD VDD VSS VSS gf180mcu_fd_sc_mcu7t5v0__fillcap_16
XFILLER_79_84 VDD VDD VSS VSS gf180mcu_fd_sc_mcu7t5v0__fill_2
XFILLER_96_737 VDD VDD VSS VSS gf180mcu_fd_sc_mcu7t5v0__fillcap_4
XFILLER_95_236 VDD VDD VSS VSS gf180mcu_fd_sc_mcu7t5v0__fill_1
XFILLER_95_258 VDD VDD VSS VSS gf180mcu_fd_sc_mcu7t5v0__fillcap_8
XFILLER_95_61 VDD VDD VSS VSS gf180mcu_fd_sc_mcu7t5v0__fill_2
XFILLER_36_314 VDD VDD VSS VSS gf180mcu_fd_sc_mcu7t5v0__fill_1
XTAP_TAPCELL_ROW_102_1304 VDD VSS gf180mcu_fd_sc_mcu7t5v0__filltie
XFILLER_20_715 VDD VDD VSS VSS gf180mcu_fd_sc_mcu7t5v0__fillcap_16
X_2803_ _2803_/D _2894_/CLK _2803_/Q VDD VDD VSS VSS gf180mcu_fd_sc_mcu7t5v0__dffq_1
XFILLER_81_2 VDD VDD VSS VSS gf180mcu_fd_sc_mcu7t5v0__fillcap_4
XFILLER_32_597 VDD VDD VSS VSS gf180mcu_fd_sc_mcu7t5v0__fillcap_32
X_2734_ _3213_/Q _2734_/A2 _2734_/A3 _2735_/A2 VDD VDD VSS VSS gf180mcu_fd_sc_mcu7t5v0__nor3_1
X_2665_ _2957_/Q _2949_/Q _2941_/Q _2933_/Q _2675_/S0 _2675_/S1 _2665_/Z VDD VDD VSS
+ VSS gf180mcu_fd_sc_mcu7t5v0__mux4_1
X_2596_ _2670_/A1 _2595_/Z _2609_/A1 VDD VDD VSS VSS gf180mcu_fd_sc_mcu7t5v0__nand2_1
X_1616_ _3163_/Q _2499_/A2 _1618_/B VDD VDD VSS VSS gf180mcu_fd_sc_mcu7t5v0__nor2_1
XFILLER_99_553 VDD VDD VSS VSS gf180mcu_fd_sc_mcu7t5v0__fillcap_4
XFILLER_59_417 VDD VDD VSS VSS gf180mcu_fd_sc_mcu7t5v0__fill_2
XFILLER_59_428 VDD VDD VSS VSS gf180mcu_fd_sc_mcu7t5v0__fill_1
X_1547_ _3051_/Q _3052_/Q _1547_/B _1551_/A2 VDD VDD VSS VSS gf180mcu_fd_sc_mcu7t5v0__oai21_1
X_1478_ _2674_/S1 _3353_/Q _1478_/A3 _1478_/Z VDD VDD VSS VSS gf180mcu_fd_sc_mcu7t5v0__and3_1
XFILLER_86_269 VDD VDD VSS VSS gf180mcu_fd_sc_mcu7t5v0__fill_1
X_3217_ _3217_/D _3303_/RN clkload9/I _3217_/Q VDD VDD VSS VSS gf180mcu_fd_sc_mcu7t5v0__dffrnq_1
X_3148_ _3148_/D _3369_/RN _3148_/CLK _3148_/Q VDD VDD VSS VSS gf180mcu_fd_sc_mcu7t5v0__dffrnq_1
XFILLER_54_100 VDD VDD VSS VSS gf180mcu_fd_sc_mcu7t5v0__fillcap_4
X_3079_ _3079_/D _3303_/RN clkload8/I _3079_/Q VDD VDD VSS VSS gf180mcu_fd_sc_mcu7t5v0__dffrnq_1
XFILLER_54_177 VDD VDD VSS VSS gf180mcu_fd_sc_mcu7t5v0__fillcap_64
XFILLER_23_542 VDD VDD VSS VSS gf180mcu_fd_sc_mcu7t5v0__fillcap_16
XTAP_TAPCELL_ROW_33_581 VDD VSS gf180mcu_fd_sc_mcu7t5v0__filltie
XFILLER_50_383 VDD VDD VSS VSS gf180mcu_fd_sc_mcu7t5v0__fill_2
XFILLER_10_247 VDD VDD VSS VSS gf180mcu_fd_sc_mcu7t5v0__fillcap_16
XTAP_TAPCELL_ROW_79_1063 VDD VSS gf180mcu_fd_sc_mcu7t5v0__filltie
XFILLER_2_457 VDD VDD VSS VSS gf180mcu_fd_sc_mcu7t5v0__fillcap_8
XFILLER_49_87 VDD VDD VSS VSS gf180mcu_fd_sc_mcu7t5v0__fillcap_8
XFILLER_18_303 VDD VDD VSS VSS gf180mcu_fd_sc_mcu7t5v0__fillcap_4
XTAP_TAPCELL_ROW_5_284 VDD VSS gf180mcu_fd_sc_mcu7t5v0__filltie
XFILLER_100_591 VDD VDD VSS VSS gf180mcu_fd_sc_mcu7t5v0__fillcap_4
XFILLER_46_656 VDD VDD VSS VSS gf180mcu_fd_sc_mcu7t5v0__fillcap_8
XFILLER_33_328 VDD VDD VSS VSS gf180mcu_fd_sc_mcu7t5v0__fillcap_4
XFILLER_65_97 VDD VDD VSS VSS gf180mcu_fd_sc_mcu7t5v0__fillcap_8
XFILLER_73_486 VDD VDD VSS VSS gf180mcu_fd_sc_mcu7t5v0__fillcap_4
X_2450_ _2450_/A1 _2450_/A2 _2450_/B _2468_/B _2471_/A2 VDD VDD VSS VSS gf180mcu_fd_sc_mcu7t5v0__aoi211_1
Xclkbuf_leaf_13_clk_i clkload1/I _3410_/CLK VDD VDD VSS VSS gf180mcu_fd_sc_mcu7t5v0__clkbuf_4
X_1401_ _3322_/D _2473_/A1 VDD VDD VSS VSS gf180mcu_fd_sc_mcu7t5v0__clkinv_1
XFILLER_5_284 VDD VDD VSS VSS gf180mcu_fd_sc_mcu7t5v0__fill_1
XFILLER_69_726 VDD VDD VSS VSS gf180mcu_fd_sc_mcu7t5v0__fill_2
X_2381_ _2407_/A1 _2381_/A2 _2407_/B _2381_/C _2382_/B VDD VDD VSS VSS gf180mcu_fd_sc_mcu7t5v0__oai211_1
Xclkbuf_leaf_28_clk_i clkload5/I _3286_/CLK VDD VDD VSS VSS gf180mcu_fd_sc_mcu7t5v0__clkbuf_4
XFILLER_68_247 VDD VDD VSS VSS gf180mcu_fd_sc_mcu7t5v0__fillcap_8
XFILLER_83_206 VDD VDD VSS VSS gf180mcu_fd_sc_mcu7t5v0__fillcap_4
XFILLER_83_228 VDD VDD VSS VSS gf180mcu_fd_sc_mcu7t5v0__fillcap_8
X_3002_ _3002_/D _3021_/CLK _3002_/Q VDD VDD VSS VSS gf180mcu_fd_sc_mcu7t5v0__dffq_1
Xinput5 spi_mosi_i input5/Z VDD VDD VSS VSS gf180mcu_fd_sc_mcu7t5v0__dlyb_1
XFILLER_37_634 VDD VDD VSS VSS gf180mcu_fd_sc_mcu7t5v0__fill_1
XTAP_TAPCELL_ROW_67_938 VDD VSS gf180mcu_fd_sc_mcu7t5v0__filltie
XFILLER_37_645 VDD VDD VSS VSS gf180mcu_fd_sc_mcu7t5v0__fillcap_8
XFILLER_24_317 VDD VDD VSS VSS gf180mcu_fd_sc_mcu7t5v0__fillcap_32
XFILLER_36_177 VDD VDD VSS VSS gf180mcu_fd_sc_mcu7t5v0__fillcap_16
XFILLER_64_486 VDD VDD VSS VSS gf180mcu_fd_sc_mcu7t5v0__fill_2
XFILLER_51_136 VDD VDD VSS VSS gf180mcu_fd_sc_mcu7t5v0__fillcap_4
XFILLER_52_659 VDD VDD VSS VSS gf180mcu_fd_sc_mcu7t5v0__fillcap_4
XFILLER_20_556 VDD VDD VSS VSS gf180mcu_fd_sc_mcu7t5v0__fillcap_8
XTAP_TAPCELL_ROW_30_551 VDD VSS gf180mcu_fd_sc_mcu7t5v0__filltie
X_2717_ _3270_/Q _2680_/C _2731_/B1 _3088_/Q _2718_/I VDD VDD VSS VSS gf180mcu_fd_sc_mcu7t5v0__aoi22_1
X_2648_ _3068_/Q _2132_/I _2664_/B1 _3100_/Q _2649_/A2 VDD VDD VSS VSS gf180mcu_fd_sc_mcu7t5v0__aoi22_1
XFILLER_99_372 VDD VDD VSS VSS gf180mcu_fd_sc_mcu7t5v0__fill_2
XFILLER_87_512 VDD VDD VSS VSS gf180mcu_fd_sc_mcu7t5v0__fill_1
X_2579_ _3197_/Q _3239_/Q _2585_/S _3239_/D VDD VDD VSS VSS gf180mcu_fd_sc_mcu7t5v0__mux2_2
XFILLER_87_534 VDD VDD VSS VSS gf180mcu_fd_sc_mcu7t5v0__fill_1
XFILLER_101_333 VDD VDD VSS VSS gf180mcu_fd_sc_mcu7t5v0__fillcap_4
XFILLER_101_388 VDD VDD VSS VSS gf180mcu_fd_sc_mcu7t5v0__fillcap_32
XFILLER_19_68 VDD VDD VSS VSS gf180mcu_fd_sc_mcu7t5v0__fill_2
XFILLER_74_217 VDD VDD VSS VSS gf180mcu_fd_sc_mcu7t5v0__fill_2
XTAP_TAPCELL_ROW_2_254 VDD VSS gf180mcu_fd_sc_mcu7t5v0__filltie
XFILLER_28_667 VDD VDD VSS VSS gf180mcu_fd_sc_mcu7t5v0__fillcap_4
XFILLER_27_188 VDD VDD VSS VSS gf180mcu_fd_sc_mcu7t5v0__fillcap_16
XFILLER_35_67 VDD VDD VSS VSS gf180mcu_fd_sc_mcu7t5v0__fill_2
XFILLER_43_659 VDD VDD VSS VSS gf180mcu_fd_sc_mcu7t5v0__fill_1
XFILLER_35_78 VDD VDD VSS VSS gf180mcu_fd_sc_mcu7t5v0__fill_1
XFILLER_51_670 VDD VDD VSS VSS gf180mcu_fd_sc_mcu7t5v0__fillcap_16
XFILLER_11_556 VDD VDD VSS VSS gf180mcu_fd_sc_mcu7t5v0__fillcap_4
XFILLER_2_210 VDD VDD VSS VSS gf180mcu_fd_sc_mcu7t5v0__fill_1
XFILLER_104_193 VDD VDD VSS VSS gf180mcu_fd_sc_mcu7t5v0__fillcap_8
XFILLER_66_718 VDD VDD VSS VSS gf180mcu_fd_sc_mcu7t5v0__fillcap_8
XFILLER_93_548 VDD VDD VSS VSS gf180mcu_fd_sc_mcu7t5v0__fillcap_8
XFILLER_76_96 VDD VDD VSS VSS gf180mcu_fd_sc_mcu7t5v0__fill_1
XFILLER_19_667 VDD VDD VSS VSS gf180mcu_fd_sc_mcu7t5v0__fill_2
XTAP_TAPCELL_ROW_64_908 VDD VSS gf180mcu_fd_sc_mcu7t5v0__filltie
XFILLER_18_177 VDD VDD VSS VSS gf180mcu_fd_sc_mcu7t5v0__fillcap_8
X_1950_ _3115_/Q _2971_/Q _1953_/S _2971_/D VDD VDD VSS VSS gf180mcu_fd_sc_mcu7t5v0__mux2_2
XTAP_TAPCELL_ROW_44_698 VDD VSS gf180mcu_fd_sc_mcu7t5v0__filltie
XTAP_TAPCELL_ROW_72_985 VDD VSS gf180mcu_fd_sc_mcu7t5v0__filltie
X_1881_ _2912_/Q _3112_/Q _1887_/S _2912_/D VDD VDD VSS VSS gf180mcu_fd_sc_mcu7t5v0__mux2_2
XTAP_TAPCELL_ROW_99_1269 VDD VSS gf180mcu_fd_sc_mcu7t5v0__filltie
X_2502_ _3166_/Q _3151_/Q wire13/Z _3166_/D VDD VDD VSS VSS gf180mcu_fd_sc_mcu7t5v0__mux2_2
XFILLER_103_609 VDD VDD VSS VSS gf180mcu_fd_sc_mcu7t5v0__fillcap_4
X_2433_ _3147_/Q _2438_/A2 _2436_/A1 VDD VDD VSS VSS gf180mcu_fd_sc_mcu7t5v0__nand2_1
XFILLER_44_2 VDD VDD VSS VSS gf180mcu_fd_sc_mcu7t5v0__fillcap_32
X_2364_ _2858_/Q _2850_/Q _2842_/Q _2834_/Q _2404_/S0 _2404_/S1 _2364_/Z VDD VDD VSS
+ VSS gf180mcu_fd_sc_mcu7t5v0__mux4_1
XFILLER_57_718 VDD VDD VSS VSS gf180mcu_fd_sc_mcu7t5v0__fill_2
X_2295_ _2427_/B _2313_/A1 _2312_/A2 VDD VDD VSS VSS gf180mcu_fd_sc_mcu7t5v0__nor2_1
XTAP_TAPCELL_ROW_108_1365 VDD VSS gf180mcu_fd_sc_mcu7t5v0__filltie
XTAP_TAPCELL_ROW_108_1376 VDD VSS gf180mcu_fd_sc_mcu7t5v0__filltie
XFILLER_24_125 VDD VDD VSS VSS gf180mcu_fd_sc_mcu7t5v0__fill_1
XFILLER_40_607 VDD VDD VSS VSS gf180mcu_fd_sc_mcu7t5v0__fill_1
XTAP_TAPCELL_ROW_76_1033 VDD VSS gf180mcu_fd_sc_mcu7t5v0__filltie
XFILLER_21_69 VDD VDD VSS VSS gf180mcu_fd_sc_mcu7t5v0__fill_1
XFILLER_87_331 VDD VDD VSS VSS gf180mcu_fd_sc_mcu7t5v0__fill_1
XFILLER_0_758 VDD VDD VSS VSS gf180mcu_fd_sc_mcu7t5v0__fillcap_4
Xmax_cap12 _2539_/S _2534_/S VDD VDD VSS VSS gf180mcu_fd_sc_mcu7t5v0__buf_8
XFILLER_28_431 VDD VDD VSS VSS gf180mcu_fd_sc_mcu7t5v0__fillcap_4
XFILLER_46_33 VDD VDD VSS VSS gf180mcu_fd_sc_mcu7t5v0__fill_2
XTAP_TAPCELL_ROW_87_1151 VDD VSS gf180mcu_fd_sc_mcu7t5v0__filltie
XFILLER_16_626 VDD VDD VSS VSS gf180mcu_fd_sc_mcu7t5v0__fillcap_16
XFILLER_28_486 VDD VDD VSS VSS gf180mcu_fd_sc_mcu7t5v0__fillcap_32
XFILLER_62_10 VDD VDD VSS VSS gf180mcu_fd_sc_mcu7t5v0__fillcap_4
XFILLER_70_297 VDD VDD VSS VSS gf180mcu_fd_sc_mcu7t5v0__fill_1
XTAP_TAPCELL_ROW_41_668 VDD VSS gf180mcu_fd_sc_mcu7t5v0__filltie
XFILLER_7_346 VDD VDD VSS VSS gf180mcu_fd_sc_mcu7t5v0__fillcap_4
XFILLER_11_80 VDD VDD VSS VSS gf180mcu_fd_sc_mcu7t5v0__fillcap_4
XTAP_TAPCELL_ROW_49_746 VDD VSS gf180mcu_fd_sc_mcu7t5v0__filltie
X_2080_ _2355_/A2 _2091_/B _2089_/B1 _2080_/B2 _3044_/D VDD VDD VSS VSS gf180mcu_fd_sc_mcu7t5v0__aoi22_1
XFILLER_53_209 VDD VDD VSS VSS gf180mcu_fd_sc_mcu7t5v0__fill_1
XFILLER_61_220 VDD VDD VSS VSS gf180mcu_fd_sc_mcu7t5v0__fill_2
XFILLER_21_106 VDD VDD VSS VSS gf180mcu_fd_sc_mcu7t5v0__fillcap_8
X_2982_ _2982_/D _2982_/CLK _2982_/Q VDD VDD VSS VSS gf180mcu_fd_sc_mcu7t5v0__dffq_1
XFILLER_21_139 VDD VDD VSS VSS gf180mcu_fd_sc_mcu7t5v0__fill_1
X_1933_ _3117_/Q _2957_/Q _1934_/S _2957_/D VDD VDD VSS VSS gf180mcu_fd_sc_mcu7t5v0__mux2_2
X_1864_ _2899_/Q _3115_/Q _1867_/S _2899_/D VDD VDD VSS VSS gf180mcu_fd_sc_mcu7t5v0__mux2_2
X_1795_ _3287_/Q _2838_/Q _1795_/S _2838_/D VDD VDD VSS VSS gf180mcu_fd_sc_mcu7t5v0__mux2_2
XFILLER_89_629 VDD VDD VSS VSS gf180mcu_fd_sc_mcu7t5v0__fill_1
X_2416_ _2416_/A1 _2416_/A2 _2416_/B _3141_/D VDD VDD VSS VSS gf180mcu_fd_sc_mcu7t5v0__oai21_1
X_3396_ _3396_/D _3416_/RN _3398_/CLK _3396_/Q VDD VDD VSS VSS gf180mcu_fd_sc_mcu7t5v0__dffrnq_1
XFILLER_84_301 VDD VDD VSS VSS gf180mcu_fd_sc_mcu7t5v0__fillcap_8
X_2347_ _2857_/Q _2849_/Q _2841_/Q _2833_/Q _3391_/Q _3392_/Q _2347_/Z VDD VDD VSS
+ VSS gf180mcu_fd_sc_mcu7t5v0__mux4_1
XFILLER_84_323 VDD VDD VSS VSS gf180mcu_fd_sc_mcu7t5v0__fillcap_16
X_2278_ _2278_/A1 _2278_/A2 _2278_/B _3140_/Q _2434_/A2 VDD VDD VSS VSS gf180mcu_fd_sc_mcu7t5v0__oai211_1
XFILLER_84_378 VDD VDD VSS VSS gf180mcu_fd_sc_mcu7t5v0__fillcap_4
XFILLER_38_762 VDD VDD VSS VSS gf180mcu_fd_sc_mcu7t5v0__fill_2
XFILLER_13_618 VDD VDD VSS VSS gf180mcu_fd_sc_mcu7t5v0__fillcap_8
XTAP_TAPCELL_ROW_82_1092 VDD VSS gf180mcu_fd_sc_mcu7t5v0__filltie
XFILLER_12_139 VDD VDD VSS VSS gf180mcu_fd_sc_mcu7t5v0__fillcap_4
XFILLER_21_684 VDD VDD VSS VSS gf180mcu_fd_sc_mcu7t5v0__fill_1
XFILLER_79_139 VDD VDD VSS VSS gf180mcu_fd_sc_mcu7t5v0__fill_1
XFILLER_87_150 VDD VDD VSS VSS gf180mcu_fd_sc_mcu7t5v0__fillcap_4
XFILLER_75_334 VDD VDD VSS VSS gf180mcu_fd_sc_mcu7t5v0__fill_2
XTAP_TAPCELL_ROW_46_716 VDD VSS gf180mcu_fd_sc_mcu7t5v0__filltie
XTAP_TAPCELL_ROW_18_418 VDD VSS gf180mcu_fd_sc_mcu7t5v0__filltie
XFILLER_16_401 VDD VDD VSS VSS gf180mcu_fd_sc_mcu7t5v0__fill_1
XFILLER_44_743 VDD VDD VSS VSS gf180mcu_fd_sc_mcu7t5v0__fillcap_16
Xclkbuf_0_host_clk_i host_clk_i clkbuf_0_host_clk_i/Z VDD VDD VSS VSS gf180mcu_fd_sc_mcu7t5v0__clkbuf_16
XFILLER_73_53 VDD VDD VSS VSS gf180mcu_fd_sc_mcu7t5v0__fill_1
XFILLER_71_562 VDD VDD VSS VSS gf180mcu_fd_sc_mcu7t5v0__fill_1
XFILLER_12_684 VDD VDD VSS VSS gf180mcu_fd_sc_mcu7t5v0__fill_1
XTAP_TAPCELL_ROW_96_1239 VDD VSS gf180mcu_fd_sc_mcu7t5v0__filltie
XFILLER_7_198 VDD VDD VSS VSS gf180mcu_fd_sc_mcu7t5v0__fill_2
X_1580_ _3337_/Q _1504_/I _1574_/Z _1580_/B2 _3368_/D _3339_/Q _1581_/A3 VDD VDD VSS
+ VSS gf180mcu_fd_sc_mcu7t5v0__oai222_1
X_3250_ _3250_/D _3369_/RN _3324_/CLK _3250_/Q VDD VDD VSS VSS gf180mcu_fd_sc_mcu7t5v0__dffrnq_1
XFILLER_94_621 VDD VDD VSS VSS gf180mcu_fd_sc_mcu7t5v0__fill_2
X_2201_ _3107_/Q _2200_/Z _2201_/S _3107_/D VDD VDD VSS VSS gf180mcu_fd_sc_mcu7t5v0__mux2_2
XFILLER_79_684 VDD VDD VSS VSS gf180mcu_fd_sc_mcu7t5v0__fill_2
X_3181_ _3181_/D _3303_/RN _3292_/CLK _3181_/Q VDD VDD VSS VSS gf180mcu_fd_sc_mcu7t5v0__dffrnq_1
XFILLER_94_654 VDD VDD VSS VSS gf180mcu_fd_sc_mcu7t5v0__fillcap_8
X_2132_ _2132_/I _2685_/A1 VDD VDD VSS VSS gf180mcu_fd_sc_mcu7t5v0__clkinv_1
XFILLER_93_142 VDD VDD VSS VSS gf180mcu_fd_sc_mcu7t5v0__fillcap_16
XFILLER_66_367 VDD VDD VSS VSS gf180mcu_fd_sc_mcu7t5v0__fill_2
XFILLER_81_337 VDD VDD VSS VSS gf180mcu_fd_sc_mcu7t5v0__fill_2
XFILLER_54_529 VDD VDD VSS VSS gf180mcu_fd_sc_mcu7t5v0__fill_1
X_2063_ _3040_/Q _3114_/Q _3410_/D _3040_/D VDD VDD VSS VSS gf180mcu_fd_sc_mcu7t5v0__mux2_2
XTAP_TAPCELL_ROW_105_1335 VDD VSS gf180mcu_fd_sc_mcu7t5v0__filltie
X_2965_ _2965_/D _2982_/CLK _2965_/Q VDD VDD VSS VSS gf180mcu_fd_sc_mcu7t5v0__dffq_1
X_1916_ _3118_/Q _2942_/Q _1916_/S _2942_/D VDD VDD VSS VSS gf180mcu_fd_sc_mcu7t5v0__mux2_2
XFILLER_30_492 VDD VDD VSS VSS gf180mcu_fd_sc_mcu7t5v0__fillcap_32
X_2896_ _2896_/D _2926_/CLK _2896_/Q VDD VDD VSS VSS gf180mcu_fd_sc_mcu7t5v0__dffq_1
X_1847_ _3284_/Q _2883_/Q _1850_/S _2883_/D VDD VDD VSS VSS gf180mcu_fd_sc_mcu7t5v0__mux2_2
X_1778_ _2823_/Q _3280_/Q _1785_/S _2823_/D VDD VDD VSS VSS gf180mcu_fd_sc_mcu7t5v0__mux2_2
XTAP_TAPCELL_ROW_73_1003 VDD VSS gf180mcu_fd_sc_mcu7t5v0__filltie
XFILLER_104_737 VDD VDD VSS VSS gf180mcu_fd_sc_mcu7t5v0__fillcap_16
XFILLER_89_437 VDD VDD VSS VSS gf180mcu_fd_sc_mcu7t5v0__fillcap_8
X_3379_ hold58/Z input1/Z _3408_/CLK _3379_/Q VDD VDD VSS VSS gf180mcu_fd_sc_mcu7t5v0__dffrnq_1
XFILLER_97_492 VDD VDD VSS VSS gf180mcu_fd_sc_mcu7t5v0__fillcap_8
XFILLER_85_632 VDD VDD VSS VSS gf180mcu_fd_sc_mcu7t5v0__fillcap_8
XFILLER_85_698 VDD VDD VSS VSS gf180mcu_fd_sc_mcu7t5v0__fill_2
XTAP_TAPCELL_ROW_84_1121 VDD VSS gf180mcu_fd_sc_mcu7t5v0__filltie
XFILLER_72_359 VDD VDD VSS VSS gf180mcu_fd_sc_mcu7t5v0__fillcap_16
XFILLER_41_702 VDD VDD VSS VSS gf180mcu_fd_sc_mcu7t5v0__fillcap_4
XFILLER_53_562 VDD VDD VSS VSS gf180mcu_fd_sc_mcu7t5v0__fillcap_64
XFILLER_80_381 VDD VDD VSS VSS gf180mcu_fd_sc_mcu7t5v0__fillcap_4
XFILLER_41_757 VDD VDD VSS VSS gf180mcu_fd_sc_mcu7t5v0__fillcap_8
XTAP_TAPCELL_ROW_51_774 VDD VSS gf180mcu_fd_sc_mcu7t5v0__filltie
XTAP_TAPCELL_ROW_23_476 VDD VSS gf180mcu_fd_sc_mcu7t5v0__filltie
XFILLER_4_113 VDD VDD VSS VSS gf180mcu_fd_sc_mcu7t5v0__fill_1
XFILLER_68_53 VDD VDD VSS VSS gf180mcu_fd_sc_mcu7t5v0__fill_2
XTAP_TAPCELL_ROW_59_852 VDD VSS gf180mcu_fd_sc_mcu7t5v0__filltie
XFILLER_84_52 VDD VDD VSS VSS gf180mcu_fd_sc_mcu7t5v0__fill_2
XFILLER_84_96 VDD VDD VSS VSS gf180mcu_fd_sc_mcu7t5v0__fillcap_8
XFILLER_16_220 VDD VDD VSS VSS gf180mcu_fd_sc_mcu7t5v0__fill_2
XFILLER_16_231 VDD VDD VSS VSS gf180mcu_fd_sc_mcu7t5v0__fill_2
X_2750_ _3224_/Q _3290_/Q _2763_/S _3290_/D VDD VDD VSS VSS gf180mcu_fd_sc_mcu7t5v0__mux2_2
XTAP_TAPCELL_ROW_100_1287 VDD VSS gf180mcu_fd_sc_mcu7t5v0__filltie
X_1701_ _3141_/Q _3140_/Q _1701_/B _1702_/B VDD VDD VSS VSS gf180mcu_fd_sc_mcu7t5v0__aoi21_1
X_2681_ _2681_/A1 _2680_/C _2681_/B1 _2681_/B2 _3254_/D VDD VDD VSS VSS gf180mcu_fd_sc_mcu7t5v0__aoi22_1
X_1632_ _2197_/A1 _3412_/Q _3131_/Q _1633_/A4 _1632_/Z VDD VDD VSS VSS gf180mcu_fd_sc_mcu7t5v0__and4_1
XFILLER_98_212 VDD VDD VSS VSS gf180mcu_fd_sc_mcu7t5v0__fill_1
X_1563_ _3307_/Q _1568_/A2 _1564_/A2 VDD VDD VSS VSS gf180mcu_fd_sc_mcu7t5v0__nand2_1
X_1494_ _3364_/Q _1494_/A2 _3364_/D VDD VDD VSS VSS gf180mcu_fd_sc_mcu7t5v0__xor2_1
X_3302_ _3302_/D _3303_/RN _3302_/CLK _3302_/Q VDD VDD VSS VSS gf180mcu_fd_sc_mcu7t5v0__dffrnq_1
XFILLER_86_429 VDD VDD VSS VSS gf180mcu_fd_sc_mcu7t5v0__fillcap_8
X_3233_ _3233_/D _3328_/RN _3264_/CLK _3233_/Q VDD VDD VSS VSS gf180mcu_fd_sc_mcu7t5v0__dffrnq_1
XFILLER_67_632 VDD VDD VSS VSS gf180mcu_fd_sc_mcu7t5v0__fillcap_16
X_3164_ _3164_/D _3328_/RN _3215_/CLK _3164_/Q VDD VDD VSS VSS gf180mcu_fd_sc_mcu7t5v0__dffrnq_1
X_3095_ _3095_/D _3328_/RN _3326_/CLK _3095_/Q VDD VDD VSS VSS gf180mcu_fd_sc_mcu7t5v0__dffrnq_1
XFILLER_54_304 VDD VDD VSS VSS gf180mcu_fd_sc_mcu7t5v0__fillcap_8
X_2115_ _3059_/Q _3060_/Q _2115_/B _2116_/A3 VDD VDD VSS VSS gf180mcu_fd_sc_mcu7t5v0__oai21_1
X_2046_ _3032_/Q _2051_/A1 _2046_/A3 _2046_/B _3032_/D VDD VDD VSS VSS gf180mcu_fd_sc_mcu7t5v0__oai31_1
XFILLER_23_702 VDD VDD VSS VSS gf180mcu_fd_sc_mcu7t5v0__fillcap_8
XFILLER_35_562 VDD VDD VSS VSS gf180mcu_fd_sc_mcu7t5v0__fill_2
X_2948_ _2948_/D _3324_/CLK _2948_/Q VDD VDD VSS VSS gf180mcu_fd_sc_mcu7t5v0__dffq_1
XTAP_TAPCELL_ROW_20_446 VDD VSS gf180mcu_fd_sc_mcu7t5v0__filltie
X_2879_ _2879_/D _2887_/CLK _2879_/Q VDD VDD VSS VSS gf180mcu_fd_sc_mcu7t5v0__dffq_1
XFILLER_77_418 VDD VDD VSS VSS gf180mcu_fd_sc_mcu7t5v0__fill_2
XTAP_TAPCELL_ROW_90_1180 VDD VSS gf180mcu_fd_sc_mcu7t5v0__filltie
XFILLER_100_762 VDD VDD VSS VSS gf180mcu_fd_sc_mcu7t5v0__fill_2
XFILLER_57_142 VDD VDD VSS VSS gf180mcu_fd_sc_mcu7t5v0__fillcap_16
XTAP_TAPCELL_ROW_56_822 VDD VSS gf180mcu_fd_sc_mcu7t5v0__filltie
XTAP_TAPCELL_ROW_28_524 VDD VSS gf180mcu_fd_sc_mcu7t5v0__filltie
XFILLER_72_123 VDD VDD VSS VSS gf180mcu_fd_sc_mcu7t5v0__fillcap_8
XFILLER_73_657 VDD VDD VSS VSS gf180mcu_fd_sc_mcu7t5v0__fill_1
XFILLER_72_189 VDD VDD VSS VSS gf180mcu_fd_sc_mcu7t5v0__fill_2
XFILLER_13_212 VDD VDD VSS VSS gf180mcu_fd_sc_mcu7t5v0__fillcap_16
Xclkload19 _3325_/CLK clkload19/ZN VDD VDD VSS VSS gf180mcu_fd_sc_mcu7t5v0__clkinv_2
XTAP_TAPCELL_ROW_93_1209 VDD VSS gf180mcu_fd_sc_mcu7t5v0__filltie
XFILLER_107_372 VDD VDD VSS VSS gf180mcu_fd_sc_mcu7t5v0__fill_2
XFILLER_5_488 VDD VDD VSS VSS gf180mcu_fd_sc_mcu7t5v0__fill_2
XFILLER_1_683 VDD VDD VSS VSS gf180mcu_fd_sc_mcu7t5v0__fillcap_16
XFILLER_49_632 VDD VDD VSS VSS gf180mcu_fd_sc_mcu7t5v0__fillcap_4
XFILLER_91_410 VDD VDD VSS VSS gf180mcu_fd_sc_mcu7t5v0__fillcap_8
XFILLER_49_687 VDD VDD VSS VSS gf180mcu_fd_sc_mcu7t5v0__fillcap_4
Xclkbuf_3_5__f_clk_i clkbuf_0_clk_i/Z clkload4/I VDD VDD VSS VSS gf180mcu_fd_sc_mcu7t5v0__clkbuf_16
XTAP_TAPCELL_ROW_102_1305 VDD VSS gf180mcu_fd_sc_mcu7t5v0__filltie
XFILLER_17_595 VDD VDD VSS VSS gf180mcu_fd_sc_mcu7t5v0__fill_2
X_2802_ _2802_/D _2894_/CLK _2802_/Q VDD VDD VSS VSS gf180mcu_fd_sc_mcu7t5v0__dffq_1
X_2733_ _2733_/A1 _2733_/A2 _3277_/D VDD VDD VSS VSS gf180mcu_fd_sc_mcu7t5v0__nand2_1
XFILLER_74_2 VDD VDD VSS VSS gf180mcu_fd_sc_mcu7t5v0__fillcap_16
X_2664_ _3070_/Q _2132_/I _2664_/B1 _3102_/Q _2664_/C _2671_/A2 VDD VDD VSS VSS gf180mcu_fd_sc_mcu7t5v0__aoi221_1
XFILLER_99_521 VDD VDD VSS VSS gf180mcu_fd_sc_mcu7t5v0__fill_2
X_2595_ _2592_/Z _2594_/Z _2591_/Z _2593_/Z _3354_/Q _3353_/Q _2595_/Z VDD VDD VSS
+ VSS gf180mcu_fd_sc_mcu7t5v0__mux4_1
X_1615_ _3160_/Q _2508_/A2 _2499_/A2 VDD VDD VSS VSS gf180mcu_fd_sc_mcu7t5v0__nand2_1
X_1546_ _2104_/A1 _3058_/Q _1546_/A3 _1545_/Z _1547_/B VDD VDD VSS VSS gf180mcu_fd_sc_mcu7t5v0__and4_1
XFILLER_86_237 VDD VDD VSS VSS gf180mcu_fd_sc_mcu7t5v0__fillcap_8
XFILLER_86_226 VDD VDD VSS VSS gf180mcu_fd_sc_mcu7t5v0__fill_1
X_1477_ _3352_/Q _1478_/A3 _3353_/Q _1484_/A2 VDD VDD VSS VSS gf180mcu_fd_sc_mcu7t5v0__aoi21_1
XFILLER_39_142 VDD VDD VSS VSS gf180mcu_fd_sc_mcu7t5v0__fillcap_16
X_3216_ _3216_/D _3303_/RN _3293_/CLK _3216_/Q VDD VDD VSS VSS gf180mcu_fd_sc_mcu7t5v0__dffrnq_1
X_3147_ _3147_/D _3369_/RN _3148_/CLK _3147_/Q VDD VDD VSS VSS gf180mcu_fd_sc_mcu7t5v0__dffrnq_1
X_3078_ _3078_/D _3328_/RN _3264_/CLK _3078_/Q VDD VDD VSS VSS gf180mcu_fd_sc_mcu7t5v0__dffrnq_1
XFILLER_82_498 VDD VDD VSS VSS gf180mcu_fd_sc_mcu7t5v0__fillcap_8
X_2029_ _2010_/Z _2027_/Z _2029_/B _2050_/C _3027_/D VDD VDD VSS VSS gf180mcu_fd_sc_mcu7t5v0__aoi211_1
XFILLER_35_392 VDD VDD VSS VSS gf180mcu_fd_sc_mcu7t5v0__fill_1
XTAP_TAPCELL_ROW_33_582 VDD VSS gf180mcu_fd_sc_mcu7t5v0__filltie
XTAP_TAPCELL_ROW_79_1064 VDD VSS gf180mcu_fd_sc_mcu7t5v0__filltie
XFILLER_40_57 VDD VDD VSS VSS gf180mcu_fd_sc_mcu7t5v0__fillcap_8
XFILLER_2_403 VDD VDD VSS VSS gf180mcu_fd_sc_mcu7t5v0__fillcap_4
XFILLER_2_469 VDD VDD VSS VSS gf180mcu_fd_sc_mcu7t5v0__fill_2
Xclkbuf_leaf_9_clk_i clkload2/I _3288_/CLK VDD VDD VSS VSS gf180mcu_fd_sc_mcu7t5v0__clkbuf_4
XFILLER_49_99 VDD VDD VSS VSS gf180mcu_fd_sc_mcu7t5v0__fill_2
XFILLER_105_72 VDD VDD VSS VSS gf180mcu_fd_sc_mcu7t5v0__fillcap_32
XFILLER_92_229 VDD VDD VSS VSS gf180mcu_fd_sc_mcu7t5v0__fillcap_4
XTAP_TAPCELL_ROW_5_285 VDD VSS gf180mcu_fd_sc_mcu7t5v0__filltie
XFILLER_58_473 VDD VDD VSS VSS gf180mcu_fd_sc_mcu7t5v0__fillcap_4
XFILLER_65_10 VDD VDD VSS VSS gf180mcu_fd_sc_mcu7t5v0__fillcap_4
XFILLER_65_65 VDD VDD VSS VSS gf180mcu_fd_sc_mcu7t5v0__fillcap_4
XFILLER_33_318 VDD VDD VSS VSS gf180mcu_fd_sc_mcu7t5v0__fill_1
XFILLER_60_104 VDD VDD VSS VSS gf180mcu_fd_sc_mcu7t5v0__fill_1
XFILLER_81_42 VDD VDD VSS VSS gf180mcu_fd_sc_mcu7t5v0__fillcap_16
XFILLER_6_753 VDD VDD VSS VSS gf180mcu_fd_sc_mcu7t5v0__fillcap_8
X_1400_ _3143_/Q _2267_/A1 VDD VDD VSS VSS gf180mcu_fd_sc_mcu7t5v0__clkinv_1
XFILLER_96_513 VDD VDD VSS VSS gf180mcu_fd_sc_mcu7t5v0__fillcap_8
X_2380_ _3393_/Q _2374_/Z _2380_/B _2381_/C VDD VDD VSS VSS gf180mcu_fd_sc_mcu7t5v0__oai21_1
XFILLER_68_259 VDD VDD VSS VSS gf180mcu_fd_sc_mcu7t5v0__fill_2
X_3001_ _3001_/D _3366_/CLK _3001_/Q VDD VDD VSS VSS gf180mcu_fd_sc_mcu7t5v0__dffq_1
XTAP_TAPCELL_ROW_67_939 VDD VSS gf180mcu_fd_sc_mcu7t5v0__filltie
XFILLER_37_657 VDD VDD VSS VSS gf180mcu_fd_sc_mcu7t5v0__fill_1
XFILLER_64_454 VDD VDD VSS VSS gf180mcu_fd_sc_mcu7t5v0__fill_1
XFILLER_32_373 VDD VDD VSS VSS gf180mcu_fd_sc_mcu7t5v0__fillcap_4
XFILLER_20_568 VDD VDD VSS VSS gf180mcu_fd_sc_mcu7t5v0__fill_2
XTAP_TAPCELL_ROW_30_552 VDD VSS gf180mcu_fd_sc_mcu7t5v0__filltie
X_2716_ _2716_/I _3269_/D VDD VDD VSS VSS gf180mcu_fd_sc_mcu7t5v0__clkinv_1
XFILLER_106_618 VDD VDD VSS VSS gf180mcu_fd_sc_mcu7t5v0__fill_1
X_2647_ _3250_/Q _2680_/C _2651_/A1 VDD VDD VSS VSS gf180mcu_fd_sc_mcu7t5v0__nand2_1
XFILLER_99_362 VDD VDD VSS VSS gf180mcu_fd_sc_mcu7t5v0__fill_1
X_2578_ _3196_/Q _3238_/Q _2585_/S _3238_/D VDD VDD VSS VSS gf180mcu_fd_sc_mcu7t5v0__mux2_2
X_1529_ _3056_/Q _3057_/Q _1546_/A3 VDD VDD VSS VSS gf180mcu_fd_sc_mcu7t5v0__nor2_1
XFILLER_101_345 VDD VDD VSS VSS gf180mcu_fd_sc_mcu7t5v0__fillcap_4
XFILLER_59_248 VDD VDD VSS VSS gf180mcu_fd_sc_mcu7t5v0__fill_2
XTAP_TAPCELL_ROW_2_255 VDD VSS gf180mcu_fd_sc_mcu7t5v0__filltie
XFILLER_27_134 VDD VDD VSS VSS gf180mcu_fd_sc_mcu7t5v0__fill_2
XTAP_TAPCELL_ROW_38_630 VDD VSS gf180mcu_fd_sc_mcu7t5v0__filltie
XFILLER_27_156 VDD VDD VSS VSS gf180mcu_fd_sc_mcu7t5v0__fillcap_32
XFILLER_82_284 VDD VDD VSS VSS gf180mcu_fd_sc_mcu7t5v0__fillcap_8
XFILLER_23_340 VDD VDD VSS VSS gf180mcu_fd_sc_mcu7t5v0__fillcap_8
XFILLER_70_457 VDD VDD VSS VSS gf180mcu_fd_sc_mcu7t5v0__fillcap_4
XPHY_EDGE_ROW_14_Right_14 VDD VSS gf180mcu_fd_sc_mcu7t5v0__endcap
XFILLER_51_56 VDD VDD VSS VSS gf180mcu_fd_sc_mcu7t5v0__fillcap_8
XFILLER_2_255 VDD VDD VSS VSS gf180mcu_fd_sc_mcu7t5v0__fillcap_4
XFILLER_4_2 VDD VDD VSS VSS gf180mcu_fd_sc_mcu7t5v0__fillcap_32
XPHY_EDGE_ROW_23_Right_23 VDD VSS gf180mcu_fd_sc_mcu7t5v0__endcap
XFILLER_93_516 VDD VDD VSS VSS gf180mcu_fd_sc_mcu7t5v0__fill_2
XFILLER_65_207 VDD VDD VSS VSS gf180mcu_fd_sc_mcu7t5v0__fill_2
XFILLER_18_123 VDD VDD VSS VSS gf180mcu_fd_sc_mcu7t5v0__fill_2
XFILLER_46_432 VDD VDD VSS VSS gf180mcu_fd_sc_mcu7t5v0__fillcap_16
XTAP_TAPCELL_ROW_64_909 VDD VSS gf180mcu_fd_sc_mcu7t5v0__filltie
XFILLER_34_605 VDD VDD VSS VSS gf180mcu_fd_sc_mcu7t5v0__fill_2
XFILLER_46_454 VDD VDD VSS VSS gf180mcu_fd_sc_mcu7t5v0__fill_1
XFILLER_18_189 VDD VDD VSS VSS gf180mcu_fd_sc_mcu7t5v0__fill_2
XPHY_EDGE_ROW_32_Right_32 VDD VSS gf180mcu_fd_sc_mcu7t5v0__endcap
XTAP_TAPCELL_ROW_44_699 VDD VSS gf180mcu_fd_sc_mcu7t5v0__filltie
XTAP_TAPCELL_ROW_72_986 VDD VSS gf180mcu_fd_sc_mcu7t5v0__filltie
XFILLER_14_395 VDD VDD VSS VSS gf180mcu_fd_sc_mcu7t5v0__fillcap_4
X_1880_ _2911_/Q _3111_/Q _1887_/S _2911_/D VDD VDD VSS VSS gf180mcu_fd_sc_mcu7t5v0__mux2_2
X_2501_ _3165_/Q _3150_/Q wire13/Z _3165_/D VDD VDD VSS VSS gf180mcu_fd_sc_mcu7t5v0__mux2_2
X_2432_ _2267_/C _2432_/A2 _2432_/A3 _2432_/B1 _2432_/B2 _3146_/D VDD VDD VSS VSS
+ gf180mcu_fd_sc_mcu7t5v0__oai32_1
XPHY_EDGE_ROW_41_Right_41 VDD VSS gf180mcu_fd_sc_mcu7t5v0__endcap
X_2363_ _3394_/Q _2362_/Z _2366_/A1 VDD VDD VSS VSS gf180mcu_fd_sc_mcu7t5v0__nand2_1
X_2294_ _3128_/Q _2313_/A1 _2301_/B VDD VDD VSS VSS gf180mcu_fd_sc_mcu7t5v0__nand2_1
XFILLER_96_387 VDD VDD VSS VSS gf180mcu_fd_sc_mcu7t5v0__fillcap_16
XPHY_EDGE_ROW_16_Left_125 VDD VSS gf180mcu_fd_sc_mcu7t5v0__endcap
XFILLER_56_207 VDD VDD VSS VSS gf180mcu_fd_sc_mcu7t5v0__fill_1
XFILLER_25_605 VDD VDD VSS VSS gf180mcu_fd_sc_mcu7t5v0__fill_2
XTAP_TAPCELL_ROW_108_1377 VDD VSS gf180mcu_fd_sc_mcu7t5v0__filltie
XTAP_TAPCELL_ROW_108_1366 VDD VSS gf180mcu_fd_sc_mcu7t5v0__filltie
XFILLER_92_593 VDD VDD VSS VSS gf180mcu_fd_sc_mcu7t5v0__fill_2
XFILLER_25_638 VDD VDD VSS VSS gf180mcu_fd_sc_mcu7t5v0__fill_1
XTAP_TAPCELL_ROW_35_600 VDD VSS gf180mcu_fd_sc_mcu7t5v0__filltie
XPHY_EDGE_ROW_50_Right_50 VDD VSS gf180mcu_fd_sc_mcu7t5v0__endcap
XFILLER_52_479 VDD VDD VSS VSS gf180mcu_fd_sc_mcu7t5v0__fillcap_8
XFILLER_20_332 VDD VDD VSS VSS gf180mcu_fd_sc_mcu7t5v0__fillcap_16
XPHY_EDGE_ROW_25_Left_134 VDD VSS gf180mcu_fd_sc_mcu7t5v0__endcap
XTAP_TAPCELL_ROW_15_390 VDD VSS gf180mcu_fd_sc_mcu7t5v0__filltie
XFILLER_20_387 VDD VDD VSS VSS gf180mcu_fd_sc_mcu7t5v0__fillcap_8
XFILLER_106_448 VDD VDD VSS VSS gf180mcu_fd_sc_mcu7t5v0__fillcap_4
XTAP_TAPCELL_ROW_76_1034 VDD VSS gf180mcu_fd_sc_mcu7t5v0__filltie
XTAP_TAPCELL_ROW_7_303 VDD VSS gf180mcu_fd_sc_mcu7t5v0__filltie
XFILLER_87_321 VDD VDD VSS VSS gf180mcu_fd_sc_mcu7t5v0__fill_1
XPHY_EDGE_ROW_34_Left_143 VDD VSS gf180mcu_fd_sc_mcu7t5v0__endcap
XFILLER_102_687 VDD VDD VSS VSS gf180mcu_fd_sc_mcu7t5v0__fill_1
XFILLER_101_142 VDD VDD VSS VSS gf180mcu_fd_sc_mcu7t5v0__fillcap_64
XTAP_TAPCELL_ROW_87_1152 VDD VSS gf180mcu_fd_sc_mcu7t5v0__filltie
XFILLER_28_454 VDD VDD VSS VSS gf180mcu_fd_sc_mcu7t5v0__fill_1
Xclkbuf_leaf_12_clk_i clkload1/I _3302_/CLK VDD VDD VSS VSS gf180mcu_fd_sc_mcu7t5v0__clkbuf_4
XFILLER_30_107 VDD VDD VSS VSS gf180mcu_fd_sc_mcu7t5v0__fillcap_8
XPHY_EDGE_ROW_43_Left_152 VDD VSS gf180mcu_fd_sc_mcu7t5v0__endcap
XFILLER_70_265 VDD VDD VSS VSS gf180mcu_fd_sc_mcu7t5v0__fillcap_32
XFILLER_7_314 VDD VDD VSS VSS gf180mcu_fd_sc_mcu7t5v0__fillcap_16
XTAP_TAPCELL_ROW_41_669 VDD VSS gf180mcu_fd_sc_mcu7t5v0__filltie
Xclkbuf_leaf_27_clk_i clkload6/I _3387_/CLK VDD VDD VSS VSS gf180mcu_fd_sc_mcu7t5v0__clkbuf_4
XPHY_EDGE_ROW_52_Left_161 VDD VSS gf180mcu_fd_sc_mcu7t5v0__endcap
XFILLER_105_492 VDD VDD VSS VSS gf180mcu_fd_sc_mcu7t5v0__fillcap_4
XFILLER_78_387 VDD VDD VSS VSS gf180mcu_fd_sc_mcu7t5v0__fillcap_8
XFILLER_66_527 VDD VDD VSS VSS gf180mcu_fd_sc_mcu7t5v0__fillcap_4
XFILLER_93_324 VDD VDD VSS VSS gf180mcu_fd_sc_mcu7t5v0__fillcap_16
XTAP_TAPCELL_ROW_49_747 VDD VSS gf180mcu_fd_sc_mcu7t5v0__filltie
XFILLER_62_700 VDD VDD VSS VSS gf180mcu_fd_sc_mcu7t5v0__fill_1
XFILLER_74_582 VDD VDD VSS VSS gf180mcu_fd_sc_mcu7t5v0__fillcap_8
XFILLER_34_446 VDD VDD VSS VSS gf180mcu_fd_sc_mcu7t5v0__fillcap_8
XPHY_EDGE_ROW_61_Left_170 VDD VSS gf180mcu_fd_sc_mcu7t5v0__endcap
X_2981_ _2981_/D _3020_/CLK _2981_/Q VDD VDD VSS VSS gf180mcu_fd_sc_mcu7t5v0__dffq_1
XFILLER_21_118 VDD VDD VSS VSS gf180mcu_fd_sc_mcu7t5v0__fill_2
XFILLER_14_181 VDD VDD VSS VSS gf180mcu_fd_sc_mcu7t5v0__fill_1
X_1932_ _3116_/Q _2956_/Q _1934_/S _2956_/D VDD VDD VSS VSS gf180mcu_fd_sc_mcu7t5v0__mux2_2
XFILLER_30_663 VDD VDD VSS VSS gf180mcu_fd_sc_mcu7t5v0__fill_2
X_1863_ _2898_/Q _3114_/Q _1867_/S _2898_/D VDD VDD VSS VSS gf180mcu_fd_sc_mcu7t5v0__mux2_2
XTAP_TAPCELL_ROW_12_360 VDD VSS gf180mcu_fd_sc_mcu7t5v0__filltie
X_1794_ _3286_/Q _2837_/Q _1795_/S _2837_/D VDD VDD VSS VSS gf180mcu_fd_sc_mcu7t5v0__mux2_2
X_2415_ _3141_/Q _2415_/A2 _2416_/B VDD VDD VSS VSS gf180mcu_fd_sc_mcu7t5v0__nand2_1
X_3395_ _3395_/D input1/Z _3399_/CLK _3395_/Q VDD VDD VSS VSS gf180mcu_fd_sc_mcu7t5v0__dffrnq_1
XFILLER_84_313 VDD VDD VSS VSS gf180mcu_fd_sc_mcu7t5v0__fill_2
X_2346_ _2793_/Q _2785_/Q _2777_/Q _2769_/Q _3391_/Q _3392_/Q _2346_/Z VDD VDD VSS
+ VSS gf180mcu_fd_sc_mcu7t5v0__mux4_1
X_2277_ _2424_/A1 _2277_/A2 _2435_/B VDD VDD VSS VSS gf180mcu_fd_sc_mcu7t5v0__nor2_1
XFILLER_16_37 VDD VDD VSS VSS gf180mcu_fd_sc_mcu7t5v0__fillcap_16
XFILLER_52_243 VDD VDD VSS VSS gf180mcu_fd_sc_mcu7t5v0__fill_2
XFILLER_12_107 VDD VDD VSS VSS gf180mcu_fd_sc_mcu7t5v0__fillcap_32
XFILLER_40_427 VDD VDD VSS VSS gf180mcu_fd_sc_mcu7t5v0__fill_1
Xclkbuf_4_10_0_host_clk_i clkbuf_0_host_clk_i/Z _2891_/CLK VDD VDD VSS VSS gf180mcu_fd_sc_mcu7t5v0__clkbuf_4
XTAP_TAPCELL_ROW_82_1093 VDD VSS gf180mcu_fd_sc_mcu7t5v0__filltie
XFILLER_107_702 VDD VDD VSS VSS gf180mcu_fd_sc_mcu7t5v0__fillcap_16
XFILLER_4_317 VDD VDD VSS VSS gf180mcu_fd_sc_mcu7t5v0__fillcap_16
XFILLER_4_339 VDD VDD VSS VSS gf180mcu_fd_sc_mcu7t5v0__fill_1
XFILLER_0_512 VDD VDD VSS VSS gf180mcu_fd_sc_mcu7t5v0__fillcap_32
XFILLER_102_451 VDD VDD VSS VSS gf180mcu_fd_sc_mcu7t5v0__fillcap_4
XFILLER_75_357 VDD VDD VSS VSS gf180mcu_fd_sc_mcu7t5v0__fill_1
XTAP_TAPCELL_ROW_18_419 VDD VSS gf180mcu_fd_sc_mcu7t5v0__filltie
XTAP_TAPCELL_ROW_46_717 VDD VSS gf180mcu_fd_sc_mcu7t5v0__filltie
XFILLER_73_43 VDD VDD VSS VSS gf180mcu_fd_sc_mcu7t5v0__fillcap_4
XFILLER_31_438 VDD VDD VSS VSS gf180mcu_fd_sc_mcu7t5v0__fillcap_8
XFILLER_43_298 VDD VDD VSS VSS gf180mcu_fd_sc_mcu7t5v0__fillcap_4
XFILLER_8_667 VDD VDD VSS VSS gf180mcu_fd_sc_mcu7t5v0__fillcap_64
XFILLER_98_51 VDD VDD VSS VSS gf180mcu_fd_sc_mcu7t5v0__fill_2
XFILLER_98_95 VDD VDD VSS VSS gf180mcu_fd_sc_mcu7t5v0__fill_2
XFILLER_98_449 VDD VDD VSS VSS gf180mcu_fd_sc_mcu7t5v0__fillcap_4
X_2200_ _2218_/B _2200_/A2 _2199_/Z _2200_/Z VDD VDD VSS VSS gf180mcu_fd_sc_mcu7t5v0__and3_1
XFILLER_3_383 VDD VDD VSS VSS gf180mcu_fd_sc_mcu7t5v0__fillcap_8
XFILLER_78_162 VDD VDD VSS VSS gf180mcu_fd_sc_mcu7t5v0__fillcap_8
X_3180_ _3180_/D _3303_/RN _3215_/CLK _3180_/Q VDD VDD VSS VSS gf180mcu_fd_sc_mcu7t5v0__dffrnq_1
XFILLER_93_121 VDD VDD VSS VSS gf180mcu_fd_sc_mcu7t5v0__fillcap_4
XFILLER_79_696 VDD VDD VSS VSS gf180mcu_fd_sc_mcu7t5v0__fillcap_4
X_2131_ _2603_/A2 _2737_/A1 _2132_/I VDD VDD VSS VSS gf180mcu_fd_sc_mcu7t5v0__and2_1
XFILLER_66_313 VDD VDD VSS VSS gf180mcu_fd_sc_mcu7t5v0__fill_2
XFILLER_93_132 VDD VDD VSS VSS gf180mcu_fd_sc_mcu7t5v0__fillcap_8
X_2062_ _2015_/B _2420_/B _2424_/C _3039_/D VDD VDD VSS VSS gf180mcu_fd_sc_mcu7t5v0__oai21_1
XTAP_TAPCELL_ROW_105_1336 VDD VSS gf180mcu_fd_sc_mcu7t5v0__filltie
XFILLER_81_349 VDD VDD VSS VSS gf180mcu_fd_sc_mcu7t5v0__fill_1
XFILLER_50_703 VDD VDD VSS VSS gf180mcu_fd_sc_mcu7t5v0__fill_1
X_2964_ _2964_/D _2984_/CLK _2964_/Q VDD VDD VSS VSS gf180mcu_fd_sc_mcu7t5v0__dffq_1
XFILLER_22_438 VDD VDD VSS VSS gf180mcu_fd_sc_mcu7t5v0__fill_2
X_1915_ _3117_/Q _2941_/Q _1916_/S _2941_/D VDD VDD VSS VSS gf180mcu_fd_sc_mcu7t5v0__mux2_2
X_2895_ _2895_/D _2926_/CLK _2895_/Q VDD VDD VSS VSS gf180mcu_fd_sc_mcu7t5v0__dffq_1
X_1846_ _3283_/Q _2882_/Q _1850_/S _2882_/D VDD VDD VSS VSS gf180mcu_fd_sc_mcu7t5v0__mux2_2
X_1777_ _1851_/A1 _1777_/A2 _1785_/S VDD VDD VSS VSS gf180mcu_fd_sc_mcu7t5v0__and2_1
XTAP_TAPCELL_ROW_73_1004 VDD VSS gf180mcu_fd_sc_mcu7t5v0__filltie
XPHY_EDGE_ROW_4_Right_4 VDD VSS gf180mcu_fd_sc_mcu7t5v0__endcap
XFILLER_89_449 VDD VDD VSS VSS gf180mcu_fd_sc_mcu7t5v0__fill_2
X_3378_ hold54/Z input1/Z _3408_/CLK _3378_/Q VDD VDD VSS VSS gf180mcu_fd_sc_mcu7t5v0__dffrnq_1
X_2329_ _2407_/A1 _2329_/A2 _2407_/B _2329_/C _2330_/B VDD VDD VSS VSS gf180mcu_fd_sc_mcu7t5v0__oai211_1
XFILLER_57_368 VDD VDD VSS VSS gf180mcu_fd_sc_mcu7t5v0__fillcap_4
XFILLER_27_69 VDD VDD VSS VSS gf180mcu_fd_sc_mcu7t5v0__fill_1
XTAP_TAPCELL_ROW_84_1111 VDD VSS gf180mcu_fd_sc_mcu7t5v0__filltie
XFILLER_26_733 VDD VDD VSS VSS gf180mcu_fd_sc_mcu7t5v0__fill_2
XFILLER_13_416 VDD VDD VSS VSS gf180mcu_fd_sc_mcu7t5v0__fillcap_4
XFILLER_25_276 VDD VDD VSS VSS gf180mcu_fd_sc_mcu7t5v0__fillcap_4
XTAP_TAPCELL_ROW_23_477 VDD VSS gf180mcu_fd_sc_mcu7t5v0__filltie
XFILLER_104_2 VDD VDD VSS VSS gf180mcu_fd_sc_mcu7t5v0__fillcap_32
XFILLER_0_342 VDD VDD VSS VSS gf180mcu_fd_sc_mcu7t5v0__fillcap_32
XFILLER_88_471 VDD VDD VSS VSS gf180mcu_fd_sc_mcu7t5v0__fillcap_32
XFILLER_48_313 VDD VDD VSS VSS gf180mcu_fd_sc_mcu7t5v0__fill_2
XFILLER_68_98 VDD VDD VSS VSS gf180mcu_fd_sc_mcu7t5v0__fillcap_4
XTAP_TAPCELL_ROW_59_853 VDD VSS gf180mcu_fd_sc_mcu7t5v0__filltie
XFILLER_91_636 VDD VDD VSS VSS gf180mcu_fd_sc_mcu7t5v0__fill_2
XFILLER_90_113 VDD VDD VSS VSS gf180mcu_fd_sc_mcu7t5v0__fillcap_16
XFILLER_90_102 VDD VDD VSS VSS gf180mcu_fd_sc_mcu7t5v0__fill_2
XFILLER_32_758 VDD VDD VSS VSS gf180mcu_fd_sc_mcu7t5v0__fillcap_4
XFILLER_44_585 VDD VDD VSS VSS gf180mcu_fd_sc_mcu7t5v0__fillcap_8
XFILLER_8_420 VDD VDD VSS VSS gf180mcu_fd_sc_mcu7t5v0__fillcap_4
XFILLER_31_279 VDD VDD VSS VSS gf180mcu_fd_sc_mcu7t5v0__fill_1
XTAP_TAPCELL_ROW_100_1288 VDD VSS gf180mcu_fd_sc_mcu7t5v0__filltie
X_1700_ _1700_/I0 _2765_/Q _1710_/S _2765_/D VDD VDD VSS VSS gf180mcu_fd_sc_mcu7t5v0__mux2_2
X_2680_ _2680_/A1 _2683_/C _2658_/Z _3072_/Q _2680_/C _2681_/B2 VDD VDD VSS VSS gf180mcu_fd_sc_mcu7t5v0__aoi221_1
X_1631_ _3129_/Q _3130_/Q _1633_/A4 VDD VDD VSS VSS gf180mcu_fd_sc_mcu7t5v0__nor2_1
X_3301_ _3301_/D _3303_/RN _3410_/CLK _3301_/Q VDD VDD VSS VSS gf180mcu_fd_sc_mcu7t5v0__dffrnq_1
X_1562_ _1562_/A1 _1571_/A2 _1562_/B _1562_/C _1566_/A2 VDD VDD VSS VSS gf180mcu_fd_sc_mcu7t5v0__aoi211_1
X_1493_ _3364_/Q _1494_/A2 _1495_/A2 VDD VDD VSS VSS gf180mcu_fd_sc_mcu7t5v0__nor2_1
X_3232_ _3232_/D _3328_/RN _3240_/CLK _3232_/Q VDD VDD VSS VSS gf180mcu_fd_sc_mcu7t5v0__dffrnq_1
X_3163_ _3163_/D _3369_/RN _3325_/CLK _3163_/Q VDD VDD VSS VSS gf180mcu_fd_sc_mcu7t5v0__dffrnq_1
X_2114_ _3059_/Q _3060_/Q _2114_/Z VDD VDD VSS VSS gf180mcu_fd_sc_mcu7t5v0__and2_1
XFILLER_39_368 VDD VDD VSS VSS gf180mcu_fd_sc_mcu7t5v0__fill_2
XFILLER_94_474 VDD VDD VSS VSS gf180mcu_fd_sc_mcu7t5v0__fill_1
X_3094_ _3094_/D _3328_/RN _3276_/CLK _3094_/Q VDD VDD VSS VSS gf180mcu_fd_sc_mcu7t5v0__dffrnq_1
XFILLER_67_699 VDD VDD VSS VSS gf180mcu_fd_sc_mcu7t5v0__fill_1
X_2045_ _3032_/Q _2023_/B _2045_/A3 _2046_/B VDD VDD VSS VSS gf180mcu_fd_sc_mcu7t5v0__nand3_1
XFILLER_81_146 VDD VDD VSS VSS gf180mcu_fd_sc_mcu7t5v0__fill_2
X_2947_ _2947_/D _3253_/CLK _2947_/Q VDD VDD VSS VSS gf180mcu_fd_sc_mcu7t5v0__dffq_1
XTAP_TAPCELL_ROW_20_447 VDD VSS gf180mcu_fd_sc_mcu7t5v0__filltie
X_2878_ _2878_/D _2891_/CLK _2878_/Q VDD VDD VSS VSS gf180mcu_fd_sc_mcu7t5v0__dffq_1
X_1829_ _3284_/Q _2867_/Q _1832_/S _2867_/D VDD VDD VSS VSS gf180mcu_fd_sc_mcu7t5v0__mux2_2
XFILLER_89_224 VDD VDD VSS VSS gf180mcu_fd_sc_mcu7t5v0__fillcap_16
XPHY_EDGE_ROW_8_Left_117 VDD VSS gf180mcu_fd_sc_mcu7t5v0__endcap
XFILLER_1_139 VDD VDD VSS VSS gf180mcu_fd_sc_mcu7t5v0__fill_1
XFILLER_89_279 VDD VDD VSS VSS gf180mcu_fd_sc_mcu7t5v0__fill_1
XTAP_TAPCELL_ROW_90_1181 VDD VSS gf180mcu_fd_sc_mcu7t5v0__filltie
XFILLER_57_110 VDD VDD VSS VSS gf180mcu_fd_sc_mcu7t5v0__fill_1
XFILLER_85_430 VDD VDD VSS VSS gf180mcu_fd_sc_mcu7t5v0__fillcap_4
XPHY_EDGE_ROW_79_Right_79 VDD VSS gf180mcu_fd_sc_mcu7t5v0__endcap
XTAP_TAPCELL_ROW_56_823 VDD VSS gf180mcu_fd_sc_mcu7t5v0__filltie
XTAP_TAPCELL_ROW_28_525 VDD VSS gf180mcu_fd_sc_mcu7t5v0__filltie
XFILLER_54_34 VDD VDD VSS VSS gf180mcu_fd_sc_mcu7t5v0__fill_1
XFILLER_72_157 VDD VDD VSS VSS gf180mcu_fd_sc_mcu7t5v0__fillcap_16
XFILLER_53_382 VDD VDD VSS VSS gf180mcu_fd_sc_mcu7t5v0__fillcap_4
XFILLER_13_268 VDD VDD VSS VSS gf180mcu_fd_sc_mcu7t5v0__fillcap_4
XFILLER_9_217 VDD VDD VSS VSS gf180mcu_fd_sc_mcu7t5v0__fillcap_4
XFILLER_21_290 VDD VDD VSS VSS gf180mcu_fd_sc_mcu7t5v0__fillcap_4
XPHY_EDGE_ROW_88_Right_88 VDD VSS gf180mcu_fd_sc_mcu7t5v0__endcap
XFILLER_79_86 VDD VDD VSS VSS gf180mcu_fd_sc_mcu7t5v0__fill_1
XFILLER_96_728 VDD VDD VSS VSS gf180mcu_fd_sc_mcu7t5v0__fillcap_4
XFILLER_95_205 VDD VDD VSS VSS gf180mcu_fd_sc_mcu7t5v0__fillcap_4
XFILLER_1_651 VDD VDD VSS VSS gf180mcu_fd_sc_mcu7t5v0__fillcap_32
XFILLER_0_172 VDD VDD VSS VSS gf180mcu_fd_sc_mcu7t5v0__fill_2
XPHY_EDGE_ROW_97_Right_97 VDD VSS gf180mcu_fd_sc_mcu7t5v0__endcap
XFILLER_95_63 VDD VDD VSS VSS gf180mcu_fd_sc_mcu7t5v0__fill_1
XFILLER_76_474 VDD VDD VSS VSS gf180mcu_fd_sc_mcu7t5v0__fillcap_32
XFILLER_48_165 VDD VDD VSS VSS gf180mcu_fd_sc_mcu7t5v0__fillcap_8
XFILLER_36_349 VDD VDD VSS VSS gf180mcu_fd_sc_mcu7t5v0__fillcap_16
XFILLER_63_124 VDD VDD VSS VSS gf180mcu_fd_sc_mcu7t5v0__fill_1
XFILLER_64_647 VDD VDD VSS VSS gf180mcu_fd_sc_mcu7t5v0__fill_2
XFILLER_17_541 VDD VDD VSS VSS gf180mcu_fd_sc_mcu7t5v0__fillcap_16
XTAP_TAPCELL_ROW_102_1306 VDD VSS gf180mcu_fd_sc_mcu7t5v0__filltie
X_2801_ _2801_/D _2887_/CLK _2801_/Q VDD VDD VSS VSS gf180mcu_fd_sc_mcu7t5v0__dffq_1
X_2732_ _3103_/Q _2732_/A2 _2732_/A3 _2733_/A2 VDD VDD VSS VSS gf180mcu_fd_sc_mcu7t5v0__nand3_1
X_2663_ _3206_/Q _2687_/A2 _2663_/B _2664_/C VDD VDD VSS VSS gf180mcu_fd_sc_mcu7t5v0__oai21_1
XFILLER_67_2 VDD VDD VSS VSS gf180mcu_fd_sc_mcu7t5v0__fillcap_8
X_1614_ _3161_/Q _3162_/Q _2508_/A2 VDD VDD VSS VSS gf180mcu_fd_sc_mcu7t5v0__nor2_1
X_2594_ _2951_/Q _2943_/Q _2935_/Q _2927_/Q _2673_/S0 _2673_/S1 _2594_/Z VDD VDD VSS
+ VSS gf180mcu_fd_sc_mcu7t5v0__mux4_1
XFILLER_5_72 VDD VDD VSS VSS gf180mcu_fd_sc_mcu7t5v0__fillcap_64
X_1545_ _3053_/Q _3054_/Q _1545_/Z VDD VDD VSS VSS gf180mcu_fd_sc_mcu7t5v0__and2_1
XFILLER_99_577 VDD VDD VSS VSS gf180mcu_fd_sc_mcu7t5v0__fillcap_8
XFILLER_59_419 VDD VDD VSS VSS gf180mcu_fd_sc_mcu7t5v0__fill_1
X_1476_ _2674_/S1 _1476_/A2 _3356_/D VDD VDD VSS VSS gf180mcu_fd_sc_mcu7t5v0__xnor2_1
X_3215_ _3215_/D _3303_/RN _3215_/CLK _3215_/Q VDD VDD VSS VSS gf180mcu_fd_sc_mcu7t5v0__dffrnq_1
X_3146_ _3146_/D _3416_/RN _3308_/CLK _3146_/Q VDD VDD VSS VSS gf180mcu_fd_sc_mcu7t5v0__dffrnq_1
X_3077_ _3077_/D _3328_/RN _3240_/CLK _3077_/Q VDD VDD VSS VSS gf180mcu_fd_sc_mcu7t5v0__dffrnq_1
X_2028_ _2010_/Z _2027_/Z _2030_/A3 VDD VDD VSS VSS gf180mcu_fd_sc_mcu7t5v0__nand2_1
XFILLER_23_511 VDD VDD VSS VSS gf180mcu_fd_sc_mcu7t5v0__fill_2
XFILLER_23_566 VDD VDD VSS VSS gf180mcu_fd_sc_mcu7t5v0__fill_2
XFILLER_24_37 VDD VDD VSS VSS gf180mcu_fd_sc_mcu7t5v0__fillcap_8
XTAP_TAPCELL_ROW_61_870 VDD VSS gf180mcu_fd_sc_mcu7t5v0__filltie
XTAP_TAPCELL_ROW_33_583 VDD VSS gf180mcu_fd_sc_mcu7t5v0__filltie
XFILLER_108_104 VDD VDD VSS VSS gf180mcu_fd_sc_mcu7t5v0__fillcap_32
XFILLER_6_209 VDD VDD VSS VSS gf180mcu_fd_sc_mcu7t5v0__fillcap_8
XFILLER_40_14 VDD VDD VSS VSS gf180mcu_fd_sc_mcu7t5v0__fill_2
XTAP_TAPCELL_ROW_79_1065 VDD VSS gf180mcu_fd_sc_mcu7t5v0__filltie
XFILLER_40_69 VDD VDD VSS VSS gf180mcu_fd_sc_mcu7t5v0__fill_1
XFILLER_104_365 VDD VDD VSS VSS gf180mcu_fd_sc_mcu7t5v0__fillcap_16
XFILLER_77_238 VDD VDD VSS VSS gf180mcu_fd_sc_mcu7t5v0__fillcap_16
XFILLER_58_452 VDD VDD VSS VSS gf180mcu_fd_sc_mcu7t5v0__fill_2
XTAP_TAPCELL_ROW_5_286 VDD VSS gf180mcu_fd_sc_mcu7t5v0__filltie
XFILLER_85_282 VDD VDD VSS VSS gf180mcu_fd_sc_mcu7t5v0__fillcap_16
XFILLER_45_135 VDD VDD VSS VSS gf180mcu_fd_sc_mcu7t5v0__fillcap_4
XFILLER_73_422 VDD VDD VSS VSS gf180mcu_fd_sc_mcu7t5v0__fillcap_32
XFILLER_61_617 VDD VDD VSS VSS gf180mcu_fd_sc_mcu7t5v0__fillcap_8
XFILLER_26_382 VDD VDD VSS VSS gf180mcu_fd_sc_mcu7t5v0__fill_2
XFILLER_41_330 VDD VDD VSS VSS gf180mcu_fd_sc_mcu7t5v0__fillcap_8
XFILLER_14_588 VDD VDD VSS VSS gf180mcu_fd_sc_mcu7t5v0__fillcap_4
XFILLER_41_363 VDD VDD VSS VSS gf180mcu_fd_sc_mcu7t5v0__fill_1
XFILLER_10_761 VDD VDD VSS VSS gf180mcu_fd_sc_mcu7t5v0__fillcap_4
XFILLER_108_682 VDD VDD VSS VSS gf180mcu_fd_sc_mcu7t5v0__fillcap_16
XFILLER_69_728 VDD VDD VSS VSS gf180mcu_fd_sc_mcu7t5v0__fill_1
XFILLER_1_470 VDD VDD VSS VSS gf180mcu_fd_sc_mcu7t5v0__fillcap_4
X_3000_ _3000_/D _3016_/CLK _3000_/Q VDD VDD VSS VSS gf180mcu_fd_sc_mcu7t5v0__dffq_1
XFILLER_91_252 VDD VDD VSS VSS gf180mcu_fd_sc_mcu7t5v0__fillcap_16
XFILLER_45_680 VDD VDD VSS VSS gf180mcu_fd_sc_mcu7t5v0__fill_2
XFILLER_64_488 VDD VDD VSS VSS gf180mcu_fd_sc_mcu7t5v0__fill_1
XFILLER_60_683 VDD VDD VSS VSS gf180mcu_fd_sc_mcu7t5v0__fill_1
Xclkbuf_4_15_0_host_clk_i clkbuf_0_host_clk_i/Z _3408_/CLK VDD VDD VSS VSS gf180mcu_fd_sc_mcu7t5v0__clkbuf_4
XTAP_TAPCELL_ROW_30_553 VDD VSS gf180mcu_fd_sc_mcu7t5v0__filltie
X_2715_ _3269_/Q _2680_/C _2729_/B1 _3087_/Q _2716_/I VDD VDD VSS VSS gf180mcu_fd_sc_mcu7t5v0__aoi22_1
X_2646_ _2644_/Z _2645_/Z _2642_/Z _2643_/Z _3353_/Q _3354_/Q _2646_/Z VDD VDD VSS
+ VSS gf180mcu_fd_sc_mcu7t5v0__mux4_1
XFILLER_99_341 VDD VDD VSS VSS gf180mcu_fd_sc_mcu7t5v0__fill_1
XFILLER_99_352 VDD VDD VSS VSS gf180mcu_fd_sc_mcu7t5v0__fillcap_8
X_2577_ _3195_/Q _3237_/Q _2585_/S _3237_/D VDD VDD VSS VSS gf180mcu_fd_sc_mcu7t5v0__mux2_2
X_1528_ _1528_/A1 _1528_/A2 _3304_/D VDD VDD VSS VSS gf180mcu_fd_sc_mcu7t5v0__nand2_1
XFILLER_59_205 VDD VDD VSS VSS gf180mcu_fd_sc_mcu7t5v0__fillcap_4
XFILLER_87_558 VDD VDD VSS VSS gf180mcu_fd_sc_mcu7t5v0__fill_2
X_1459_ _3404_/Q _1455_/I _3405_/Q _1466_/A2 VDD VDD VSS VSS gf180mcu_fd_sc_mcu7t5v0__aoi21_1
XPHY_EDGE_ROW_98_Left_207 VDD VSS gf180mcu_fd_sc_mcu7t5v0__endcap
XFILLER_68_761 VDD VDD VSS VSS gf180mcu_fd_sc_mcu7t5v0__fillcap_4
XFILLER_74_219 VDD VDD VSS VSS gf180mcu_fd_sc_mcu7t5v0__fill_1
XTAP_TAPCELL_ROW_2_256 VDD VSS gf180mcu_fd_sc_mcu7t5v0__filltie
XFILLER_28_636 VDD VDD VSS VSS gf180mcu_fd_sc_mcu7t5v0__fill_2
XFILLER_28_647 VDD VDD VSS VSS gf180mcu_fd_sc_mcu7t5v0__fillcap_4
XTAP_TAPCELL_ROW_38_631 VDD VSS gf180mcu_fd_sc_mcu7t5v0__filltie
XFILLER_55_422 VDD VDD VSS VSS gf180mcu_fd_sc_mcu7t5v0__fillcap_4
XFILLER_55_411 VDD VDD VSS VSS gf180mcu_fd_sc_mcu7t5v0__fillcap_8
XFILLER_67_282 VDD VDD VSS VSS gf180mcu_fd_sc_mcu7t5v0__fillcap_4
X_3129_ _3129_/D _3416_/RN _3131_/CLK _3129_/Q VDD VDD VSS VSS gf180mcu_fd_sc_mcu7t5v0__dffrnq_1
XFILLER_83_764 VDD VDD VSS VSS gf180mcu_fd_sc_mcu7t5v0__fill_1
XFILLER_82_230 VDD VDD VSS VSS gf180mcu_fd_sc_mcu7t5v0__fillcap_4
XFILLER_55_488 VDD VDD VSS VSS gf180mcu_fd_sc_mcu7t5v0__fill_2
XFILLER_35_69 VDD VDD VSS VSS gf180mcu_fd_sc_mcu7t5v0__fill_1
XFILLER_70_447 VDD VDD VSS VSS gf180mcu_fd_sc_mcu7t5v0__fillcap_8
XFILLER_23_352 VDD VDD VSS VSS gf180mcu_fd_sc_mcu7t5v0__fillcap_4
XFILLER_23_374 VDD VDD VSS VSS gf180mcu_fd_sc_mcu7t5v0__fillcap_4
XFILLER_51_694 VDD VDD VSS VSS gf180mcu_fd_sc_mcu7t5v0__fillcap_4
XFILLER_51_68 VDD VDD VSS VSS gf180mcu_fd_sc_mcu7t5v0__fill_2
XFILLER_3_702 VDD VDD VSS VSS gf180mcu_fd_sc_mcu7t5v0__fillcap_8
XFILLER_76_43 VDD VDD VSS VSS gf180mcu_fd_sc_mcu7t5v0__fill_2
XFILLER_76_54 VDD VDD VSS VSS gf180mcu_fd_sc_mcu7t5v0__fill_1
XFILLER_58_282 VDD VDD VSS VSS gf180mcu_fd_sc_mcu7t5v0__fill_1
XFILLER_58_271 VDD VDD VSS VSS gf180mcu_fd_sc_mcu7t5v0__fill_2
XFILLER_74_753 VDD VDD VSS VSS gf180mcu_fd_sc_mcu7t5v0__fillcap_8
XFILLER_92_86 VDD VDD VSS VSS gf180mcu_fd_sc_mcu7t5v0__fill_1
XFILLER_61_458 VDD VDD VSS VSS gf180mcu_fd_sc_mcu7t5v0__fill_2
XTAP_TAPCELL_ROW_72_987 VDD VSS gf180mcu_fd_sc_mcu7t5v0__filltie
X_2500_ _3164_/Q _3324_/Q wire13/Z _3164_/D VDD VDD VSS VSS gf180mcu_fd_sc_mcu7t5v0__mux2_2
X_2431_ _3146_/Q _2431_/A2 _2431_/B _2432_/A3 VDD VDD VSS VSS gf180mcu_fd_sc_mcu7t5v0__aoi21_1
X_2362_ _2794_/Q _2786_/Q _2778_/Q _2770_/Q _2404_/S0 _2404_/S1 _2362_/Z VDD VDD VSS
+ VSS gf180mcu_fd_sc_mcu7t5v0__mux4_1
X_2293_ _2438_/A2 _2293_/A2 _2293_/B _2414_/B _2313_/A1 VDD VDD VSS VSS gf180mcu_fd_sc_mcu7t5v0__oai211_1
XFILLER_69_547 VDD VDD VSS VSS gf180mcu_fd_sc_mcu7t5v0__fillcap_8
XFILLER_49_282 VDD VDD VSS VSS gf180mcu_fd_sc_mcu7t5v0__fillcap_4
XFILLER_64_241 VDD VDD VSS VSS gf180mcu_fd_sc_mcu7t5v0__fillcap_4
XTAP_TAPCELL_ROW_108_1378 VDD VSS gf180mcu_fd_sc_mcu7t5v0__filltie
XTAP_TAPCELL_ROW_108_1367 VDD VSS gf180mcu_fd_sc_mcu7t5v0__filltie
XFILLER_80_734 VDD VDD VSS VSS gf180mcu_fd_sc_mcu7t5v0__fill_1
XTAP_TAPCELL_ROW_35_601 VDD VSS gf180mcu_fd_sc_mcu7t5v0__filltie
XFILLER_32_171 VDD VDD VSS VSS gf180mcu_fd_sc_mcu7t5v0__fillcap_4
XFILLER_32_193 VDD VDD VSS VSS gf180mcu_fd_sc_mcu7t5v0__fill_1
XFILLER_33_694 VDD VDD VSS VSS gf180mcu_fd_sc_mcu7t5v0__fillcap_4
XTAP_TAPCELL_ROW_15_391 VDD VSS gf180mcu_fd_sc_mcu7t5v0__filltie
Xclkbuf_leaf_8_clk_i clkload0/I _3222_/CLK VDD VDD VSS VSS gf180mcu_fd_sc_mcu7t5v0__clkbuf_4
XTAP_TAPCELL_ROW_76_1035 VDD VSS gf180mcu_fd_sc_mcu7t5v0__filltie
XTAP_TAPCELL_ROW_7_304 VDD VSS gf180mcu_fd_sc_mcu7t5v0__filltie
X_2629_ _2629_/A1 _2629_/A2 _3248_/D VDD VDD VSS VSS gf180mcu_fd_sc_mcu7t5v0__nand2_1
XFILLER_0_716 VDD VDD VSS VSS gf180mcu_fd_sc_mcu7t5v0__fillcap_32
XFILLER_87_377 VDD VDD VSS VSS gf180mcu_fd_sc_mcu7t5v0__fillcap_32
XFILLER_47_208 VDD VDD VSS VSS gf180mcu_fd_sc_mcu7t5v0__fill_2
Xmax_cap14 _2760_/S _2763_/S VDD VDD VSS VSS gf180mcu_fd_sc_mcu7t5v0__buf_4
XFILLER_56_753 VDD VDD VSS VSS gf180mcu_fd_sc_mcu7t5v0__fillcap_8
XFILLER_15_138 VDD VDD VSS VSS gf180mcu_fd_sc_mcu7t5v0__fill_2
XFILLER_24_661 VDD VDD VSS VSS gf180mcu_fd_sc_mcu7t5v0__fillcap_4
XFILLER_30_119 VDD VDD VSS VSS gf180mcu_fd_sc_mcu7t5v0__fill_2
XFILLER_62_34 VDD VDD VSS VSS gf180mcu_fd_sc_mcu7t5v0__fill_1
XFILLER_70_255 VDD VDD VSS VSS gf180mcu_fd_sc_mcu7t5v0__fill_2
XFILLER_51_480 VDD VDD VSS VSS gf180mcu_fd_sc_mcu7t5v0__fillcap_8
XFILLER_11_344 VDD VDD VSS VSS gf180mcu_fd_sc_mcu7t5v0__fillcap_4
XFILLER_11_388 VDD VDD VSS VSS gf180mcu_fd_sc_mcu7t5v0__fill_2
XTAP_TAPCELL_ROW_98_1260 VDD VSS gf180mcu_fd_sc_mcu7t5v0__filltie
XFILLER_105_471 VDD VDD VSS VSS gf180mcu_fd_sc_mcu7t5v0__fill_1
XFILLER_87_53 VDD VDD VSS VSS gf180mcu_fd_sc_mcu7t5v0__fillcap_8
XFILLER_19_422 VDD VDD VSS VSS gf180mcu_fd_sc_mcu7t5v0__fillcap_16
XFILLER_19_400 VDD VDD VSS VSS gf180mcu_fd_sc_mcu7t5v0__fillcap_4
XTAP_TAPCELL_ROW_49_748 VDD VSS gf180mcu_fd_sc_mcu7t5v0__filltie
XFILLER_74_550 VDD VDD VSS VSS gf180mcu_fd_sc_mcu7t5v0__fillcap_32
XFILLER_74_594 VDD VDD VSS VSS gf180mcu_fd_sc_mcu7t5v0__fill_1
XFILLER_61_222 VDD VDD VSS VSS gf180mcu_fd_sc_mcu7t5v0__fill_1
X_2980_ _2980_/D _2988_/CLK _2980_/Q VDD VDD VSS VSS gf180mcu_fd_sc_mcu7t5v0__dffq_1
X_1931_ _3115_/Q _2955_/Q _1934_/S _2955_/D VDD VDD VSS VSS gf180mcu_fd_sc_mcu7t5v0__mux2_2
X_1862_ _2897_/Q _3113_/Q _1867_/S _2897_/D VDD VDD VSS VSS gf180mcu_fd_sc_mcu7t5v0__mux2_2
XTAP_TAPCELL_ROW_12_361 VDD VSS gf180mcu_fd_sc_mcu7t5v0__filltie
X_1793_ _3285_/Q _2836_/Q _1795_/S _2836_/D VDD VDD VSS VSS gf180mcu_fd_sc_mcu7t5v0__mux2_2
XFILLER_6_381 VDD VDD VSS VSS gf180mcu_fd_sc_mcu7t5v0__fillcap_4
X_2414_ _2438_/A2 _2410_/Z _2414_/B _2415_/A2 VDD VDD VSS VSS gf180mcu_fd_sc_mcu7t5v0__oai21_1
X_3394_ _3394_/D input1/Z _3399_/CLK _3394_/Q VDD VDD VSS VSS gf180mcu_fd_sc_mcu7t5v0__dffrnq_1
X_2345_ _3135_/Q _2409_/A1 _2357_/B VDD VDD VSS VSS gf180mcu_fd_sc_mcu7t5v0__nand2_1
XFILLER_96_196 VDD VDD VSS VSS gf180mcu_fd_sc_mcu7t5v0__fillcap_32
X_2276_ _3123_/Q _2267_/C _2281_/A1 VDD VDD VSS VSS gf180mcu_fd_sc_mcu7t5v0__nand2_1
XFILLER_57_528 VDD VDD VSS VSS gf180mcu_fd_sc_mcu7t5v0__fillcap_32
XFILLER_84_347 VDD VDD VSS VSS gf180mcu_fd_sc_mcu7t5v0__fillcap_4
XFILLER_38_764 VDD VDD VSS VSS gf180mcu_fd_sc_mcu7t5v0__fill_1
XFILLER_80_575 VDD VDD VSS VSS gf180mcu_fd_sc_mcu7t5v0__fill_1
XFILLER_80_597 VDD VDD VSS VSS gf180mcu_fd_sc_mcu7t5v0__fillcap_32
XFILLER_21_620 VDD VDD VSS VSS gf180mcu_fd_sc_mcu7t5v0__fillcap_8
XTAP_TAPCELL_ROW_82_1094 VDD VSS gf180mcu_fd_sc_mcu7t5v0__filltie
XFILLER_21_664 VDD VDD VSS VSS gf180mcu_fd_sc_mcu7t5v0__fillcap_16
XFILLER_20_163 VDD VDD VSS VSS gf180mcu_fd_sc_mcu7t5v0__fillcap_8
XFILLER_88_653 VDD VDD VSS VSS gf180mcu_fd_sc_mcu7t5v0__fill_1
XFILLER_0_546 VDD VDD VSS VSS gf180mcu_fd_sc_mcu7t5v0__fillcap_8
XFILLER_88_664 VDD VDD VSS VSS gf180mcu_fd_sc_mcu7t5v0__fill_1
XFILLER_88_675 VDD VDD VSS VSS gf180mcu_fd_sc_mcu7t5v0__fillcap_4
XFILLER_75_336 VDD VDD VSS VSS gf180mcu_fd_sc_mcu7t5v0__fill_1
XFILLER_57_56 VDD VDD VSS VSS gf180mcu_fd_sc_mcu7t5v0__fillcap_8
XFILLER_90_339 VDD VDD VSS VSS gf180mcu_fd_sc_mcu7t5v0__fillcap_4
XFILLER_90_317 VDD VDD VSS VSS gf180mcu_fd_sc_mcu7t5v0__fill_2
XFILLER_28_263 VDD VDD VSS VSS gf180mcu_fd_sc_mcu7t5v0__fill_2
XTAP_TAPCELL_ROW_46_718 VDD VSS gf180mcu_fd_sc_mcu7t5v0__filltie
XFILLER_83_380 VDD VDD VSS VSS gf180mcu_fd_sc_mcu7t5v0__fill_2
XFILLER_73_88 VDD VDD VSS VSS gf180mcu_fd_sc_mcu7t5v0__fillcap_8
XFILLER_78_152 VDD VDD VSS VSS gf180mcu_fd_sc_mcu7t5v0__fill_2
XFILLER_94_623 VDD VDD VSS VSS gf180mcu_fd_sc_mcu7t5v0__fill_1
XFILLER_93_100 VDD VDD VSS VSS gf180mcu_fd_sc_mcu7t5v0__fill_1
XFILLER_78_174 VDD VDD VSS VSS gf180mcu_fd_sc_mcu7t5v0__fill_1
XFILLER_39_539 VDD VDD VSS VSS gf180mcu_fd_sc_mcu7t5v0__fill_2
X_2130_ _3205_/Q _3204_/Q _3206_/Q _3207_/Q _2737_/A1 VDD VDD VSS VSS gf180mcu_fd_sc_mcu7t5v0__nor4_1
X_2061_ _3038_/Q _2061_/A2 _3038_/D VDD VDD VSS VSS gf180mcu_fd_sc_mcu7t5v0__and2_1
XFILLER_94_667 VDD VDD VSS VSS gf180mcu_fd_sc_mcu7t5v0__fillcap_16
XFILLER_66_369 VDD VDD VSS VSS gf180mcu_fd_sc_mcu7t5v0__fill_1
XFILLER_93_166 VDD VDD VSS VSS gf180mcu_fd_sc_mcu7t5v0__fill_2
XTAP_TAPCELL_ROW_105_1337 VDD VSS gf180mcu_fd_sc_mcu7t5v0__filltie
XFILLER_81_339 VDD VDD VSS VSS gf180mcu_fd_sc_mcu7t5v0__fill_1
XFILLER_34_233 VDD VDD VSS VSS gf180mcu_fd_sc_mcu7t5v0__fillcap_8
XFILLER_97_2 VDD VDD VSS VSS gf180mcu_fd_sc_mcu7t5v0__fillcap_8
X_2963_ _2963_/D _2988_/CLK _2963_/Q VDD VDD VSS VSS gf180mcu_fd_sc_mcu7t5v0__dffq_1
XFILLER_62_597 VDD VDD VSS VSS gf180mcu_fd_sc_mcu7t5v0__fillcap_4
X_1914_ _3116_/Q _2940_/Q _1916_/S _2940_/D VDD VDD VSS VSS gf180mcu_fd_sc_mcu7t5v0__mux2_2
X_2894_ _2894_/D _2894_/CLK _2894_/Q VDD VDD VSS VSS gf180mcu_fd_sc_mcu7t5v0__dffq_1
XFILLER_30_461 VDD VDD VSS VSS gf180mcu_fd_sc_mcu7t5v0__fill_2
X_1845_ _3282_/Q _2881_/Q _1850_/S _2881_/D VDD VDD VSS VSS gf180mcu_fd_sc_mcu7t5v0__mux2_2
XFILLER_8_61 VDD VDD VSS VSS gf180mcu_fd_sc_mcu7t5v0__fill_2
X_1776_ _3287_/Q _2822_/Q _1776_/S _2822_/D VDD VDD VSS VSS gf180mcu_fd_sc_mcu7t5v0__mux2_2
XFILLER_104_706 VDD VDD VSS VSS gf180mcu_fd_sc_mcu7t5v0__fillcap_4
XTAP_TAPCELL_ROW_73_1005 VDD VSS gf180mcu_fd_sc_mcu7t5v0__filltie
XFILLER_103_205 VDD VDD VSS VSS gf180mcu_fd_sc_mcu7t5v0__fillcap_4
XFILLER_89_417 VDD VDD VSS VSS gf180mcu_fd_sc_mcu7t5v0__fill_2
Xclkbuf_leaf_11_clk_i clkload2/I _3308_/CLK VDD VDD VSS VSS gf180mcu_fd_sc_mcu7t5v0__clkbuf_4
X_3377_ hold42/Z _3416_/RN _3408_/CLK _3377_/Q VDD VDD VSS VSS gf180mcu_fd_sc_mcu7t5v0__dffrnq_1
Xclkbuf_leaf_26_clk_i clkload6/I _3398_/CLK VDD VDD VSS VSS gf180mcu_fd_sc_mcu7t5v0__clkbuf_4
X_2328_ _3393_/Q _2322_/Z _2328_/B _2406_/C _2329_/C VDD VDD VSS VSS gf180mcu_fd_sc_mcu7t5v0__oai211_1
XFILLER_57_314 VDD VDD VSS VSS gf180mcu_fd_sc_mcu7t5v0__fill_2
XFILLER_69_174 VDD VDD VSS VSS gf180mcu_fd_sc_mcu7t5v0__fill_2
XFILLER_85_678 VDD VDD VSS VSS gf180mcu_fd_sc_mcu7t5v0__fillcap_16
XFILLER_27_26 VDD VDD VSS VSS gf180mcu_fd_sc_mcu7t5v0__fill_1
XFILLER_69_196 VDD VDD VSS VSS gf180mcu_fd_sc_mcu7t5v0__fillcap_8
XFILLER_84_177 VDD VDD VSS VSS gf180mcu_fd_sc_mcu7t5v0__fillcap_16
X_2259_ _3103_/Q _2254_/Z _2259_/A3 _2259_/A4 _2259_/Z VDD VDD VSS VSS gf180mcu_fd_sc_mcu7t5v0__and4_1
XFILLER_72_317 VDD VDD VSS VSS gf180mcu_fd_sc_mcu7t5v0__fillcap_32
XTAP_TAPCELL_ROW_84_1112 VDD VSS gf180mcu_fd_sc_mcu7t5v0__filltie
XFILLER_53_553 VDD VDD VSS VSS gf180mcu_fd_sc_mcu7t5v0__fillcap_4
XFILLER_43_36 VDD VDD VSS VSS gf180mcu_fd_sc_mcu7t5v0__fillcap_16
XFILLER_40_247 VDD VDD VSS VSS gf180mcu_fd_sc_mcu7t5v0__fillcap_8
XTAP_TAPCELL_ROW_51_765 VDD VSS gf180mcu_fd_sc_mcu7t5v0__filltie
XPHY_EDGE_ROW_80_Left_189 VDD VSS gf180mcu_fd_sc_mcu7t5v0__endcap
XTAP_TAPCELL_ROW_23_478 VDD VSS gf180mcu_fd_sc_mcu7t5v0__filltie
XTAP_TAPCELL_ROW_95_1230 VDD VSS gf180mcu_fd_sc_mcu7t5v0__filltie
XFILLER_88_461 VDD VDD VSS VSS gf180mcu_fd_sc_mcu7t5v0__fill_2
XFILLER_76_612 VDD VDD VSS VSS gf180mcu_fd_sc_mcu7t5v0__fillcap_32
XFILLER_0_376 VDD VDD VSS VSS gf180mcu_fd_sc_mcu7t5v0__fillcap_32
XFILLER_76_667 VDD VDD VSS VSS gf180mcu_fd_sc_mcu7t5v0__fillcap_8
XTAP_TAPCELL_ROW_59_854 VDD VSS gf180mcu_fd_sc_mcu7t5v0__filltie
XFILLER_91_626 VDD VDD VSS VSS gf180mcu_fd_sc_mcu7t5v0__fillcap_4
XFILLER_63_306 VDD VDD VSS VSS gf180mcu_fd_sc_mcu7t5v0__fillcap_4
XFILLER_90_169 VDD VDD VSS VSS gf180mcu_fd_sc_mcu7t5v0__fillcap_4
XFILLER_44_597 VDD VDD VSS VSS gf180mcu_fd_sc_mcu7t5v0__fill_2
XTAP_TAPCELL_ROW_100_1289 VDD VSS gf180mcu_fd_sc_mcu7t5v0__filltie
XFILLER_33_80 VDD VDD VSS VSS gf180mcu_fd_sc_mcu7t5v0__fill_1
X_1630_ _2197_/A1 _3412_/Q _2292_/A1 VDD VDD VSS VSS gf180mcu_fd_sc_mcu7t5v0__nand2_1
XFILLER_8_465 VDD VDD VSS VSS gf180mcu_fd_sc_mcu7t5v0__fillcap_4
X_3300_ _3300_/D _3303_/RN _3302_/CLK _3300_/Q VDD VDD VSS VSS gf180mcu_fd_sc_mcu7t5v0__dffrnq_1
X_1561_ _1561_/A1 _1537_/B _1561_/B1 _1561_/B2 _1571_/A2 VDD VDD VSS VSS gf180mcu_fd_sc_mcu7t5v0__oai22_1
XFILLER_98_247 VDD VDD VSS VSS gf180mcu_fd_sc_mcu7t5v0__fill_2
X_1492_ _1490_/Z _1498_/A2 _3365_/D VDD VDD VSS VSS gf180mcu_fd_sc_mcu7t5v0__nor2_1
X_3231_ _3231_/D _3328_/RN _3271_/CLK _3231_/Q VDD VDD VSS VSS gf180mcu_fd_sc_mcu7t5v0__dffrnq_1
X_3162_ _3162_/D _3369_/RN _3327_/CLK _3162_/Q VDD VDD VSS VSS gf180mcu_fd_sc_mcu7t5v0__dffrnq_1
XFILLER_66_100 VDD VDD VSS VSS gf180mcu_fd_sc_mcu7t5v0__fillcap_4
X_2113_ _3059_/Q _2124_/A1 _2113_/B _3059_/D VDD VDD VSS VSS gf180mcu_fd_sc_mcu7t5v0__aoi21_1
XFILLER_12_2 VDD VDD VSS VSS gf180mcu_fd_sc_mcu7t5v0__fillcap_32
XFILLER_39_347 VDD VDD VSS VSS gf180mcu_fd_sc_mcu7t5v0__fill_2
XFILLER_66_133 VDD VDD VSS VSS gf180mcu_fd_sc_mcu7t5v0__fill_1
XFILLER_67_656 VDD VDD VSS VSS gf180mcu_fd_sc_mcu7t5v0__fillcap_4
X_3093_ _3093_/D _3328_/RN _3328_/CLK _3093_/Q VDD VDD VSS VSS gf180mcu_fd_sc_mcu7t5v0__dffrnq_1
XFILLER_54_317 VDD VDD VSS VSS gf180mcu_fd_sc_mcu7t5v0__fillcap_16
XFILLER_66_177 VDD VDD VSS VSS gf180mcu_fd_sc_mcu7t5v0__fill_1
X_2044_ _3031_/Q _2048_/A4 _2046_/A3 VDD VDD VSS VSS gf180mcu_fd_sc_mcu7t5v0__nand2_1
XFILLER_81_136 VDD VDD VSS VSS gf180mcu_fd_sc_mcu7t5v0__fillcap_4
XFILLER_35_564 VDD VDD VSS VSS gf180mcu_fd_sc_mcu7t5v0__fill_1
XFILLER_23_726 VDD VDD VSS VSS gf180mcu_fd_sc_mcu7t5v0__fillcap_4
XFILLER_22_247 VDD VDD VSS VSS gf180mcu_fd_sc_mcu7t5v0__fill_1
X_2946_ _2946_/D _3313_/CLK _2946_/Q VDD VDD VSS VSS gf180mcu_fd_sc_mcu7t5v0__dffq_1
XFILLER_108_308 VDD VDD VSS VSS gf180mcu_fd_sc_mcu7t5v0__fillcap_32
X_2877_ _2877_/D _2892_/CLK _2877_/Q VDD VDD VSS VSS gf180mcu_fd_sc_mcu7t5v0__dffq_1
XTAP_TAPCELL_ROW_20_448 VDD VSS gf180mcu_fd_sc_mcu7t5v0__filltie
X_1828_ _3283_/Q _2866_/Q _1832_/S _2866_/D VDD VDD VSS VSS gf180mcu_fd_sc_mcu7t5v0__mux2_2
X_1759_ _1833_/A1 _1777_/A2 _1767_/S VDD VDD VSS VSS gf180mcu_fd_sc_mcu7t5v0__nand2_1
XTAP_TAPCELL_ROW_90_1182 VDD VSS gf180mcu_fd_sc_mcu7t5v0__filltie
XFILLER_100_731 VDD VDD VSS VSS gf180mcu_fd_sc_mcu7t5v0__fillcap_4
XFILLER_57_122 VDD VDD VSS VSS gf180mcu_fd_sc_mcu7t5v0__fillcap_16
XFILLER_58_667 VDD VDD VSS VSS gf180mcu_fd_sc_mcu7t5v0__fillcap_4
XFILLER_100_764 VDD VDD VSS VSS gf180mcu_fd_sc_mcu7t5v0__fill_1
XFILLER_72_103 VDD VDD VSS VSS gf180mcu_fd_sc_mcu7t5v0__fill_2
XTAP_TAPCELL_ROW_28_526 VDD VSS gf180mcu_fd_sc_mcu7t5v0__filltie
XTAP_TAPCELL_ROW_56_824 VDD VSS gf180mcu_fd_sc_mcu7t5v0__filltie
XFILLER_26_542 VDD VDD VSS VSS gf180mcu_fd_sc_mcu7t5v0__fillcap_16
XFILLER_54_57 VDD VDD VSS VSS gf180mcu_fd_sc_mcu7t5v0__fill_1
XFILLER_14_737 VDD VDD VSS VSS gf180mcu_fd_sc_mcu7t5v0__fillcap_16
XFILLER_26_597 VDD VDD VSS VSS gf180mcu_fd_sc_mcu7t5v0__fill_2
XFILLER_13_236 VDD VDD VSS VSS gf180mcu_fd_sc_mcu7t5v0__fillcap_4
XFILLER_107_352 VDD VDD VSS VSS gf180mcu_fd_sc_mcu7t5v0__fillcap_16
XFILLER_5_468 VDD VDD VSS VSS gf180mcu_fd_sc_mcu7t5v0__fillcap_16
XFILLER_95_228 VDD VDD VSS VSS gf180mcu_fd_sc_mcu7t5v0__fillcap_8
XFILLER_95_53 VDD VDD VSS VSS gf180mcu_fd_sc_mcu7t5v0__fillcap_8
XFILLER_88_280 VDD VDD VSS VSS gf180mcu_fd_sc_mcu7t5v0__fillcap_32
XFILLER_36_317 VDD VDD VSS VSS gf180mcu_fd_sc_mcu7t5v0__fillcap_4
XFILLER_48_177 VDD VDD VSS VSS gf180mcu_fd_sc_mcu7t5v0__fillcap_8
XTAP_TAPCELL_ROW_102_1307 VDD VSS gf180mcu_fd_sc_mcu7t5v0__filltie
XFILLER_17_597 VDD VDD VSS VSS gf180mcu_fd_sc_mcu7t5v0__fill_1
XFILLER_71_180 VDD VDD VSS VSS gf180mcu_fd_sc_mcu7t5v0__fillcap_8
X_2800_ _2800_/D _2887_/CLK _2800_/Q VDD VDD VSS VSS gf180mcu_fd_sc_mcu7t5v0__dffq_1
XFILLER_32_589 VDD VDD VSS VSS gf180mcu_fd_sc_mcu7t5v0__fillcap_4
X_2731_ _3277_/Q _2680_/C _2731_/B1 _3095_/Q _2733_/A1 VDD VDD VSS VSS gf180mcu_fd_sc_mcu7t5v0__aoi22_1
X_2662_ _3252_/Q _2680_/C _2671_/C VDD VDD VSS VSS gf180mcu_fd_sc_mcu7t5v0__nand2_1
X_1613_ _2473_/A1 _1610_/Z _2508_/A1 VDD VDD VSS VSS gf180mcu_fd_sc_mcu7t5v0__nand2_1
X_2593_ _2919_/Q _2911_/Q _2903_/Q _2895_/Q _2674_/S0 _2674_/S1 _2593_/Z VDD VDD VSS
+ VSS gf180mcu_fd_sc_mcu7t5v0__mux4_1
XFILLER_99_523 VDD VDD VSS VSS gf180mcu_fd_sc_mcu7t5v0__fill_1
X_1544_ _3051_/Q _3052_/Q _3054_/Q _1561_/B1 _1544_/Z VDD VDD VSS VSS gf180mcu_fd_sc_mcu7t5v0__or4_1
XFILLER_59_409 VDD VDD VSS VSS gf180mcu_fd_sc_mcu7t5v0__fillcap_8
X_1475_ _2673_/S1 _1478_/A3 _3352_/D VDD VDD VSS VSS gf180mcu_fd_sc_mcu7t5v0__xor2_1
X_3214_ _3214_/D _3303_/RN _3222_/CLK _3214_/Q VDD VDD VSS VSS gf180mcu_fd_sc_mcu7t5v0__dffrnq_1
XFILLER_39_133 VDD VDD VSS VSS gf180mcu_fd_sc_mcu7t5v0__fillcap_4
X_3145_ _3145_/D _3416_/RN _3423_/CLK _3145_/Q VDD VDD VSS VSS gf180mcu_fd_sc_mcu7t5v0__dffrnq_1
XFILLER_39_166 VDD VDD VSS VSS gf180mcu_fd_sc_mcu7t5v0__fillcap_4
XFILLER_55_626 VDD VDD VSS VSS gf180mcu_fd_sc_mcu7t5v0__fillcap_4
XFILLER_67_486 VDD VDD VSS VSS gf180mcu_fd_sc_mcu7t5v0__fillcap_4
X_3076_ _3076_/D _3328_/RN _3273_/CLK _3076_/Q VDD VDD VSS VSS gf180mcu_fd_sc_mcu7t5v0__dffrnq_1
XFILLER_39_188 VDD VDD VSS VSS gf180mcu_fd_sc_mcu7t5v0__fillcap_4
XFILLER_54_136 VDD VDD VSS VSS gf180mcu_fd_sc_mcu7t5v0__fillcap_4
X_2027_ _3027_/Q _2025_/Z _2027_/Z VDD VDD VSS VSS gf180mcu_fd_sc_mcu7t5v0__and2_1
XTAP_TAPCELL_ROW_61_871 VDD VSS gf180mcu_fd_sc_mcu7t5v0__filltie
X_2929_ _2929_/D _2954_/CLK _2929_/Q VDD VDD VSS VSS gf180mcu_fd_sc_mcu7t5v0__dffq_1
XTAP_TAPCELL_ROW_33_584 VDD VSS gf180mcu_fd_sc_mcu7t5v0__filltie
XFILLER_108_138 VDD VDD VSS VSS gf180mcu_fd_sc_mcu7t5v0__fillcap_32
XTAP_TAPCELL_ROW_79_1066 VDD VSS gf180mcu_fd_sc_mcu7t5v0__filltie
XFILLER_40_37 VDD VDD VSS VSS gf180mcu_fd_sc_mcu7t5v0__fillcap_4
XTAP_TAPCELL_ROW_92_1200 VDD VSS gf180mcu_fd_sc_mcu7t5v0__filltie
XFILLER_2_438 VDD VDD VSS VSS gf180mcu_fd_sc_mcu7t5v0__fillcap_16
XFILLER_78_718 VDD VDD VSS VSS gf180mcu_fd_sc_mcu7t5v0__fillcap_16
XFILLER_18_317 VDD VDD VSS VSS gf180mcu_fd_sc_mcu7t5v0__fill_2
XTAP_TAPCELL_ROW_5_287 VDD VSS gf180mcu_fd_sc_mcu7t5v0__filltie
XTAP_TAPCELL_ROW_69_960 VDD VSS gf180mcu_fd_sc_mcu7t5v0__filltie
XFILLER_73_412 VDD VDD VSS VSS gf180mcu_fd_sc_mcu7t5v0__fillcap_8
XFILLER_73_478 VDD VDD VSS VSS gf180mcu_fd_sc_mcu7t5v0__fillcap_8
XFILLER_61_629 VDD VDD VSS VSS gf180mcu_fd_sc_mcu7t5v0__fill_1
XFILLER_14_556 VDD VDD VSS VSS gf180mcu_fd_sc_mcu7t5v0__fillcap_32
XFILLER_41_320 VDD VDD VSS VSS gf180mcu_fd_sc_mcu7t5v0__fill_2
XFILLER_81_66 VDD VDD VSS VSS gf180mcu_fd_sc_mcu7t5v0__fillcap_4
XFILLER_81_88 VDD VDD VSS VSS gf180mcu_fd_sc_mcu7t5v0__fillcap_4
XFILLER_6_733 VDD VDD VSS VSS gf180mcu_fd_sc_mcu7t5v0__fill_2
XFILLER_5_254 VDD VDD VSS VSS gf180mcu_fd_sc_mcu7t5v0__fillcap_16
XFILLER_69_718 VDD VDD VSS VSS gf180mcu_fd_sc_mcu7t5v0__fillcap_8
XFILLER_68_239 VDD VDD VSS VSS gf180mcu_fd_sc_mcu7t5v0__fillcap_4
XFILLER_77_762 VDD VDD VSS VSS gf180mcu_fd_sc_mcu7t5v0__fill_2
XFILLER_76_261 VDD VDD VSS VSS gf180mcu_fd_sc_mcu7t5v0__fill_1
XFILLER_37_626 VDD VDD VSS VSS gf180mcu_fd_sc_mcu7t5v0__fillcap_4
XFILLER_24_309 VDD VDD VSS VSS gf180mcu_fd_sc_mcu7t5v0__fillcap_4
XFILLER_51_128 VDD VDD VSS VSS gf180mcu_fd_sc_mcu7t5v0__fillcap_8
XFILLER_52_629 VDD VDD VSS VSS gf180mcu_fd_sc_mcu7t5v0__fillcap_16
XTAP_TAPCELL_ROW_30_554 VDD VSS gf180mcu_fd_sc_mcu7t5v0__filltie
X_2714_ _2714_/I _3268_/D VDD VDD VSS VSS gf180mcu_fd_sc_mcu7t5v0__clkinv_1
X_2645_ _2987_/Q _2979_/Q _2971_/Q _2963_/Q _2672_/S0 _2675_/S1 _2645_/Z VDD VDD VSS
+ VSS gf180mcu_fd_sc_mcu7t5v0__mux4_1
XFILLER_99_320 VDD VDD VSS VSS gf180mcu_fd_sc_mcu7t5v0__fill_1
X_2576_ _3194_/Q _3236_/Q _2585_/S _3236_/D VDD VDD VSS VSS gf180mcu_fd_sc_mcu7t5v0__mux2_2
X_1527_ _3305_/Q _3127_/Q _1527_/B1 _3304_/Q _1528_/A2 VDD VDD VSS VSS gf180mcu_fd_sc_mcu7t5v0__aoi22_1
XFILLER_101_325 VDD VDD VSS VSS gf180mcu_fd_sc_mcu7t5v0__fillcap_8
X_1458_ _3405_/Q _3404_/Q _1455_/I _1458_/Z VDD VDD VSS VSS gf180mcu_fd_sc_mcu7t5v0__and3_1
X_3128_ _3128_/D _3416_/RN _3131_/CLK _3128_/Q VDD VDD VSS VSS gf180mcu_fd_sc_mcu7t5v0__dffrnq_1
X_1389_ _3035_/Q _1606_/B VDD VDD VSS VSS gf180mcu_fd_sc_mcu7t5v0__clkinv_1
XFILLER_95_581 VDD VDD VSS VSS gf180mcu_fd_sc_mcu7t5v0__fill_2
XFILLER_28_626 VDD VDD VSS VSS gf180mcu_fd_sc_mcu7t5v0__fillcap_4
XTAP_TAPCELL_ROW_66_930 VDD VSS gf180mcu_fd_sc_mcu7t5v0__filltie
XFILLER_82_253 VDD VDD VSS VSS gf180mcu_fd_sc_mcu7t5v0__fillcap_8
XTAP_TAPCELL_ROW_2_257 VDD VSS gf180mcu_fd_sc_mcu7t5v0__filltie
XTAP_TAPCELL_ROW_38_632 VDD VSS gf180mcu_fd_sc_mcu7t5v0__filltie
X_3059_ _3059_/D _3416_/RN _3425_/CLK _3059_/Q VDD VDD VSS VSS gf180mcu_fd_sc_mcu7t5v0__dffrnq_1
XFILLER_43_629 VDD VDD VSS VSS gf180mcu_fd_sc_mcu7t5v0__fill_1
XFILLER_7_508 VDD VDD VSS VSS gf180mcu_fd_sc_mcu7t5v0__fillcap_8
XFILLER_3_758 VDD VDD VSS VSS gf180mcu_fd_sc_mcu7t5v0__fillcap_4
XFILLER_105_697 VDD VDD VSS VSS gf180mcu_fd_sc_mcu7t5v0__fill_2
XFILLER_93_518 VDD VDD VSS VSS gf180mcu_fd_sc_mcu7t5v0__fill_1
XFILLER_19_604 VDD VDD VSS VSS gf180mcu_fd_sc_mcu7t5v0__fillcap_16
XFILLER_65_209 VDD VDD VSS VSS gf180mcu_fd_sc_mcu7t5v0__fill_1
XFILLER_18_125 VDD VDD VSS VSS gf180mcu_fd_sc_mcu7t5v0__fill_1
XFILLER_92_10 VDD VDD VSS VSS gf180mcu_fd_sc_mcu7t5v0__fillcap_4
XFILLER_33_117 VDD VDD VSS VSS gf180mcu_fd_sc_mcu7t5v0__fillcap_8
XTAP_TAPCELL_ROW_72_988 VDD VSS gf180mcu_fd_sc_mcu7t5v0__filltie
XFILLER_10_592 VDD VDD VSS VSS gf180mcu_fd_sc_mcu7t5v0__fill_2
X_2430_ _2438_/A2 _2432_/A2 _2432_/B1 VDD VDD VSS VSS gf180mcu_fd_sc_mcu7t5v0__nor2_1
X_2361_ _2359_/Z _2360_/Z _3394_/Q _2361_/Z VDD VDD VSS VSS gf180mcu_fd_sc_mcu7t5v0__mux2_2
X_2292_ _2292_/A1 _1686_/B _2315_/A2 _2315_/A1 _2407_/B _2293_/A2 VDD VDD VSS VSS
+ gf180mcu_fd_sc_mcu7t5v0__aoi221_1
XFILLER_69_559 VDD VDD VSS VSS gf180mcu_fd_sc_mcu7t5v0__fill_1
XFILLER_84_518 VDD VDD VSS VSS gf180mcu_fd_sc_mcu7t5v0__fillcap_4
XTAP_TAPCELL_ROW_108_1379 VDD VSS gf180mcu_fd_sc_mcu7t5v0__filltie
XTAP_TAPCELL_ROW_108_1368 VDD VSS gf180mcu_fd_sc_mcu7t5v0__filltie
XTAP_TAPCELL_ROW_35_602 VDD VSS gf180mcu_fd_sc_mcu7t5v0__filltie
XTAP_TAPCELL_ROW_63_900 VDD VSS gf180mcu_fd_sc_mcu7t5v0__filltie
XFILLER_80_746 VDD VDD VSS VSS gf180mcu_fd_sc_mcu7t5v0__fillcap_16
XFILLER_24_139 VDD VDD VSS VSS gf180mcu_fd_sc_mcu7t5v0__fill_1
XFILLER_64_297 VDD VDD VSS VSS gf180mcu_fd_sc_mcu7t5v0__fillcap_4
XTAP_TAPCELL_ROW_15_392 VDD VSS gf180mcu_fd_sc_mcu7t5v0__filltie
XFILLER_20_356 VDD VDD VSS VSS gf180mcu_fd_sc_mcu7t5v0__fillcap_4
XTAP_TAPCELL_ROW_43_690 VDD VSS gf180mcu_fd_sc_mcu7t5v0__filltie
XTAP_TAPCELL_ROW_76_1036 VDD VSS gf180mcu_fd_sc_mcu7t5v0__filltie
XTAP_TAPCELL_ROW_7_305 VDD VSS gf180mcu_fd_sc_mcu7t5v0__filltie
X_2628_ _2670_/A1 _2624_/Z _2628_/B1 _2732_/A3 _2629_/A2 VDD VDD VSS VSS gf180mcu_fd_sc_mcu7t5v0__aoi22_1
XFILLER_102_612 VDD VDD VSS VSS gf180mcu_fd_sc_mcu7t5v0__fill_2
X_2559_ _3177_/Q _3219_/Q _2569_/S _3219_/D VDD VDD VSS VSS gf180mcu_fd_sc_mcu7t5v0__mux2_2
XFILLER_102_667 VDD VDD VSS VSS gf180mcu_fd_sc_mcu7t5v0__fillcap_16
XFILLER_28_401 VDD VDD VSS VSS gf180mcu_fd_sc_mcu7t5v0__fill_1
XFILLER_46_25 VDD VDD VSS VSS gf180mcu_fd_sc_mcu7t5v0__fillcap_8
XTAP_TAPCELL_ROW_87_1143 VDD VSS gf180mcu_fd_sc_mcu7t5v0__filltie
XFILLER_83_540 VDD VDD VSS VSS gf180mcu_fd_sc_mcu7t5v0__fill_1
Xmax_cap15 _2166_/S _2165_/S VDD VDD VSS VSS gf180mcu_fd_sc_mcu7t5v0__buf_8
XFILLER_83_562 VDD VDD VSS VSS gf180mcu_fd_sc_mcu7t5v0__fillcap_8
XFILLER_55_275 VDD VDD VSS VSS gf180mcu_fd_sc_mcu7t5v0__fillcap_4
XFILLER_71_702 VDD VDD VSS VSS gf180mcu_fd_sc_mcu7t5v0__fillcap_4
XFILLER_71_757 VDD VDD VSS VSS gf180mcu_fd_sc_mcu7t5v0__fillcap_8
XFILLER_24_684 VDD VDD VSS VSS gf180mcu_fd_sc_mcu7t5v0__fillcap_16
XFILLER_51_492 VDD VDD VSS VSS gf180mcu_fd_sc_mcu7t5v0__fillcap_8
XFILLER_23_194 VDD VDD VSS VSS gf180mcu_fd_sc_mcu7t5v0__fill_1
XTAP_TAPCELL_ROW_98_1261 VDD VSS gf180mcu_fd_sc_mcu7t5v0__filltie
XFILLER_11_72 VDD VDD VSS VSS gf180mcu_fd_sc_mcu7t5v0__fillcap_8
XFILLER_11_61 VDD VDD VSS VSS gf180mcu_fd_sc_mcu7t5v0__fillcap_8
XFILLER_78_301 VDD VDD VSS VSS gf180mcu_fd_sc_mcu7t5v0__fill_2
XTAP_TAPCELL_ROW_49_749 VDD VSS gf180mcu_fd_sc_mcu7t5v0__filltie
XFILLER_36_80 VDD VDD VSS VSS gf180mcu_fd_sc_mcu7t5v0__fillcap_8
XFILLER_61_212 VDD VDD VSS VSS gf180mcu_fd_sc_mcu7t5v0__fillcap_8
XFILLER_61_278 VDD VDD VSS VSS gf180mcu_fd_sc_mcu7t5v0__fill_2
X_1930_ _3114_/Q _2954_/Q _1934_/S _2954_/D VDD VDD VSS VSS gf180mcu_fd_sc_mcu7t5v0__mux2_2
XFILLER_30_643 VDD VDD VSS VSS gf180mcu_fd_sc_mcu7t5v0__fillcap_16
X_1861_ _2896_/Q _3112_/Q _1867_/S _2896_/D VDD VDD VSS VSS gf180mcu_fd_sc_mcu7t5v0__mux2_2
XTAP_TAPCELL_ROW_12_362 VDD VSS gf180mcu_fd_sc_mcu7t5v0__filltie
XFILLER_52_90 VDD VDD VSS VSS gf180mcu_fd_sc_mcu7t5v0__fillcap_8
X_1792_ _3284_/Q _2835_/Q _1795_/S _2835_/D VDD VDD VSS VSS gf180mcu_fd_sc_mcu7t5v0__mux2_2
X_3393_ _3393_/D _3416_/RN _3398_/CLK _3393_/Q VDD VDD VSS VSS gf180mcu_fd_sc_mcu7t5v0__dffrnq_1
X_2413_ _2413_/A1 _2416_/A2 _2413_/B _3140_/D VDD VDD VSS VSS gf180mcu_fd_sc_mcu7t5v0__oai21_1
XFILLER_42_2 VDD VDD VSS VSS gf180mcu_fd_sc_mcu7t5v0__fillcap_32
X_2344_ _2409_/A1 _2344_/A2 _2344_/B _3134_/D VDD VDD VSS VSS gf180mcu_fd_sc_mcu7t5v0__oai21_1
XFILLER_69_312 VDD VDD VSS VSS gf180mcu_fd_sc_mcu7t5v0__fill_2
X_2275_ _3415_/Q _3122_/Q _2275_/S _3122_/D VDD VDD VSS VSS gf180mcu_fd_sc_mcu7t5v0__mux2_2
XFILLER_80_510 VDD VDD VSS VSS gf180mcu_fd_sc_mcu7t5v0__fillcap_8
XFILLER_25_415 VDD VDD VSS VSS gf180mcu_fd_sc_mcu7t5v0__fillcap_4
XFILLER_65_562 VDD VDD VSS VSS gf180mcu_fd_sc_mcu7t5v0__fillcap_4
XFILLER_37_286 VDD VDD VSS VSS gf180mcu_fd_sc_mcu7t5v0__fillcap_32
XFILLER_33_470 VDD VDD VSS VSS gf180mcu_fd_sc_mcu7t5v0__fillcap_8
XTAP_TAPCELL_ROW_82_1095 VDD VSS gf180mcu_fd_sc_mcu7t5v0__filltie
XFILLER_21_632 VDD VDD VSS VSS gf180mcu_fd_sc_mcu7t5v0__fillcap_32
XFILLER_33_492 VDD VDD VSS VSS gf180mcu_fd_sc_mcu7t5v0__fill_1
XFILLER_107_726 VDD VDD VSS VSS gf180mcu_fd_sc_mcu7t5v0__fillcap_4
XFILLER_88_621 VDD VDD VSS VSS gf180mcu_fd_sc_mcu7t5v0__fillcap_32
XFILLER_87_120 VDD VDD VSS VSS gf180mcu_fd_sc_mcu7t5v0__fillcap_16
XFILLER_87_142 VDD VDD VSS VSS gf180mcu_fd_sc_mcu7t5v0__fillcap_8
XFILLER_102_497 VDD VDD VSS VSS gf180mcu_fd_sc_mcu7t5v0__fillcap_16
XFILLER_75_326 VDD VDD VSS VSS gf180mcu_fd_sc_mcu7t5v0__fillcap_8
XFILLER_57_68 VDD VDD VSS VSS gf180mcu_fd_sc_mcu7t5v0__fill_2
XFILLER_43_201 VDD VDD VSS VSS gf180mcu_fd_sc_mcu7t5v0__fillcap_8
XTAP_TAPCELL_ROW_46_719 VDD VSS gf180mcu_fd_sc_mcu7t5v0__filltie
XFILLER_12_621 VDD VDD VSS VSS gf180mcu_fd_sc_mcu7t5v0__fillcap_4
XTAP_TAPCELL_ROW_54_796 VDD VSS gf180mcu_fd_sc_mcu7t5v0__filltie
XFILLER_11_120 VDD VDD VSS VSS gf180mcu_fd_sc_mcu7t5v0__fillcap_4
XFILLER_8_658 VDD VDD VSS VSS gf180mcu_fd_sc_mcu7t5v0__fillcap_4
XFILLER_7_124 VDD VDD VSS VSS gf180mcu_fd_sc_mcu7t5v0__fillcap_16
XFILLER_79_632 VDD VDD VSS VSS gf180mcu_fd_sc_mcu7t5v0__fillcap_16
XFILLER_79_676 VDD VDD VSS VSS gf180mcu_fd_sc_mcu7t5v0__fillcap_8
XFILLER_94_613 VDD VDD VSS VSS gf180mcu_fd_sc_mcu7t5v0__fillcap_8
Xclkbuf_leaf_7_clk_i clkload0/I _3215_/CLK VDD VDD VSS VSS gf180mcu_fd_sc_mcu7t5v0__clkbuf_4
X_2060_ _3037_/Q _2061_/A2 _3037_/D VDD VDD VSS VSS gf180mcu_fd_sc_mcu7t5v0__and2_1
XFILLER_94_646 VDD VDD VSS VSS gf180mcu_fd_sc_mcu7t5v0__fill_2
XFILLER_66_359 VDD VDD VSS VSS gf180mcu_fd_sc_mcu7t5v0__fillcap_8
XFILLER_47_562 VDD VDD VSS VSS gf180mcu_fd_sc_mcu7t5v0__fillcap_16
XTAP_TAPCELL_ROW_17_410 VDD VSS gf180mcu_fd_sc_mcu7t5v0__filltie
XFILLER_35_746 VDD VDD VSS VSS gf180mcu_fd_sc_mcu7t5v0__fillcap_16
XFILLER_62_521 VDD VDD VSS VSS gf180mcu_fd_sc_mcu7t5v0__fillcap_4
XTAP_TAPCELL_ROW_105_1338 VDD VSS gf180mcu_fd_sc_mcu7t5v0__filltie
X_2962_ _2962_/D _2984_/CLK _2962_/Q VDD VDD VSS VSS gf180mcu_fd_sc_mcu7t5v0__dffq_1
XFILLER_50_749 VDD VDD VSS VSS gf180mcu_fd_sc_mcu7t5v0__fillcap_16
X_1913_ _3115_/Q _2939_/Q _1916_/S _2939_/D VDD VDD VSS VSS gf180mcu_fd_sc_mcu7t5v0__mux2_2
X_2893_ _2893_/D _2893_/CLK _2893_/Q VDD VDD VSS VSS gf180mcu_fd_sc_mcu7t5v0__dffq_1
X_1844_ _3281_/Q _2880_/Q _1850_/S _2880_/D VDD VDD VSS VSS gf180mcu_fd_sc_mcu7t5v0__mux2_2
X_1775_ _3286_/Q _2821_/Q _1776_/S _2821_/D VDD VDD VSS VSS gf180mcu_fd_sc_mcu7t5v0__mux2_2
XFILLER_103_228 VDD VDD VSS VSS gf180mcu_fd_sc_mcu7t5v0__fill_2
XFILLER_97_462 VDD VDD VSS VSS gf180mcu_fd_sc_mcu7t5v0__fillcap_16
X_3376_ hold57/Z input1/Z _3407_/CLK _3376_/Q VDD VDD VSS VSS gf180mcu_fd_sc_mcu7t5v0__dffrnq_1
XFILLER_69_142 VDD VDD VSS VSS gf180mcu_fd_sc_mcu7t5v0__fillcap_32
X_2327_ _3393_/Q _2327_/A2 _2327_/A3 _2328_/B VDD VDD VSS VSS gf180mcu_fd_sc_mcu7t5v0__nand3_1
X_2258_ _2256_/Z _2257_/Z _2259_/A4 VDD VDD VSS VSS gf180mcu_fd_sc_mcu7t5v0__nor2_1
XFILLER_84_156 VDD VDD VSS VSS gf180mcu_fd_sc_mcu7t5v0__fillcap_16
XFILLER_38_573 VDD VDD VSS VSS gf180mcu_fd_sc_mcu7t5v0__fillcap_8
X_2189_ _1658_/Z _1679_/C _2189_/A3 _2201_/S VDD VDD VSS VSS gf180mcu_fd_sc_mcu7t5v0__nor3_1
XTAP_TAPCELL_ROW_84_1113 VDD VSS gf180mcu_fd_sc_mcu7t5v0__filltie
XFILLER_25_212 VDD VDD VSS VSS gf180mcu_fd_sc_mcu7t5v0__fillcap_64
XFILLER_80_373 VDD VDD VSS VSS gf180mcu_fd_sc_mcu7t5v0__fillcap_8
XFILLER_40_259 VDD VDD VSS VSS gf180mcu_fd_sc_mcu7t5v0__fill_2
XFILLER_21_462 VDD VDD VSS VSS gf180mcu_fd_sc_mcu7t5v0__fillcap_4
XTAP_TAPCELL_ROW_23_479 VDD VSS gf180mcu_fd_sc_mcu7t5v0__filltie
XTAP_TAPCELL_ROW_51_766 VDD VSS gf180mcu_fd_sc_mcu7t5v0__filltie
XFILLER_107_556 VDD VDD VSS VSS gf180mcu_fd_sc_mcu7t5v0__fillcap_4
XTAP_TAPCELL_ROW_95_1231 VDD VSS gf180mcu_fd_sc_mcu7t5v0__filltie
XFILLER_103_762 VDD VDD VSS VSS gf180mcu_fd_sc_mcu7t5v0__fill_2
XFILLER_88_440 VDD VDD VSS VSS gf180mcu_fd_sc_mcu7t5v0__fillcap_8
XTAP_TAPCELL_ROW_59_855 VDD VSS gf180mcu_fd_sc_mcu7t5v0__filltie
XFILLER_90_104 VDD VDD VSS VSS gf180mcu_fd_sc_mcu7t5v0__fill_1
XFILLER_84_33 VDD VDD VSS VSS gf180mcu_fd_sc_mcu7t5v0__fill_2
XFILLER_76_679 VDD VDD VSS VSS gf180mcu_fd_sc_mcu7t5v0__fill_2
XFILLER_17_702 VDD VDD VSS VSS gf180mcu_fd_sc_mcu7t5v0__fillcap_16
XFILLER_63_318 VDD VDD VSS VSS gf180mcu_fd_sc_mcu7t5v0__fillcap_32
XFILLER_71_384 VDD VDD VSS VSS gf180mcu_fd_sc_mcu7t5v0__fillcap_4
XFILLER_12_451 VDD VDD VSS VSS gf180mcu_fd_sc_mcu7t5v0__fillcap_4
XTAP_TAPCELL_ROW_100_1279 VDD VSS gf180mcu_fd_sc_mcu7t5v0__filltie
X_1560_ _1562_/C _1562_/B _1567_/A2 VDD VDD VSS VSS gf180mcu_fd_sc_mcu7t5v0__nor2_1
XFILLER_99_727 VDD VDD VSS VSS gf180mcu_fd_sc_mcu7t5v0__fillcap_4
XFILLER_4_683 VDD VDD VSS VSS gf180mcu_fd_sc_mcu7t5v0__fillcap_8
X_1491_ _3364_/Q _1494_/A2 _3365_/Q _1498_/A2 VDD VDD VSS VSS gf180mcu_fd_sc_mcu7t5v0__aoi21_1
XFILLER_79_451 VDD VDD VSS VSS gf180mcu_fd_sc_mcu7t5v0__fillcap_4
X_3230_ _3230_/D _3369_/RN _3327_/CLK _3230_/Q VDD VDD VSS VSS gf180mcu_fd_sc_mcu7t5v0__dffrnq_1
X_3161_ _3161_/D _3369_/RN _3270_/CLK _3161_/Q VDD VDD VSS VSS gf180mcu_fd_sc_mcu7t5v0__dffrnq_1
X_2112_ _3059_/Q _2115_/B _2113_/B VDD VDD VSS VSS gf180mcu_fd_sc_mcu7t5v0__nor2_1
X_3092_ _3092_/D _3369_/RN _3329_/CLK _3092_/Q VDD VDD VSS VSS gf180mcu_fd_sc_mcu7t5v0__dffrnq_1
X_2043_ _2043_/A1 _2043_/A2 _3031_/D VDD VDD VSS VSS gf180mcu_fd_sc_mcu7t5v0__nor2_1
XFILLER_47_392 VDD VDD VSS VSS gf180mcu_fd_sc_mcu7t5v0__fillcap_16
XFILLER_66_189 VDD VDD VSS VSS gf180mcu_fd_sc_mcu7t5v0__fillcap_32
XFILLER_81_148 VDD VDD VSS VSS gf180mcu_fd_sc_mcu7t5v0__fill_1
XFILLER_35_554 VDD VDD VSS VSS gf180mcu_fd_sc_mcu7t5v0__fillcap_4
XFILLER_62_384 VDD VDD VSS VSS gf180mcu_fd_sc_mcu7t5v0__fill_1
XFILLER_13_18 VDD VDD VSS VSS gf180mcu_fd_sc_mcu7t5v0__fill_1
X_2945_ _2945_/D _2958_/CLK _2945_/Q VDD VDD VSS VSS gf180mcu_fd_sc_mcu7t5v0__dffq_1
X_2876_ _2876_/D _2892_/CLK _2876_/Q VDD VDD VSS VSS gf180mcu_fd_sc_mcu7t5v0__dffq_1
XFILLER_30_281 VDD VDD VSS VSS gf180mcu_fd_sc_mcu7t5v0__fillcap_32
X_1827_ _3282_/Q _2865_/Q _1832_/S _2865_/D VDD VDD VSS VSS gf180mcu_fd_sc_mcu7t5v0__mux2_2
XTAP_TAPCELL_ROW_20_449 VDD VSS gf180mcu_fd_sc_mcu7t5v0__filltie
X_1758_ _3287_/Q _2806_/Q _1758_/S _2806_/D VDD VDD VSS VSS gf180mcu_fd_sc_mcu7t5v0__mux2_2
X_1689_ _2429_/B _1689_/A2 _1689_/A3 _1710_/S VDD VDD VSS VSS gf180mcu_fd_sc_mcu7t5v0__nand3_1
XFILLER_89_248 VDD VDD VSS VSS gf180mcu_fd_sc_mcu7t5v0__fillcap_16
XFILLER_97_270 VDD VDD VSS VSS gf180mcu_fd_sc_mcu7t5v0__fill_2
XTAP_TAPCELL_ROW_90_1183 VDD VSS gf180mcu_fd_sc_mcu7t5v0__filltie
X_3359_ _3359_/D input1/Z _3409_/CLK _3359_/Q VDD VDD VSS VSS gf180mcu_fd_sc_mcu7t5v0__dffrnq_1
XFILLER_97_292 VDD VDD VSS VSS gf180mcu_fd_sc_mcu7t5v0__fillcap_16
XFILLER_38_37 VDD VDD VSS VSS gf180mcu_fd_sc_mcu7t5v0__fillcap_16
XFILLER_73_605 VDD VDD VSS VSS gf180mcu_fd_sc_mcu7t5v0__fillcap_16
XTAP_TAPCELL_ROW_28_527 VDD VSS gf180mcu_fd_sc_mcu7t5v0__filltie
XTAP_TAPCELL_ROW_56_825 VDD VSS gf180mcu_fd_sc_mcu7t5v0__filltie
XFILLER_73_649 VDD VDD VSS VSS gf180mcu_fd_sc_mcu7t5v0__fillcap_8
XFILLER_70_79 VDD VDD VSS VSS gf180mcu_fd_sc_mcu7t5v0__fillcap_16
XFILLER_79_66 VDD VDD VSS VSS gf180mcu_fd_sc_mcu7t5v0__fillcap_4
XFILLER_103_570 VDD VDD VSS VSS gf180mcu_fd_sc_mcu7t5v0__fillcap_4
XFILLER_95_10 VDD VDD VSS VSS gf180mcu_fd_sc_mcu7t5v0__fillcap_4
XFILLER_49_624 VDD VDD VSS VSS gf180mcu_fd_sc_mcu7t5v0__fillcap_4
XFILLER_48_145 VDD VDD VSS VSS gf180mcu_fd_sc_mcu7t5v0__fillcap_4
XFILLER_49_679 VDD VDD VSS VSS gf180mcu_fd_sc_mcu7t5v0__fillcap_8
XFILLER_64_605 VDD VDD VSS VSS gf180mcu_fd_sc_mcu7t5v0__fillcap_4
XFILLER_63_115 VDD VDD VSS VSS gf180mcu_fd_sc_mcu7t5v0__fill_1
XFILLER_63_104 VDD VDD VSS VSS gf180mcu_fd_sc_mcu7t5v0__fill_2
XFILLER_64_649 VDD VDD VSS VSS gf180mcu_fd_sc_mcu7t5v0__fill_1
XFILLER_44_340 VDD VDD VSS VSS gf180mcu_fd_sc_mcu7t5v0__fillcap_16
XTAP_TAPCELL_ROW_102_1308 VDD VSS gf180mcu_fd_sc_mcu7t5v0__filltie
XFILLER_44_384 VDD VDD VSS VSS gf180mcu_fd_sc_mcu7t5v0__fill_1
Xclkbuf_leaf_10_clk_i clkload2/I _3297_/CLK VDD VDD VSS VSS gf180mcu_fd_sc_mcu7t5v0__clkbuf_4
XFILLER_72_682 VDD VDD VSS VSS gf180mcu_fd_sc_mcu7t5v0__fillcap_16
XFILLER_81_6 VDD VDD VSS VSS gf180mcu_fd_sc_mcu7t5v0__fill_2
X_2730_ _2730_/I _3276_/D VDD VDD VSS VSS gf180mcu_fd_sc_mcu7t5v0__clkinv_1
Xclkbuf_leaf_25_clk_i clkload6/I _3399_/CLK VDD VDD VSS VSS gf180mcu_fd_sc_mcu7t5v0__clkbuf_4
X_2661_ _2607_/Z _2661_/A2 _2661_/B _2661_/C _3251_/D VDD VDD VSS VSS gf180mcu_fd_sc_mcu7t5v0__oai211_1
XFILLER_9_764 VDD VDD VSS VSS gf180mcu_fd_sc_mcu7t5v0__fill_1
XFILLER_8_263 VDD VDD VSS VSS gf180mcu_fd_sc_mcu7t5v0__fillcap_8
X_1612_ _3322_/Q _3322_/D _1612_/Z VDD VDD VSS VSS gf180mcu_fd_sc_mcu7t5v0__xor2_1
X_2592_ _3015_/Q _3007_/Q _2999_/Q _2991_/Q _3351_/Q _3352_/Q _2592_/Z VDD VDD VSS
+ VSS gf180mcu_fd_sc_mcu7t5v0__mux4_1
X_1543_ _3055_/Q _3058_/Q _1546_/A3 _1561_/B1 VDD VDD VSS VSS gf180mcu_fd_sc_mcu7t5v0__nand3_1
XFILLER_99_557 VDD VDD VSS VSS gf180mcu_fd_sc_mcu7t5v0__fill_2
XFILLER_4_480 VDD VDD VSS VSS gf180mcu_fd_sc_mcu7t5v0__fillcap_4
X_1474_ _3352_/Q _1478_/A3 _1480_/A2 VDD VDD VSS VSS gf180mcu_fd_sc_mcu7t5v0__nor2_1
XFILLER_86_218 VDD VDD VSS VSS gf180mcu_fd_sc_mcu7t5v0__fillcap_8
X_3213_ _3213_/D _3369_/RN _3326_/CLK _3213_/Q VDD VDD VSS VSS gf180mcu_fd_sc_mcu7t5v0__dffrnq_1
XFILLER_95_730 VDD VDD VSS VSS gf180mcu_fd_sc_mcu7t5v0__fill_1
XFILLER_79_292 VDD VDD VSS VSS gf180mcu_fd_sc_mcu7t5v0__fillcap_8
X_3144_ _3144_/D _3416_/RN _3311_/CLK _3144_/Q VDD VDD VSS VSS gf180mcu_fd_sc_mcu7t5v0__dffrnq_1
XFILLER_94_284 VDD VDD VSS VSS gf180mcu_fd_sc_mcu7t5v0__fillcap_16
X_3075_ _3075_/D _3303_/RN clkload9/I _3075_/Q VDD VDD VSS VSS gf180mcu_fd_sc_mcu7t5v0__dffrnq_1
XFILLER_54_104 VDD VDD VSS VSS gf180mcu_fd_sc_mcu7t5v0__fill_1
X_2026_ _2010_/Z _2025_/Z _3027_/Q _2029_/B VDD VDD VSS VSS gf180mcu_fd_sc_mcu7t5v0__aoi21_1
XFILLER_82_457 VDD VDD VSS VSS gf180mcu_fd_sc_mcu7t5v0__fillcap_16
XFILLER_23_568 VDD VDD VSS VSS gf180mcu_fd_sc_mcu7t5v0__fill_1
XTAP_TAPCELL_ROW_61_872 VDD VSS gf180mcu_fd_sc_mcu7t5v0__filltie
X_2928_ _2928_/D _3324_/CLK _2928_/Q VDD VDD VSS VSS gf180mcu_fd_sc_mcu7t5v0__dffq_1
XTAP_TAPCELL_ROW_33_585 VDD VSS gf180mcu_fd_sc_mcu7t5v0__filltie
XTAP_TAPCELL_ROW_79_1067 VDD VSS gf180mcu_fd_sc_mcu7t5v0__filltie
X_2859_ _2859_/D _2892_/CLK _2859_/Q VDD VDD VSS VSS gf180mcu_fd_sc_mcu7t5v0__dffq_1
XTAP_TAPCELL_ROW_92_1201 VDD VSS gf180mcu_fd_sc_mcu7t5v0__filltie
XFILLER_77_207 VDD VDD VSS VSS gf180mcu_fd_sc_mcu7t5v0__fill_2
XFILLER_86_741 VDD VDD VSS VSS gf180mcu_fd_sc_mcu7t5v0__fill_2
XFILLER_86_763 VDD VDD VSS VSS gf180mcu_fd_sc_mcu7t5v0__fill_2
XTAP_TAPCELL_ROW_5_288 VDD VSS gf180mcu_fd_sc_mcu7t5v0__filltie
XFILLER_46_605 VDD VDD VSS VSS gf180mcu_fd_sc_mcu7t5v0__fill_1
XFILLER_58_454 VDD VDD VSS VSS gf180mcu_fd_sc_mcu7t5v0__fill_1
XTAP_TAPCELL_ROW_69_961 VDD VSS gf180mcu_fd_sc_mcu7t5v0__filltie
XFILLER_39_690 VDD VDD VSS VSS gf180mcu_fd_sc_mcu7t5v0__fillcap_8
XFILLER_60_107 VDD VDD VSS VSS gf180mcu_fd_sc_mcu7t5v0__fillcap_32
XFILLER_14_524 VDD VDD VSS VSS gf180mcu_fd_sc_mcu7t5v0__fill_1
XFILLER_26_384 VDD VDD VSS VSS gf180mcu_fd_sc_mcu7t5v0__fill_1
XFILLER_36_115 VDD VDD VSS VSS gf180mcu_fd_sc_mcu7t5v0__fillcap_4
XFILLER_91_276 VDD VDD VSS VSS gf180mcu_fd_sc_mcu7t5v0__fillcap_4
XFILLER_72_490 VDD VDD VSS VSS gf180mcu_fd_sc_mcu7t5v0__fill_2
XFILLER_32_365 VDD VDD VSS VSS gf180mcu_fd_sc_mcu7t5v0__fillcap_8
XFILLER_32_398 VDD VDD VSS VSS gf180mcu_fd_sc_mcu7t5v0__fillcap_8
XTAP_TAPCELL_ROW_30_544 VDD VSS gf180mcu_fd_sc_mcu7t5v0__filltie
XFILLER_72_2 VDD VDD VSS VSS gf180mcu_fd_sc_mcu7t5v0__fillcap_32
X_2713_ _3268_/Q _2680_/C _2729_/B1 _3086_/Q _2714_/I VDD VDD VSS VSS gf180mcu_fd_sc_mcu7t5v0__aoi22_1
X_2644_ _3019_/Q _3011_/Q _3003_/Q _2995_/Q _2673_/S0 _2673_/S1 _2644_/Z VDD VDD VSS
+ VSS gf180mcu_fd_sc_mcu7t5v0__mux4_1
XFILLER_99_310 VDD VDD VSS VSS gf180mcu_fd_sc_mcu7t5v0__fillcap_8
X_2575_ _3193_/Q _3235_/Q _2585_/S _3235_/D VDD VDD VSS VSS gf180mcu_fd_sc_mcu7t5v0__mux2_2
X_1526_ _3126_/Q _3125_/Q _3306_/Q _1526_/C _1528_/A1 VDD VDD VSS VSS gf180mcu_fd_sc_mcu7t5v0__oai211_1
XFILLER_99_398 VDD VDD VSS VSS gf180mcu_fd_sc_mcu7t5v0__fillcap_4
X_1457_ _3405_/Q _1455_/I _1719_/A2 VDD VDD VSS VSS gf180mcu_fd_sc_mcu7t5v0__nand2_1
X_1388_ _3036_/Q _2059_/A1 VDD VDD VSS VSS gf180mcu_fd_sc_mcu7t5v0__clkinv_1
X_3127_ _3127_/D _3416_/RN _3306_/CLK _3127_/Q VDD VDD VSS VSS gf180mcu_fd_sc_mcu7t5v0__dffrnq_1
XFILLER_27_126 VDD VDD VSS VSS gf180mcu_fd_sc_mcu7t5v0__fillcap_8
XFILLER_28_638 VDD VDD VSS VSS gf180mcu_fd_sc_mcu7t5v0__fill_1
XTAP_TAPCELL_ROW_66_931 VDD VSS gf180mcu_fd_sc_mcu7t5v0__filltie
XTAP_TAPCELL_ROW_2_258 VDD VSS gf180mcu_fd_sc_mcu7t5v0__filltie
XTAP_TAPCELL_ROW_38_633 VDD VSS gf180mcu_fd_sc_mcu7t5v0__filltie
X_3058_ _3058_/D _3303_/RN _3297_/CLK _3058_/Q VDD VDD VSS VSS gf180mcu_fd_sc_mcu7t5v0__dffrnq_1
X_2009_ _3039_/Q _2031_/A2 _2267_/C _2061_/A2 VDD VDD VSS VSS gf180mcu_fd_sc_mcu7t5v0__nor3_1
XFILLER_3_726 VDD VDD VSS VSS gf180mcu_fd_sc_mcu7t5v0__fillcap_32
XFILLER_105_632 VDD VDD VSS VSS gf180mcu_fd_sc_mcu7t5v0__fillcap_4
XFILLER_2_247 VDD VDD VSS VSS gf180mcu_fd_sc_mcu7t5v0__fillcap_8
XFILLER_105_665 VDD VDD VSS VSS gf180mcu_fd_sc_mcu7t5v0__fillcap_32
XFILLER_93_508 VDD VDD VSS VSS gf180mcu_fd_sc_mcu7t5v0__fillcap_8
XFILLER_100_370 VDD VDD VSS VSS gf180mcu_fd_sc_mcu7t5v0__fill_2
XFILLER_18_104 VDD VDD VSS VSS gf180mcu_fd_sc_mcu7t5v0__fill_1
XFILLER_46_457 VDD VDD VSS VSS gf180mcu_fd_sc_mcu7t5v0__fillcap_64
XFILLER_92_77 VDD VDD VSS VSS gf180mcu_fd_sc_mcu7t5v0__fillcap_4
XFILLER_42_663 VDD VDD VSS VSS gf180mcu_fd_sc_mcu7t5v0__fill_2
XTAP_TAPCELL_ROW_72_989 VDD VSS gf180mcu_fd_sc_mcu7t5v0__filltie
XFILLER_14_387 VDD VDD VSS VSS gf180mcu_fd_sc_mcu7t5v0__fillcap_8
XFILLER_6_531 VDD VDD VSS VSS gf180mcu_fd_sc_mcu7t5v0__fill_2
XFILLER_41_92 VDD VDD VSS VSS gf180mcu_fd_sc_mcu7t5v0__fill_2
XFILLER_6_597 VDD VDD VSS VSS gf180mcu_fd_sc_mcu7t5v0__fillcap_16
X_2360_ _2826_/Q _2818_/Q _2810_/Q _2802_/Q _2388_/S0 _2390_/S1 _2360_/Z VDD VDD VSS
+ VSS gf180mcu_fd_sc_mcu7t5v0__mux4_1
XFILLER_69_516 VDD VDD VSS VSS gf180mcu_fd_sc_mcu7t5v0__fill_2
XFILLER_96_335 VDD VDD VSS VSS gf180mcu_fd_sc_mcu7t5v0__fillcap_4
X_2291_ _2432_/B2 _2424_/A1 _1706_/Z _2291_/B _3127_/D VDD VDD VSS VSS gf180mcu_fd_sc_mcu7t5v0__oai31_1
XPHY_EDGE_ROW_10_Right_10 VDD VSS gf180mcu_fd_sc_mcu7t5v0__endcap
XTAP_TAPCELL_ROW_108_1369 VDD VSS gf180mcu_fd_sc_mcu7t5v0__filltie
XFILLER_80_714 VDD VDD VSS VSS gf180mcu_fd_sc_mcu7t5v0__fillcap_16
XFILLER_24_107 VDD VDD VSS VSS gf180mcu_fd_sc_mcu7t5v0__fillcap_16
XTAP_TAPCELL_ROW_35_603 VDD VSS gf180mcu_fd_sc_mcu7t5v0__filltie
XFILLER_33_674 VDD VDD VSS VSS gf180mcu_fd_sc_mcu7t5v0__fill_1
XFILLER_20_302 VDD VDD VSS VSS gf180mcu_fd_sc_mcu7t5v0__fill_2
XTAP_TAPCELL_ROW_15_393 VDD VSS gf180mcu_fd_sc_mcu7t5v0__filltie
XTAP_TAPCELL_ROW_76_1037 VDD VSS gf180mcu_fd_sc_mcu7t5v0__filltie
X_2627_ _3206_/Q _2687_/A2 _2627_/B _2628_/B1 VDD VDD VSS VSS gf180mcu_fd_sc_mcu7t5v0__oai21_1
XTAP_TAPCELL_ROW_7_306 VDD VSS gf180mcu_fd_sc_mcu7t5v0__filltie
XFILLER_0_707 VDD VDD VSS VSS gf180mcu_fd_sc_mcu7t5v0__fillcap_4
X_2558_ _3176_/Q _3218_/Q _2569_/S _3218_/D VDD VDD VSS VSS gf180mcu_fd_sc_mcu7t5v0__mux2_2
Xclkbuf_4_1_0_host_clk_i clkbuf_0_host_clk_i/Z _3314_/CLK VDD VDD VSS VSS gf180mcu_fd_sc_mcu7t5v0__clkbuf_4
X_1509_ _1628_/A1 _1507_/Z _2414_/B VDD VDD VSS VSS gf180mcu_fd_sc_mcu7t5v0__nand2_1
X_2489_ _3160_/Q _2491_/A2 _2490_/B VDD VDD VSS VSS gf180mcu_fd_sc_mcu7t5v0__nand2_1
XFILLER_87_368 VDD VDD VSS VSS gf180mcu_fd_sc_mcu7t5v0__fill_2
XFILLER_68_593 VDD VDD VSS VSS gf180mcu_fd_sc_mcu7t5v0__fill_2
XPHY_EDGE_ROW_106_Right_106 VDD VSS gf180mcu_fd_sc_mcu7t5v0__endcap
XFILLER_95_390 VDD VDD VSS VSS gf180mcu_fd_sc_mcu7t5v0__fillcap_8
XTAP_TAPCELL_ROW_87_1144 VDD VSS gf180mcu_fd_sc_mcu7t5v0__filltie
XFILLER_28_435 VDD VDD VSS VSS gf180mcu_fd_sc_mcu7t5v0__fill_2
Xmax_cap16 _1886_/S _1887_/S VDD VDD VSS VSS gf180mcu_fd_sc_mcu7t5v0__buf_4
XPHY_EDGE_ROW_12_Left_121 VDD VSS gf180mcu_fd_sc_mcu7t5v0__endcap
XTAP_TAPCELL_ROW_98_1262 VDD VSS gf180mcu_fd_sc_mcu7t5v0__filltie
XFILLER_11_84 VDD VDD VSS VSS gf180mcu_fd_sc_mcu7t5v0__fill_2
XFILLER_2_2 VDD VDD VSS VSS gf180mcu_fd_sc_mcu7t5v0__fillcap_32
XFILLER_87_88 VDD VDD VSS VSS gf180mcu_fd_sc_mcu7t5v0__fillcap_32
XPHY_EDGE_ROW_21_Left_130 VDD VSS gf180mcu_fd_sc_mcu7t5v0__endcap
XFILLER_19_468 VDD VDD VSS VSS gf180mcu_fd_sc_mcu7t5v0__fillcap_4
XFILLER_61_257 VDD VDD VSS VSS gf180mcu_fd_sc_mcu7t5v0__fillcap_4
XFILLER_15_696 VDD VDD VSS VSS gf180mcu_fd_sc_mcu7t5v0__fillcap_4
XFILLER_30_633 VDD VDD VSS VSS gf180mcu_fd_sc_mcu7t5v0__fillcap_4
X_1860_ _2895_/Q _3111_/Q _1867_/S _2895_/D VDD VDD VSS VSS gf180mcu_fd_sc_mcu7t5v0__mux2_2
XTAP_TAPCELL_ROW_12_363 VDD VSS gf180mcu_fd_sc_mcu7t5v0__filltie
XTAP_TAPCELL_ROW_40_650 VDD VSS gf180mcu_fd_sc_mcu7t5v0__filltie
X_1791_ _3283_/Q _2834_/Q _1795_/S _2834_/D VDD VDD VSS VSS gf180mcu_fd_sc_mcu7t5v0__mux2_2
X_3392_ _3392_/D _3416_/RN _3399_/CLK _3392_/Q VDD VDD VSS VSS gf180mcu_fd_sc_mcu7t5v0__dffrnq_1
X_2412_ _3140_/Q _2416_/A2 _2413_/B VDD VDD VSS VSS gf180mcu_fd_sc_mcu7t5v0__nand2_1
X_2343_ _3133_/Q _2407_/B _2343_/B _2344_/A2 VDD VDD VSS VSS gf180mcu_fd_sc_mcu7t5v0__oai21_1
XFILLER_35_2 VDD VDD VSS VSS gf180mcu_fd_sc_mcu7t5v0__fillcap_16
XFILLER_97_655 VDD VDD VSS VSS gf180mcu_fd_sc_mcu7t5v0__fill_2
XFILLER_69_346 VDD VDD VSS VSS gf180mcu_fd_sc_mcu7t5v0__fillcap_4
X_2274_ _2274_/A1 _2274_/A2 _2275_/S VDD VDD VSS VSS gf180mcu_fd_sc_mcu7t5v0__nand2_1
XFILLER_97_699 VDD VDD VSS VSS gf180mcu_fd_sc_mcu7t5v0__fill_1
XFILLER_69_379 VDD VDD VSS VSS gf180mcu_fd_sc_mcu7t5v0__fillcap_4
XFILLER_38_733 VDD VDD VSS VSS gf180mcu_fd_sc_mcu7t5v0__fill_2
XFILLER_37_243 VDD VDD VSS VSS gf180mcu_fd_sc_mcu7t5v0__fill_2
XFILLER_80_522 VDD VDD VSS VSS gf180mcu_fd_sc_mcu7t5v0__fill_2
XFILLER_52_235 VDD VDD VSS VSS gf180mcu_fd_sc_mcu7t5v0__fillcap_8
XFILLER_40_419 VDD VDD VSS VSS gf180mcu_fd_sc_mcu7t5v0__fillcap_8
XTAP_TAPCELL_ROW_82_1096 VDD VSS gf180mcu_fd_sc_mcu7t5v0__filltie
X_1989_ _3117_/Q _3005_/Q _1990_/S _3005_/D VDD VDD VSS VSS gf180mcu_fd_sc_mcu7t5v0__mux2_2
XFILLER_102_465 VDD VDD VSS VSS gf180mcu_fd_sc_mcu7t5v0__fill_2
XFILLER_90_319 VDD VDD VSS VSS gf180mcu_fd_sc_mcu7t5v0__fill_1
XTAP_TAPCELL_ROW_54_797 VDD VSS gf180mcu_fd_sc_mcu7t5v0__filltie
XFILLER_8_626 VDD VDD VSS VSS gf180mcu_fd_sc_mcu7t5v0__fillcap_32
XFILLER_11_176 VDD VDD VSS VSS gf180mcu_fd_sc_mcu7t5v0__fill_2
XFILLER_98_43 VDD VDD VSS VSS gf180mcu_fd_sc_mcu7t5v0__fillcap_8
XFILLER_39_508 VDD VDD VSS VSS gf180mcu_fd_sc_mcu7t5v0__fillcap_4
XFILLER_93_113 VDD VDD VSS VSS gf180mcu_fd_sc_mcu7t5v0__fillcap_8
XFILLER_47_80 VDD VDD VSS VSS gf180mcu_fd_sc_mcu7t5v0__fill_2
XFILLER_19_298 VDD VDD VSS VSS gf180mcu_fd_sc_mcu7t5v0__fillcap_8
XFILLER_19_276 VDD VDD VSS VSS gf180mcu_fd_sc_mcu7t5v0__fillcap_4
XTAP_TAPCELL_ROW_17_411 VDD VSS gf180mcu_fd_sc_mcu7t5v0__filltie
XTAP_TAPCELL_ROW_105_1339 VDD VSS gf180mcu_fd_sc_mcu7t5v0__filltie
X_2961_ _2961_/D _3020_/CLK _2961_/Q VDD VDD VSS VSS gf180mcu_fd_sc_mcu7t5v0__dffq_1
XFILLER_34_268 VDD VDD VSS VSS gf180mcu_fd_sc_mcu7t5v0__fillcap_16
X_1912_ _3114_/Q _2938_/Q _1916_/S _2938_/D VDD VDD VSS VSS gf180mcu_fd_sc_mcu7t5v0__mux2_2
X_2892_ _2892_/D _2892_/CLK _2892_/Q VDD VDD VSS VSS gf180mcu_fd_sc_mcu7t5v0__dffq_1
X_1843_ _3280_/Q _2879_/Q _1850_/S _2879_/D VDD VDD VSS VSS gf180mcu_fd_sc_mcu7t5v0__mux2_2
XFILLER_8_63 VDD VDD VSS VSS gf180mcu_fd_sc_mcu7t5v0__fill_1
X_1774_ _3285_/Q _2820_/Q _1776_/S _2820_/D VDD VDD VSS VSS gf180mcu_fd_sc_mcu7t5v0__mux2_2
XFILLER_7_681 VDD VDD VSS VSS gf180mcu_fd_sc_mcu7t5v0__fillcap_4
XFILLER_89_419 VDD VDD VSS VSS gf180mcu_fd_sc_mcu7t5v0__fill_1
XFILLER_97_430 VDD VDD VSS VSS gf180mcu_fd_sc_mcu7t5v0__fill_2
X_3375_ hold59/Z input1/Z _3407_/CLK _3375_/Q VDD VDD VSS VSS gf180mcu_fd_sc_mcu7t5v0__dffrnq_1
X_2326_ _3394_/Q _2325_/Z _2327_/A3 VDD VDD VSS VSS gf180mcu_fd_sc_mcu7t5v0__nand2_1
X_2257_ _3135_/Q _3099_/Q _2257_/Z VDD VDD VSS VSS gf180mcu_fd_sc_mcu7t5v0__xor2_1
XFILLER_72_308 VDD VDD VSS VSS gf180mcu_fd_sc_mcu7t5v0__fillcap_4
X_2188_ _2224_/B _2188_/A2 _2267_/C _2188_/C _2189_/A3 VDD VDD VSS VSS gf180mcu_fd_sc_mcu7t5v0__aoi211_1
XFILLER_93_680 VDD VDD VSS VSS gf180mcu_fd_sc_mcu7t5v0__fillcap_8
XTAP_TAPCELL_ROW_84_1114 VDD VSS gf180mcu_fd_sc_mcu7t5v0__filltie
XFILLER_26_725 VDD VDD VSS VSS gf180mcu_fd_sc_mcu7t5v0__fillcap_8
XFILLER_41_706 VDD VDD VSS VSS gf180mcu_fd_sc_mcu7t5v0__fill_1
XFILLER_40_227 VDD VDD VSS VSS gf180mcu_fd_sc_mcu7t5v0__fill_1
XTAP_TAPCELL_ROW_51_767 VDD VSS gf180mcu_fd_sc_mcu7t5v0__filltie
XFILLER_5_629 VDD VDD VSS VSS gf180mcu_fd_sc_mcu7t5v0__fill_1
XTAP_TAPCELL_ROW_95_1232 VDD VSS gf180mcu_fd_sc_mcu7t5v0__filltie
XFILLER_108_86 VDD VDD VSS VSS gf180mcu_fd_sc_mcu7t5v0__fillcap_16
XFILLER_88_452 VDD VDD VSS VSS gf180mcu_fd_sc_mcu7t5v0__fill_2
XFILLER_88_463 VDD VDD VSS VSS gf180mcu_fd_sc_mcu7t5v0__fill_1
XTAP_TAPCELL_ROW_59_856 VDD VSS gf180mcu_fd_sc_mcu7t5v0__filltie
XFILLER_29_541 VDD VDD VSS VSS gf180mcu_fd_sc_mcu7t5v0__fillcap_4
XFILLER_56_382 VDD VDD VSS VSS gf180mcu_fd_sc_mcu7t5v0__fill_2
XFILLER_16_257 VDD VDD VSS VSS gf180mcu_fd_sc_mcu7t5v0__fill_2
XFILLER_17_72 VDD VDD VSS VSS gf180mcu_fd_sc_mcu7t5v0__fill_1
XFILLER_71_352 VDD VDD VSS VSS gf180mcu_fd_sc_mcu7t5v0__fillcap_32
XFILLER_44_599 VDD VDD VSS VSS gf180mcu_fd_sc_mcu7t5v0__fill_1
X_1490_ _3365_/Q _3364_/Q _3119_/Q _1490_/A4 _1490_/Z VDD VDD VSS VSS gf180mcu_fd_sc_mcu7t5v0__and4_1
XFILLER_79_474 VDD VDD VSS VSS gf180mcu_fd_sc_mcu7t5v0__fillcap_4
X_3160_ _3160_/D _3369_/RN _3270_/CLK _3160_/Q VDD VDD VSS VSS gf180mcu_fd_sc_mcu7t5v0__dffrnq_1
X_2111_ _2111_/A1 _2111_/A2 _2091_/B _2115_/B VDD VDD VSS VSS gf180mcu_fd_sc_mcu7t5v0__nor3_1
X_3091_ _3091_/D _3328_/RN _3273_/CLK _3091_/Q VDD VDD VSS VSS gf180mcu_fd_sc_mcu7t5v0__dffrnq_1
XFILLER_39_349 VDD VDD VSS VSS gf180mcu_fd_sc_mcu7t5v0__fill_1
X_2042_ _2010_/Z _2048_/A4 _3031_/Q _2043_/A2 VDD VDD VSS VSS gf180mcu_fd_sc_mcu7t5v0__aoi21_1
XFILLER_82_628 VDD VDD VSS VSS gf180mcu_fd_sc_mcu7t5v0__fillcap_4
XFILLER_35_500 VDD VDD VSS VSS gf180mcu_fd_sc_mcu7t5v0__fillcap_4
XPHY_EDGE_ROW_8_Right_8 VDD VSS gf180mcu_fd_sc_mcu7t5v0__endcap
X_2944_ _2944_/D _3324_/CLK _2944_/Q VDD VDD VSS VSS gf180mcu_fd_sc_mcu7t5v0__dffq_1
X_2875_ _2875_/D _2891_/CLK _2875_/Q VDD VDD VSS VSS gf180mcu_fd_sc_mcu7t5v0__dffq_1
XTAP_TAPCELL_ROW_20_439 VDD VSS gf180mcu_fd_sc_mcu7t5v0__filltie
X_1826_ _3281_/Q _2864_/Q _1832_/S _2864_/D VDD VDD VSS VSS gf180mcu_fd_sc_mcu7t5v0__mux2_2
X_1757_ _3286_/Q _2805_/Q _1758_/S _2805_/D VDD VDD VSS VSS gf180mcu_fd_sc_mcu7t5v0__mux2_2
XFILLER_104_527 VDD VDD VSS VSS gf180mcu_fd_sc_mcu7t5v0__fillcap_4
X_1688_ _2418_/B _1688_/A2 _2218_/B _1689_/A3 VDD VDD VSS VSS gf180mcu_fd_sc_mcu7t5v0__oai21_1
XPHY_EDGE_ROW_39_Right_39 VDD VSS gf180mcu_fd_sc_mcu7t5v0__endcap
XTAP_TAPCELL_ROW_90_1184 VDD VSS gf180mcu_fd_sc_mcu7t5v0__filltie
X_3358_ _3358_/D input1/Z _3358_/CLK _3358_/Q VDD VDD VSS VSS gf180mcu_fd_sc_mcu7t5v0__dffrnq_1
X_2309_ _2312_/A2 _2309_/A2 _3130_/Q _2310_/A2 VDD VDD VSS VSS gf180mcu_fd_sc_mcu7t5v0__aoi21_1
XFILLER_85_422 VDD VDD VSS VSS gf180mcu_fd_sc_mcu7t5v0__fillcap_8
X_3289_ _3289_/D _3303_/RN _3302_/CLK _3289_/Q VDD VDD VSS VSS gf180mcu_fd_sc_mcu7t5v0__dffrnq_1
XFILLER_85_488 VDD VDD VSS VSS gf180mcu_fd_sc_mcu7t5v0__fill_2
XTAP_TAPCELL_ROW_28_528 VDD VSS gf180mcu_fd_sc_mcu7t5v0__filltie
XTAP_TAPCELL_ROW_56_826 VDD VSS gf180mcu_fd_sc_mcu7t5v0__filltie
XFILLER_54_37 VDD VDD VSS VSS gf180mcu_fd_sc_mcu7t5v0__fillcap_16
XFILLER_81_683 VDD VDD VSS VSS gf180mcu_fd_sc_mcu7t5v0__fill_2
XFILLER_26_566 VDD VDD VSS VSS gf180mcu_fd_sc_mcu7t5v0__fill_2
XFILLER_26_599 VDD VDD VSS VSS gf180mcu_fd_sc_mcu7t5v0__fill_1
XPHY_EDGE_ROW_48_Right_48 VDD VSS gf180mcu_fd_sc_mcu7t5v0__endcap
XFILLER_22_761 VDD VDD VSS VSS gf180mcu_fd_sc_mcu7t5v0__fillcap_4
XFILLER_21_282 VDD VDD VSS VSS gf180mcu_fd_sc_mcu7t5v0__fillcap_8
XFILLER_70_69 VDD VDD VSS VSS gf180mcu_fd_sc_mcu7t5v0__fill_2
XFILLER_5_404 VDD VDD VSS VSS gf180mcu_fd_sc_mcu7t5v0__fillcap_16
Xclkbuf_leaf_6_clk_i clkload0/I _3257_/CLK VDD VDD VSS VSS gf180mcu_fd_sc_mcu7t5v0__clkbuf_4
XFILLER_5_437 VDD VDD VSS VSS gf180mcu_fd_sc_mcu7t5v0__fill_2
XFILLER_102_2 VDD VDD VSS VSS gf180mcu_fd_sc_mcu7t5v0__fillcap_32
XFILLER_1_610 VDD VDD VSS VSS gf180mcu_fd_sc_mcu7t5v0__fillcap_16
XPHY_EDGE_ROW_57_Right_57 VDD VSS gf180mcu_fd_sc_mcu7t5v0__endcap
XFILLER_1_632 VDD VDD VSS VSS gf180mcu_fd_sc_mcu7t5v0__fillcap_4
XFILLER_95_22 VDD VDD VSS VSS gf180mcu_fd_sc_mcu7t5v0__fillcap_4
XFILLER_48_113 VDD VDD VSS VSS gf180mcu_fd_sc_mcu7t5v0__fillcap_32
XFILLER_95_77 VDD VDD VSS VSS gf180mcu_fd_sc_mcu7t5v0__fillcap_32
XFILLER_36_308 VDD VDD VSS VSS gf180mcu_fd_sc_mcu7t5v0__fillcap_4
XFILLER_29_360 VDD VDD VSS VSS gf180mcu_fd_sc_mcu7t5v0__fillcap_4
XFILLER_57_680 VDD VDD VSS VSS gf180mcu_fd_sc_mcu7t5v0__fillcap_16
XFILLER_64_639 VDD VDD VSS VSS gf180mcu_fd_sc_mcu7t5v0__fillcap_8
XTAP_TAPCELL_ROW_102_1309 VDD VSS gf180mcu_fd_sc_mcu7t5v0__filltie
XPHY_EDGE_ROW_66_Right_66 VDD VSS gf180mcu_fd_sc_mcu7t5v0__endcap
XPHY_EDGE_ROW_4_Left_113 VDD VSS gf180mcu_fd_sc_mcu7t5v0__endcap
XFILLER_8_231 VDD VDD VSS VSS gf180mcu_fd_sc_mcu7t5v0__fill_2
XFILLER_40_591 VDD VDD VSS VSS gf180mcu_fd_sc_mcu7t5v0__fillcap_4
X_2660_ _3069_/Q _2132_/I _2664_/B1 _3101_/Q _2661_/A2 VDD VDD VSS VSS gf180mcu_fd_sc_mcu7t5v0__aoi22_1
X_1611_ _3322_/Q _3322_/D _2440_/A2 VDD VDD VSS VSS gf180mcu_fd_sc_mcu7t5v0__nor2_1
XFILLER_60_80 VDD VDD VSS VSS gf180mcu_fd_sc_mcu7t5v0__fillcap_16
XPHY_EDGE_ROW_75_Right_75 VDD VSS gf180mcu_fd_sc_mcu7t5v0__endcap
X_2591_ _2983_/Q _2975_/Q _2967_/Q _2959_/Q _2673_/S0 _2673_/S1 _2591_/Z VDD VDD VSS
+ VSS gf180mcu_fd_sc_mcu7t5v0__mux4_1
X_1542_ _3311_/Q _2414_/B _2108_/B VDD VDD VSS VSS gf180mcu_fd_sc_mcu7t5v0__nand2_1
X_1473_ _3408_/Q _1473_/A2 _3403_/D VDD VDD VSS VSS gf180mcu_fd_sc_mcu7t5v0__xnor2_1
XFILLER_79_260 VDD VDD VSS VSS gf180mcu_fd_sc_mcu7t5v0__fillcap_4
X_3212_ _3212_/D _3369_/RN _3326_/CLK _3212_/Q VDD VDD VSS VSS gf180mcu_fd_sc_mcu7t5v0__dffrnq_1
Xclkbuf_4_6_0_host_clk_i clkbuf_0_host_clk_i/Z _3406_/CLK VDD VDD VSS VSS gf180mcu_fd_sc_mcu7t5v0__clkbuf_4
XFILLER_67_422 VDD VDD VSS VSS gf180mcu_fd_sc_mcu7t5v0__fillcap_64
X_3143_ _3143_/D _3416_/RN _3423_/CLK _3143_/Q VDD VDD VSS VSS gf180mcu_fd_sc_mcu7t5v0__dffrnq_1
XPHY_EDGE_ROW_84_Right_84 VDD VSS gf180mcu_fd_sc_mcu7t5v0__endcap
X_3074_ _3074_/D _3328_/RN clkload8/I _3074_/Q VDD VDD VSS VSS gf180mcu_fd_sc_mcu7t5v0__dffrnq_1
X_2025_ _3024_/Q _3023_/Q _3026_/Q _3025_/Q _2025_/Z VDD VDD VSS VSS gf180mcu_fd_sc_mcu7t5v0__and4_1
XFILLER_82_447 VDD VDD VSS VSS gf180mcu_fd_sc_mcu7t5v0__fill_2
XPHY_EDGE_ROW_59_Left_168 VDD VSS gf180mcu_fd_sc_mcu7t5v0__endcap
XFILLER_23_558 VDD VDD VSS VSS gf180mcu_fd_sc_mcu7t5v0__fill_2
X_2927_ _2927_/D _2988_/CLK _2927_/Q VDD VDD VSS VSS gf180mcu_fd_sc_mcu7t5v0__dffq_1
XTAP_TAPCELL_ROW_61_873 VDD VSS gf180mcu_fd_sc_mcu7t5v0__filltie
XPHY_EDGE_ROW_93_Right_93 VDD VSS gf180mcu_fd_sc_mcu7t5v0__endcap
X_2858_ _2858_/D _2858_/CLK _2858_/Q VDD VDD VSS VSS gf180mcu_fd_sc_mcu7t5v0__dffq_1
XTAP_TAPCELL_ROW_92_1202 VDD VSS gf180mcu_fd_sc_mcu7t5v0__filltie
XTAP_TAPCELL_ROW_79_1068 VDD VSS gf180mcu_fd_sc_mcu7t5v0__filltie
X_1809_ _3283_/Q _2850_/Q _1813_/S _2850_/D VDD VDD VSS VSS gf180mcu_fd_sc_mcu7t5v0__mux2_2
X_2789_ _2789_/D _3314_/CLK _2789_/Q VDD VDD VSS VSS gf180mcu_fd_sc_mcu7t5v0__dffq_1
XFILLER_2_407 VDD VDD VSS VSS gf180mcu_fd_sc_mcu7t5v0__fill_2
XPHY_EDGE_ROW_68_Left_177 VDD VSS gf180mcu_fd_sc_mcu7t5v0__endcap
XTAP_TAPCELL_ROW_5_289 VDD VSS gf180mcu_fd_sc_mcu7t5v0__filltie
XFILLER_65_14 VDD VDD VSS VSS gf180mcu_fd_sc_mcu7t5v0__fill_1
XTAP_TAPCELL_ROW_69_962 VDD VSS gf180mcu_fd_sc_mcu7t5v0__filltie
XFILLER_18_319 VDD VDD VSS VSS gf180mcu_fd_sc_mcu7t5v0__fill_1
XFILLER_58_477 VDD VDD VSS VSS gf180mcu_fd_sc_mcu7t5v0__fill_2
XFILLER_26_330 VDD VDD VSS VSS gf180mcu_fd_sc_mcu7t5v0__fill_2
XFILLER_65_69 VDD VDD VSS VSS gf180mcu_fd_sc_mcu7t5v0__fill_1
XPHY_EDGE_ROW_77_Left_186 VDD VSS gf180mcu_fd_sc_mcu7t5v0__endcap
XFILLER_14_51 VDD VDD VSS VSS gf180mcu_fd_sc_mcu7t5v0__fill_1
XFILLER_10_753 VDD VDD VSS VSS gf180mcu_fd_sc_mcu7t5v0__fillcap_8
XFILLER_5_212 VDD VDD VSS VSS gf180mcu_fd_sc_mcu7t5v0__fillcap_8
XPHY_EDGE_ROW_86_Left_195 VDD VSS gf180mcu_fd_sc_mcu7t5v0__endcap
XFILLER_5_278 VDD VDD VSS VSS gf180mcu_fd_sc_mcu7t5v0__fill_2
XFILLER_1_462 VDD VDD VSS VSS gf180mcu_fd_sc_mcu7t5v0__fillcap_8
XFILLER_103_390 VDD VDD VSS VSS gf180mcu_fd_sc_mcu7t5v0__fill_1
XFILLER_77_764 VDD VDD VSS VSS gf180mcu_fd_sc_mcu7t5v0__fill_1
XFILLER_49_488 VDD VDD VSS VSS gf180mcu_fd_sc_mcu7t5v0__fill_2
XFILLER_91_244 VDD VDD VSS VSS gf180mcu_fd_sc_mcu7t5v0__fill_2
XFILLER_76_296 VDD VDD VSS VSS gf180mcu_fd_sc_mcu7t5v0__fillcap_8
XFILLER_17_330 VDD VDD VSS VSS gf180mcu_fd_sc_mcu7t5v0__fillcap_16
XFILLER_17_352 VDD VDD VSS VSS gf180mcu_fd_sc_mcu7t5v0__fillcap_4
XFILLER_32_300 VDD VDD VSS VSS gf180mcu_fd_sc_mcu7t5v0__fill_1
XFILLER_55_91 VDD VDD VSS VSS gf180mcu_fd_sc_mcu7t5v0__fillcap_4
XFILLER_32_355 VDD VDD VSS VSS gf180mcu_fd_sc_mcu7t5v0__fill_2
XFILLER_60_664 VDD VDD VSS VSS gf180mcu_fd_sc_mcu7t5v0__fill_1
XFILLER_32_377 VDD VDD VSS VSS gf180mcu_fd_sc_mcu7t5v0__fill_2
X_2712_ _2687_/Z _2712_/A2 _3267_/D VDD VDD VSS VSS gf180mcu_fd_sc_mcu7t5v0__nand2_1
XFILLER_9_562 VDD VDD VSS VSS gf180mcu_fd_sc_mcu7t5v0__fill_2
XTAP_TAPCELL_ROW_30_545 VDD VSS gf180mcu_fd_sc_mcu7t5v0__filltie
X_2643_ _2923_/Q _2915_/Q _2907_/Q _2899_/Q _2675_/S0 _2674_/S1 _2643_/Z VDD VDD VSS
+ VSS gf180mcu_fd_sc_mcu7t5v0__mux4_1
XFILLER_65_2 VDD VDD VSS VSS gf180mcu_fd_sc_mcu7t5v0__fillcap_8
X_2574_ _3192_/Q _3234_/Q _2585_/S _3234_/D VDD VDD VSS VSS gf180mcu_fd_sc_mcu7t5v0__mux2_2
X_1525_ _2431_/A2 _3127_/Q _1526_/C _1525_/B2 _3305_/D VDD VDD VSS VSS gf180mcu_fd_sc_mcu7t5v0__oai22_1
XFILLER_87_528 VDD VDD VSS VSS gf180mcu_fd_sc_mcu7t5v0__fillcap_4
X_1456_ _3404_/Q _1455_/I _1729_/A2 VDD VDD VSS VSS gf180mcu_fd_sc_mcu7t5v0__nand2_1
XFILLER_101_349 VDD VDD VSS VSS gf180mcu_fd_sc_mcu7t5v0__fill_1
X_1387_ _3326_/Q _1572_/A1 VDD VDD VSS VSS gf180mcu_fd_sc_mcu7t5v0__clkinv_1
XFILLER_67_252 VDD VDD VSS VSS gf180mcu_fd_sc_mcu7t5v0__fillcap_16
XFILLER_68_753 VDD VDD VSS VSS gf180mcu_fd_sc_mcu7t5v0__fillcap_8
X_3126_ _3126_/D _3416_/RN _3306_/CLK _3126_/Q VDD VDD VSS VSS gf180mcu_fd_sc_mcu7t5v0__dffrnq_1
XFILLER_83_756 VDD VDD VSS VSS gf180mcu_fd_sc_mcu7t5v0__fillcap_8
XFILLER_82_222 VDD VDD VSS VSS gf180mcu_fd_sc_mcu7t5v0__fillcap_8
XTAP_TAPCELL_ROW_2_259 VDD VSS gf180mcu_fd_sc_mcu7t5v0__filltie
XTAP_TAPCELL_ROW_38_634 VDD VSS gf180mcu_fd_sc_mcu7t5v0__filltie
XTAP_TAPCELL_ROW_66_932 VDD VSS gf180mcu_fd_sc_mcu7t5v0__filltie
X_3057_ _3057_/D _3303_/RN _3297_/CLK _3057_/Q VDD VDD VSS VSS gf180mcu_fd_sc_mcu7t5v0__dffrnq_1
X_2008_ _3118_/Q _3022_/Q _2008_/S _3022_/D VDD VDD VSS VSS gf180mcu_fd_sc_mcu7t5v0__mux2_2
XFILLER_36_683 VDD VDD VSS VSS gf180mcu_fd_sc_mcu7t5v0__fillcap_16
XFILLER_50_185 VDD VDD VSS VSS gf180mcu_fd_sc_mcu7t5v0__fill_2
XFILLER_50_174 VDD VDD VSS VSS gf180mcu_fd_sc_mcu7t5v0__fill_1
XFILLER_51_686 VDD VDD VSS VSS gf180mcu_fd_sc_mcu7t5v0__fillcap_8
XFILLER_105_611 VDD VDD VSS VSS gf180mcu_fd_sc_mcu7t5v0__fillcap_16
XFILLER_2_204 VDD VDD VSS VSS gf180mcu_fd_sc_mcu7t5v0__fillcap_4
XFILLER_2_259 VDD VDD VSS VSS gf180mcu_fd_sc_mcu7t5v0__fill_1
XFILLER_105_699 VDD VDD VSS VSS gf180mcu_fd_sc_mcu7t5v0__fill_1
XFILLER_86_594 VDD VDD VSS VSS gf180mcu_fd_sc_mcu7t5v0__fill_1
XFILLER_19_628 VDD VDD VSS VSS gf180mcu_fd_sc_mcu7t5v0__fill_2
XFILLER_58_263 VDD VDD VSS VSS gf180mcu_fd_sc_mcu7t5v0__fillcap_8
Xclkbuf_leaf_24_clk_i clkload5/I _3287_/CLK VDD VDD VSS VSS gf180mcu_fd_sc_mcu7t5v0__clkbuf_4
XFILLER_54_491 VDD VDD VSS VSS gf180mcu_fd_sc_mcu7t5v0__fillcap_32
Xclkbuf_leaf_39_clk_i clkload4/I _2988_/CLK VDD VDD VSS VSS gf180mcu_fd_sc_mcu7t5v0__clkbuf_4
XFILLER_25_72 VDD VDD VSS VSS gf180mcu_fd_sc_mcu7t5v0__fill_2
XFILLER_26_193 VDD VDD VSS VSS gf180mcu_fd_sc_mcu7t5v0__fillcap_8
XFILLER_14_399 VDD VDD VSS VSS gf180mcu_fd_sc_mcu7t5v0__fill_1
XPHY_EDGE_ROW_94_Left_203 VDD VSS gf180mcu_fd_sc_mcu7t5v0__endcap
XFILLER_10_594 VDD VDD VSS VSS gf180mcu_fd_sc_mcu7t5v0__fill_1
XFILLER_6_521 VDD VDD VSS VSS gf180mcu_fd_sc_mcu7t5v0__fillcap_4
X_2290_ _3127_/Q _2267_/C _2291_/B VDD VDD VSS VSS gf180mcu_fd_sc_mcu7t5v0__nand2_1
XFILLER_49_274 VDD VDD VSS VSS gf180mcu_fd_sc_mcu7t5v0__fillcap_4
XFILLER_64_233 VDD VDD VSS VSS gf180mcu_fd_sc_mcu7t5v0__fillcap_8
XTAP_TAPCELL_ROW_35_604 VDD VSS gf180mcu_fd_sc_mcu7t5v0__filltie
XFILLER_64_255 VDD VDD VSS VSS gf180mcu_fd_sc_mcu7t5v0__fillcap_4
XFILLER_92_597 VDD VDD VSS VSS gf180mcu_fd_sc_mcu7t5v0__fillcap_8
XFILLER_80_737 VDD VDD VSS VSS gf180mcu_fd_sc_mcu7t5v0__fill_2
XTAP_TAPCELL_ROW_15_394 VDD VSS gf180mcu_fd_sc_mcu7t5v0__filltie
XTAP_TAPCELL_ROW_43_681 VDD VSS gf180mcu_fd_sc_mcu7t5v0__filltie
XTAP_TAPCELL_ROW_76_1027 VDD VSS gf180mcu_fd_sc_mcu7t5v0__filltie
X_2626_ _3066_/Q _2132_/I _2664_/B1 _3098_/Q _2766_/Q _2603_/Z _2627_/B VDD VDD VSS
+ VSS gf180mcu_fd_sc_mcu7t5v0__aoi222_1
XTAP_TAPCELL_ROW_7_307 VDD VSS gf180mcu_fd_sc_mcu7t5v0__filltie
X_2557_ _3175_/Q _3217_/Q _2569_/S _3217_/D VDD VDD VSS VSS gf180mcu_fd_sc_mcu7t5v0__mux2_2
XFILLER_102_614 VDD VDD VSS VSS gf180mcu_fd_sc_mcu7t5v0__fill_1
XFILLER_99_174 VDD VDD VSS VSS gf180mcu_fd_sc_mcu7t5v0__fill_2
X_1508_ _3415_/Q _2413_/A1 _2197_/A1 _2420_/B VDD VDD VSS VSS gf180mcu_fd_sc_mcu7t5v0__nor3_1
X_2488_ _1610_/Z _1612_/Z _2488_/A3 _3159_/D VDD VDD VSS VSS gf180mcu_fd_sc_mcu7t5v0__nor3_1
X_1439_ _1439_/A1 _3110_/Q _1439_/B _1441_/A2 VDD VDD VSS VSS gf180mcu_fd_sc_mcu7t5v0__aoi21_1
XFILLER_68_561 VDD VDD VSS VSS gf180mcu_fd_sc_mcu7t5v0__fill_1
Xmax_cap17 _1876_/S _1877_/S VDD VDD VSS VSS gf180mcu_fd_sc_mcu7t5v0__buf_2
X_3109_ _3109_/D _3416_/RN _3131_/CLK _3109_/Q VDD VDD VSS VSS gf180mcu_fd_sc_mcu7t5v0__dffrnq_1
XTAP_TAPCELL_ROW_87_1145 VDD VSS gf180mcu_fd_sc_mcu7t5v0__filltie
XFILLER_62_37 VDD VDD VSS VSS gf180mcu_fd_sc_mcu7t5v0__fillcap_16
XFILLER_70_247 VDD VDD VSS VSS gf180mcu_fd_sc_mcu7t5v0__fillcap_8
XFILLER_23_174 VDD VDD VSS VSS gf180mcu_fd_sc_mcu7t5v0__fillcap_16
XFILLER_11_336 VDD VDD VSS VSS gf180mcu_fd_sc_mcu7t5v0__fillcap_8
XTAP_TAPCELL_ROW_98_1263 VDD VSS gf180mcu_fd_sc_mcu7t5v0__filltie
XFILLER_105_430 VDD VDD VSS VSS gf180mcu_fd_sc_mcu7t5v0__fillcap_4
XFILLER_78_314 VDD VDD VSS VSS gf180mcu_fd_sc_mcu7t5v0__fill_1
XFILLER_74_520 VDD VDD VSS VSS gf180mcu_fd_sc_mcu7t5v0__fillcap_4
XFILLER_59_594 VDD VDD VSS VSS gf180mcu_fd_sc_mcu7t5v0__fillcap_4
XFILLER_46_244 VDD VDD VSS VSS gf180mcu_fd_sc_mcu7t5v0__fill_1
XFILLER_74_597 VDD VDD VSS VSS gf180mcu_fd_sc_mcu7t5v0__fillcap_32
XFILLER_62_759 VDD VDD VSS VSS gf180mcu_fd_sc_mcu7t5v0__fillcap_4
XFILLER_14_196 VDD VDD VSS VSS gf180mcu_fd_sc_mcu7t5v0__fillcap_32
XFILLER_30_667 VDD VDD VSS VSS gf180mcu_fd_sc_mcu7t5v0__fillcap_64
XTAP_TAPCELL_ROW_40_651 VDD VSS gf180mcu_fd_sc_mcu7t5v0__filltie
X_1790_ _3282_/Q _2833_/Q _1795_/S _2833_/D VDD VDD VSS VSS gf180mcu_fd_sc_mcu7t5v0__mux2_2
XTAP_TAPCELL_ROW_12_364 VDD VSS gf180mcu_fd_sc_mcu7t5v0__filltie
XFILLER_10_391 VDD VDD VSS VSS gf180mcu_fd_sc_mcu7t5v0__fill_2
X_3391_ _3391_/D _3416_/RN _3398_/CLK _3391_/Q VDD VDD VSS VSS gf180mcu_fd_sc_mcu7t5v0__dffrnq_1
X_2411_ _2218_/B _2410_/Z _2416_/A2 VDD VDD VSS VSS gf180mcu_fd_sc_mcu7t5v0__nand2_1
XFILLER_96_100 VDD VDD VSS VSS gf180mcu_fd_sc_mcu7t5v0__fillcap_4
X_2342_ _2407_/A1 _2342_/A2 _2407_/B _2342_/C _2343_/B VDD VDD VSS VSS gf180mcu_fd_sc_mcu7t5v0__oai211_1
XFILLER_96_133 VDD VDD VSS VSS gf180mcu_fd_sc_mcu7t5v0__fill_2
XFILLER_28_2 VDD VDD VSS VSS gf180mcu_fd_sc_mcu7t5v0__fillcap_8
X_2273_ _3131_/Q _2267_/C _2273_/A3 _2303_/A2 _2274_/A2 VDD VDD VSS VSS gf180mcu_fd_sc_mcu7t5v0__nor4_1
XFILLER_96_177 VDD VDD VSS VSS gf180mcu_fd_sc_mcu7t5v0__fill_2
XFILLER_84_339 VDD VDD VSS VSS gf180mcu_fd_sc_mcu7t5v0__fillcap_8
XTAP_TAPCELL_ROW_48_740 VDD VSS gf180mcu_fd_sc_mcu7t5v0__filltie
XFILLER_92_383 VDD VDD VSS VSS gf180mcu_fd_sc_mcu7t5v0__fill_2
XFILLER_80_589 VDD VDD VSS VSS gf180mcu_fd_sc_mcu7t5v0__fillcap_4
XTAP_TAPCELL_ROW_82_1097 VDD VSS gf180mcu_fd_sc_mcu7t5v0__filltie
XFILLER_20_111 VDD VDD VSS VSS gf180mcu_fd_sc_mcu7t5v0__fill_2
XFILLER_32_18 VDD VDD VSS VSS gf180mcu_fd_sc_mcu7t5v0__fill_1
XFILLER_60_291 VDD VDD VSS VSS gf180mcu_fd_sc_mcu7t5v0__fillcap_8
X_1988_ _3116_/Q _3004_/Q _1990_/S _3004_/D VDD VDD VSS VSS gf180mcu_fd_sc_mcu7t5v0__mux2_2
XFILLER_20_177 VDD VDD VSS VSS gf180mcu_fd_sc_mcu7t5v0__fillcap_64
X_2609_ _2609_/A1 _2609_/A2 _3246_/D VDD VDD VSS VSS gf180mcu_fd_sc_mcu7t5v0__nand2_1
XFILLER_88_667 VDD VDD VSS VSS gf180mcu_fd_sc_mcu7t5v0__fillcap_8
XFILLER_28_200 VDD VDD VSS VSS gf180mcu_fd_sc_mcu7t5v0__fill_2
XFILLER_16_439 VDD VDD VSS VSS gf180mcu_fd_sc_mcu7t5v0__fill_1
XFILLER_56_597 VDD VDD VSS VSS gf180mcu_fd_sc_mcu7t5v0__fillcap_8
XFILLER_44_759 VDD VDD VSS VSS gf180mcu_fd_sc_mcu7t5v0__fillcap_4
XTAP_TAPCELL_ROW_54_798 VDD VSS gf180mcu_fd_sc_mcu7t5v0__filltie
XFILLER_105_282 VDD VDD VSS VSS gf180mcu_fd_sc_mcu7t5v0__fillcap_4
XFILLER_78_177 VDD VDD VSS VSS gf180mcu_fd_sc_mcu7t5v0__fillcap_4
XFILLER_66_317 VDD VDD VSS VSS gf180mcu_fd_sc_mcu7t5v0__fillcap_32
XFILLER_93_125 VDD VDD VSS VSS gf180mcu_fd_sc_mcu7t5v0__fill_2
XFILLER_93_158 VDD VDD VSS VSS gf180mcu_fd_sc_mcu7t5v0__fillcap_8
XTAP_TAPCELL_ROW_17_412 VDD VSS gf180mcu_fd_sc_mcu7t5v0__filltie
XTAP_TAPCELL_ROW_45_710 VDD VSS gf180mcu_fd_sc_mcu7t5v0__filltie
XFILLER_47_586 VDD VDD VSS VSS gf180mcu_fd_sc_mcu7t5v0__fillcap_4
XFILLER_34_247 VDD VDD VSS VSS gf180mcu_fd_sc_mcu7t5v0__fillcap_4
X_2960_ _2960_/D _2984_/CLK _2960_/Q VDD VDD VSS VSS gf180mcu_fd_sc_mcu7t5v0__dffq_1
XFILLER_50_729 VDD VDD VSS VSS gf180mcu_fd_sc_mcu7t5v0__fillcap_4
X_2891_ _2891_/D _2891_/CLK _2891_/Q VDD VDD VSS VSS gf180mcu_fd_sc_mcu7t5v0__dffq_1
X_1911_ _3113_/Q _2937_/Q _1916_/S _2937_/D VDD VDD VSS VSS gf180mcu_fd_sc_mcu7t5v0__mux2_2
X_1842_ _1842_/A1 _1851_/A2 _1850_/S VDD VDD VSS VSS gf180mcu_fd_sc_mcu7t5v0__nand2_1
XFILLER_8_53 VDD VDD VSS VSS gf180mcu_fd_sc_mcu7t5v0__fillcap_8
X_1773_ _3284_/Q _2819_/Q _1776_/S _2819_/D VDD VDD VSS VSS gf180mcu_fd_sc_mcu7t5v0__mux2_2
XFILLER_7_693 VDD VDD VSS VSS gf180mcu_fd_sc_mcu7t5v0__fillcap_4
X_3374_ _3395_/Q input1/Z _3408_/CLK hold58/I VDD VDD VSS VSS gf180mcu_fd_sc_mcu7t5v0__dffrnq_1
XFILLER_97_486 VDD VDD VSS VSS gf180mcu_fd_sc_mcu7t5v0__fillcap_4
X_2325_ _2791_/Q _2783_/Q _2775_/Q _2767_/Q _3391_/Q _3392_/Q _2325_/Z VDD VDD VSS
+ VSS gf180mcu_fd_sc_mcu7t5v0__mux4_1
X_2256_ _3134_/Q _3098_/Q _2256_/Z VDD VDD VSS VSS gf180mcu_fd_sc_mcu7t5v0__xor2_1
X_2187_ _2219_/B _2187_/A2 _2188_/A2 VDD VDD VSS VSS gf180mcu_fd_sc_mcu7t5v0__nand2_1
XTAP_TAPCELL_ROW_84_1115 VDD VSS gf180mcu_fd_sc_mcu7t5v0__filltie
XFILLER_65_372 VDD VDD VSS VSS gf180mcu_fd_sc_mcu7t5v0__fill_1
XPHY_EDGE_ROW_40_Left_149 VDD VSS gf180mcu_fd_sc_mcu7t5v0__endcap
XFILLER_53_545 VDD VDD VSS VSS gf180mcu_fd_sc_mcu7t5v0__fillcap_8
XTAP_TAPCELL_ROW_51_768 VDD VSS gf180mcu_fd_sc_mcu7t5v0__filltie
XTAP_TAPCELL_ROW_95_1233 VDD VSS gf180mcu_fd_sc_mcu7t5v0__filltie
XFILLER_4_107 VDD VDD VSS VSS gf180mcu_fd_sc_mcu7t5v0__fillcap_4
XFILLER_103_742 VDD VDD VSS VSS gf180mcu_fd_sc_mcu7t5v0__fillcap_16
XFILLER_103_764 VDD VDD VSS VSS gf180mcu_fd_sc_mcu7t5v0__fill_1
XFILLER_102_241 VDD VDD VSS VSS gf180mcu_fd_sc_mcu7t5v0__fillcap_4
XTAP_TAPCELL_ROW_59_857 VDD VSS gf180mcu_fd_sc_mcu7t5v0__filltie
XFILLER_17_726 VDD VDD VSS VSS gf180mcu_fd_sc_mcu7t5v0__fillcap_4
XFILLER_44_501 VDD VDD VSS VSS gf180mcu_fd_sc_mcu7t5v0__fillcap_8
XFILLER_17_759 VDD VDD VSS VSS gf180mcu_fd_sc_mcu7t5v0__fillcap_4
XFILLER_17_51 VDD VDD VSS VSS gf180mcu_fd_sc_mcu7t5v0__fillcap_16
XFILLER_8_424 VDD VDD VSS VSS gf180mcu_fd_sc_mcu7t5v0__fill_2
XTAP_TAPCELL_ROW_22_470 VDD VSS gf180mcu_fd_sc_mcu7t5v0__filltie
XFILLER_33_72 VDD VDD VSS VSS gf180mcu_fd_sc_mcu7t5v0__fillcap_8
XFILLER_8_457 VDD VDD VSS VSS gf180mcu_fd_sc_mcu7t5v0__fillcap_8
XFILLER_79_442 VDD VDD VSS VSS gf180mcu_fd_sc_mcu7t5v0__fill_2
XFILLER_39_306 VDD VDD VSS VSS gf180mcu_fd_sc_mcu7t5v0__fillcap_4
X_2110_ _2111_/A2 _2110_/A2 _2110_/A3 _2124_/A1 VDD VDD VSS VSS gf180mcu_fd_sc_mcu7t5v0__nor3_1
X_3090_ _3090_/D _3328_/RN _3240_/CLK _3090_/Q VDD VDD VSS VSS gf180mcu_fd_sc_mcu7t5v0__dffrnq_1
XFILLER_67_648 VDD VDD VSS VSS gf180mcu_fd_sc_mcu7t5v0__fillcap_8
X_2041_ _2023_/B _2045_/A3 _2043_/A1 VDD VDD VSS VSS gf180mcu_fd_sc_mcu7t5v0__nand2_1
XFILLER_66_169 VDD VDD VSS VSS gf180mcu_fd_sc_mcu7t5v0__fill_1
XFILLER_81_128 VDD VDD VSS VSS gf180mcu_fd_sc_mcu7t5v0__fillcap_8
XFILLER_62_364 VDD VDD VSS VSS gf180mcu_fd_sc_mcu7t5v0__fillcap_16
XFILLER_95_2 VDD VDD VSS VSS gf180mcu_fd_sc_mcu7t5v0__fillcap_8
X_2943_ _2943_/D _3020_/CLK _2943_/Q VDD VDD VSS VSS gf180mcu_fd_sc_mcu7t5v0__dffq_1
XFILLER_22_239 VDD VDD VSS VSS gf180mcu_fd_sc_mcu7t5v0__fillcap_4
X_2874_ _2874_/D _2891_/CLK _2874_/Q VDD VDD VSS VSS gf180mcu_fd_sc_mcu7t5v0__dffq_1
X_1825_ _3280_/Q _2863_/Q _1832_/S _2863_/D VDD VDD VSS VSS gf180mcu_fd_sc_mcu7t5v0__mux2_2
X_1756_ _3285_/Q _2804_/Q _1758_/S _2804_/D VDD VDD VSS VSS gf180mcu_fd_sc_mcu7t5v0__mux2_2
X_1687_ _1687_/I _1688_/A2 VDD VDD VSS VSS gf180mcu_fd_sc_mcu7t5v0__clkinv_1
XFILLER_97_261 VDD VDD VSS VSS gf180mcu_fd_sc_mcu7t5v0__fill_1
XTAP_TAPCELL_ROW_90_1174 VDD VSS gf180mcu_fd_sc_mcu7t5v0__filltie
X_3357_ _3357_/D input1/Z _3358_/CLK _3357_/Q VDD VDD VSS VSS gf180mcu_fd_sc_mcu7t5v0__dffrnq_1
X_2308_ _2313_/A1 _2313_/A2 _2310_/A1 VDD VDD VSS VSS gf180mcu_fd_sc_mcu7t5v0__nor2_1
XFILLER_100_723 VDD VDD VSS VSS gf180mcu_fd_sc_mcu7t5v0__fillcap_8
XFILLER_100_745 VDD VDD VSS VSS gf180mcu_fd_sc_mcu7t5v0__fillcap_4
XFILLER_85_434 VDD VDD VSS VSS gf180mcu_fd_sc_mcu7t5v0__fill_2
XFILLER_57_158 VDD VDD VSS VSS gf180mcu_fd_sc_mcu7t5v0__fillcap_8
X_3288_ _3288_/D _3303_/RN _3288_/CLK _3288_/Q VDD VDD VSS VSS gf180mcu_fd_sc_mcu7t5v0__dffrnq_1
XTAP_TAPCELL_ROW_28_529 VDD VSS gf180mcu_fd_sc_mcu7t5v0__filltie
XFILLER_38_361 VDD VDD VSS VSS gf180mcu_fd_sc_mcu7t5v0__fillcap_16
XTAP_TAPCELL_ROW_56_827 VDD VSS gf180mcu_fd_sc_mcu7t5v0__filltie
X_2239_ _3134_/Q _3114_/Q _2242_/S _3114_/D VDD VDD VSS VSS gf180mcu_fd_sc_mcu7t5v0__mux2_2
XFILLER_73_629 VDD VDD VSS VSS gf180mcu_fd_sc_mcu7t5v0__fill_1
XFILLER_81_640 VDD VDD VSS VSS gf180mcu_fd_sc_mcu7t5v0__fillcap_4
XFILLER_72_139 VDD VDD VSS VSS gf180mcu_fd_sc_mcu7t5v0__fillcap_4
XFILLER_14_718 VDD VDD VSS VSS gf180mcu_fd_sc_mcu7t5v0__fill_2
XFILLER_13_206 VDD VDD VSS VSS gf180mcu_fd_sc_mcu7t5v0__fillcap_4
XFILLER_13_228 VDD VDD VSS VSS gf180mcu_fd_sc_mcu7t5v0__fillcap_8
XFILLER_70_26 VDD VDD VSS VSS gf180mcu_fd_sc_mcu7t5v0__fill_2
XFILLER_70_37 VDD VDD VSS VSS gf180mcu_fd_sc_mcu7t5v0__fillcap_32
XFILLER_95_209 VDD VDD VSS VSS gf180mcu_fd_sc_mcu7t5v0__fill_1
XFILLER_0_154 VDD VDD VSS VSS gf180mcu_fd_sc_mcu7t5v0__fill_1
XFILLER_1_699 VDD VDD VSS VSS gf180mcu_fd_sc_mcu7t5v0__fill_1
XFILLER_63_106 VDD VDD VSS VSS gf180mcu_fd_sc_mcu7t5v0__fill_1
XFILLER_44_364 VDD VDD VSS VSS gf180mcu_fd_sc_mcu7t5v0__fillcap_4
XFILLER_13_762 VDD VDD VSS VSS gf180mcu_fd_sc_mcu7t5v0__fill_2
XFILLER_32_559 VDD VDD VSS VSS gf180mcu_fd_sc_mcu7t5v0__fill_1
XFILLER_12_283 VDD VDD VSS VSS gf180mcu_fd_sc_mcu7t5v0__fill_1
XFILLER_8_243 VDD VDD VSS VSS gf180mcu_fd_sc_mcu7t5v0__fill_2
X_1610_ _3159_/Q _3158_/Q _3157_/Q _2481_/A1 _1610_/Z VDD VDD VSS VSS gf180mcu_fd_sc_mcu7t5v0__and4_1
X_2590_ _3340_/Q _2680_/C _2734_/A3 _2670_/A1 VDD VDD VSS VSS gf180mcu_fd_sc_mcu7t5v0__nor3_1
X_1541_ _1568_/A2 _1541_/A2 _1541_/B1 _2107_/S _3307_/D VDD VDD VSS VSS gf180mcu_fd_sc_mcu7t5v0__aoi22_1
XFILLER_99_559 VDD VDD VSS VSS gf180mcu_fd_sc_mcu7t5v0__fill_1
X_1472_ _3408_/Q _1718_/S _3408_/D VDD VDD VSS VSS gf180mcu_fd_sc_mcu7t5v0__xor2_1
XPHY_EDGE_ROW_105_Left_214 VDD VSS gf180mcu_fd_sc_mcu7t5v0__endcap
X_3211_ _3211_/D _3328_/RN _3257_/CLK _3211_/Q VDD VDD VSS VSS gf180mcu_fd_sc_mcu7t5v0__dffrnq_1
X_3142_ _3142_/D _3416_/RN _3306_/CLK _3142_/Q VDD VDD VSS VSS gf180mcu_fd_sc_mcu7t5v0__dffrnq_1
XFILLER_39_125 VDD VDD VSS VSS gf180mcu_fd_sc_mcu7t5v0__fillcap_8
XFILLER_10_2 VDD VDD VSS VSS gf180mcu_fd_sc_mcu7t5v0__fillcap_32
XFILLER_39_158 VDD VDD VSS VSS gf180mcu_fd_sc_mcu7t5v0__fillcap_8
X_3073_ _3073_/D _3303_/RN _3292_/CLK _3073_/Q VDD VDD VSS VSS gf180mcu_fd_sc_mcu7t5v0__dffrnq_1
X_2024_ _3026_/Q _2051_/A1 _2024_/A3 _2024_/B _3026_/D VDD VDD VSS VSS gf180mcu_fd_sc_mcu7t5v0__oai31_1
XFILLER_35_331 VDD VDD VSS VSS gf180mcu_fd_sc_mcu7t5v0__fill_1
XFILLER_35_386 VDD VDD VSS VSS gf180mcu_fd_sc_mcu7t5v0__fillcap_4
XFILLER_62_194 VDD VDD VSS VSS gf180mcu_fd_sc_mcu7t5v0__fillcap_32
XFILLER_31_570 VDD VDD VSS VSS gf180mcu_fd_sc_mcu7t5v0__fill_2
XTAP_TAPCELL_ROW_33_576 VDD VSS gf180mcu_fd_sc_mcu7t5v0__filltie
X_2926_ _2926_/D _2926_/CLK _2926_/Q VDD VDD VSS VSS gf180mcu_fd_sc_mcu7t5v0__dffq_1
XTAP_TAPCELL_ROW_61_874 VDD VSS gf180mcu_fd_sc_mcu7t5v0__filltie
X_2857_ _2857_/D _3409_/CLK _2857_/Q VDD VDD VSS VSS gf180mcu_fd_sc_mcu7t5v0__dffq_1
X_1808_ _3282_/Q _2849_/Q _1813_/S _2849_/D VDD VDD VSS VSS gf180mcu_fd_sc_mcu7t5v0__mux2_2
X_2788_ _2788_/D _2796_/CLK _2788_/Q VDD VDD VSS VSS gf180mcu_fd_sc_mcu7t5v0__dffq_1
XTAP_TAPCELL_ROW_92_1203 VDD VSS gf180mcu_fd_sc_mcu7t5v0__filltie
X_1739_ _3405_/Q _3404_/Q _1739_/A3 _1851_/A1 VDD VDD VSS VSS gf180mcu_fd_sc_mcu7t5v0__nor3_1
XFILLER_77_209 VDD VDD VSS VSS gf180mcu_fd_sc_mcu7t5v0__fill_1
X_3409_ _3409_/D input1/Z _3409_/CLK _3409_/Q VDD VDD VSS VSS gf180mcu_fd_sc_mcu7t5v0__dffrnq_1
XFILLER_100_520 VDD VDD VSS VSS gf180mcu_fd_sc_mcu7t5v0__fillcap_4
XFILLER_105_66 VDD VDD VSS VSS gf180mcu_fd_sc_mcu7t5v0__fillcap_4
XFILLER_85_220 VDD VDD VSS VSS gf180mcu_fd_sc_mcu7t5v0__fillcap_16
XTAP_TAPCELL_ROW_69_963 VDD VSS gf180mcu_fd_sc_mcu7t5v0__filltie
XFILLER_100_597 VDD VDD VSS VSS gf180mcu_fd_sc_mcu7t5v0__fillcap_64
XFILLER_45_139 VDD VDD VSS VSS gf180mcu_fd_sc_mcu7t5v0__fill_1
XFILLER_53_150 VDD VDD VSS VSS gf180mcu_fd_sc_mcu7t5v0__fillcap_4
XFILLER_54_662 VDD VDD VSS VSS gf180mcu_fd_sc_mcu7t5v0__fill_2
XFILLER_81_492 VDD VDD VSS VSS gf180mcu_fd_sc_mcu7t5v0__fillcap_64
XFILLER_81_58 VDD VDD VSS VSS gf180mcu_fd_sc_mcu7t5v0__fillcap_8
XFILLER_10_710 VDD VDD VSS VSS gf180mcu_fd_sc_mcu7t5v0__fillcap_16
XFILLER_6_725 VDD VDD VSS VSS gf180mcu_fd_sc_mcu7t5v0__fillcap_8
XFILLER_1_430 VDD VDD VSS VSS gf180mcu_fd_sc_mcu7t5v0__fill_2
XFILLER_39_93 VDD VDD VSS VSS gf180mcu_fd_sc_mcu7t5v0__fillcap_32
XFILLER_76_253 VDD VDD VSS VSS gf180mcu_fd_sc_mcu7t5v0__fillcap_8
XFILLER_91_212 VDD VDD VSS VSS gf180mcu_fd_sc_mcu7t5v0__fillcap_32
XFILLER_32_323 VDD VDD VSS VSS gf180mcu_fd_sc_mcu7t5v0__fillcap_32
X_2711_ _3267_/Q _2680_/C _2729_/B1 _3085_/Q _2712_/A2 VDD VDD VSS VSS gf180mcu_fd_sc_mcu7t5v0__aoi22_1
XTAP_TAPCELL_ROW_30_546 VDD VSS gf180mcu_fd_sc_mcu7t5v0__filltie
XFILLER_71_80 VDD VDD VSS VSS gf180mcu_fd_sc_mcu7t5v0__fillcap_8
X_2642_ _2955_/Q _2947_/Q _2939_/Q _2931_/Q _2675_/S0 _2675_/S1 _2642_/Z VDD VDD VSS
+ VSS gf180mcu_fd_sc_mcu7t5v0__mux4_1
X_2573_ _3191_/Q _3233_/Q _2585_/S _3233_/D VDD VDD VSS VSS gf180mcu_fd_sc_mcu7t5v0__mux2_2
XFILLER_58_2 VDD VDD VSS VSS gf180mcu_fd_sc_mcu7t5v0__fillcap_16
X_1524_ _3125_/Q _2179_/A1 _1526_/C VDD VDD VSS VSS gf180mcu_fd_sc_mcu7t5v0__nand2_1
XFILLER_59_209 VDD VDD VSS VSS gf180mcu_fd_sc_mcu7t5v0__fill_1
XFILLER_68_721 VDD VDD VSS VSS gf180mcu_fd_sc_mcu7t5v0__fillcap_8
X_1455_ _1455_/I _1739_/A3 VDD VDD VSS VSS gf180mcu_fd_sc_mcu7t5v0__clkinv_1
X_1386_ _3063_/Q _2126_/A1 VDD VDD VSS VSS gf180mcu_fd_sc_mcu7t5v0__clkinv_1
X_3125_ _3125_/D _3416_/RN _3306_/CLK _3125_/Q VDD VDD VSS VSS gf180mcu_fd_sc_mcu7t5v0__dffrnq_1
XFILLER_83_702 VDD VDD VSS VSS gf180mcu_fd_sc_mcu7t5v0__fill_2
Xclkbuf_leaf_5_clk_i clkbuf_leaf_5_clk_i/I _3292_/CLK VDD VDD VSS VSS gf180mcu_fd_sc_mcu7t5v0__clkbuf_4
XTAP_TAPCELL_ROW_66_922 VDD VSS gf180mcu_fd_sc_mcu7t5v0__filltie
XFILLER_82_234 VDD VDD VSS VSS gf180mcu_fd_sc_mcu7t5v0__fill_1
XTAP_TAPCELL_ROW_38_635 VDD VSS gf180mcu_fd_sc_mcu7t5v0__filltie
X_3056_ _3056_/D _3303_/RN _3297_/CLK _3056_/Q VDD VDD VSS VSS gf180mcu_fd_sc_mcu7t5v0__dffrnq_1
XFILLER_67_286 VDD VDD VSS VSS gf180mcu_fd_sc_mcu7t5v0__fill_2
X_2007_ _3117_/Q _3021_/Q _2008_/S _3021_/D VDD VDD VSS VSS gf180mcu_fd_sc_mcu7t5v0__mux2_2
XFILLER_35_18 VDD VDD VSS VSS gf180mcu_fd_sc_mcu7t5v0__fill_1
XFILLER_35_150 VDD VDD VSS VSS gf180mcu_fd_sc_mcu7t5v0__fill_2
XFILLER_51_632 VDD VDD VSS VSS gf180mcu_fd_sc_mcu7t5v0__fillcap_4
XFILLER_63_492 VDD VDD VSS VSS gf180mcu_fd_sc_mcu7t5v0__fillcap_8
XFILLER_23_356 VDD VDD VSS VSS gf180mcu_fd_sc_mcu7t5v0__fill_2
XFILLER_51_698 VDD VDD VSS VSS gf180mcu_fd_sc_mcu7t5v0__fill_2
X_2909_ _2909_/D _2954_/CLK _2909_/Q VDD VDD VSS VSS gf180mcu_fd_sc_mcu7t5v0__dffq_1
XFILLER_104_177 VDD VDD VSS VSS gf180mcu_fd_sc_mcu7t5v0__fillcap_16
XFILLER_86_562 VDD VDD VSS VSS gf180mcu_fd_sc_mcu7t5v0__fillcap_32
XFILLER_100_383 VDD VDD VSS VSS gf180mcu_fd_sc_mcu7t5v0__fill_2
XFILLER_100_372 VDD VDD VSS VSS gf180mcu_fd_sc_mcu7t5v0__fill_1
XFILLER_46_448 VDD VDD VSS VSS gf180mcu_fd_sc_mcu7t5v0__fillcap_4
XFILLER_73_212 VDD VDD VSS VSS gf180mcu_fd_sc_mcu7t5v0__fillcap_16
XFILLER_14_312 VDD VDD VSS VSS gf180mcu_fd_sc_mcu7t5v0__fill_2
XFILLER_41_142 VDD VDD VSS VSS gf180mcu_fd_sc_mcu7t5v0__fill_2
XFILLER_10_551 VDD VDD VSS VSS gf180mcu_fd_sc_mcu7t5v0__fillcap_4
XFILLER_10_584 VDD VDD VSS VSS gf180mcu_fd_sc_mcu7t5v0__fillcap_8
XFILLER_41_72 VDD VDD VSS VSS gf180mcu_fd_sc_mcu7t5v0__fillcap_16
XFILLER_41_94 VDD VDD VSS VSS gf180mcu_fd_sc_mcu7t5v0__fill_1
XFILLER_1_260 VDD VDD VSS VSS gf180mcu_fd_sc_mcu7t5v0__fillcap_4
XFILLER_2_761 VDD VDD VSS VSS gf180mcu_fd_sc_mcu7t5v0__fillcap_4
XFILLER_1_282 VDD VDD VSS VSS gf180mcu_fd_sc_mcu7t5v0__fillcap_16
XFILLER_49_220 VDD VDD VSS VSS gf180mcu_fd_sc_mcu7t5v0__fillcap_4
XFILLER_49_286 VDD VDD VSS VSS gf180mcu_fd_sc_mcu7t5v0__fill_2
XTAP_TAPCELL_ROW_35_605 VDD VSS gf180mcu_fd_sc_mcu7t5v0__filltie
XFILLER_37_459 VDD VDD VSS VSS gf180mcu_fd_sc_mcu7t5v0__fill_2
XFILLER_33_621 VDD VDD VSS VSS gf180mcu_fd_sc_mcu7t5v0__fillcap_8
XFILLER_33_610 VDD VDD VSS VSS gf180mcu_fd_sc_mcu7t5v0__fillcap_4
XFILLER_64_289 VDD VDD VSS VSS gf180mcu_fd_sc_mcu7t5v0__fillcap_8
XFILLER_33_632 VDD VDD VSS VSS gf180mcu_fd_sc_mcu7t5v0__fillcap_8
XFILLER_45_492 VDD VDD VSS VSS gf180mcu_fd_sc_mcu7t5v0__fillcap_8
XFILLER_82_90 VDD VDD VSS VSS gf180mcu_fd_sc_mcu7t5v0__fillcap_8
XFILLER_20_304 VDD VDD VSS VSS gf180mcu_fd_sc_mcu7t5v0__fill_1
XFILLER_33_687 VDD VDD VSS VSS gf180mcu_fd_sc_mcu7t5v0__fill_1
XFILLER_33_698 VDD VDD VSS VSS gf180mcu_fd_sc_mcu7t5v0__fill_2
XTAP_TAPCELL_ROW_71_980 VDD VSS gf180mcu_fd_sc_mcu7t5v0__filltie
XTAP_TAPCELL_ROW_15_395 VDD VSS gf180mcu_fd_sc_mcu7t5v0__filltie
XFILLER_20_348 VDD VDD VSS VSS gf180mcu_fd_sc_mcu7t5v0__fillcap_8
XTAP_TAPCELL_ROW_43_682 VDD VSS gf180mcu_fd_sc_mcu7t5v0__filltie
XFILLER_9_393 VDD VDD VSS VSS gf180mcu_fd_sc_mcu7t5v0__fillcap_8
XTAP_TAPCELL_ROW_76_1028 VDD VSS gf180mcu_fd_sc_mcu7t5v0__filltie
X_2625_ _3248_/Q _2680_/C _2629_/A1 VDD VDD VSS VSS gf180mcu_fd_sc_mcu7t5v0__nand2_1
XFILLER_99_142 VDD VDD VSS VSS gf180mcu_fd_sc_mcu7t5v0__fillcap_32
XFILLER_99_131 VDD VDD VSS VSS gf180mcu_fd_sc_mcu7t5v0__fillcap_8
XTAP_TAPCELL_ROW_7_308 VDD VSS gf180mcu_fd_sc_mcu7t5v0__filltie
X_2556_ _3174_/Q _3216_/Q _2569_/S _3216_/D VDD VDD VSS VSS gf180mcu_fd_sc_mcu7t5v0__mux2_2
X_1507_ _3415_/D _3418_/Q _1507_/Z VDD VDD VSS VSS gf180mcu_fd_sc_mcu7t5v0__and2_1
X_2487_ _3158_/Q _2483_/B _3159_/Q _2488_/A3 VDD VDD VSS VSS gf180mcu_fd_sc_mcu7t5v0__aoi21_1
XFILLER_102_659 VDD VDD VSS VSS gf180mcu_fd_sc_mcu7t5v0__fillcap_4
XFILLER_101_136 VDD VDD VSS VSS gf180mcu_fd_sc_mcu7t5v0__fillcap_4
X_1438_ _2373_/S1 _1436_/Z _3392_/D VDD VDD VSS VSS gf180mcu_fd_sc_mcu7t5v0__xor2_1
XFILLER_87_337 VDD VDD VSS VSS gf180mcu_fd_sc_mcu7t5v0__fill_2
X_3108_ _3108_/D _3416_/RN _3131_/CLK _3108_/Q VDD VDD VSS VSS gf180mcu_fd_sc_mcu7t5v0__dffsnq_1
X_1369_ _3415_/Q _1628_/A1 VDD VDD VSS VSS gf180mcu_fd_sc_mcu7t5v0__clkinv_1
XFILLER_83_510 VDD VDD VSS VSS gf180mcu_fd_sc_mcu7t5v0__fill_1
Xmax_cap18 _2732_/A2 _2664_/B1 VDD VDD VSS VSS gf180mcu_fd_sc_mcu7t5v0__buf_2
XFILLER_55_212 VDD VDD VSS VSS gf180mcu_fd_sc_mcu7t5v0__fillcap_8
XTAP_TAPCELL_ROW_87_1146 VDD VSS gf180mcu_fd_sc_mcu7t5v0__filltie
XFILLER_55_267 VDD VDD VSS VSS gf180mcu_fd_sc_mcu7t5v0__fillcap_8
XFILLER_102_34 VDD VDD VSS VSS gf180mcu_fd_sc_mcu7t5v0__fill_1
X_3039_ _3039_/D _3416_/RN _3306_/CLK _3039_/Q VDD VDD VSS VSS gf180mcu_fd_sc_mcu7t5v0__dffsnq_1
XFILLER_43_418 VDD VDD VSS VSS gf180mcu_fd_sc_mcu7t5v0__fill_2
XFILLER_23_142 VDD VDD VSS VSS gf180mcu_fd_sc_mcu7t5v0__fillcap_32
XFILLER_11_348 VDD VDD VSS VSS gf180mcu_fd_sc_mcu7t5v0__fill_2
XTAP_TAPCELL_ROW_98_1264 VDD VSS gf180mcu_fd_sc_mcu7t5v0__filltie
XFILLER_19_404 VDD VDD VSS VSS gf180mcu_fd_sc_mcu7t5v0__fill_2
XFILLER_47_702 VDD VDD VSS VSS gf180mcu_fd_sc_mcu7t5v0__fill_2
XFILLER_47_757 VDD VDD VSS VSS gf180mcu_fd_sc_mcu7t5v0__fillcap_8
XTAP_TAPCELL_ROW_107_1360 VDD VSS gf180mcu_fd_sc_mcu7t5v0__filltie
XFILLER_36_61 VDD VDD VSS VSS gf180mcu_fd_sc_mcu7t5v0__fillcap_4
XFILLER_61_204 VDD VDD VSS VSS gf180mcu_fd_sc_mcu7t5v0__fillcap_4
XFILLER_15_632 VDD VDD VSS VSS gf180mcu_fd_sc_mcu7t5v0__fillcap_64
XFILLER_27_492 VDD VDD VSS VSS gf180mcu_fd_sc_mcu7t5v0__fillcap_64
XFILLER_30_613 VDD VDD VSS VSS gf180mcu_fd_sc_mcu7t5v0__fillcap_4
XTAP_TAPCELL_ROW_40_652 VDD VSS gf180mcu_fd_sc_mcu7t5v0__filltie
XTAP_TAPCELL_ROW_12_365 VDD VSS gf180mcu_fd_sc_mcu7t5v0__filltie
X_2410_ _2426_/A1 _2410_/A2 _2410_/Z VDD VDD VSS VSS gf180mcu_fd_sc_mcu7t5v0__and2_1
X_3390_ hold56/Z input1/Z _3399_/CLK _3390_/Q VDD VDD VSS VSS gf180mcu_fd_sc_mcu7t5v0__dffrnq_1
X_2341_ _3393_/Q _2335_/Z _2341_/B _2406_/C _2342_/C VDD VDD VSS VSS gf180mcu_fd_sc_mcu7t5v0__oai211_1
X_2272_ _3129_/Q _3128_/Q _2303_/A2 VDD VDD VSS VSS gf180mcu_fd_sc_mcu7t5v0__nand2_1
XFILLER_37_201 VDD VDD VSS VSS gf180mcu_fd_sc_mcu7t5v0__fill_2
XFILLER_25_407 VDD VDD VSS VSS gf180mcu_fd_sc_mcu7t5v0__fillcap_8
XFILLER_37_245 VDD VDD VSS VSS gf180mcu_fd_sc_mcu7t5v0__fill_1
XTAP_TAPCELL_ROW_48_741 VDD VSS gf180mcu_fd_sc_mcu7t5v0__filltie
XFILLER_80_524 VDD VDD VSS VSS gf180mcu_fd_sc_mcu7t5v0__fill_1
XTAP_TAPCELL_ROW_82_1098 VDD VSS gf180mcu_fd_sc_mcu7t5v0__filltie
X_1987_ _3115_/Q _3003_/Q _1990_/S _3003_/D VDD VDD VSS VSS gf180mcu_fd_sc_mcu7t5v0__mux2_2
XFILLER_107_718 VDD VDD VSS VSS gf180mcu_fd_sc_mcu7t5v0__fillcap_8
Xclkbuf_leaf_23_clk_i clkload2/I _3285_/CLK VDD VDD VSS VSS gf180mcu_fd_sc_mcu7t5v0__clkbuf_4
X_2608_ _3246_/Q _2680_/C _2732_/A3 _2608_/B2 _2609_/A2 VDD VDD VSS VSS gf180mcu_fd_sc_mcu7t5v0__aoi22_1
X_2539_ _3202_/Q _3194_/Q _2539_/S _3202_/D VDD VDD VSS VSS gf180mcu_fd_sc_mcu7t5v0__mux2_2
Xclkbuf_leaf_38_clk_i clkload4/I _3020_/CLK VDD VDD VSS VSS gf180mcu_fd_sc_mcu7t5v0__clkbuf_4
XFILLER_102_467 VDD VDD VSS VSS gf180mcu_fd_sc_mcu7t5v0__fill_1
XFILLER_56_543 VDD VDD VSS VSS gf180mcu_fd_sc_mcu7t5v0__fillcap_4
XFILLER_71_557 VDD VDD VSS VSS gf180mcu_fd_sc_mcu7t5v0__fill_2
XFILLER_12_613 VDD VDD VSS VSS gf180mcu_fd_sc_mcu7t5v0__fillcap_8
XFILLER_24_473 VDD VDD VSS VSS gf180mcu_fd_sc_mcu7t5v0__fill_1
XTAP_TAPCELL_ROW_54_799 VDD VSS gf180mcu_fd_sc_mcu7t5v0__filltie
XFILLER_12_657 VDD VDD VSS VSS gf180mcu_fd_sc_mcu7t5v0__fillcap_8
XFILLER_11_178 VDD VDD VSS VSS gf180mcu_fd_sc_mcu7t5v0__fill_1
XFILLER_22_63 VDD VDD VSS VSS gf180mcu_fd_sc_mcu7t5v0__fillcap_8
XFILLER_98_34 VDD VDD VSS VSS gf180mcu_fd_sc_mcu7t5v0__fill_1
XFILLER_94_638 VDD VDD VSS VSS gf180mcu_fd_sc_mcu7t5v0__fillcap_8
XFILLER_19_212 VDD VDD VSS VSS gf180mcu_fd_sc_mcu7t5v0__fillcap_64
XFILLER_47_60 VDD VDD VSS VSS gf180mcu_fd_sc_mcu7t5v0__fillcap_8
XTAP_TAPCELL_ROW_45_711 VDD VSS gf180mcu_fd_sc_mcu7t5v0__filltie
XFILLER_74_395 VDD VDD VSS VSS gf180mcu_fd_sc_mcu7t5v0__fill_2
XTAP_TAPCELL_ROW_17_413 VDD VSS gf180mcu_fd_sc_mcu7t5v0__filltie
XFILLER_15_462 VDD VDD VSS VSS gf180mcu_fd_sc_mcu7t5v0__fillcap_16
X_2890_ _2890_/D _2891_/CLK _2890_/Q VDD VDD VSS VSS gf180mcu_fd_sc_mcu7t5v0__dffq_1
X_1910_ _3112_/Q _2936_/Q _1916_/S _2936_/D VDD VDD VSS VSS gf180mcu_fd_sc_mcu7t5v0__mux2_2
X_1841_ _3287_/Q _2878_/Q _1841_/S _2878_/D VDD VDD VSS VSS gf180mcu_fd_sc_mcu7t5v0__mux2_2
X_1772_ _3283_/Q _2818_/Q _1776_/S _2818_/D VDD VDD VSS VSS gf180mcu_fd_sc_mcu7t5v0__mux2_2
XFILLER_8_98 VDD VDD VSS VSS gf180mcu_fd_sc_mcu7t5v0__fillcap_4
XFILLER_103_209 VDD VDD VSS VSS gf180mcu_fd_sc_mcu7t5v0__fill_1
X_3373_ _3399_/Q input1/Z _3408_/CLK hold54/I VDD VDD VSS VSS gf180mcu_fd_sc_mcu7t5v0__dffrnq_1
XFILLER_40_2 VDD VDD VSS VSS gf180mcu_fd_sc_mcu7t5v0__fillcap_8
XFILLER_97_432 VDD VDD VSS VSS gf180mcu_fd_sc_mcu7t5v0__fill_1
X_2324_ _2405_/S _2323_/Z _2327_/A2 VDD VDD VSS VSS gf180mcu_fd_sc_mcu7t5v0__nand2_1
XFILLER_84_104 VDD VDD VSS VSS gf180mcu_fd_sc_mcu7t5v0__fill_1
X_2255_ _3136_/Q _2255_/A2 _3102_/Q _2262_/B2 _2259_/A3 VDD VDD VSS VSS gf180mcu_fd_sc_mcu7t5v0__aoi22_1
X_2186_ _3128_/Q _2296_/A2 _2224_/B VDD VDD VSS VSS gf180mcu_fd_sc_mcu7t5v0__nor2_1
XFILLER_38_543 VDD VDD VSS VSS gf180mcu_fd_sc_mcu7t5v0__fill_1
XTAP_TAPCELL_ROW_84_1116 VDD VSS gf180mcu_fd_sc_mcu7t5v0__filltie
XFILLER_80_310 VDD VDD VSS VSS gf180mcu_fd_sc_mcu7t5v0__fillcap_4
XFILLER_53_557 VDD VDD VSS VSS gf180mcu_fd_sc_mcu7t5v0__fill_2
XFILLER_80_387 VDD VDD VSS VSS gf180mcu_fd_sc_mcu7t5v0__fillcap_32
XFILLER_33_270 VDD VDD VSS VSS gf180mcu_fd_sc_mcu7t5v0__fillcap_8
XTAP_TAPCELL_ROW_51_769 VDD VSS gf180mcu_fd_sc_mcu7t5v0__filltie
XTAP_TAPCELL_ROW_95_1234 VDD VSS gf180mcu_fd_sc_mcu7t5v0__filltie
XFILLER_0_303 VDD VDD VSS VSS gf180mcu_fd_sc_mcu7t5v0__fill_2
XFILLER_68_26 VDD VDD VSS VSS gf180mcu_fd_sc_mcu7t5v0__fill_1
XFILLER_68_37 VDD VDD VSS VSS gf180mcu_fd_sc_mcu7t5v0__fillcap_16
XFILLER_88_454 VDD VDD VSS VSS gf180mcu_fd_sc_mcu7t5v0__fill_1
XFILLER_75_126 VDD VDD VSS VSS gf180mcu_fd_sc_mcu7t5v0__fillcap_4
XTAP_TAPCELL_ROW_59_858 VDD VSS gf180mcu_fd_sc_mcu7t5v0__filltie
XFILLER_56_384 VDD VDD VSS VSS gf180mcu_fd_sc_mcu7t5v0__fill_1
XFILLER_71_343 VDD VDD VSS VSS gf180mcu_fd_sc_mcu7t5v0__fillcap_4
XTAP_TAPCELL_ROW_104_1330 VDD VSS gf180mcu_fd_sc_mcu7t5v0__filltie
XFILLER_8_403 VDD VDD VSS VSS gf180mcu_fd_sc_mcu7t5v0__fill_2
XTAP_TAPCELL_ROW_22_460 VDD VSS gf180mcu_fd_sc_mcu7t5v0__filltie
XFILLER_106_592 VDD VDD VSS VSS gf180mcu_fd_sc_mcu7t5v0__fill_2
XFILLER_94_435 VDD VDD VSS VSS gf180mcu_fd_sc_mcu7t5v0__fillcap_4
XFILLER_66_104 VDD VDD VSS VSS gf180mcu_fd_sc_mcu7t5v0__fill_1
XFILLER_94_457 VDD VDD VSS VSS gf180mcu_fd_sc_mcu7t5v0__fill_2
X_2040_ _3031_/Q _2010_/Z _2048_/A4 _2045_/A3 VDD VDD VSS VSS gf180mcu_fd_sc_mcu7t5v0__nand3_1
XFILLER_66_159 VDD VDD VSS VSS gf180mcu_fd_sc_mcu7t5v0__fill_2
XFILLER_90_630 VDD VDD VSS VSS gf180mcu_fd_sc_mcu7t5v0__fillcap_8
XFILLER_35_535 VDD VDD VSS VSS gf180mcu_fd_sc_mcu7t5v0__fillcap_4
XFILLER_74_192 VDD VDD VSS VSS gf180mcu_fd_sc_mcu7t5v0__fillcap_4
XFILLER_62_343 VDD VDD VSS VSS gf180mcu_fd_sc_mcu7t5v0__fillcap_4
XFILLER_15_270 VDD VDD VSS VSS gf180mcu_fd_sc_mcu7t5v0__fill_2
X_2942_ _2942_/D _2954_/CLK _2942_/Q VDD VDD VSS VSS gf180mcu_fd_sc_mcu7t5v0__dffq_1
XFILLER_31_730 VDD VDD VSS VSS gf180mcu_fd_sc_mcu7t5v0__fill_1
XFILLER_62_387 VDD VDD VSS VSS gf180mcu_fd_sc_mcu7t5v0__fillcap_4
X_2873_ _2873_/D _2891_/CLK _2873_/Q VDD VDD VSS VSS gf180mcu_fd_sc_mcu7t5v0__dffq_1
XFILLER_90_90 VDD VDD VSS VSS gf180mcu_fd_sc_mcu7t5v0__fillcap_8
XFILLER_88_2 VDD VDD VSS VSS gf180mcu_fd_sc_mcu7t5v0__fillcap_16
X_1824_ _1458_/Z _1851_/A2 _1832_/S VDD VDD VSS VSS gf180mcu_fd_sc_mcu7t5v0__nand2_1
X_1755_ _3284_/Q _2803_/Q _1758_/S _2803_/D VDD VDD VSS VSS gf180mcu_fd_sc_mcu7t5v0__mux2_2
XFILLER_89_218 VDD VDD VSS VSS gf180mcu_fd_sc_mcu7t5v0__fill_1
X_1686_ _3148_/Q _1645_/Z _1686_/B _1686_/C _1687_/I VDD VDD VSS VSS gf180mcu_fd_sc_mcu7t5v0__oai211_1
X_3425_ _3425_/D _3416_/RN _3425_/CLK _3425_/Q VDD VDD VSS VSS gf180mcu_fd_sc_mcu7t5v0__dffsnq_1
XTAP_TAPCELL_ROW_90_1175 VDD VSS gf180mcu_fd_sc_mcu7t5v0__filltie
X_3356_ _3356_/D _3369_/RN _3358_/CLK _3356_/Q VDD VDD VSS VSS gf180mcu_fd_sc_mcu7t5v0__dffrnq_1
XFILLER_58_605 VDD VDD VSS VSS gf180mcu_fd_sc_mcu7t5v0__fillcap_4
X_2307_ _3130_/Q _2309_/A2 _2427_/B _2313_/A2 VDD VDD VSS VSS gf180mcu_fd_sc_mcu7t5v0__aoi21_1
XFILLER_38_29 VDD VDD VSS VSS gf180mcu_fd_sc_mcu7t5v0__fillcap_4
XFILLER_57_104 VDD VDD VSS VSS gf180mcu_fd_sc_mcu7t5v0__fillcap_4
X_3287_ _3287_/D _3369_/RN _3287_/CLK _3287_/Q VDD VDD VSS VSS gf180mcu_fd_sc_mcu7t5v0__dffrnq_1
X_2238_ _2263_/A1 _2242_/S _2238_/B _3113_/D VDD VDD VSS VSS gf180mcu_fd_sc_mcu7t5v0__oai21_1
XTAP_TAPCELL_ROW_56_817 VDD VSS gf180mcu_fd_sc_mcu7t5v0__filltie
XFILLER_72_107 VDD VDD VSS VSS gf180mcu_fd_sc_mcu7t5v0__fillcap_16
XFILLER_26_524 VDD VDD VSS VSS gf180mcu_fd_sc_mcu7t5v0__fill_1
X_2169_ _3320_/Q _3212_/Q _3213_/Q _2732_/A2 _2178_/S VDD VDD VSS VSS gf180mcu_fd_sc_mcu7t5v0__and4_1
XFILLER_65_170 VDD VDD VSS VSS gf180mcu_fd_sc_mcu7t5v0__fill_1
XFILLER_81_685 VDD VDD VSS VSS gf180mcu_fd_sc_mcu7t5v0__fill_1
XFILLER_80_173 VDD VDD VSS VSS gf180mcu_fd_sc_mcu7t5v0__fill_2
XFILLER_21_273 VDD VDD VSS VSS gf180mcu_fd_sc_mcu7t5v0__fillcap_4
XFILLER_107_345 VDD VDD VSS VSS gf180mcu_fd_sc_mcu7t5v0__fillcap_4
XFILLER_103_562 VDD VDD VSS VSS gf180mcu_fd_sc_mcu7t5v0__fillcap_8
XFILLER_103_551 VDD VDD VSS VSS gf180mcu_fd_sc_mcu7t5v0__fillcap_8
XFILLER_49_616 VDD VDD VSS VSS gf180mcu_fd_sc_mcu7t5v0__fillcap_8
XFILLER_76_457 VDD VDD VSS VSS gf180mcu_fd_sc_mcu7t5v0__fill_1
XFILLER_17_557 VDD VDD VSS VSS gf180mcu_fd_sc_mcu7t5v0__fill_2
XFILLER_32_527 VDD VDD VSS VSS gf180mcu_fd_sc_mcu7t5v0__fillcap_32
XFILLER_44_387 VDD VDD VSS VSS gf180mcu_fd_sc_mcu7t5v0__fillcap_64
XFILLER_25_590 VDD VDD VSS VSS gf180mcu_fd_sc_mcu7t5v0__fill_1
XFILLER_8_233 VDD VDD VSS VSS gf180mcu_fd_sc_mcu7t5v0__fill_1
X_1540_ _3307_/Q _2420_/B _1541_/B1 VDD VDD VSS VSS gf180mcu_fd_sc_mcu7t5v0__nor2_1
X_1471_ _1786_/A2 _1471_/A2 _3402_/D VDD VDD VSS VSS gf180mcu_fd_sc_mcu7t5v0__xor2_1
XFILLER_4_472 VDD VDD VSS VSS gf180mcu_fd_sc_mcu7t5v0__fillcap_8
XFILLER_5_66 VDD VDD VSS VSS gf180mcu_fd_sc_mcu7t5v0__fillcap_4
X_3210_ _3210_/D _3328_/RN _3257_/CLK _3210_/Q VDD VDD VSS VSS gf180mcu_fd_sc_mcu7t5v0__dffrnq_1
XFILLER_69_80 VDD VDD VSS VSS gf180mcu_fd_sc_mcu7t5v0__fillcap_4
X_3141_ _3141_/D _3369_/RN _3148_/CLK _3141_/Q VDD VDD VSS VSS gf180mcu_fd_sc_mcu7t5v0__dffrnq_1
XFILLER_67_402 VDD VDD VSS VSS gf180mcu_fd_sc_mcu7t5v0__fillcap_16
XFILLER_39_137 VDD VDD VSS VSS gf180mcu_fd_sc_mcu7t5v0__fill_2
X_3072_ _3072_/D _3328_/RN _3222_/CLK _3072_/Q VDD VDD VSS VSS gf180mcu_fd_sc_mcu7t5v0__dffrnq_1
X_2023_ _2061_/A2 _2024_/A3 _2023_/B _3026_/Q _2024_/B VDD VDD VSS VSS gf180mcu_fd_sc_mcu7t5v0__oai211_1
XFILLER_82_449 VDD VDD VSS VSS gf180mcu_fd_sc_mcu7t5v0__fill_1
XFILLER_35_310 VDD VDD VSS VSS gf180mcu_fd_sc_mcu7t5v0__fill_2
XFILLER_62_151 VDD VDD VSS VSS gf180mcu_fd_sc_mcu7t5v0__fill_2
XFILLER_63_696 VDD VDD VSS VSS gf180mcu_fd_sc_mcu7t5v0__fillcap_4
XFILLER_16_590 VDD VDD VSS VSS gf180mcu_fd_sc_mcu7t5v0__fillcap_4
XFILLER_50_357 VDD VDD VSS VSS gf180mcu_fd_sc_mcu7t5v0__fill_2
XTAP_TAPCELL_ROW_33_577 VDD VSS gf180mcu_fd_sc_mcu7t5v0__filltie
X_2925_ _2925_/D _2958_/CLK _2925_/Q VDD VDD VSS VSS gf180mcu_fd_sc_mcu7t5v0__dffq_1
XFILLER_50_379 VDD VDD VSS VSS gf180mcu_fd_sc_mcu7t5v0__fillcap_4
XTAP_TAPCELL_ROW_61_875 VDD VSS gf180mcu_fd_sc_mcu7t5v0__filltie
X_2856_ _2856_/D _2858_/CLK _2856_/Q VDD VDD VSS VSS gf180mcu_fd_sc_mcu7t5v0__dffq_1
X_1807_ _3281_/Q _2848_/Q _1813_/S _2848_/D VDD VDD VSS VSS gf180mcu_fd_sc_mcu7t5v0__mux2_2
XTAP_TAPCELL_ROW_79_1059 VDD VSS gf180mcu_fd_sc_mcu7t5v0__filltie
X_2787_ _2787_/D _2828_/CLK _2787_/Q VDD VDD VSS VSS gf180mcu_fd_sc_mcu7t5v0__dffq_1
XTAP_TAPCELL_ROW_92_1204 VDD VSS gf180mcu_fd_sc_mcu7t5v0__filltie
X_1738_ _2790_/Q _3287_/Q _1738_/S _2790_/D VDD VDD VSS VSS gf180mcu_fd_sc_mcu7t5v0__mux2_2
X_1669_ _3144_/Q _2427_/A1 _2187_/A2 VDD VDD VSS VSS gf180mcu_fd_sc_mcu7t5v0__nand2_1
X_3408_ _3408_/D input1/Z _3408_/CLK _3408_/Q VDD VDD VSS VSS gf180mcu_fd_sc_mcu7t5v0__dffrnq_1
XFILLER_98_593 VDD VDD VSS VSS gf180mcu_fd_sc_mcu7t5v0__fill_2
XFILLER_86_733 VDD VDD VSS VSS gf180mcu_fd_sc_mcu7t5v0__fill_2
X_3339_ hold52/Z _3369_/RN _3369_/CLK _3339_/Q VDD VDD VSS VSS gf180mcu_fd_sc_mcu7t5v0__dffrnq_1
XFILLER_58_457 VDD VDD VSS VSS gf180mcu_fd_sc_mcu7t5v0__fillcap_16
XFILLER_85_276 VDD VDD VSS VSS gf180mcu_fd_sc_mcu7t5v0__fillcap_4
XFILLER_65_49 VDD VDD VSS VSS gf180mcu_fd_sc_mcu7t5v0__fillcap_16
XFILLER_85_298 VDD VDD VSS VSS gf180mcu_fd_sc_mcu7t5v0__fill_1
XFILLER_26_387 VDD VDD VSS VSS gf180mcu_fd_sc_mcu7t5v0__fillcap_64
XFILLER_14_86 VDD VDD VSS VSS gf180mcu_fd_sc_mcu7t5v0__fillcap_16
XFILLER_107_120 VDD VDD VSS VSS gf180mcu_fd_sc_mcu7t5v0__fillcap_8
XFILLER_6_737 VDD VDD VSS VSS gf180mcu_fd_sc_mcu7t5v0__fillcap_16
XFILLER_107_142 VDD VDD VSS VSS gf180mcu_fd_sc_mcu7t5v0__fillcap_32
XFILLER_39_72 VDD VDD VSS VSS gf180mcu_fd_sc_mcu7t5v0__fillcap_4
XFILLER_36_107 VDD VDD VSS VSS gf180mcu_fd_sc_mcu7t5v0__fillcap_8
XPHY_EDGE_ROW_101_Right_101 VDD VSS gf180mcu_fd_sc_mcu7t5v0__endcap
XFILLER_17_310 VDD VDD VSS VSS gf180mcu_fd_sc_mcu7t5v0__fill_2
XTAP_TAPCELL_ROW_4_280 VDD VSS gf180mcu_fd_sc_mcu7t5v0__filltie
XFILLER_91_268 VDD VDD VSS VSS gf180mcu_fd_sc_mcu7t5v0__fillcap_8
XFILLER_91_246 VDD VDD VSS VSS gf180mcu_fd_sc_mcu7t5v0__fill_1
X_2710_ _2687_/Z _2710_/A2 _3266_/D VDD VDD VSS VSS gf180mcu_fd_sc_mcu7t5v0__nand2_1
XFILLER_71_92 VDD VDD VSS VSS gf180mcu_fd_sc_mcu7t5v0__fill_2
XFILLER_9_564 VDD VDD VSS VSS gf180mcu_fd_sc_mcu7t5v0__fill_1
XTAP_TAPCELL_ROW_30_547 VDD VSS gf180mcu_fd_sc_mcu7t5v0__filltie
X_2641_ _2641_/I0 _3249_/Q _2680_/C _3249_/D VDD VDD VSS VSS gf180mcu_fd_sc_mcu7t5v0__mux2_2
X_2572_ _3190_/Q _3232_/Q _2585_/S _3232_/D VDD VDD VSS VSS gf180mcu_fd_sc_mcu7t5v0__mux2_2
XFILLER_99_335 VDD VDD VSS VSS gf180mcu_fd_sc_mcu7t5v0__fillcap_4
X_1523_ _3126_/Q _3125_/Q _1525_/B2 _1523_/B _3306_/D VDD VDD VSS VSS gf180mcu_fd_sc_mcu7t5v0__oai31_1
XFILLER_87_508 VDD VDD VSS VSS gf180mcu_fd_sc_mcu7t5v0__fillcap_4
X_1454_ _3409_/Q _1454_/A2 _1453_/Z _1455_/I VDD VDD VSS VSS gf180mcu_fd_sc_mcu7t5v0__nor3_1
XFILLER_68_733 VDD VDD VSS VSS gf180mcu_fd_sc_mcu7t5v0__fill_2
X_1385_ _3209_/Q _2587_/A1 VDD VDD VSS VSS gf180mcu_fd_sc_mcu7t5v0__clkinv_1
X_3124_ _3124_/D _3416_/RN _3416_/CLK _3124_/Q VDD VDD VSS VSS gf180mcu_fd_sc_mcu7t5v0__dffrnq_1
XFILLER_67_276 VDD VDD VSS VSS gf180mcu_fd_sc_mcu7t5v0__fillcap_4
XFILLER_82_213 VDD VDD VSS VSS gf180mcu_fd_sc_mcu7t5v0__fill_2
XTAP_TAPCELL_ROW_38_636 VDD VSS gf180mcu_fd_sc_mcu7t5v0__filltie
X_3055_ _3055_/D _3303_/RN _3297_/CLK _3055_/Q VDD VDD VSS VSS gf180mcu_fd_sc_mcu7t5v0__dffrnq_1
XTAP_TAPCELL_ROW_66_923 VDD VSS gf180mcu_fd_sc_mcu7t5v0__filltie
X_2006_ _3116_/Q _3020_/Q _2008_/S _3020_/D VDD VDD VSS VSS gf180mcu_fd_sc_mcu7t5v0__mux2_2
XFILLER_35_195 VDD VDD VSS VSS gf180mcu_fd_sc_mcu7t5v0__fill_2
XFILLER_50_143 VDD VDD VSS VSS gf180mcu_fd_sc_mcu7t5v0__fillcap_8
X_2908_ _2908_/D _3119_/CLK _2908_/Q VDD VDD VSS VSS gf180mcu_fd_sc_mcu7t5v0__dffq_1
X_2839_ _2839_/D _3314_/CLK _2839_/Q VDD VDD VSS VSS gf180mcu_fd_sc_mcu7t5v0__dffq_1
XFILLER_104_101 VDD VDD VSS VSS gf180mcu_fd_sc_mcu7t5v0__fillcap_4
XFILLER_104_134 VDD VDD VSS VSS gf180mcu_fd_sc_mcu7t5v0__fillcap_4
XFILLER_100_362 VDD VDD VSS VSS gf180mcu_fd_sc_mcu7t5v0__fillcap_8
XFILLER_18_107 VDD VDD VSS VSS gf180mcu_fd_sc_mcu7t5v0__fillcap_16
XFILLER_92_14 VDD VDD VSS VSS gf180mcu_fd_sc_mcu7t5v0__fill_1
XFILLER_27_641 VDD VDD VSS VSS gf180mcu_fd_sc_mcu7t5v0__fillcap_4
XFILLER_92_69 VDD VDD VSS VSS gf180mcu_fd_sc_mcu7t5v0__fillcap_8
XFILLER_73_279 VDD VDD VSS VSS gf180mcu_fd_sc_mcu7t5v0__fill_1
XFILLER_42_699 VDD VDD VSS VSS gf180mcu_fd_sc_mcu7t5v0__fill_2
XFILLER_2_34 VDD VDD VSS VSS gf180mcu_fd_sc_mcu7t5v0__fill_1
XFILLER_65_725 VDD VDD VSS VSS gf180mcu_fd_sc_mcu7t5v0__fillcap_4
XFILLER_18_663 VDD VDD VSS VSS gf180mcu_fd_sc_mcu7t5v0__fill_2
XFILLER_80_739 VDD VDD VSS VSS gf180mcu_fd_sc_mcu7t5v0__fill_1
XFILLER_18_696 VDD VDD VSS VSS gf180mcu_fd_sc_mcu7t5v0__fillcap_32
XTAP_TAPCELL_ROW_35_606 VDD VSS gf180mcu_fd_sc_mcu7t5v0__filltie
XFILLER_60_441 VDD VDD VSS VSS gf180mcu_fd_sc_mcu7t5v0__fillcap_8
XTAP_TAPCELL_ROW_43_683 VDD VSS gf180mcu_fd_sc_mcu7t5v0__filltie
XTAP_TAPCELL_ROW_71_981 VDD VSS gf180mcu_fd_sc_mcu7t5v0__filltie
XTAP_TAPCELL_ROW_15_396 VDD VSS gf180mcu_fd_sc_mcu7t5v0__filltie
XFILLER_70_2 VDD VDD VSS VSS gf180mcu_fd_sc_mcu7t5v0__fillcap_16
XTAP_TAPCELL_ROW_76_1029 VDD VSS gf180mcu_fd_sc_mcu7t5v0__filltie
X_2624_ _2622_/Z _2623_/Z _2621_/Z _2620_/Z _3353_/Q _3354_/Q _2624_/Z VDD VDD VSS
+ VSS gf180mcu_fd_sc_mcu7t5v0__mux4_1
XTAP_TAPCELL_ROW_7_309 VDD VSS gf180mcu_fd_sc_mcu7t5v0__filltie
X_2555_ _3173_/Q _3215_/Q _2569_/S _3215_/D VDD VDD VSS VSS gf180mcu_fd_sc_mcu7t5v0__mux2_2
XFILLER_87_327 VDD VDD VSS VSS gf180mcu_fd_sc_mcu7t5v0__fillcap_4
X_2486_ _1610_/Z _1612_/Z _2491_/A2 VDD VDD VSS VSS gf180mcu_fd_sc_mcu7t5v0__nor2_1
X_1506_ _3368_/Q _1506_/A2 _3363_/D VDD VDD VSS VSS gf180mcu_fd_sc_mcu7t5v0__xnor2_1
X_1437_ _3392_/Q _1436_/Z _1445_/A2 VDD VDD VSS VSS gf180mcu_fd_sc_mcu7t5v0__nor2_1
X_1368_ _3120_/Q _2269_/B2 VDD VDD VSS VSS gf180mcu_fd_sc_mcu7t5v0__clkinv_1
Xmax_cap19 _2427_/B _2438_/A2 VDD VDD VSS VSS gf180mcu_fd_sc_mcu7t5v0__buf_2
X_3107_ _3107_/D _3416_/RN _3287_/CLK _3107_/Q VDD VDD VSS VSS gf180mcu_fd_sc_mcu7t5v0__dffrnq_1
XTAP_TAPCELL_ROW_87_1147 VDD VSS gf180mcu_fd_sc_mcu7t5v0__filltie
XFILLER_55_235 VDD VDD VSS VSS gf180mcu_fd_sc_mcu7t5v0__fillcap_32
XFILLER_71_706 VDD VDD VSS VSS gf180mcu_fd_sc_mcu7t5v0__fill_1
X_3038_ _3038_/D _3416_/RN _3424_/CLK _3038_/Q VDD VDD VSS VSS gf180mcu_fd_sc_mcu7t5v0__dffrnq_1
XFILLER_55_279 VDD VDD VSS VSS gf180mcu_fd_sc_mcu7t5v0__fill_1
XFILLER_70_205 VDD VDD VSS VSS gf180mcu_fd_sc_mcu7t5v0__fillcap_4
XTAP_TAPCELL_ROW_98_1265 VDD VSS gf180mcu_fd_sc_mcu7t5v0__filltie
XFILLER_105_465 VDD VDD VSS VSS gf180mcu_fd_sc_mcu7t5v0__fillcap_4
XFILLER_105_487 VDD VDD VSS VSS gf180mcu_fd_sc_mcu7t5v0__fill_2
XFILLER_59_541 VDD VDD VSS VSS gf180mcu_fd_sc_mcu7t5v0__fillcap_4
XFILLER_19_438 VDD VDD VSS VSS gf180mcu_fd_sc_mcu7t5v0__fill_1
XTAP_TAPCELL_ROW_107_1361 VDD VSS gf180mcu_fd_sc_mcu7t5v0__filltie
XFILLER_42_441 VDD VDD VSS VSS gf180mcu_fd_sc_mcu7t5v0__fillcap_8
XFILLER_70_761 VDD VDD VSS VSS gf180mcu_fd_sc_mcu7t5v0__fillcap_4
XFILLER_30_625 VDD VDD VSS VSS gf180mcu_fd_sc_mcu7t5v0__fillcap_8
XTAP_TAPCELL_ROW_40_653 VDD VSS gf180mcu_fd_sc_mcu7t5v0__filltie
XTAP_TAPCELL_ROW_12_355 VDD VSS gf180mcu_fd_sc_mcu7t5v0__filltie
XFILLER_10_393 VDD VDD VSS VSS gf180mcu_fd_sc_mcu7t5v0__fill_1
Xclkbuf_leaf_4_clk_i clkbuf_leaf_5_clk_i/I clkload9/I VDD VDD VSS VSS gf180mcu_fd_sc_mcu7t5v0__clkbuf_4
X_2340_ _3393_/Q _2340_/A2 _2340_/A3 _2341_/B VDD VDD VSS VSS gf180mcu_fd_sc_mcu7t5v0__nand3_1
XFILLER_97_647 VDD VDD VSS VSS gf180mcu_fd_sc_mcu7t5v0__fillcap_8
XFILLER_96_135 VDD VDD VSS VSS gf180mcu_fd_sc_mcu7t5v0__fill_1
X_2271_ _2407_/A1 _2271_/A2 _2271_/B _3121_/D VDD VDD VSS VSS gf180mcu_fd_sc_mcu7t5v0__oai21_1
XFILLER_96_179 VDD VDD VSS VSS gf180mcu_fd_sc_mcu7t5v0__fill_1
XFILLER_92_341 VDD VDD VSS VSS gf180mcu_fd_sc_mcu7t5v0__fill_1
XFILLER_37_235 VDD VDD VSS VSS gf180mcu_fd_sc_mcu7t5v0__fillcap_8
XFILLER_38_758 VDD VDD VSS VSS gf180mcu_fd_sc_mcu7t5v0__fillcap_4
XTAP_TAPCELL_ROW_48_742 VDD VSS gf180mcu_fd_sc_mcu7t5v0__filltie
XFILLER_65_566 VDD VDD VSS VSS gf180mcu_fd_sc_mcu7t5v0__fill_2
XFILLER_25_419 VDD VDD VSS VSS gf180mcu_fd_sc_mcu7t5v0__fill_1
XTAP_TAPCELL_ROW_82_1099 VDD VSS gf180mcu_fd_sc_mcu7t5v0__filltie
X_1986_ _3114_/Q _3002_/Q _1990_/S _3002_/D VDD VDD VSS VSS gf180mcu_fd_sc_mcu7t5v0__mux2_2
X_2607_ _2126_/B _2680_/C _2607_/Z VDD VDD VSS VSS gf180mcu_fd_sc_mcu7t5v0__or2_1
X_2538_ _3201_/Q _3193_/Q _2539_/S _3201_/D VDD VDD VSS VSS gf180mcu_fd_sc_mcu7t5v0__mux2_2
XFILLER_0_507 VDD VDD VSS VSS gf180mcu_fd_sc_mcu7t5v0__fill_2
XFILLER_102_457 VDD VDD VSS VSS gf180mcu_fd_sc_mcu7t5v0__fillcap_8
X_2469_ _2469_/A1 _2469_/A2 _2469_/B _2469_/C _2472_/A1 VDD VDD VSS VSS gf180mcu_fd_sc_mcu7t5v0__aoi211_1
XFILLER_57_39 VDD VDD VSS VSS gf180mcu_fd_sc_mcu7t5v0__fillcap_8
XFILLER_28_202 VDD VDD VSS VSS gf180mcu_fd_sc_mcu7t5v0__fill_1
XFILLER_29_725 VDD VDD VSS VSS gf180mcu_fd_sc_mcu7t5v0__fillcap_4
XFILLER_56_522 VDD VDD VSS VSS gf180mcu_fd_sc_mcu7t5v0__fill_2
XFILLER_83_352 VDD VDD VSS VSS gf180mcu_fd_sc_mcu7t5v0__fillcap_16
XFILLER_43_227 VDD VDD VSS VSS gf180mcu_fd_sc_mcu7t5v0__fillcap_4
XFILLER_24_441 VDD VDD VSS VSS gf180mcu_fd_sc_mcu7t5v0__fillcap_8
XFILLER_12_625 VDD VDD VSS VSS gf180mcu_fd_sc_mcu7t5v0__fill_2
XFILLER_51_271 VDD VDD VSS VSS gf180mcu_fd_sc_mcu7t5v0__fillcap_8
XFILLER_11_124 VDD VDD VSS VSS gf180mcu_fd_sc_mcu7t5v0__fill_1
XFILLER_105_262 VDD VDD VSS VSS gf180mcu_fd_sc_mcu7t5v0__fillcap_16
XFILLER_0_2 VDD VDD VSS VSS gf180mcu_fd_sc_mcu7t5v0__fillcap_32
XFILLER_3_367 VDD VDD VSS VSS gf180mcu_fd_sc_mcu7t5v0__fillcap_16
XFILLER_47_72 VDD VDD VSS VSS gf180mcu_fd_sc_mcu7t5v0__fillcap_8
XFILLER_47_533 VDD VDD VSS VSS gf180mcu_fd_sc_mcu7t5v0__fillcap_16
XTAP_TAPCELL_ROW_17_414 VDD VSS gf180mcu_fd_sc_mcu7t5v0__filltie
X_1840_ _3286_/Q _2877_/Q _1841_/S _2877_/D VDD VDD VSS VSS gf180mcu_fd_sc_mcu7t5v0__mux2_2
X_1771_ _3282_/Q _2817_/Q _1776_/S _2817_/D VDD VDD VSS VSS gf180mcu_fd_sc_mcu7t5v0__mux2_2
XFILLER_7_640 VDD VDD VSS VSS gf180mcu_fd_sc_mcu7t5v0__fill_2
XFILLER_7_673 VDD VDD VSS VSS gf180mcu_fd_sc_mcu7t5v0__fillcap_8
X_3372_ _3398_/Q _3416_/RN _3407_/CLK hold42/I VDD VDD VSS VSS gf180mcu_fd_sc_mcu7t5v0__dffrnq_1
XFILLER_97_422 VDD VDD VSS VSS gf180mcu_fd_sc_mcu7t5v0__fillcap_8
XFILLER_33_2 VDD VDD VSS VSS gf180mcu_fd_sc_mcu7t5v0__fillcap_4
X_2323_ _2855_/Q _2847_/Q _2839_/Q _2831_/Q _3391_/Q _2388_/S1 _2323_/Z VDD VDD VSS
+ VSS gf180mcu_fd_sc_mcu7t5v0__mux4_1
XFILLER_85_628 VDD VDD VSS VSS gf180mcu_fd_sc_mcu7t5v0__fill_2
X_2254_ _3136_/Q _2255_/A2 _2254_/Z VDD VDD VSS VSS gf180mcu_fd_sc_mcu7t5v0__or2_1
X_2185_ _2185_/A1 _2185_/A2 _2185_/B _3106_/D VDD VDD VSS VSS gf180mcu_fd_sc_mcu7t5v0__aoi21_1
XFILLER_92_160 VDD VDD VSS VSS gf180mcu_fd_sc_mcu7t5v0__fillcap_8
XFILLER_65_352 VDD VDD VSS VSS gf180mcu_fd_sc_mcu7t5v0__fillcap_16
XFILLER_92_193 VDD VDD VSS VSS gf180mcu_fd_sc_mcu7t5v0__fillcap_4
XTAP_TAPCELL_ROW_84_1117 VDD VSS gf180mcu_fd_sc_mcu7t5v0__filltie
XFILLER_21_400 VDD VDD VSS VSS gf180mcu_fd_sc_mcu7t5v0__fillcap_4
XFILLER_21_422 VDD VDD VSS VSS gf180mcu_fd_sc_mcu7t5v0__fillcap_8
X_1969_ _3116_/Q _2988_/Q _1971_/S _2988_/D VDD VDD VSS VSS gf180mcu_fd_sc_mcu7t5v0__mux2_2
XTAP_TAPCELL_ROW_95_1235 VDD VSS gf180mcu_fd_sc_mcu7t5v0__filltie
XFILLER_102_287 VDD VDD VSS VSS gf180mcu_fd_sc_mcu7t5v0__fill_2
XFILLER_84_48 VDD VDD VSS VSS gf180mcu_fd_sc_mcu7t5v0__fillcap_4
XFILLER_29_577 VDD VDD VSS VSS gf180mcu_fd_sc_mcu7t5v0__fillcap_4
XFILLER_56_374 VDD VDD VSS VSS gf180mcu_fd_sc_mcu7t5v0__fillcap_8
XTAP_TAPCELL_ROW_104_1331 VDD VSS gf180mcu_fd_sc_mcu7t5v0__filltie
XFILLER_71_388 VDD VDD VSS VSS gf180mcu_fd_sc_mcu7t5v0__fill_2
XFILLER_40_764 VDD VDD VSS VSS gf180mcu_fd_sc_mcu7t5v0__fill_1
XFILLER_52_591 VDD VDD VSS VSS gf180mcu_fd_sc_mcu7t5v0__fillcap_4
XTAP_TAPCELL_ROW_22_461 VDD VSS gf180mcu_fd_sc_mcu7t5v0__filltie
XFILLER_79_422 VDD VDD VSS VSS gf180mcu_fd_sc_mcu7t5v0__fillcap_16
XFILLER_79_466 VDD VDD VSS VSS gf180mcu_fd_sc_mcu7t5v0__fillcap_8
XFILLER_79_455 VDD VDD VSS VSS gf180mcu_fd_sc_mcu7t5v0__fill_2
XFILLER_79_444 VDD VDD VSS VSS gf180mcu_fd_sc_mcu7t5v0__fill_1
XFILLER_79_488 VDD VDD VSS VSS gf180mcu_fd_sc_mcu7t5v0__fill_2
XFILLER_47_352 VDD VDD VSS VSS gf180mcu_fd_sc_mcu7t5v0__fillcap_4
XFILLER_90_642 VDD VDD VSS VSS gf180mcu_fd_sc_mcu7t5v0__fill_2
Xclkbuf_leaf_22_clk_i clkload2/I _3148_/CLK VDD VDD VSS VSS gf180mcu_fd_sc_mcu7t5v0__clkbuf_4
XFILLER_74_171 VDD VDD VSS VSS gf180mcu_fd_sc_mcu7t5v0__fillcap_4
XFILLER_16_761 VDD VDD VSS VSS gf180mcu_fd_sc_mcu7t5v0__fillcap_4
XFILLER_35_558 VDD VDD VSS VSS gf180mcu_fd_sc_mcu7t5v0__fill_2
X_2941_ _2941_/D _3253_/CLK _2941_/Q VDD VDD VSS VSS gf180mcu_fd_sc_mcu7t5v0__dffq_1
XFILLER_31_720 VDD VDD VSS VSS gf180mcu_fd_sc_mcu7t5v0__fillcap_8
Xclkbuf_leaf_37_clk_i clkload4/I _3016_/CLK VDD VDD VSS VSS gf180mcu_fd_sc_mcu7t5v0__clkbuf_4
X_2872_ _2872_/D _2891_/CLK _2872_/Q VDD VDD VSS VSS gf180mcu_fd_sc_mcu7t5v0__dffq_1
X_1823_ _3406_/Q _3407_/Q _1851_/A2 VDD VDD VSS VSS gf180mcu_fd_sc_mcu7t5v0__nor2_1
X_1754_ _3283_/Q _2802_/Q _1758_/S _2802_/D VDD VDD VSS VSS gf180mcu_fd_sc_mcu7t5v0__mux2_2
XFILLER_7_492 VDD VDD VSS VSS gf180mcu_fd_sc_mcu7t5v0__fillcap_16
X_3424_ _3424_/D _3416_/RN _3424_/CLK _3424_/Q VDD VDD VSS VSS gf180mcu_fd_sc_mcu7t5v0__dffsnq_1
XFILLER_89_208 VDD VDD VSS VSS gf180mcu_fd_sc_mcu7t5v0__fill_2
X_1685_ _3148_/Q _3380_/Q _2406_/C _1686_/C VDD VDD VSS VSS gf180mcu_fd_sc_mcu7t5v0__nand3_1
XFILLER_98_764 VDD VDD VSS VSS gf180mcu_fd_sc_mcu7t5v0__fill_1
XFILLER_97_230 VDD VDD VSS VSS gf180mcu_fd_sc_mcu7t5v0__fill_1
X_3355_ _3355_/D input1/Z _3358_/CLK _3355_/Q VDD VDD VSS VSS gf180mcu_fd_sc_mcu7t5v0__dffrnq_1
X_2306_ _2306_/A1 _2306_/A2 _3129_/D VDD VDD VSS VSS gf180mcu_fd_sc_mcu7t5v0__nor2_1
XTAP_TAPCELL_ROW_90_1176 VDD VSS gf180mcu_fd_sc_mcu7t5v0__filltie
X_3286_ _3286_/D _3369_/RN _3286_/CLK _3286_/Q VDD VDD VSS VSS gf180mcu_fd_sc_mcu7t5v0__dffrnq_1
XFILLER_85_436 VDD VDD VSS VSS gf180mcu_fd_sc_mcu7t5v0__fill_1
XFILLER_57_138 VDD VDD VSS VSS gf180mcu_fd_sc_mcu7t5v0__fill_2
X_2237_ _3113_/Q _2242_/S _2238_/B VDD VDD VSS VSS gf180mcu_fd_sc_mcu7t5v0__nand2_1
XTAP_TAPCELL_ROW_56_818 VDD VSS gf180mcu_fd_sc_mcu7t5v0__filltie
XFILLER_66_661 VDD VDD VSS VSS gf180mcu_fd_sc_mcu7t5v0__fillcap_4
X_2168_ _3206_/Q _3208_/Q _1517_/Z _2601_/A2 _2732_/A2 VDD VDD VSS VSS gf180mcu_fd_sc_mcu7t5v0__nor4_1
XFILLER_53_333 VDD VDD VSS VSS gf180mcu_fd_sc_mcu7t5v0__fill_2
XFILLER_54_18 VDD VDD VSS VSS gf180mcu_fd_sc_mcu7t5v0__fill_1
XFILLER_81_675 VDD VDD VSS VSS gf180mcu_fd_sc_mcu7t5v0__fillcap_8
XFILLER_26_558 VDD VDD VSS VSS gf180mcu_fd_sc_mcu7t5v0__fillcap_8
XFILLER_53_366 VDD VDD VSS VSS gf180mcu_fd_sc_mcu7t5v0__fillcap_16
X_2099_ _3112_/Q _3052_/Q _2107_/S _3052_/D VDD VDD VSS VSS gf180mcu_fd_sc_mcu7t5v0__mux2_2
XFILLER_80_185 VDD VDD VSS VSS gf180mcu_fd_sc_mcu7t5v0__fill_1
XFILLER_22_731 VDD VDD VSS VSS gf180mcu_fd_sc_mcu7t5v0__fillcap_4
XFILLER_22_753 VDD VDD VSS VSS gf180mcu_fd_sc_mcu7t5v0__fillcap_8
XFILLER_34_591 VDD VDD VSS VSS gf180mcu_fd_sc_mcu7t5v0__fillcap_4
XFILLER_21_241 VDD VDD VSS VSS gf180mcu_fd_sc_mcu7t5v0__fillcap_32
XFILLER_70_28 VDD VDD VSS VSS gf180mcu_fd_sc_mcu7t5v0__fill_1
XPHY_EDGE_ROW_17_Right_17 VDD VSS gf180mcu_fd_sc_mcu7t5v0__endcap
XFILLER_107_368 VDD VDD VSS VSS gf180mcu_fd_sc_mcu7t5v0__fillcap_4
XFILLER_95_14 VDD VDD VSS VSS gf180mcu_fd_sc_mcu7t5v0__fill_2
XFILLER_103_574 VDD VDD VSS VSS gf180mcu_fd_sc_mcu7t5v0__fill_2
XFILLER_95_36 VDD VDD VSS VSS gf180mcu_fd_sc_mcu7t5v0__fill_1
XPHY_EDGE_ROW_26_Right_26 VDD VSS gf180mcu_fd_sc_mcu7t5v0__endcap
XFILLER_49_628 VDD VDD VSS VSS gf180mcu_fd_sc_mcu7t5v0__fill_2
XFILLER_76_447 VDD VDD VSS VSS gf180mcu_fd_sc_mcu7t5v0__fillcap_8
XFILLER_48_149 VDD VDD VSS VSS gf180mcu_fd_sc_mcu7t5v0__fill_1
XFILLER_64_609 VDD VDD VSS VSS gf180mcu_fd_sc_mcu7t5v0__fill_1
XFILLER_29_352 VDD VDD VSS VSS gf180mcu_fd_sc_mcu7t5v0__fillcap_8
XFILLER_57_650 VDD VDD VSS VSS gf180mcu_fd_sc_mcu7t5v0__fill_1
XTAP_TAPCELL_ROW_27_520 VDD VSS gf180mcu_fd_sc_mcu7t5v0__filltie
XFILLER_44_333 VDD VDD VSS VSS gf180mcu_fd_sc_mcu7t5v0__fill_2
XFILLER_56_193 VDD VDD VSS VSS gf180mcu_fd_sc_mcu7t5v0__fillcap_8
XFILLER_32_517 VDD VDD VSS VSS gf180mcu_fd_sc_mcu7t5v0__fillcap_8
XFILLER_13_764 VDD VDD VSS VSS gf180mcu_fd_sc_mcu7t5v0__fill_1
XFILLER_12_241 VDD VDD VSS VSS gf180mcu_fd_sc_mcu7t5v0__fillcap_4
XPHY_EDGE_ROW_35_Right_35 VDD VSS gf180mcu_fd_sc_mcu7t5v0__endcap
X_1470_ _1718_/S _1473_/A2 _3407_/D VDD VDD VSS VSS gf180mcu_fd_sc_mcu7t5v0__nor2_1
XFILLER_4_484 VDD VDD VSS VSS gf180mcu_fd_sc_mcu7t5v0__fill_1
XPHY_EDGE_ROW_44_Right_44 VDD VSS gf180mcu_fd_sc_mcu7t5v0__endcap
X_3140_ _3140_/D _3369_/RN _3148_/CLK _3140_/Q VDD VDD VSS VSS gf180mcu_fd_sc_mcu7t5v0__dffrnq_1
XFILLER_94_244 VDD VDD VSS VSS gf180mcu_fd_sc_mcu7t5v0__fill_1
XPHY_EDGE_ROW_19_Left_128 VDD VSS gf180mcu_fd_sc_mcu7t5v0__endcap
X_3071_ _3071_/D _3369_/RN _3119_/CLK _3071_/Q VDD VDD VSS VSS gf180mcu_fd_sc_mcu7t5v0__dffrnq_1
X_2022_ _2022_/A1 _2022_/A2 _2050_/C _2022_/C _3025_/D VDD VDD VSS VSS gf180mcu_fd_sc_mcu7t5v0__aoi211_1
XFILLER_82_439 VDD VDD VSS VSS gf180mcu_fd_sc_mcu7t5v0__fillcap_8
XFILLER_63_664 VDD VDD VSS VSS gf180mcu_fd_sc_mcu7t5v0__fillcap_4
XFILLER_50_314 VDD VDD VSS VSS gf180mcu_fd_sc_mcu7t5v0__fill_1
XFILLER_62_174 VDD VDD VSS VSS gf180mcu_fd_sc_mcu7t5v0__fill_1
XPHY_EDGE_ROW_53_Right_53 VDD VSS gf180mcu_fd_sc_mcu7t5v0__endcap
XFILLER_62_185 VDD VDD VSS VSS gf180mcu_fd_sc_mcu7t5v0__fillcap_4
XTAP_TAPCELL_ROW_33_578 VDD VSS gf180mcu_fd_sc_mcu7t5v0__filltie
X_2924_ _2924_/D _2958_/CLK _2924_/Q VDD VDD VSS VSS gf180mcu_fd_sc_mcu7t5v0__dffq_1
XTAP_TAPCELL_ROW_61_876 VDD VSS gf180mcu_fd_sc_mcu7t5v0__filltie
XPHY_EDGE_ROW_28_Left_137 VDD VSS gf180mcu_fd_sc_mcu7t5v0__endcap
X_2855_ _2855_/D _3315_/CLK _2855_/Q VDD VDD VSS VSS gf180mcu_fd_sc_mcu7t5v0__dffq_1
X_1806_ _3280_/Q _2847_/Q _1813_/S _2847_/D VDD VDD VSS VSS gf180mcu_fd_sc_mcu7t5v0__mux2_2
X_2786_ _2786_/D _2893_/CLK _2786_/Q VDD VDD VSS VSS gf180mcu_fd_sc_mcu7t5v0__dffq_1
XTAP_TAPCELL_ROW_92_1205 VDD VSS gf180mcu_fd_sc_mcu7t5v0__filltie
Xclkbuf_3_1__f_clk_i clkbuf_0_clk_i/Z clkload0/I VDD VDD VSS VSS gf180mcu_fd_sc_mcu7t5v0__clkbuf_16
X_1737_ _2789_/Q _3286_/Q _1738_/S _2789_/D VDD VDD VSS VSS gf180mcu_fd_sc_mcu7t5v0__mux2_2
X_1668_ _3144_/Q _2427_/A1 _1701_/B VDD VDD VSS VSS gf180mcu_fd_sc_mcu7t5v0__and2_1
XPHY_EDGE_ROW_62_Right_62 VDD VSS gf180mcu_fd_sc_mcu7t5v0__endcap
X_3407_ _3407_/D _3416_/RN _3407_/CLK _3407_/Q VDD VDD VSS VSS gf180mcu_fd_sc_mcu7t5v0__dffrnq_1
X_1599_ _3386_/Q _3396_/D _1602_/A1 VDD VDD VSS VSS gf180mcu_fd_sc_mcu7t5v0__xnor2_1
X_3338_ hold55/Z input1/Z _3387_/CLK _3338_/Q VDD VDD VSS VSS gf180mcu_fd_sc_mcu7t5v0__dffrnq_1
XFILLER_85_244 VDD VDD VSS VSS gf180mcu_fd_sc_mcu7t5v0__fillcap_32
XPHY_EDGE_ROW_37_Left_146 VDD VSS gf180mcu_fd_sc_mcu7t5v0__endcap
XTAP_TAPCELL_ROW_69_954 VDD VSS gf180mcu_fd_sc_mcu7t5v0__filltie
X_3269_ _3269_/D _3328_/RN _3273_/CLK _3269_/Q VDD VDD VSS VSS gf180mcu_fd_sc_mcu7t5v0__dffrnq_1
XFILLER_45_119 VDD VDD VSS VSS gf180mcu_fd_sc_mcu7t5v0__fillcap_16
XFILLER_38_193 VDD VDD VSS VSS gf180mcu_fd_sc_mcu7t5v0__fillcap_4
XFILLER_54_664 VDD VDD VSS VSS gf180mcu_fd_sc_mcu7t5v0__fill_1
XFILLER_81_472 VDD VDD VSS VSS gf180mcu_fd_sc_mcu7t5v0__fillcap_16
XFILLER_26_366 VDD VDD VSS VSS gf180mcu_fd_sc_mcu7t5v0__fillcap_16
XFILLER_54_675 VDD VDD VSS VSS gf180mcu_fd_sc_mcu7t5v0__fillcap_4
XPHY_EDGE_ROW_71_Right_71 VDD VSS gf180mcu_fd_sc_mcu7t5v0__endcap
XPHY_EDGE_ROW_46_Left_155 VDD VSS gf180mcu_fd_sc_mcu7t5v0__endcap
XFILLER_10_734 VDD VDD VSS VSS gf180mcu_fd_sc_mcu7t5v0__fill_1
XPHY_EDGE_ROW_80_Right_80 VDD VSS gf180mcu_fd_sc_mcu7t5v0__endcap
XFILLER_100_2 VDD VDD VSS VSS gf180mcu_fd_sc_mcu7t5v0__fillcap_32
XFILLER_1_432 VDD VDD VSS VSS gf180mcu_fd_sc_mcu7t5v0__fill_1
XPHY_EDGE_ROW_55_Left_164 VDD VSS gf180mcu_fd_sc_mcu7t5v0__endcap
XFILLER_92_737 VDD VDD VSS VSS gf180mcu_fd_sc_mcu7t5v0__fill_2
XTAP_TAPCELL_ROW_4_281 VDD VSS gf180mcu_fd_sc_mcu7t5v0__filltie
XFILLER_36_119 VDD VDD VSS VSS gf180mcu_fd_sc_mcu7t5v0__fill_2
XFILLER_45_664 VDD VDD VSS VSS gf180mcu_fd_sc_mcu7t5v0__fillcap_16
XFILLER_55_72 VDD VDD VSS VSS gf180mcu_fd_sc_mcu7t5v0__fillcap_4
XFILLER_44_174 VDD VDD VSS VSS gf180mcu_fd_sc_mcu7t5v0__fill_1
XPHY_EDGE_ROW_64_Left_173 VDD VSS gf180mcu_fd_sc_mcu7t5v0__endcap
XFILLER_60_667 VDD VDD VSS VSS gf180mcu_fd_sc_mcu7t5v0__fillcap_16
XFILLER_40_380 VDD VDD VSS VSS gf180mcu_fd_sc_mcu7t5v0__fillcap_4
XFILLER_9_554 VDD VDD VSS VSS gf180mcu_fd_sc_mcu7t5v0__fillcap_4
XTAP_TAPCELL_ROW_30_548 VDD VSS gf180mcu_fd_sc_mcu7t5v0__filltie
X_2640_ _3340_/Q _2734_/A3 _2640_/A3 _2640_/B1 _2126_/B _2641_/I0 VDD VDD VSS VSS
+ gf180mcu_fd_sc_mcu7t5v0__oai32_1
X_2571_ _3189_/Q _3231_/Q _2585_/S _3231_/D VDD VDD VSS VSS gf180mcu_fd_sc_mcu7t5v0__mux2_2
X_1522_ _3425_/Q _3304_/Q _3124_/Q _1523_/B VDD VDD VSS VSS gf180mcu_fd_sc_mcu7t5v0__nand3_1
X_1453_ _3319_/D _3319_/Q _1453_/Z VDD VDD VSS VSS gf180mcu_fd_sc_mcu7t5v0__and2_1
XPHY_EDGE_ROW_73_Left_182 VDD VSS gf180mcu_fd_sc_mcu7t5v0__endcap
X_1384_ _3107_/Q _1513_/B VDD VDD VSS VSS gf180mcu_fd_sc_mcu7t5v0__clkinv_1
XFILLER_83_704 VDD VDD VSS VSS gf180mcu_fd_sc_mcu7t5v0__fill_1
X_3123_ _3123_/D _3416_/RN _3311_/CLK _3123_/Q VDD VDD VSS VSS gf180mcu_fd_sc_mcu7t5v0__dffrnq_1
XTAP_TAPCELL_ROW_38_637 VDD VSS gf180mcu_fd_sc_mcu7t5v0__filltie
X_3054_ _3054_/D _3303_/RN _3302_/CLK _3054_/Q VDD VDD VSS VSS gf180mcu_fd_sc_mcu7t5v0__dffrnq_1
XTAP_TAPCELL_ROW_66_924 VDD VSS gf180mcu_fd_sc_mcu7t5v0__filltie
XFILLER_67_288 VDD VDD VSS VSS gf180mcu_fd_sc_mcu7t5v0__fill_1
XFILLER_82_269 VDD VDD VSS VSS gf180mcu_fd_sc_mcu7t5v0__fill_2
X_2005_ _3115_/Q _3019_/Q _2008_/S _3019_/D VDD VDD VSS VSS gf180mcu_fd_sc_mcu7t5v0__mux2_2
XFILLER_36_664 VDD VDD VSS VSS gf180mcu_fd_sc_mcu7t5v0__fill_1
XPHY_EDGE_ROW_82_Left_191 VDD VSS gf180mcu_fd_sc_mcu7t5v0__endcap
XFILLER_23_303 VDD VDD VSS VSS gf180mcu_fd_sc_mcu7t5v0__fill_2
XFILLER_35_152 VDD VDD VSS VSS gf180mcu_fd_sc_mcu7t5v0__fill_1
XFILLER_36_675 VDD VDD VSS VSS gf180mcu_fd_sc_mcu7t5v0__fillcap_4
XFILLER_63_472 VDD VDD VSS VSS gf180mcu_fd_sc_mcu7t5v0__fillcap_16
XFILLER_23_358 VDD VDD VSS VSS gf180mcu_fd_sc_mcu7t5v0__fill_1
XFILLER_50_166 VDD VDD VSS VSS gf180mcu_fd_sc_mcu7t5v0__fillcap_8
XFILLER_31_380 VDD VDD VSS VSS gf180mcu_fd_sc_mcu7t5v0__fillcap_32
X_2907_ _2907_/D _3313_/CLK _2907_/Q VDD VDD VSS VSS gf180mcu_fd_sc_mcu7t5v0__dffq_1
XFILLER_50_177 VDD VDD VSS VSS gf180mcu_fd_sc_mcu7t5v0__fillcap_8
X_2838_ _2838_/D _2892_/CLK _2838_/Q VDD VDD VSS VSS gf180mcu_fd_sc_mcu7t5v0__dffq_1
X_2769_ _2769_/D _3409_/CLK _2769_/Q VDD VDD VSS VSS gf180mcu_fd_sc_mcu7t5v0__dffq_1
XFILLER_86_531 VDD VDD VSS VSS gf180mcu_fd_sc_mcu7t5v0__fill_2
XFILLER_86_597 VDD VDD VSS VSS gf180mcu_fd_sc_mcu7t5v0__fillcap_8
XFILLER_74_737 VDD VDD VSS VSS gf180mcu_fd_sc_mcu7t5v0__fillcap_16
XTAP_TAPCELL_ROW_1_240 VDD VSS gf180mcu_fd_sc_mcu7t5v0__filltie
XFILLER_92_37 VDD VDD VSS VSS gf180mcu_fd_sc_mcu7t5v0__fillcap_32
XFILLER_27_697 VDD VDD VSS VSS gf180mcu_fd_sc_mcu7t5v0__fill_2
XFILLER_14_314 VDD VDD VSS VSS gf180mcu_fd_sc_mcu7t5v0__fill_1
XFILLER_42_667 VDD VDD VSS VSS gf180mcu_fd_sc_mcu7t5v0__fillcap_32
XFILLER_10_597 VDD VDD VSS VSS gf180mcu_fd_sc_mcu7t5v0__fill_1
XFILLER_96_317 VDD VDD VSS VSS gf180mcu_fd_sc_mcu7t5v0__fill_1
XFILLER_96_339 VDD VDD VSS VSS gf180mcu_fd_sc_mcu7t5v0__fill_2
XFILLER_92_523 VDD VDD VSS VSS gf180mcu_fd_sc_mcu7t5v0__fill_2
XFILLER_92_589 VDD VDD VSS VSS gf180mcu_fd_sc_mcu7t5v0__fillcap_4
XFILLER_32_100 VDD VDD VSS VSS gf180mcu_fd_sc_mcu7t5v0__fillcap_4
XFILLER_72_280 VDD VDD VSS VSS gf180mcu_fd_sc_mcu7t5v0__fillcap_16
XFILLER_60_453 VDD VDD VSS VSS gf180mcu_fd_sc_mcu7t5v0__fill_2
XFILLER_20_317 VDD VDD VSS VSS gf180mcu_fd_sc_mcu7t5v0__fill_2
XFILLER_32_177 VDD VDD VSS VSS gf180mcu_fd_sc_mcu7t5v0__fillcap_16
XTAP_TAPCELL_ROW_43_684 VDD VSS gf180mcu_fd_sc_mcu7t5v0__filltie
XFILLER_60_486 VDD VDD VSS VSS gf180mcu_fd_sc_mcu7t5v0__fillcap_4
XTAP_TAPCELL_ROW_71_982 VDD VSS gf180mcu_fd_sc_mcu7t5v0__filltie
X_2623_ _2985_/Q _2977_/Q _2969_/Q _2961_/Q _2674_/S0 _2673_/S1 _2623_/Z VDD VDD VSS
+ VSS gf180mcu_fd_sc_mcu7t5v0__mux4_1
XFILLER_63_2 VDD VDD VSS VSS gf180mcu_fd_sc_mcu7t5v0__fillcap_4
X_2554_ _3172_/Q _3214_/Q _2569_/S _3214_/D VDD VDD VSS VSS gf180mcu_fd_sc_mcu7t5v0__mux2_2
X_1505_ _3368_/Q _1867_/S _3368_/D VDD VDD VSS VSS gf180mcu_fd_sc_mcu7t5v0__xor2_1
X_2485_ _2469_/B _2481_/Z _2484_/Z _2480_/S _3158_/D VDD VDD VSS VSS gf180mcu_fd_sc_mcu7t5v0__oai22_1
X_1436_ _1439_/A1 _1439_/B _3110_/Q _1436_/Z VDD VDD VSS VSS gf180mcu_fd_sc_mcu7t5v0__and3_1
X_1367_ _3367_/Q _1935_/A2 VDD VDD VSS VSS gf180mcu_fd_sc_mcu7t5v0__clkinv_1
X_3106_ _3106_/D _3416_/RN _3423_/CLK _3413_/D VDD VDD VSS VSS gf180mcu_fd_sc_mcu7t5v0__dffsnq_1
XFILLER_56_737 VDD VDD VSS VSS gf180mcu_fd_sc_mcu7t5v0__fillcap_16
XTAP_TAPCELL_ROW_87_1148 VDD VSS gf180mcu_fd_sc_mcu7t5v0__filltie
XFILLER_83_556 VDD VDD VSS VSS gf180mcu_fd_sc_mcu7t5v0__fillcap_4
X_3037_ _3037_/D _3416_/RN _3424_/CLK _3037_/Q VDD VDD VSS VSS gf180mcu_fd_sc_mcu7t5v0__dffrnq_1
XFILLER_24_667 VDD VDD VSS VSS gf180mcu_fd_sc_mcu7t5v0__fill_2
XFILLER_51_464 VDD VDD VSS VSS gf180mcu_fd_sc_mcu7t5v0__fillcap_16
XTAP_TAPCELL_ROW_98_1266 VDD VSS gf180mcu_fd_sc_mcu7t5v0__filltie
XFILLER_105_422 VDD VDD VSS VSS gf180mcu_fd_sc_mcu7t5v0__fillcap_8
XFILLER_87_37 VDD VDD VSS VSS gf180mcu_fd_sc_mcu7t5v0__fillcap_16
XFILLER_78_317 VDD VDD VSS VSS gf180mcu_fd_sc_mcu7t5v0__fillcap_64
XFILLER_100_193 VDD VDD VSS VSS gf180mcu_fd_sc_mcu7t5v0__fillcap_4
XFILLER_100_171 VDD VDD VSS VSS gf180mcu_fd_sc_mcu7t5v0__fillcap_4
XFILLER_46_247 VDD VDD VSS VSS gf180mcu_fd_sc_mcu7t5v0__fillcap_64
XTAP_TAPCELL_ROW_107_1362 VDD VSS gf180mcu_fd_sc_mcu7t5v0__filltie
XFILLER_42_453 VDD VDD VSS VSS gf180mcu_fd_sc_mcu7t5v0__fill_2
XFILLER_14_177 VDD VDD VSS VSS gf180mcu_fd_sc_mcu7t5v0__fillcap_4
XFILLER_30_659 VDD VDD VSS VSS gf180mcu_fd_sc_mcu7t5v0__fillcap_4
XTAP_TAPCELL_ROW_40_654 VDD VSS gf180mcu_fd_sc_mcu7t5v0__filltie
XTAP_TAPCELL_ROW_12_356 VDD VSS gf180mcu_fd_sc_mcu7t5v0__filltie
XFILLER_6_387 VDD VDD VSS VSS gf180mcu_fd_sc_mcu7t5v0__fillcap_32
XFILLER_96_125 VDD VDD VSS VSS gf180mcu_fd_sc_mcu7t5v0__fillcap_8
X_2270_ _3121_/Q _2267_/C _2271_/B VDD VDD VSS VSS gf180mcu_fd_sc_mcu7t5v0__nand2_1
XFILLER_2_593 VDD VDD VSS VSS gf180mcu_fd_sc_mcu7t5v0__fill_2
XFILLER_84_309 VDD VDD VSS VSS gf180mcu_fd_sc_mcu7t5v0__fillcap_4
XFILLER_65_512 VDD VDD VSS VSS gf180mcu_fd_sc_mcu7t5v0__fillcap_4
XTAP_TAPCELL_ROW_48_743 VDD VSS gf180mcu_fd_sc_mcu7t5v0__filltie
XFILLER_65_556 VDD VDD VSS VSS gf180mcu_fd_sc_mcu7t5v0__fillcap_4
XFILLER_92_375 VDD VDD VSS VSS gf180mcu_fd_sc_mcu7t5v0__fillcap_8
XFILLER_80_559 VDD VDD VSS VSS gf180mcu_fd_sc_mcu7t5v0__fillcap_16
XFILLER_60_261 VDD VDD VSS VSS gf180mcu_fd_sc_mcu7t5v0__fill_1
XFILLER_20_147 VDD VDD VSS VSS gf180mcu_fd_sc_mcu7t5v0__fillcap_16
X_1985_ _3113_/Q _3001_/Q _1990_/S _3001_/D VDD VDD VSS VSS gf180mcu_fd_sc_mcu7t5v0__mux2_2
X_2606_ _2663_/B _2687_/A2 _2606_/A3 _2606_/A4 _2608_/B2 VDD VDD VSS VSS gf180mcu_fd_sc_mcu7t5v0__nand4_1
X_2537_ _3200_/Q _3192_/Q _2539_/S _3200_/D VDD VDD VSS VSS gf180mcu_fd_sc_mcu7t5v0__mux2_2
XFILLER_87_136 VDD VDD VSS VSS gf180mcu_fd_sc_mcu7t5v0__fillcap_4
X_2468_ _2468_/A1 _2468_/A2 _2468_/B _2469_/A2 VDD VDD VSS VSS gf180mcu_fd_sc_mcu7t5v0__aoi21_1
X_1419_ _3046_/Q _2381_/A2 VDD VDD VSS VSS gf180mcu_fd_sc_mcu7t5v0__clkinv_1
X_2399_ _3394_/Q _2398_/Z _2402_/A2 VDD VDD VSS VSS gf180mcu_fd_sc_mcu7t5v0__nand2_1
XFILLER_28_247 VDD VDD VSS VSS gf180mcu_fd_sc_mcu7t5v0__fillcap_16
XFILLER_71_559 VDD VDD VSS VSS gf180mcu_fd_sc_mcu7t5v0__fill_1
XFILLER_24_453 VDD VDD VSS VSS gf180mcu_fd_sc_mcu7t5v0__fill_2
XFILLER_52_762 VDD VDD VSS VSS gf180mcu_fd_sc_mcu7t5v0__fill_2
XFILLER_22_10 VDD VDD VSS VSS gf180mcu_fd_sc_mcu7t5v0__fill_2
XFILLER_106_731 VDD VDD VSS VSS gf180mcu_fd_sc_mcu7t5v0__fillcap_4
XFILLER_79_648 VDD VDD VSS VSS gf180mcu_fd_sc_mcu7t5v0__fillcap_4
XFILLER_78_136 VDD VDD VSS VSS gf180mcu_fd_sc_mcu7t5v0__fillcap_16
XFILLER_66_309 VDD VDD VSS VSS gf180mcu_fd_sc_mcu7t5v0__fillcap_4
XFILLER_59_372 VDD VDD VSS VSS gf180mcu_fd_sc_mcu7t5v0__fill_2
XTAP_TAPCELL_ROW_45_702 VDD VSS gf180mcu_fd_sc_mcu7t5v0__filltie
XFILLER_47_578 VDD VDD VSS VSS gf180mcu_fd_sc_mcu7t5v0__fillcap_8
XFILLER_74_397 VDD VDD VSS VSS gf180mcu_fd_sc_mcu7t5v0__fill_1
XTAP_TAPCELL_ROW_17_415 VDD VSS gf180mcu_fd_sc_mcu7t5v0__filltie
XFILLER_15_486 VDD VDD VSS VSS gf180mcu_fd_sc_mcu7t5v0__fillcap_4
XFILLER_42_261 VDD VDD VSS VSS gf180mcu_fd_sc_mcu7t5v0__fill_1
XFILLER_63_72 VDD VDD VSS VSS gf180mcu_fd_sc_mcu7t5v0__fillcap_32
XTAP_TAPCELL_ROW_25_492 VDD VSS gf180mcu_fd_sc_mcu7t5v0__filltie
XTAP_TAPCELL_ROW_53_790 VDD VSS gf180mcu_fd_sc_mcu7t5v0__filltie
X_1770_ _3281_/Q _2816_/Q _1776_/S _2816_/D VDD VDD VSS VSS gf180mcu_fd_sc_mcu7t5v0__mux2_2
XFILLER_8_34 VDD VDD VSS VSS gf180mcu_fd_sc_mcu7t5v0__fill_1
XFILLER_11_692 VDD VDD VSS VSS gf180mcu_fd_sc_mcu7t5v0__fillcap_8
XFILLER_7_685 VDD VDD VSS VSS gf180mcu_fd_sc_mcu7t5v0__fill_2
X_3371_ _3397_/Q input1/Z _3407_/CLK hold57/I VDD VDD VSS VSS gf180mcu_fd_sc_mcu7t5v0__dffrnq_1
X_2322_ _2320_/Z _2321_/Z _2405_/S _2322_/Z VDD VDD VSS VSS gf180mcu_fd_sc_mcu7t5v0__mux2_2
XFILLER_69_136 VDD VDD VSS VSS gf180mcu_fd_sc_mcu7t5v0__fillcap_4
XFILLER_97_478 VDD VDD VSS VSS gf180mcu_fd_sc_mcu7t5v0__fillcap_8
X_2253_ _2312_/A1 _2426_/A1 _2224_/B _2267_/A2 _2265_/B VDD VDD VSS VSS gf180mcu_fd_sc_mcu7t5v0__aoi22_1
XFILLER_26_2 VDD VDD VSS VSS gf180mcu_fd_sc_mcu7t5v0__fillcap_32
X_2184_ _3424_/D _3423_/D _3424_/Q _2185_/B VDD VDD VSS VSS gf180mcu_fd_sc_mcu7t5v0__nor3_1
XFILLER_92_172 VDD VDD VSS VSS gf180mcu_fd_sc_mcu7t5v0__fill_2
XTAP_TAPCELL_ROW_84_1118 VDD VSS gf180mcu_fd_sc_mcu7t5v0__filltie
XFILLER_53_526 VDD VDD VSS VSS gf180mcu_fd_sc_mcu7t5v0__fillcap_4
XFILLER_34_762 VDD VDD VSS VSS gf180mcu_fd_sc_mcu7t5v0__fill_2
XFILLER_53_559 VDD VDD VSS VSS gf180mcu_fd_sc_mcu7t5v0__fill_1
X_1968_ _3115_/Q _2987_/Q _1971_/S _2987_/D VDD VDD VSS VSS gf180mcu_fd_sc_mcu7t5v0__mux2_2
XTAP_TAPCELL_ROW_95_1236 VDD VSS gf180mcu_fd_sc_mcu7t5v0__filltie
X_1899_ _1490_/Z _1926_/A2 _1907_/S VDD VDD VSS VSS gf180mcu_fd_sc_mcu7t5v0__and2_1
XFILLER_0_305 VDD VDD VSS VSS gf180mcu_fd_sc_mcu7t5v0__fill_1
XTAP_TAPCELL_ROW_59_849 VDD VSS gf180mcu_fd_sc_mcu7t5v0__filltie
XFILLER_17_718 VDD VDD VSS VSS gf180mcu_fd_sc_mcu7t5v0__fillcap_8
XFILLER_56_342 VDD VDD VSS VSS gf180mcu_fd_sc_mcu7t5v0__fill_1
Xclkbuf_leaf_3_clk_i clkbuf_leaf_5_clk_i/I _3293_/CLK VDD VDD VSS VSS gf180mcu_fd_sc_mcu7t5v0__clkbuf_4
XTAP_TAPCELL_ROW_104_1321 VDD VSS gf180mcu_fd_sc_mcu7t5v0__filltie
XFILLER_83_194 VDD VDD VSS VSS gf180mcu_fd_sc_mcu7t5v0__fillcap_4
XFILLER_24_294 VDD VDD VSS VSS gf180mcu_fd_sc_mcu7t5v0__fill_2
XTAP_TAPCELL_ROW_50_760 VDD VSS gf180mcu_fd_sc_mcu7t5v0__filltie
XFILLER_12_489 VDD VDD VSS VSS gf180mcu_fd_sc_mcu7t5v0__fill_1
XTAP_TAPCELL_ROW_22_462 VDD VSS gf180mcu_fd_sc_mcu7t5v0__filltie
XFILLER_106_594 VDD VDD VSS VSS gf180mcu_fd_sc_mcu7t5v0__fill_1
XFILLER_3_165 VDD VDD VSS VSS gf180mcu_fd_sc_mcu7t5v0__fill_1
XFILLER_79_478 VDD VDD VSS VSS gf180mcu_fd_sc_mcu7t5v0__fill_2
XFILLER_66_117 VDD VDD VSS VSS gf180mcu_fd_sc_mcu7t5v0__fillcap_16
XFILLER_67_629 VDD VDD VSS VSS gf180mcu_fd_sc_mcu7t5v0__fill_1
XFILLER_59_180 VDD VDD VSS VSS gf180mcu_fd_sc_mcu7t5v0__fillcap_4
XFILLER_35_504 VDD VDD VSS VSS gf180mcu_fd_sc_mcu7t5v0__fill_2
XFILLER_74_71 VDD VDD VSS VSS gf180mcu_fd_sc_mcu7t5v0__fill_2
X_2940_ _2940_/D _3324_/CLK _2940_/Q VDD VDD VSS VSS gf180mcu_fd_sc_mcu7t5v0__dffq_1
XFILLER_31_710 VDD VDD VSS VSS gf180mcu_fd_sc_mcu7t5v0__fillcap_4
X_2871_ _2871_/D _2894_/CLK _2871_/Q VDD VDD VSS VSS gf180mcu_fd_sc_mcu7t5v0__dffq_1
X_1822_ _2862_/Q _3287_/Q _1822_/S _2862_/D VDD VDD VSS VSS gf180mcu_fd_sc_mcu7t5v0__mux2_2
XFILLER_30_242 VDD VDD VSS VSS gf180mcu_fd_sc_mcu7t5v0__fill_2
X_1753_ _3282_/Q _2801_/Q _1758_/S _2801_/D VDD VDD VSS VSS gf180mcu_fd_sc_mcu7t5v0__mux2_2
X_1684_ _2407_/A1 _2432_/B2 _2379_/B VDD VDD VSS VSS gf180mcu_fd_sc_mcu7t5v0__nand2_1
X_3423_ _3423_/D _3416_/RN _3423_/CLK _3424_/D VDD VDD VSS VSS gf180mcu_fd_sc_mcu7t5v0__dffsnq_1
Xclkbuf_4_11_0_host_clk_i clkbuf_0_host_clk_i/Z _2894_/CLK VDD VDD VSS VSS gf180mcu_fd_sc_mcu7t5v0__clkbuf_4
X_3354_ _3354_/D _3369_/RN _3358_/CLK _3354_/Q VDD VDD VSS VSS gf180mcu_fd_sc_mcu7t5v0__dffrnq_1
X_2305_ _3129_/Q _2313_/A1 _2305_/B _2306_/A2 VDD VDD VSS VSS gf180mcu_fd_sc_mcu7t5v0__aoi21_1
XTAP_TAPCELL_ROW_90_1177 VDD VSS gf180mcu_fd_sc_mcu7t5v0__filltie
X_3285_ _3285_/D _3303_/RN _3285_/CLK _3285_/Q VDD VDD VSS VSS gf180mcu_fd_sc_mcu7t5v0__dffrnq_1
XFILLER_100_737 VDD VDD VSS VSS gf180mcu_fd_sc_mcu7t5v0__fillcap_8
X_2236_ _3132_/Q _3112_/Q _2242_/S _3112_/D VDD VDD VSS VSS gf180mcu_fd_sc_mcu7t5v0__mux2_2
XTAP_TAPCELL_ROW_56_819 VDD VSS gf180mcu_fd_sc_mcu7t5v0__filltie
XFILLER_93_492 VDD VDD VSS VSS gf180mcu_fd_sc_mcu7t5v0__fillcap_16
XFILLER_81_632 VDD VDD VSS VSS gf180mcu_fd_sc_mcu7t5v0__fillcap_8
X_2167_ _3207_/Q _2747_/A3 _2601_/A2 VDD VDD VSS VSS gf180mcu_fd_sc_mcu7t5v0__nand2_1
X_2098_ _2098_/A1 _3310_/D _2098_/B _3051_/D VDD VDD VSS VSS gf180mcu_fd_sc_mcu7t5v0__oai21_1
XFILLER_80_153 VDD VDD VSS VSS gf180mcu_fd_sc_mcu7t5v0__fillcap_16
XFILLER_70_18 VDD VDD VSS VSS gf180mcu_fd_sc_mcu7t5v0__fillcap_8
XFILLER_95_26 VDD VDD VSS VSS gf180mcu_fd_sc_mcu7t5v0__fill_1
XFILLER_88_275 VDD VDD VSS VSS gf180mcu_fd_sc_mcu7t5v0__fill_1
XFILLER_28_31 VDD VDD VSS VSS gf180mcu_fd_sc_mcu7t5v0__fillcap_4
XFILLER_91_418 VDD VDD VSS VSS gf180mcu_fd_sc_mcu7t5v0__fill_2
XFILLER_29_364 VDD VDD VSS VSS gf180mcu_fd_sc_mcu7t5v0__fill_2
XFILLER_56_172 VDD VDD VSS VSS gf180mcu_fd_sc_mcu7t5v0__fill_2
XFILLER_17_559 VDD VDD VSS VSS gf180mcu_fd_sc_mcu7t5v0__fill_1
XTAP_TAPCELL_ROW_27_521 VDD VSS gf180mcu_fd_sc_mcu7t5v0__filltie
XFILLER_44_356 VDD VDD VSS VSS gf180mcu_fd_sc_mcu7t5v0__fillcap_8
XFILLER_71_142 VDD VDD VSS VSS gf180mcu_fd_sc_mcu7t5v0__fill_1
XFILLER_44_52 VDD VDD VSS VSS gf180mcu_fd_sc_mcu7t5v0__fill_2
XFILLER_71_164 VDD VDD VSS VSS gf180mcu_fd_sc_mcu7t5v0__fillcap_16
XFILLER_13_754 VDD VDD VSS VSS gf180mcu_fd_sc_mcu7t5v0__fillcap_8
XFILLER_69_60 VDD VDD VSS VSS gf180mcu_fd_sc_mcu7t5v0__fill_1
XFILLER_95_702 VDD VDD VSS VSS gf180mcu_fd_sc_mcu7t5v0__fillcap_16
XFILLER_39_139 VDD VDD VSS VSS gf180mcu_fd_sc_mcu7t5v0__fill_1
X_3070_ _3070_/D _3369_/RN _3119_/CLK _3070_/Q VDD VDD VSS VSS gf180mcu_fd_sc_mcu7t5v0__dffrnq_1
X_2021_ _2061_/A2 _2024_/A3 _2022_/C VDD VDD VSS VSS gf180mcu_fd_sc_mcu7t5v0__nor2_1
XFILLER_85_92 VDD VDD VSS VSS gf180mcu_fd_sc_mcu7t5v0__fillcap_32
XFILLER_35_312 VDD VDD VSS VSS gf180mcu_fd_sc_mcu7t5v0__fill_1
XFILLER_35_323 VDD VDD VSS VSS gf180mcu_fd_sc_mcu7t5v0__fillcap_8
XFILLER_47_150 VDD VDD VSS VSS gf180mcu_fd_sc_mcu7t5v0__fill_2
XFILLER_47_172 VDD VDD VSS VSS gf180mcu_fd_sc_mcu7t5v0__fillcap_32
XFILLER_63_610 VDD VDD VSS VSS gf180mcu_fd_sc_mcu7t5v0__fillcap_4
XFILLER_63_632 VDD VDD VSS VSS gf180mcu_fd_sc_mcu7t5v0__fillcap_32
XFILLER_75_492 VDD VDD VSS VSS gf180mcu_fd_sc_mcu7t5v0__fillcap_64
XFILLER_23_507 VDD VDD VSS VSS gf180mcu_fd_sc_mcu7t5v0__fillcap_4
XFILLER_62_153 VDD VDD VSS VSS gf180mcu_fd_sc_mcu7t5v0__fill_1
XFILLER_93_2 VDD VDD VSS VSS gf180mcu_fd_sc_mcu7t5v0__fillcap_4
XFILLER_31_562 VDD VDD VSS VSS gf180mcu_fd_sc_mcu7t5v0__fillcap_8
XTAP_TAPCELL_ROW_33_579 VDD VSS gf180mcu_fd_sc_mcu7t5v0__filltie
X_2923_ _2923_/D _2954_/CLK _2923_/Q VDD VDD VSS VSS gf180mcu_fd_sc_mcu7t5v0__dffq_1
XFILLER_50_359 VDD VDD VSS VSS gf180mcu_fd_sc_mcu7t5v0__fill_1
XTAP_TAPCELL_ROW_61_877 VDD VSS gf180mcu_fd_sc_mcu7t5v0__filltie
X_2854_ _2854_/D _2892_/CLK _2854_/Q VDD VDD VSS VSS gf180mcu_fd_sc_mcu7t5v0__dffq_1
X_1805_ _1842_/A1 _1786_/Z _1813_/S VDD VDD VSS VSS gf180mcu_fd_sc_mcu7t5v0__nand2_1
X_2785_ _2785_/D _3406_/CLK _2785_/Q VDD VDD VSS VSS gf180mcu_fd_sc_mcu7t5v0__dffq_1
X_1736_ _2788_/Q _3285_/Q _1738_/S _2788_/D VDD VDD VSS VSS gf180mcu_fd_sc_mcu7t5v0__mux2_2
XFILLER_104_317 VDD VDD VSS VSS gf180mcu_fd_sc_mcu7t5v0__fill_1
X_1667_ _2424_/A1 _1637_/Z _2267_/C _2285_/B VDD VDD VSS VSS gf180mcu_fd_sc_mcu7t5v0__aoi21_1
X_1598_ _3389_/Q _3399_/D _1598_/Z VDD VDD VSS VSS gf180mcu_fd_sc_mcu7t5v0__xor2_1
X_3406_ _3406_/D _3416_/RN _3406_/CLK _3406_/Q VDD VDD VSS VSS gf180mcu_fd_sc_mcu7t5v0__dffrnq_1
X_3337_ hold53/Z input1/Z _3337_/CLK _3337_/Q VDD VDD VSS VSS gf180mcu_fd_sc_mcu7t5v0__dffrnq_1
XFILLER_58_448 VDD VDD VSS VSS gf180mcu_fd_sc_mcu7t5v0__fillcap_4
XTAP_TAPCELL_ROW_69_955 VDD VSS gf180mcu_fd_sc_mcu7t5v0__filltie
X_3268_ _3268_/D _3328_/RN _3271_/CLK _3268_/Q VDD VDD VSS VSS gf180mcu_fd_sc_mcu7t5v0__dffrnq_1
X_2219_ _3144_/Q _2427_/A1 _2219_/B _2278_/B VDD VDD VSS VSS gf180mcu_fd_sc_mcu7t5v0__aoi21_1
XFILLER_26_312 VDD VDD VSS VSS gf180mcu_fd_sc_mcu7t5v0__fill_2
X_3199_ _3199_/D _3328_/RN clkload7/I _3199_/Q VDD VDD VSS VSS gf180mcu_fd_sc_mcu7t5v0__dffrnq_1
XFILLER_54_654 VDD VDD VSS VSS gf180mcu_fd_sc_mcu7t5v0__fillcap_8
XFILLER_66_492 VDD VDD VSS VSS gf180mcu_fd_sc_mcu7t5v0__fill_1
XFILLER_81_462 VDD VDD VSS VSS gf180mcu_fd_sc_mcu7t5v0__fill_2
XFILLER_53_142 VDD VDD VSS VSS gf180mcu_fd_sc_mcu7t5v0__fillcap_8
XFILLER_22_551 VDD VDD VSS VSS gf180mcu_fd_sc_mcu7t5v0__fillcap_4
XPHY_EDGE_ROW_101_Left_210 VDD VSS gf180mcu_fd_sc_mcu7t5v0__endcap
Xclkbuf_leaf_21_clk_i clkload2/I _3131_/CLK VDD VDD VSS VSS gf180mcu_fd_sc_mcu7t5v0__clkbuf_4
XFILLER_1_422 VDD VDD VSS VSS gf180mcu_fd_sc_mcu7t5v0__fillcap_8
XFILLER_89_562 VDD VDD VSS VSS gf180mcu_fd_sc_mcu7t5v0__fillcap_4
XFILLER_77_702 VDD VDD VSS VSS gf180mcu_fd_sc_mcu7t5v0__fillcap_16
Xclkbuf_leaf_36_clk_i clkload4/I _3021_/CLK VDD VDD VSS VSS gf180mcu_fd_sc_mcu7t5v0__clkbuf_4
XFILLER_17_312 VDD VDD VSS VSS gf180mcu_fd_sc_mcu7t5v0__fill_1
XTAP_TAPCELL_ROW_4_271 VDD VSS gf180mcu_fd_sc_mcu7t5v0__filltie
XFILLER_45_632 VDD VDD VSS VSS gf180mcu_fd_sc_mcu7t5v0__fillcap_32
XFILLER_57_492 VDD VDD VSS VSS gf180mcu_fd_sc_mcu7t5v0__fillcap_4
XFILLER_17_367 VDD VDD VSS VSS gf180mcu_fd_sc_mcu7t5v0__fill_1
XFILLER_17_356 VDD VDD VSS VSS gf180mcu_fd_sc_mcu7t5v0__fill_2
XFILLER_55_95 VDD VDD VSS VSS gf180mcu_fd_sc_mcu7t5v0__fill_2
XFILLER_60_613 VDD VDD VSS VSS gf180mcu_fd_sc_mcu7t5v0__fillcap_4
XFILLER_13_562 VDD VDD VSS VSS gf180mcu_fd_sc_mcu7t5v0__fillcap_16
XFILLER_71_50 VDD VDD VSS VSS gf180mcu_fd_sc_mcu7t5v0__fillcap_16
XTAP_TAPCELL_ROW_30_549 VDD VSS gf180mcu_fd_sc_mcu7t5v0__filltie
XFILLER_71_94 VDD VDD VSS VSS gf180mcu_fd_sc_mcu7t5v0__fill_1
XTAP_TAPCELL_ROW_78_1050 VDD VSS gf180mcu_fd_sc_mcu7t5v0__filltie
X_2570_ _3188_/Q _3230_/Q _2585_/S _3230_/D VDD VDD VSS VSS gf180mcu_fd_sc_mcu7t5v0__mux2_2
X_1521_ _3425_/Q _3124_/Q _1527_/B1 VDD VDD VSS VSS gf180mcu_fd_sc_mcu7t5v0__nand2_1
X_1452_ _3319_/D _3319_/Q _1454_/A2 VDD VDD VSS VSS gf180mcu_fd_sc_mcu7t5v0__nor2_1
X_1383_ _3109_/Q _1515_/A1 VDD VDD VSS VSS gf180mcu_fd_sc_mcu7t5v0__clkinv_1
X_3122_ _3122_/D _3416_/RN _3424_/CLK _3122_/Q VDD VDD VSS VSS gf180mcu_fd_sc_mcu7t5v0__dffrnq_1
XFILLER_67_212 VDD VDD VSS VSS gf180mcu_fd_sc_mcu7t5v0__fillcap_4
XFILLER_82_215 VDD VDD VSS VSS gf180mcu_fd_sc_mcu7t5v0__fill_1
X_3053_ _3053_/D _3303_/RN _3302_/CLK _3053_/Q VDD VDD VSS VSS gf180mcu_fd_sc_mcu7t5v0__dffrnq_1
XTAP_TAPCELL_ROW_66_925 VDD VSS gf180mcu_fd_sc_mcu7t5v0__filltie
X_2004_ _3114_/Q _3018_/Q _2008_/S _3018_/D VDD VDD VSS VSS gf180mcu_fd_sc_mcu7t5v0__mux2_2
XTAP_TAPCELL_ROW_38_638 VDD VSS gf180mcu_fd_sc_mcu7t5v0__filltie
XFILLER_35_142 VDD VDD VSS VSS gf180mcu_fd_sc_mcu7t5v0__fillcap_8
XFILLER_23_348 VDD VDD VSS VSS gf180mcu_fd_sc_mcu7t5v0__fill_2
XFILLER_35_197 VDD VDD VSS VSS gf180mcu_fd_sc_mcu7t5v0__fill_1
X_2906_ _2906_/D _3119_/CLK _2906_/Q VDD VDD VSS VSS gf180mcu_fd_sc_mcu7t5v0__dffq_1
X_2837_ _2837_/D _2858_/CLK _2837_/Q VDD VDD VSS VSS gf180mcu_fd_sc_mcu7t5v0__dffq_1
X_2768_ _2768_/D _2828_/CLK _2768_/Q VDD VDD VSS VSS gf180mcu_fd_sc_mcu7t5v0__dffq_1
X_1719_ _3404_/Q _1719_/A2 _1833_/A1 VDD VDD VSS VSS gf180mcu_fd_sc_mcu7t5v0__nor2_1
XFILLER_2_208 VDD VDD VSS VSS gf180mcu_fd_sc_mcu7t5v0__fill_2
X_2699_ _3261_/Q _2680_/C _2731_/B1 _3079_/Q _2700_/I VDD VDD VSS VSS gf180mcu_fd_sc_mcu7t5v0__aoi22_1
XFILLER_58_278 VDD VDD VSS VSS gf180mcu_fd_sc_mcu7t5v0__fillcap_4
XTAP_TAPCELL_ROW_1_241 VDD VSS gf180mcu_fd_sc_mcu7t5v0__filltie
XFILLER_27_632 VDD VDD VSS VSS gf180mcu_fd_sc_mcu7t5v0__fillcap_4
XFILLER_39_492 VDD VDD VSS VSS gf180mcu_fd_sc_mcu7t5v0__fillcap_16
XFILLER_41_178 VDD VDD VSS VSS gf180mcu_fd_sc_mcu7t5v0__fillcap_32
XFILLER_10_543 VDD VDD VSS VSS gf180mcu_fd_sc_mcu7t5v0__fillcap_8
XFILLER_10_521 VDD VDD VSS VSS gf180mcu_fd_sc_mcu7t5v0__fillcap_4
XFILLER_41_42 VDD VDD VSS VSS gf180mcu_fd_sc_mcu7t5v0__fillcap_16
XTAP_TAPCELL_ROW_9_330 VDD VSS gf180mcu_fd_sc_mcu7t5v0__filltie
XFILLER_2_731 VDD VDD VSS VSS gf180mcu_fd_sc_mcu7t5v0__fillcap_4
XFILLER_96_307 VDD VDD VSS VSS gf180mcu_fd_sc_mcu7t5v0__fill_1
XFILLER_2_753 VDD VDD VSS VSS gf180mcu_fd_sc_mcu7t5v0__fillcap_8
XFILLER_49_212 VDD VDD VSS VSS gf180mcu_fd_sc_mcu7t5v0__fillcap_8
XFILLER_77_554 VDD VDD VSS VSS gf180mcu_fd_sc_mcu7t5v0__fillcap_4
XFILLER_49_278 VDD VDD VSS VSS gf180mcu_fd_sc_mcu7t5v0__fill_2
XFILLER_66_61 VDD VDD VSS VSS gf180mcu_fd_sc_mcu7t5v0__fill_1
XFILLER_92_557 VDD VDD VSS VSS gf180mcu_fd_sc_mcu7t5v0__fillcap_32
XFILLER_64_259 VDD VDD VSS VSS gf180mcu_fd_sc_mcu7t5v0__fill_1
XTAP_TAPCELL_ROW_43_685 VDD VSS gf180mcu_fd_sc_mcu7t5v0__filltie
XTAP_TAPCELL_ROW_71_983 VDD VSS gf180mcu_fd_sc_mcu7t5v0__filltie
XTAP_TAPCELL_ROW_15_387 VDD VSS gf180mcu_fd_sc_mcu7t5v0__filltie
XFILLER_9_352 VDD VDD VSS VSS gf180mcu_fd_sc_mcu7t5v0__fillcap_4
X_2622_ _3017_/Q _3009_/Q _3001_/Q _2993_/Q _3351_/Q _3352_/Q _2622_/Z VDD VDD VSS
+ VSS gf180mcu_fd_sc_mcu7t5v0__mux4_1
X_2553_ _3163_/Q _3213_/Q _2585_/S _3213_/D VDD VDD VSS VSS gf180mcu_fd_sc_mcu7t5v0__mux2_2
XFILLER_56_2 VDD VDD VSS VSS gf180mcu_fd_sc_mcu7t5v0__fillcap_16
X_1504_ _1504_/I _3362_/D VDD VDD VSS VSS gf180mcu_fd_sc_mcu7t5v0__clkinv_1
XFILLER_87_307 VDD VDD VSS VSS gf180mcu_fd_sc_mcu7t5v0__fill_1
X_2484_ _2469_/B _3157_/Q _2484_/Z VDD VDD VSS VSS gf180mcu_fd_sc_mcu7t5v0__xor2_1
X_1435_ _1478_/A3 _1476_/A2 _3351_/D VDD VDD VSS VSS gf180mcu_fd_sc_mcu7t5v0__nor2_1
X_1366_ _3407_/Q _1786_/A2 VDD VDD VSS VSS gf180mcu_fd_sc_mcu7t5v0__clkinv_1
X_3105_ _3105_/D _3416_/RN _3424_/CLK _3417_/D VDD VDD VSS VSS gf180mcu_fd_sc_mcu7t5v0__dffsnq_1
XFILLER_83_502 VDD VDD VSS VSS gf180mcu_fd_sc_mcu7t5v0__fillcap_8
X_3036_ _3036_/D _3416_/RN _3419_/CLK _3036_/Q VDD VDD VSS VSS gf180mcu_fd_sc_mcu7t5v0__dffrnq_1
XTAP_TAPCELL_ROW_87_1149 VDD VSS gf180mcu_fd_sc_mcu7t5v0__filltie
XFILLER_102_37 VDD VDD VSS VSS gf180mcu_fd_sc_mcu7t5v0__fillcap_64
XTAP_TAPCELL_ROW_98_1267 VDD VSS gf180mcu_fd_sc_mcu7t5v0__filltie
XFILLER_105_434 VDD VDD VSS VSS gf180mcu_fd_sc_mcu7t5v0__fill_2
XTAP_TAPCELL_ROW_6_300 VDD VSS gf180mcu_fd_sc_mcu7t5v0__filltie
XFILLER_105_489 VDD VDD VSS VSS gf180mcu_fd_sc_mcu7t5v0__fill_1
XFILLER_86_384 VDD VDD VSS VSS gf180mcu_fd_sc_mcu7t5v0__fill_1
XFILLER_74_524 VDD VDD VSS VSS gf180mcu_fd_sc_mcu7t5v0__fill_1
XFILLER_46_204 VDD VDD VSS VSS gf180mcu_fd_sc_mcu7t5v0__fillcap_4
XFILLER_59_598 VDD VDD VSS VSS gf180mcu_fd_sc_mcu7t5v0__fill_2
XFILLER_74_535 VDD VDD VSS VSS gf180mcu_fd_sc_mcu7t5v0__fillcap_4
XFILLER_36_53 VDD VDD VSS VSS gf180mcu_fd_sc_mcu7t5v0__fillcap_8
XFILLER_27_484 VDD VDD VSS VSS gf180mcu_fd_sc_mcu7t5v0__fillcap_4
XFILLER_42_410 VDD VDD VSS VSS gf180mcu_fd_sc_mcu7t5v0__fill_2
XFILLER_14_167 VDD VDD VSS VSS gf180mcu_fd_sc_mcu7t5v0__fillcap_8
XFILLER_52_41 VDD VDD VSS VSS gf180mcu_fd_sc_mcu7t5v0__fill_2
XTAP_TAPCELL_ROW_12_357 VDD VSS gf180mcu_fd_sc_mcu7t5v0__filltie
XFILLER_10_362 VDD VDD VSS VSS gf180mcu_fd_sc_mcu7t5v0__fillcap_4
XTAP_TAPCELL_ROW_40_655 VDD VSS gf180mcu_fd_sc_mcu7t5v0__filltie
XTAP_TAPCELL_ROW_75_1020 VDD VSS gf180mcu_fd_sc_mcu7t5v0__filltie
XFILLER_96_104 VDD VDD VSS VSS gf180mcu_fd_sc_mcu7t5v0__fill_1
XFILLER_77_340 VDD VDD VSS VSS gf180mcu_fd_sc_mcu7t5v0__fill_2
XFILLER_77_384 VDD VDD VSS VSS gf180mcu_fd_sc_mcu7t5v0__fillcap_4
XFILLER_92_321 VDD VDD VSS VSS gf180mcu_fd_sc_mcu7t5v0__fill_2
XTAP_TAPCELL_ROW_48_733 VDD VSS gf180mcu_fd_sc_mcu7t5v0__filltie
XFILLER_65_568 VDD VDD VSS VSS gf180mcu_fd_sc_mcu7t5v0__fill_1
XFILLER_92_387 VDD VDD VSS VSS gf180mcu_fd_sc_mcu7t5v0__fillcap_16
XFILLER_80_527 VDD VDD VSS VSS gf180mcu_fd_sc_mcu7t5v0__fillcap_32
XFILLER_18_473 VDD VDD VSS VSS gf180mcu_fd_sc_mcu7t5v0__fillcap_8
XFILLER_33_454 VDD VDD VSS VSS gf180mcu_fd_sc_mcu7t5v0__fillcap_16
X_1984_ _3112_/Q _3000_/Q _1990_/S _3000_/D VDD VDD VSS VSS gf180mcu_fd_sc_mcu7t5v0__mux2_2
X_2605_ _3064_/Q _2132_/I _2664_/B1 _3096_/Q _2606_/A4 VDD VDD VSS VSS gf180mcu_fd_sc_mcu7t5v0__aoi22_1
XFILLER_88_605 VDD VDD VSS VSS gf180mcu_fd_sc_mcu7t5v0__fill_1
XFILLER_0_509 VDD VDD VSS VSS gf180mcu_fd_sc_mcu7t5v0__fill_1
X_2536_ _3199_/Q _3191_/Q _2540_/S _3199_/D VDD VDD VSS VSS gf180mcu_fd_sc_mcu7t5v0__mux2_2
X_2467_ _3263_/Q _2443_/Z _2467_/B1 _3255_/Q _3157_/Q _2468_/A2 VDD VDD VSS VSS gf180mcu_fd_sc_mcu7t5v0__aoi221_1
XFILLER_87_159 VDD VDD VSS VSS gf180mcu_fd_sc_mcu7t5v0__fillcap_16
X_1418_ _3045_/Q _2368_/A2 VDD VDD VSS VSS gf180mcu_fd_sc_mcu7t5v0__clkinv_1
X_2398_ _2829_/Q _2821_/Q _2813_/Q _2805_/Q _2404_/S0 _2404_/S1 _2398_/Z VDD VDD VSS
+ VSS gf180mcu_fd_sc_mcu7t5v0__mux4_1
XFILLER_28_237 VDD VDD VSS VSS gf180mcu_fd_sc_mcu7t5v0__fillcap_8
XFILLER_56_524 VDD VDD VSS VSS gf180mcu_fd_sc_mcu7t5v0__fill_1
XFILLER_83_376 VDD VDD VSS VSS gf180mcu_fd_sc_mcu7t5v0__fillcap_4
XFILLER_37_760 VDD VDD VSS VSS gf180mcu_fd_sc_mcu7t5v0__fillcap_4
X_3019_ _3019_/D _3022_/CLK _3019_/Q VDD VDD VSS VSS gf180mcu_fd_sc_mcu7t5v0__dffq_1
XFILLER_36_292 VDD VDD VSS VSS gf180mcu_fd_sc_mcu7t5v0__fillcap_16
XFILLER_12_627 VDD VDD VSS VSS gf180mcu_fd_sc_mcu7t5v0__fill_1
XFILLER_105_220 VDD VDD VSS VSS gf180mcu_fd_sc_mcu7t5v0__fillcap_4
XFILLER_105_286 VDD VDD VSS VSS gf180mcu_fd_sc_mcu7t5v0__fill_1
XFILLER_78_104 VDD VDD VSS VSS gf180mcu_fd_sc_mcu7t5v0__fill_1
XFILLER_78_115 VDD VDD VSS VSS gf180mcu_fd_sc_mcu7t5v0__fill_1
XFILLER_59_340 VDD VDD VSS VSS gf180mcu_fd_sc_mcu7t5v0__fillcap_8
XFILLER_101_492 VDD VDD VSS VSS gf180mcu_fd_sc_mcu7t5v0__fillcap_64
XFILLER_28_760 VDD VDD VSS VSS gf180mcu_fd_sc_mcu7t5v0__fillcap_4
XTAP_TAPCELL_ROW_45_703 VDD VSS gf180mcu_fd_sc_mcu7t5v0__filltie
XFILLER_47_557 VDD VDD VSS VSS gf180mcu_fd_sc_mcu7t5v0__fill_2
XFILLER_74_387 VDD VDD VSS VSS gf180mcu_fd_sc_mcu7t5v0__fillcap_8
XTAP_TAPCELL_ROW_17_416 VDD VSS gf180mcu_fd_sc_mcu7t5v0__filltie
XFILLER_62_527 VDD VDD VSS VSS gf180mcu_fd_sc_mcu7t5v0__fillcap_64
XTAP_TAPCELL_ROW_25_493 VDD VSS gf180mcu_fd_sc_mcu7t5v0__filltie
XFILLER_30_435 VDD VDD VSS VSS gf180mcu_fd_sc_mcu7t5v0__fillcap_4
XTAP_TAPCELL_ROW_53_791 VDD VSS gf180mcu_fd_sc_mcu7t5v0__filltie
XFILLER_70_593 VDD VDD VSS VSS gf180mcu_fd_sc_mcu7t5v0__fill_2
XFILLER_30_457 VDD VDD VSS VSS gf180mcu_fd_sc_mcu7t5v0__fillcap_4
XFILLER_7_697 VDD VDD VSS VSS gf180mcu_fd_sc_mcu7t5v0__fill_2
XFILLER_6_174 VDD VDD VSS VSS gf180mcu_fd_sc_mcu7t5v0__fill_1
X_3370_ _3396_/Q input1/Z _3407_/CLK hold59/I VDD VDD VSS VSS gf180mcu_fd_sc_mcu7t5v0__dffrnq_1
X_2321_ _2887_/Q _2879_/Q _2871_/Q _2863_/Q _2388_/S0 _2390_/S1 _2321_/Z VDD VDD VSS
+ VSS gf180mcu_fd_sc_mcu7t5v0__mux4_1
XFILLER_69_104 VDD VDD VSS VSS gf180mcu_fd_sc_mcu7t5v0__fillcap_32
X_2252_ _2252_/A1 _2252_/A2 _2422_/S VDD VDD VSS VSS gf180mcu_fd_sc_mcu7t5v0__nand2_1
XFILLER_84_107 VDD VDD VSS VSS gf180mcu_fd_sc_mcu7t5v0__fill_1
X_2183_ _3424_/D _3423_/D _3424_/Q _2185_/A2 VDD VDD VSS VSS gf180mcu_fd_sc_mcu7t5v0__nand3_1
XFILLER_19_2 VDD VDD VSS VSS gf180mcu_fd_sc_mcu7t5v0__fillcap_4
XTAP_TAPCELL_ROW_84_1119 VDD VSS gf180mcu_fd_sc_mcu7t5v0__filltie
XFILLER_25_207 VDD VDD VSS VSS gf180mcu_fd_sc_mcu7t5v0__fill_2
X_1967_ _3114_/Q _2986_/Q _1971_/S _2986_/D VDD VDD VSS VSS gf180mcu_fd_sc_mcu7t5v0__mux2_2
X_1898_ _3366_/Q _1935_/A2 _1926_/A2 VDD VDD VSS VSS gf180mcu_fd_sc_mcu7t5v0__nor2_1
XFILLER_108_36 VDD VDD VSS VSS gf180mcu_fd_sc_mcu7t5v0__fillcap_32
XFILLER_103_702 VDD VDD VSS VSS gf180mcu_fd_sc_mcu7t5v0__fillcap_4
X_2519_ _3182_/Q _3174_/Q _2540_/S _3182_/D VDD VDD VSS VSS gf180mcu_fd_sc_mcu7t5v0__mux2_2
XFILLER_68_18 VDD VDD VSS VSS gf180mcu_fd_sc_mcu7t5v0__fillcap_8
XFILLER_88_457 VDD VDD VSS VSS gf180mcu_fd_sc_mcu7t5v0__fillcap_4
XFILLER_102_289 VDD VDD VSS VSS gf180mcu_fd_sc_mcu7t5v0__fill_1
XFILLER_56_387 VDD VDD VSS VSS gf180mcu_fd_sc_mcu7t5v0__fillcap_16
XTAP_TAPCELL_ROW_104_1322 VDD VSS gf180mcu_fd_sc_mcu7t5v0__filltie
XFILLER_24_262 VDD VDD VSS VSS gf180mcu_fd_sc_mcu7t5v0__fillcap_4
XFILLER_33_43 VDD VDD VSS VSS gf180mcu_fd_sc_mcu7t5v0__fillcap_16
XFILLER_12_457 VDD VDD VSS VSS gf180mcu_fd_sc_mcu7t5v0__fillcap_32
XTAP_TAPCELL_ROW_50_761 VDD VSS gf180mcu_fd_sc_mcu7t5v0__filltie
XTAP_TAPCELL_ROW_22_463 VDD VSS gf180mcu_fd_sc_mcu7t5v0__filltie
XFILLER_4_601 VDD VDD VSS VSS gf180mcu_fd_sc_mcu7t5v0__fill_2
XFILLER_4_667 VDD VDD VSS VSS gf180mcu_fd_sc_mcu7t5v0__fillcap_16
XFILLER_106_584 VDD VDD VSS VSS gf180mcu_fd_sc_mcu7t5v0__fillcap_8
XFILLER_79_457 VDD VDD VSS VSS gf180mcu_fd_sc_mcu7t5v0__fill_1
XFILLER_58_62 VDD VDD VSS VSS gf180mcu_fd_sc_mcu7t5v0__fillcap_16
XFILLER_75_674 VDD VDD VSS VSS gf180mcu_fd_sc_mcu7t5v0__fill_2
XFILLER_75_652 VDD VDD VSS VSS gf180mcu_fd_sc_mcu7t5v0__fill_1
XFILLER_90_644 VDD VDD VSS VSS gf180mcu_fd_sc_mcu7t5v0__fill_1
XFILLER_74_94 VDD VDD VSS VSS gf180mcu_fd_sc_mcu7t5v0__fill_2
X_2870_ _2870_/D _2891_/CLK _2870_/Q VDD VDD VSS VSS gf180mcu_fd_sc_mcu7t5v0__dffq_1
XFILLER_15_295 VDD VDD VSS VSS gf180mcu_fd_sc_mcu7t5v0__fillcap_4
X_1821_ _2861_/Q _3286_/Q _1822_/S _2861_/D VDD VDD VSS VSS gf180mcu_fd_sc_mcu7t5v0__mux2_2
X_1752_ _3281_/Q _2800_/Q _1758_/S _2800_/D VDD VDD VSS VSS gf180mcu_fd_sc_mcu7t5v0__mux2_2
X_1683_ _3142_/Q _3146_/Q _2406_/C VDD VDD VSS VSS gf180mcu_fd_sc_mcu7t5v0__nor2_1
X_3422_ input3/Z _3416_/RN _3423_/CLK _3423_/D VDD VDD VSS VSS gf180mcu_fd_sc_mcu7t5v0__dffsnq_1
XFILLER_98_733 VDD VDD VSS VSS gf180mcu_fd_sc_mcu7t5v0__fill_2
X_3353_ _3353_/D input1/Z _3358_/CLK _3353_/Q VDD VDD VSS VSS gf180mcu_fd_sc_mcu7t5v0__dffrnq_1
X_2304_ _2427_/B _2313_/A1 _2309_/A2 _2305_/B VDD VDD VSS VSS gf180mcu_fd_sc_mcu7t5v0__nor3_1
XFILLER_100_705 VDD VDD VSS VSS gf180mcu_fd_sc_mcu7t5v0__fillcap_4
XTAP_TAPCELL_ROW_90_1178 VDD VSS gf180mcu_fd_sc_mcu7t5v0__filltie
X_3284_ _3284_/D _3303_/RN _3285_/CLK _3284_/Q VDD VDD VSS VSS gf180mcu_fd_sc_mcu7t5v0__dffrnq_1
XFILLER_100_749 VDD VDD VSS VSS gf180mcu_fd_sc_mcu7t5v0__fill_1
X_2235_ _2413_/A1 _2242_/S _2235_/B _3111_/D VDD VDD VSS VSS gf180mcu_fd_sc_mcu7t5v0__oai21_1
X_2166_ _3245_/Q _3095_/Q _2166_/S _3095_/D VDD VDD VSS VSS gf180mcu_fd_sc_mcu7t5v0__mux2_2
XFILLER_81_611 VDD VDD VSS VSS gf180mcu_fd_sc_mcu7t5v0__fillcap_16
XFILLER_38_387 VDD VDD VSS VSS gf180mcu_fd_sc_mcu7t5v0__fillcap_32
XFILLER_53_313 VDD VDD VSS VSS gf180mcu_fd_sc_mcu7t5v0__fill_1
XFILLER_81_666 VDD VDD VSS VSS gf180mcu_fd_sc_mcu7t5v0__fill_2
XFILLER_81_644 VDD VDD VSS VSS gf180mcu_fd_sc_mcu7t5v0__fill_2
XFILLER_80_121 VDD VDD VSS VSS gf180mcu_fd_sc_mcu7t5v0__fillcap_32
X_2097_ _3111_/Q _3310_/D _2098_/B VDD VDD VSS VSS gf180mcu_fd_sc_mcu7t5v0__nand2_1
XFILLER_65_195 VDD VDD VSS VSS gf180mcu_fd_sc_mcu7t5v0__fillcap_8
XPHY_EDGE_ROW_3_Right_3 VDD VSS gf180mcu_fd_sc_mcu7t5v0__endcap
X_2999_ _2999_/D _3021_/CLK _2999_/Q VDD VDD VSS VSS gf180mcu_fd_sc_mcu7t5v0__dffq_1
XFILLER_1_626 VDD VDD VSS VSS gf180mcu_fd_sc_mcu7t5v0__fillcap_4
XFILLER_103_576 VDD VDD VSS VSS gf180mcu_fd_sc_mcu7t5v0__fill_1
XFILLER_28_10 VDD VDD VSS VSS gf180mcu_fd_sc_mcu7t5v0__fillcap_4
XFILLER_29_332 VDD VDD VSS VSS gf180mcu_fd_sc_mcu7t5v0__fill_2
XFILLER_29_343 VDD VDD VSS VSS gf180mcu_fd_sc_mcu7t5v0__fillcap_4
XFILLER_57_696 VDD VDD VSS VSS gf180mcu_fd_sc_mcu7t5v0__fillcap_4
XTAP_TAPCELL_ROW_27_522 VDD VSS gf180mcu_fd_sc_mcu7t5v0__filltie
XFILLER_44_368 VDD VDD VSS VSS gf180mcu_fd_sc_mcu7t5v0__fill_1
XFILLER_9_748 VDD VDD VSS VSS gf180mcu_fd_sc_mcu7t5v0__fillcap_16
XFILLER_100_92 VDD VDD VSS VSS gf180mcu_fd_sc_mcu7t5v0__fillcap_8
XFILLER_8_247 VDD VDD VSS VSS gf180mcu_fd_sc_mcu7t5v0__fillcap_16
XFILLER_60_96 VDD VDD VSS VSS gf180mcu_fd_sc_mcu7t5v0__fillcap_8
XFILLER_69_72 VDD VDD VSS VSS gf180mcu_fd_sc_mcu7t5v0__fillcap_8
X_2020_ _3024_/Q _3023_/Q _3025_/Q _2024_/A3 VDD VDD VSS VSS gf180mcu_fd_sc_mcu7t5v0__nand3_1
XFILLER_75_471 VDD VDD VSS VSS gf180mcu_fd_sc_mcu7t5v0__fillcap_16
XFILLER_90_441 VDD VDD VSS VSS gf180mcu_fd_sc_mcu7t5v0__fillcap_8
XFILLER_63_688 VDD VDD VSS VSS gf180mcu_fd_sc_mcu7t5v0__fillcap_8
X_2922_ _2922_/D _2926_/CLK _2922_/Q VDD VDD VSS VSS gf180mcu_fd_sc_mcu7t5v0__dffq_1
XFILLER_50_349 VDD VDD VSS VSS gf180mcu_fd_sc_mcu7t5v0__fillcap_8
XTAP_TAPCELL_ROW_61_878 VDD VSS gf180mcu_fd_sc_mcu7t5v0__filltie
XFILLER_86_2 VDD VDD VSS VSS gf180mcu_fd_sc_mcu7t5v0__fillcap_16
X_2853_ _2853_/D _3314_/CLK _2853_/Q VDD VDD VSS VSS gf180mcu_fd_sc_mcu7t5v0__dffq_1
X_1804_ _3287_/Q _2846_/Q _1804_/S _2846_/D VDD VDD VSS VSS gf180mcu_fd_sc_mcu7t5v0__mux2_2
X_2784_ _2784_/D _2796_/CLK _2784_/Q VDD VDD VSS VSS gf180mcu_fd_sc_mcu7t5v0__dffq_1
X_1735_ _2787_/Q _3284_/Q _1738_/S _2787_/D VDD VDD VSS VSS gf180mcu_fd_sc_mcu7t5v0__mux2_2
Xclkbuf_leaf_2_clk_i clkbuf_leaf_5_clk_i/I clkload8/I VDD VDD VSS VSS gf180mcu_fd_sc_mcu7t5v0__clkbuf_4
X_1666_ _2765_/Q _2267_/C _2289_/A2 VDD VDD VSS VSS gf180mcu_fd_sc_mcu7t5v0__nor2_1
X_1597_ _3390_/Q _3395_/D _1597_/Z VDD VDD VSS VSS gf180mcu_fd_sc_mcu7t5v0__xor2_1
X_3405_ _3405_/D input1/Z _3409_/CLK _3405_/Q VDD VDD VSS VSS gf180mcu_fd_sc_mcu7t5v0__dffrnq_1
X_3336_ hold62/Z input1/Z _3337_/CLK _3336_/Q VDD VDD VSS VSS gf180mcu_fd_sc_mcu7t5v0__dffrnq_1
XFILLER_100_524 VDD VDD VSS VSS gf180mcu_fd_sc_mcu7t5v0__fill_1
XFILLER_98_585 VDD VDD VSS VSS gf180mcu_fd_sc_mcu7t5v0__fillcap_8
X_3267_ _3267_/D _3328_/RN _3276_/CLK _3267_/Q VDD VDD VSS VSS gf180mcu_fd_sc_mcu7t5v0__dffrnq_1
XTAP_TAPCELL_ROW_69_956 VDD VSS gf180mcu_fd_sc_mcu7t5v0__filltie
X_2218_ _2218_/A1 _1686_/C _2218_/B _2315_/B VDD VDD VSS VSS gf180mcu_fd_sc_mcu7t5v0__oai21_1
X_3198_ _3198_/D _3328_/RN _3240_/CLK _3198_/Q VDD VDD VSS VSS gf180mcu_fd_sc_mcu7t5v0__dffrnq_1
X_2149_ _3228_/Q _3078_/Q _2165_/S _3078_/D VDD VDD VSS VSS gf180mcu_fd_sc_mcu7t5v0__mux2_2
XFILLER_53_132 VDD VDD VSS VSS gf180mcu_fd_sc_mcu7t5v0__fillcap_8
XFILLER_14_508 VDD VDD VSS VSS gf180mcu_fd_sc_mcu7t5v0__fillcap_16
XFILLER_53_154 VDD VDD VSS VSS gf180mcu_fd_sc_mcu7t5v0__fill_1
XFILLER_41_316 VDD VDD VSS VSS gf180mcu_fd_sc_mcu7t5v0__fillcap_4
XFILLER_41_338 VDD VDD VSS VSS gf180mcu_fd_sc_mcu7t5v0__fillcap_4
XFILLER_14_45 VDD VDD VSS VSS gf180mcu_fd_sc_mcu7t5v0__fillcap_4
XFILLER_14_34 VDD VDD VSS VSS gf180mcu_fd_sc_mcu7t5v0__fill_1
XFILLER_103_340 VDD VDD VSS VSS gf180mcu_fd_sc_mcu7t5v0__fill_1
XFILLER_103_384 VDD VDD VSS VSS gf180mcu_fd_sc_mcu7t5v0__fillcap_4
XTAP_TAPCELL_ROW_4_272 VDD VSS gf180mcu_fd_sc_mcu7t5v0__filltie
XFILLER_29_151 VDD VDD VSS VSS gf180mcu_fd_sc_mcu7t5v0__fillcap_4
XFILLER_17_346 VDD VDD VSS VSS gf180mcu_fd_sc_mcu7t5v0__fillcap_4
XFILLER_55_41 VDD VDD VSS VSS gf180mcu_fd_sc_mcu7t5v0__fillcap_16
XFILLER_72_474 VDD VDD VSS VSS gf180mcu_fd_sc_mcu7t5v0__fillcap_4
XTAP_TAPCELL_ROW_78_1051 VDD VSS gf180mcu_fd_sc_mcu7t5v0__filltie
X_1520_ _1520_/I _3320_/D VDD VDD VSS VSS gf180mcu_fd_sc_mcu7t5v0__clkinv_1
X_1451_ _3395_/Q _1451_/A2 _3399_/D VDD VDD VSS VSS gf180mcu_fd_sc_mcu7t5v0__xnor2_1
X_1382_ _3145_/Q _2427_/A1 VDD VDD VSS VSS gf180mcu_fd_sc_mcu7t5v0__clkinv_1
X_3121_ _3121_/D _3369_/RN _3148_/CLK _3121_/Q VDD VDD VSS VSS gf180mcu_fd_sc_mcu7t5v0__dffrnq_1
XFILLER_95_577 VDD VDD VSS VSS gf180mcu_fd_sc_mcu7t5v0__fillcap_4
XFILLER_83_739 VDD VDD VSS VSS gf180mcu_fd_sc_mcu7t5v0__fillcap_4
XTAP_TAPCELL_ROW_38_628 VDD VSS gf180mcu_fd_sc_mcu7t5v0__filltie
XFILLER_55_419 VDD VDD VSS VSS gf180mcu_fd_sc_mcu7t5v0__fill_1
X_3052_ _3052_/D _3303_/RN _3288_/CLK _3052_/Q VDD VDD VSS VSS gf180mcu_fd_sc_mcu7t5v0__dffrnq_1
XFILLER_67_268 VDD VDD VSS VSS gf180mcu_fd_sc_mcu7t5v0__fillcap_8
XTAP_TAPCELL_ROW_66_926 VDD VSS gf180mcu_fd_sc_mcu7t5v0__filltie
X_2003_ _3113_/Q _3017_/Q _2008_/S _3017_/D VDD VDD VSS VSS gf180mcu_fd_sc_mcu7t5v0__mux2_2
XFILLER_23_305 VDD VDD VSS VSS gf180mcu_fd_sc_mcu7t5v0__fill_1
XFILLER_90_282 VDD VDD VSS VSS gf180mcu_fd_sc_mcu7t5v0__fillcap_4
XFILLER_35_187 VDD VDD VSS VSS gf180mcu_fd_sc_mcu7t5v0__fillcap_8
XFILLER_36_699 VDD VDD VSS VSS gf180mcu_fd_sc_mcu7t5v0__fill_2
X_2905_ _2905_/D _2958_/CLK _2905_/Q VDD VDD VSS VSS gf180mcu_fd_sc_mcu7t5v0__dffq_1
X_2836_ _2836_/D _3315_/CLK _2836_/Q VDD VDD VSS VSS gf180mcu_fd_sc_mcu7t5v0__dffq_1
X_2767_ _2767_/D _2796_/CLK _2767_/Q VDD VDD VSS VSS gf180mcu_fd_sc_mcu7t5v0__dffq_1
XFILLER_105_627 VDD VDD VSS VSS gf180mcu_fd_sc_mcu7t5v0__fill_2
X_1718_ _2774_/Q _3287_/Q _1718_/S _2774_/D VDD VDD VSS VSS gf180mcu_fd_sc_mcu7t5v0__mux2_2
X_2698_ _2687_/Z _2698_/A2 _3260_/D VDD VDD VSS VSS gf180mcu_fd_sc_mcu7t5v0__nand2_1
XFILLER_104_115 VDD VDD VSS VSS gf180mcu_fd_sc_mcu7t5v0__fillcap_4
X_1649_ _2764_/Q _2202_/A2 _2222_/B2 VDD VDD VSS VSS gf180mcu_fd_sc_mcu7t5v0__nand2_1
XFILLER_76_18 VDD VDD VSS VSS gf180mcu_fd_sc_mcu7t5v0__fill_1
XFILLER_59_725 VDD VDD VSS VSS gf180mcu_fd_sc_mcu7t5v0__fillcap_4
X_3319_ _3319_/D input1/Z _3409_/CLK _3319_/Q VDD VDD VSS VSS gf180mcu_fd_sc_mcu7t5v0__dffrnq_1
XFILLER_100_387 VDD VDD VSS VSS gf180mcu_fd_sc_mcu7t5v0__fillcap_64
XFILLER_73_205 VDD VDD VSS VSS gf180mcu_fd_sc_mcu7t5v0__fillcap_4
XTAP_TAPCELL_ROW_1_242 VDD VSS gf180mcu_fd_sc_mcu7t5v0__filltie
XFILLER_82_761 VDD VDD VSS VSS gf180mcu_fd_sc_mcu7t5v0__fillcap_4
XFILLER_81_282 VDD VDD VSS VSS gf180mcu_fd_sc_mcu7t5v0__fill_2
XFILLER_81_260 VDD VDD VSS VSS gf180mcu_fd_sc_mcu7t5v0__fillcap_8
XFILLER_27_699 VDD VDD VSS VSS gf180mcu_fd_sc_mcu7t5v0__fill_1
XFILLER_42_625 VDD VDD VSS VSS gf180mcu_fd_sc_mcu7t5v0__fillcap_4
XFILLER_14_349 VDD VDD VSS VSS gf180mcu_fd_sc_mcu7t5v0__fill_2
XFILLER_108_410 VDD VDD VSS VSS gf180mcu_fd_sc_mcu7t5v0__fillcap_32
XFILLER_6_548 VDD VDD VSS VSS gf180mcu_fd_sc_mcu7t5v0__fillcap_32
XTAP_TAPCELL_ROW_9_331 VDD VSS gf180mcu_fd_sc_mcu7t5v0__filltie
XFILLER_104_682 VDD VDD VSS VSS gf180mcu_fd_sc_mcu7t5v0__fillcap_16
XFILLER_1_264 VDD VDD VSS VSS gf180mcu_fd_sc_mcu7t5v0__fill_1
XFILLER_49_224 VDD VDD VSS VSS gf180mcu_fd_sc_mcu7t5v0__fill_1
XFILLER_2_37 VDD VDD VSS VSS gf180mcu_fd_sc_mcu7t5v0__fillcap_64
XFILLER_77_577 VDD VDD VSS VSS gf180mcu_fd_sc_mcu7t5v0__fillcap_4
XFILLER_65_717 VDD VDD VSS VSS gf180mcu_fd_sc_mcu7t5v0__fillcap_8
XFILLER_18_622 VDD VDD VSS VSS gf180mcu_fd_sc_mcu7t5v0__fillcap_8
XFILLER_33_614 VDD VDD VSS VSS gf180mcu_fd_sc_mcu7t5v0__fill_2
XFILLER_20_319 VDD VDD VSS VSS gf180mcu_fd_sc_mcu7t5v0__fill_1
XTAP_TAPCELL_ROW_43_686 VDD VSS gf180mcu_fd_sc_mcu7t5v0__filltie
XTAP_TAPCELL_ROW_71_984 VDD VSS gf180mcu_fd_sc_mcu7t5v0__filltie
XTAP_TAPCELL_ROW_15_388 VDD VSS gf180mcu_fd_sc_mcu7t5v0__filltie
XFILLER_41_691 VDD VDD VSS VSS gf180mcu_fd_sc_mcu7t5v0__fillcap_8
X_2621_ _2953_/Q _2945_/Q _2937_/Q _2929_/Q _2674_/S0 _2675_/S1 _2621_/Z VDD VDD VSS
+ VSS gf180mcu_fd_sc_mcu7t5v0__mux4_1
X_2552_ _2569_/S _2552_/A2 _3212_/D VDD VDD VSS VSS gf180mcu_fd_sc_mcu7t5v0__nand2_1
X_1503_ _3367_/Q _1503_/A2 _1504_/I VDD VDD VSS VSS gf180mcu_fd_sc_mcu7t5v0__xor2_1
X_2483_ _2458_/B _2480_/S _2483_/B _3157_/D VDD VDD VSS VSS gf180mcu_fd_sc_mcu7t5v0__aoi21_1
XFILLER_87_319 VDD VDD VSS VSS gf180mcu_fd_sc_mcu7t5v0__fill_2
X_1434_ _3351_/Q _1434_/A2 _1476_/A2 VDD VDD VSS VSS gf180mcu_fd_sc_mcu7t5v0__nor2_1
X_1365_ _3394_/Q _2405_/S VDD VDD VSS VSS gf180mcu_fd_sc_mcu7t5v0__clkinv_1
X_3104_ _3104_/D _3416_/RN _3306_/CLK _3104_/Q VDD VDD VSS VSS gf180mcu_fd_sc_mcu7t5v0__dffrnq_1
XFILLER_68_577 VDD VDD VSS VSS gf180mcu_fd_sc_mcu7t5v0__fillcap_16
X_3035_ _3035_/D _3416_/RN _3419_/CLK _3035_/Q VDD VDD VSS VSS gf180mcu_fd_sc_mcu7t5v0__dffrnq_1
Xclkbuf_leaf_20_clk_i clkload2/I _3423_/CLK VDD VDD VSS VSS gf180mcu_fd_sc_mcu7t5v0__clkbuf_4
XFILLER_51_422 VDD VDD VSS VSS gf180mcu_fd_sc_mcu7t5v0__fillcap_4
XFILLER_63_282 VDD VDD VSS VSS gf180mcu_fd_sc_mcu7t5v0__fillcap_16
XFILLER_51_444 VDD VDD VSS VSS gf180mcu_fd_sc_mcu7t5v0__fillcap_4
XFILLER_51_488 VDD VDD VSS VSS gf180mcu_fd_sc_mcu7t5v0__fill_2
Xclkbuf_leaf_35_clk_i clkload4/I _3022_/CLK VDD VDD VSS VSS gf180mcu_fd_sc_mcu7t5v0__clkbuf_4
X_2819_ _2819_/D _2894_/CLK _2819_/Q VDD VDD VSS VSS gf180mcu_fd_sc_mcu7t5v0__dffq_1
XTAP_TAPCELL_ROW_98_1268 VDD VSS gf180mcu_fd_sc_mcu7t5v0__filltie
XTAP_TAPCELL_ROW_6_301 VDD VSS gf180mcu_fd_sc_mcu7t5v0__filltie
XFILLER_59_500 VDD VDD VSS VSS gf180mcu_fd_sc_mcu7t5v0__fill_1
XFILLER_59_533 VDD VDD VSS VSS gf180mcu_fd_sc_mcu7t5v0__fillcap_8
XFILLER_101_696 VDD VDD VSS VSS gf180mcu_fd_sc_mcu7t5v0__fillcap_4
XFILLER_36_10 VDD VDD VSS VSS gf180mcu_fd_sc_mcu7t5v0__fill_2
XFILLER_61_208 VDD VDD VSS VSS gf180mcu_fd_sc_mcu7t5v0__fill_2
XTAP_TAPCELL_ROW_107_1353 VDD VSS gf180mcu_fd_sc_mcu7t5v0__filltie
XFILLER_14_102 VDD VDD VSS VSS gf180mcu_fd_sc_mcu7t5v0__fill_2
XFILLER_70_753 VDD VDD VSS VSS gf180mcu_fd_sc_mcu7t5v0__fillcap_8
XFILLER_14_157 VDD VDD VSS VSS gf180mcu_fd_sc_mcu7t5v0__fillcap_4
XTAP_TAPCELL_ROW_12_358 VDD VSS gf180mcu_fd_sc_mcu7t5v0__filltie
XTAP_TAPCELL_ROW_40_656 VDD VSS gf180mcu_fd_sc_mcu7t5v0__filltie
XFILLER_108_240 VDD VDD VSS VSS gf180mcu_fd_sc_mcu7t5v0__fillcap_32
XTAP_TAPCELL_ROW_75_1021 VDD VSS gf180mcu_fd_sc_mcu7t5v0__filltie
XFILLER_2_573 VDD VDD VSS VSS gf180mcu_fd_sc_mcu7t5v0__fillcap_16
XFILLER_77_352 VDD VDD VSS VSS gf180mcu_fd_sc_mcu7t5v0__fillcap_32
XTAP_TAPCELL_ROW_48_734 VDD VSS gf180mcu_fd_sc_mcu7t5v0__filltie
XFILLER_46_761 VDD VDD VSS VSS gf180mcu_fd_sc_mcu7t5v0__fillcap_4
XFILLER_33_400 VDD VDD VSS VSS gf180mcu_fd_sc_mcu7t5v0__fillcap_4
XFILLER_33_422 VDD VDD VSS VSS gf180mcu_fd_sc_mcu7t5v0__fillcap_32
XFILLER_45_282 VDD VDD VSS VSS gf180mcu_fd_sc_mcu7t5v0__fillcap_64
XFILLER_21_628 VDD VDD VSS VSS gf180mcu_fd_sc_mcu7t5v0__fill_2
X_1983_ _3111_/Q _2999_/Q _1990_/S _2999_/D VDD VDD VSS VSS gf180mcu_fd_sc_mcu7t5v0__mux2_2
X_2604_ _2764_/Q _2603_/Z _2606_/A3 VDD VDD VSS VSS gf180mcu_fd_sc_mcu7t5v0__nand2_1
X_2535_ _3198_/Q _3190_/Q _2540_/S _3198_/D VDD VDD VSS VSS gf180mcu_fd_sc_mcu7t5v0__mux2_2
X_2466_ _3247_/Q _1617_/Z _2466_/B1 _3271_/Q _2468_/A1 VDD VDD VSS VSS gf180mcu_fd_sc_mcu7t5v0__aoi22_1
X_1417_ _3044_/Q _2355_/A2 VDD VDD VSS VSS gf180mcu_fd_sc_mcu7t5v0__clkinv_1
XFILLER_96_650 VDD VDD VSS VSS gf180mcu_fd_sc_mcu7t5v0__fillcap_8
X_2397_ _3139_/Q _2409_/A1 _2409_/B VDD VDD VSS VSS gf180mcu_fd_sc_mcu7t5v0__nand2_1
XFILLER_29_717 VDD VDD VSS VSS gf180mcu_fd_sc_mcu7t5v0__fillcap_8
XFILLER_56_514 VDD VDD VSS VSS gf180mcu_fd_sc_mcu7t5v0__fillcap_8
X_3018_ _3018_/D _3021_/CLK _3018_/Q VDD VDD VSS VSS gf180mcu_fd_sc_mcu7t5v0__dffq_1
XFILLER_52_764 VDD VDD VSS VSS gf180mcu_fd_sc_mcu7t5v0__fill_1
XFILLER_20_683 VDD VDD VSS VSS gf180mcu_fd_sc_mcu7t5v0__fill_2
XFILLER_22_45 VDD VDD VSS VSS gf180mcu_fd_sc_mcu7t5v0__fill_2
XFILLER_79_628 VDD VDD VSS VSS gf180mcu_fd_sc_mcu7t5v0__fill_2
XFILLER_101_460 VDD VDD VSS VSS gf180mcu_fd_sc_mcu7t5v0__fill_1
XFILLER_19_205 VDD VDD VSS VSS gf180mcu_fd_sc_mcu7t5v0__fillcap_4
XFILLER_59_374 VDD VDD VSS VSS gf180mcu_fd_sc_mcu7t5v0__fill_1
XFILLER_47_97 VDD VDD VSS VSS gf180mcu_fd_sc_mcu7t5v0__fill_1
XTAP_TAPCELL_ROW_17_417 VDD VSS gf180mcu_fd_sc_mcu7t5v0__filltie
XTAP_TAPCELL_ROW_45_704 VDD VSS gf180mcu_fd_sc_mcu7t5v0__filltie
XFILLER_15_422 VDD VDD VSS VSS gf180mcu_fd_sc_mcu7t5v0__fillcap_8
XFILLER_55_591 VDD VDD VSS VSS gf180mcu_fd_sc_mcu7t5v0__fillcap_4
XTAP_TAPCELL_ROW_25_494 VDD VSS gf180mcu_fd_sc_mcu7t5v0__filltie
XTAP_TAPCELL_ROW_53_792 VDD VSS gf180mcu_fd_sc_mcu7t5v0__filltie
XTAP_TAPCELL_ROW_81_1080 VDD VSS gf180mcu_fd_sc_mcu7t5v0__filltie
XFILLER_7_632 VDD VDD VSS VSS gf180mcu_fd_sc_mcu7t5v0__fillcap_8
XFILLER_6_131 VDD VDD VSS VSS gf180mcu_fd_sc_mcu7t5v0__fill_2
X_2320_ _2823_/Q _2815_/Q _2807_/Q _2799_/Q _1439_/B _2373_/S1 _2320_/Z VDD VDD VSS
+ VSS gf180mcu_fd_sc_mcu7t5v0__mux4_1
X_2251_ _3142_/Q _2438_/A2 _2218_/B _2418_/B _2251_/C _2252_/A2 VDD VDD VSS VSS gf180mcu_fd_sc_mcu7t5v0__aoi221_1
XFILLER_78_661 VDD VDD VSS VSS gf180mcu_fd_sc_mcu7t5v0__fillcap_4
X_2182_ _2182_/A1 _2182_/A2 _2182_/B _3105_/D VDD VDD VSS VSS gf180mcu_fd_sc_mcu7t5v0__aoi21_1
XFILLER_93_664 VDD VDD VSS VSS gf180mcu_fd_sc_mcu7t5v0__fillcap_16
XFILLER_92_174 VDD VDD VSS VSS gf180mcu_fd_sc_mcu7t5v0__fill_1
XFILLER_80_325 VDD VDD VSS VSS gf180mcu_fd_sc_mcu7t5v0__fillcap_4
XFILLER_80_314 VDD VDD VSS VSS gf180mcu_fd_sc_mcu7t5v0__fill_1
XFILLER_46_591 VDD VDD VSS VSS gf180mcu_fd_sc_mcu7t5v0__fillcap_4
XFILLER_34_764 VDD VDD VSS VSS gf180mcu_fd_sc_mcu7t5v0__fill_1
X_1966_ _3113_/Q _2985_/Q _1971_/S _2985_/D VDD VDD VSS VSS gf180mcu_fd_sc_mcu7t5v0__mux2_2
XTAP_TAPCELL_ROW_95_1227 VDD VSS gf180mcu_fd_sc_mcu7t5v0__filltie
X_1897_ _3118_/Q _2926_/Q _1897_/S _2926_/D VDD VDD VSS VSS gf180mcu_fd_sc_mcu7t5v0__mux2_2
X_2518_ _3181_/Q _3173_/Q _2534_/S _3181_/D VDD VDD VSS VSS gf180mcu_fd_sc_mcu7t5v0__mux2_2
XFILLER_103_758 VDD VDD VSS VSS gf180mcu_fd_sc_mcu7t5v0__fillcap_4
XFILLER_102_279 VDD VDD VSS VSS gf180mcu_fd_sc_mcu7t5v0__fillcap_8
X_2449_ _3157_/Q _2449_/A2 _2449_/A3 _2450_/B VDD VDD VSS VSS gf180mcu_fd_sc_mcu7t5v0__and3_1
XFILLER_68_193 VDD VDD VSS VSS gf180mcu_fd_sc_mcu7t5v0__fillcap_8
XFILLER_84_675 VDD VDD VSS VSS gf180mcu_fd_sc_mcu7t5v0__fillcap_4
XFILLER_71_314 VDD VDD VSS VSS gf180mcu_fd_sc_mcu7t5v0__fill_2
XTAP_TAPCELL_ROW_104_1323 VDD VSS gf180mcu_fd_sc_mcu7t5v0__filltie
XFILLER_17_67 VDD VDD VSS VSS gf180mcu_fd_sc_mcu7t5v0__fill_2
XFILLER_71_347 VDD VDD VSS VSS gf180mcu_fd_sc_mcu7t5v0__fill_2
XTAP_TAPCELL_ROW_22_464 VDD VSS gf180mcu_fd_sc_mcu7t5v0__filltie
XTAP_TAPCELL_ROW_50_762 VDD VSS gf180mcu_fd_sc_mcu7t5v0__filltie
XFILLER_106_552 VDD VDD VSS VSS gf180mcu_fd_sc_mcu7t5v0__fill_2
XFILLER_94_439 VDD VDD VSS VSS gf180mcu_fd_sc_mcu7t5v0__fill_1
XTAP_TAPCELL_ROW_58_840 VDD VSS gf180mcu_fd_sc_mcu7t5v0__filltie
XFILLER_28_591 VDD VDD VSS VSS gf180mcu_fd_sc_mcu7t5v0__fillcap_4
XFILLER_62_347 VDD VDD VSS VSS gf180mcu_fd_sc_mcu7t5v0__fill_2
XFILLER_74_196 VDD VDD VSS VSS gf180mcu_fd_sc_mcu7t5v0__fill_1
XFILLER_16_753 VDD VDD VSS VSS gf180mcu_fd_sc_mcu7t5v0__fillcap_8
XFILLER_30_244 VDD VDD VSS VSS gf180mcu_fd_sc_mcu7t5v0__fill_1
X_1820_ _2860_/Q _3285_/Q _1822_/S _2860_/D VDD VDD VSS VSS gf180mcu_fd_sc_mcu7t5v0__mux2_2
X_1751_ _3280_/Q _2799_/Q _1758_/S _2799_/D VDD VDD VSS VSS gf180mcu_fd_sc_mcu7t5v0__mux2_2
X_1682_ _2267_/C _2218_/A1 _2230_/I1 VDD VDD VSS VSS gf180mcu_fd_sc_mcu7t5v0__nor2_1
X_3421_ _3421_/D _3416_/RN _3424_/CLK _3421_/Q VDD VDD VSS VSS gf180mcu_fd_sc_mcu7t5v0__dffsnq_1
X_3352_ _3352_/D input1/Z _3352_/CLK _3352_/Q VDD VDD VSS VSS gf180mcu_fd_sc_mcu7t5v0__dffrnq_1
X_2303_ _2314_/A1 _2303_/A2 _2309_/A2 VDD VDD VSS VSS gf180mcu_fd_sc_mcu7t5v0__nor2_1
XFILLER_31_2 VDD VDD VSS VSS gf180mcu_fd_sc_mcu7t5v0__fillcap_16
XFILLER_97_266 VDD VDD VSS VSS gf180mcu_fd_sc_mcu7t5v0__fillcap_4
XFILLER_97_277 VDD VDD VSS VSS gf180mcu_fd_sc_mcu7t5v0__fill_2
XFILLER_97_255 VDD VDD VSS VSS gf180mcu_fd_sc_mcu7t5v0__fillcap_4
XTAP_TAPCELL_ROW_90_1179 VDD VSS gf180mcu_fd_sc_mcu7t5v0__filltie
XFILLER_85_417 VDD VDD VSS VSS gf180mcu_fd_sc_mcu7t5v0__fill_2
X_3283_ _3283_/D _3369_/RN _3286_/CLK _3283_/Q VDD VDD VSS VSS gf180mcu_fd_sc_mcu7t5v0__dffrnq_1
XFILLER_57_108 VDD VDD VSS VSS gf180mcu_fd_sc_mcu7t5v0__fill_2
XFILLER_58_609 VDD VDD VSS VSS gf180mcu_fd_sc_mcu7t5v0__fill_1
X_2234_ _3111_/Q _2242_/S _2235_/B VDD VDD VSS VSS gf180mcu_fd_sc_mcu7t5v0__nand2_1
X_2165_ _3244_/Q _3094_/Q _2165_/S _3094_/D VDD VDD VSS VSS gf180mcu_fd_sc_mcu7t5v0__mux2_2
XFILLER_38_377 VDD VDD VSS VSS gf180mcu_fd_sc_mcu7t5v0__fillcap_8
XFILLER_66_686 VDD VDD VSS VSS gf180mcu_fd_sc_mcu7t5v0__fill_2
X_2096_ _2096_/A1 _2091_/B _2096_/B _3050_/D VDD VDD VSS VSS gf180mcu_fd_sc_mcu7t5v0__aoi21_1
XFILLER_0_70 VDD VDD VSS VSS gf180mcu_fd_sc_mcu7t5v0__fillcap_32
XFILLER_19_580 VDD VDD VSS VSS gf180mcu_fd_sc_mcu7t5v0__fillcap_8
XFILLER_41_509 VDD VDD VSS VSS gf180mcu_fd_sc_mcu7t5v0__fillcap_32
XFILLER_80_177 VDD VDD VSS VSS gf180mcu_fd_sc_mcu7t5v0__fillcap_8
XFILLER_22_723 VDD VDD VSS VSS gf180mcu_fd_sc_mcu7t5v0__fillcap_8
XFILLER_21_277 VDD VDD VSS VSS gf180mcu_fd_sc_mcu7t5v0__fill_2
X_2998_ _2998_/D _3366_/CLK _2998_/Q VDD VDD VSS VSS gf180mcu_fd_sc_mcu7t5v0__dffq_1
X_1949_ _3114_/Q _2970_/Q _1953_/S _2970_/D VDD VDD VSS VSS gf180mcu_fd_sc_mcu7t5v0__mux2_2
XFILLER_107_349 VDD VDD VSS VSS gf180mcu_fd_sc_mcu7t5v0__fill_1
XFILLER_103_500 VDD VDD VSS VSS gf180mcu_fd_sc_mcu7t5v0__fillcap_4
XFILLER_0_104 VDD VDD VSS VSS gf180mcu_fd_sc_mcu7t5v0__fillcap_32
XFILLER_88_255 VDD VDD VSS VSS gf180mcu_fd_sc_mcu7t5v0__fillcap_4
XFILLER_29_366 VDD VDD VSS VSS gf180mcu_fd_sc_mcu7t5v0__fill_1
XFILLER_44_314 VDD VDD VSS VSS gf180mcu_fd_sc_mcu7t5v0__fill_1
XFILLER_56_174 VDD VDD VSS VSS gf180mcu_fd_sc_mcu7t5v0__fill_1
XTAP_TAPCELL_ROW_55_810 VDD VSS gf180mcu_fd_sc_mcu7t5v0__filltie
XFILLER_72_612 VDD VDD VSS VSS gf180mcu_fd_sc_mcu7t5v0__fillcap_8
XFILLER_71_133 VDD VDD VSS VSS gf180mcu_fd_sc_mcu7t5v0__fillcap_4
XFILLER_44_54 VDD VDD VSS VSS gf180mcu_fd_sc_mcu7t5v0__fill_1
XFILLER_71_188 VDD VDD VSS VSS gf180mcu_fd_sc_mcu7t5v0__fill_2
XFILLER_71_199 VDD VDD VSS VSS gf180mcu_fd_sc_mcu7t5v0__fill_2
XFILLER_9_716 VDD VDD VSS VSS gf180mcu_fd_sc_mcu7t5v0__fillcap_32
XFILLER_52_391 VDD VDD VSS VSS gf180mcu_fd_sc_mcu7t5v0__fill_2
XFILLER_12_288 VDD VDD VSS VSS gf180mcu_fd_sc_mcu7t5v0__fillcap_16
XFILLER_40_597 VDD VDD VSS VSS gf180mcu_fd_sc_mcu7t5v0__fillcap_8
XFILLER_60_31 VDD VDD VSS VSS gf180mcu_fd_sc_mcu7t5v0__fillcap_4
XFILLER_106_371 VDD VDD VSS VSS gf180mcu_fd_sc_mcu7t5v0__fillcap_8
XFILLER_79_244 VDD VDD VSS VSS gf180mcu_fd_sc_mcu7t5v0__fillcap_16
XFILLER_95_726 VDD VDD VSS VSS gf180mcu_fd_sc_mcu7t5v0__fillcap_4
XFILLER_79_277 VDD VDD VSS VSS gf180mcu_fd_sc_mcu7t5v0__fill_2
XFILLER_0_682 VDD VDD VSS VSS gf180mcu_fd_sc_mcu7t5v0__fill_1
XFILLER_94_247 VDD VDD VSS VSS gf180mcu_fd_sc_mcu7t5v0__fillcap_32
XPHY_EDGE_ROW_13_Right_13 VDD VSS gf180mcu_fd_sc_mcu7t5v0__endcap
XFILLER_48_675 VDD VDD VSS VSS gf180mcu_fd_sc_mcu7t5v0__fill_2
XFILLER_90_453 VDD VDD VSS VSS gf180mcu_fd_sc_mcu7t5v0__fill_2
XFILLER_50_306 VDD VDD VSS VSS gf180mcu_fd_sc_mcu7t5v0__fillcap_8
XFILLER_16_594 VDD VDD VSS VSS gf180mcu_fd_sc_mcu7t5v0__fill_1
X_2921_ _2921_/D _3367_/CLK _2921_/Q VDD VDD VSS VSS gf180mcu_fd_sc_mcu7t5v0__dffq_1
XFILLER_50_317 VDD VDD VSS VSS gf180mcu_fd_sc_mcu7t5v0__fillcap_32
XFILLER_62_177 VDD VDD VSS VSS gf180mcu_fd_sc_mcu7t5v0__fillcap_8
XTAP_TAPCELL_ROW_61_879 VDD VSS gf180mcu_fd_sc_mcu7t5v0__filltie
X_2852_ _2852_/D _3406_/CLK _2852_/Q VDD VDD VSS VSS gf180mcu_fd_sc_mcu7t5v0__dffq_1
XFILLER_79_2 VDD VDD VSS VSS gf180mcu_fd_sc_mcu7t5v0__fillcap_64
XPHY_EDGE_ROW_22_Right_22 VDD VSS gf180mcu_fd_sc_mcu7t5v0__endcap
X_1803_ _3286_/Q _2845_/Q _1804_/S _2845_/D VDD VDD VSS VSS gf180mcu_fd_sc_mcu7t5v0__mux2_2
X_2783_ _2783_/D _3406_/CLK _2783_/Q VDD VDD VSS VSS gf180mcu_fd_sc_mcu7t5v0__dffq_1
X_1734_ _2786_/Q _3283_/Q _1738_/S _2786_/D VDD VDD VSS VSS gf180mcu_fd_sc_mcu7t5v0__mux2_2
X_1665_ _2286_/B _1671_/A2 _1665_/B _1679_/B1 VDD VDD VSS VSS gf180mcu_fd_sc_mcu7t5v0__oai21_1
X_3404_ _3404_/D input1/Z _3409_/CLK _3404_/Q VDD VDD VSS VSS gf180mcu_fd_sc_mcu7t5v0__dffrnq_1
X_1596_ _1596_/A1 _1596_/A2 _1591_/Z _1596_/A4 _3409_/D VDD VDD VSS VSS gf180mcu_fd_sc_mcu7t5v0__nor4_1
X_3335_ hold51/Z input1/Z _3337_/CLK _3335_/Q VDD VDD VSS VSS gf180mcu_fd_sc_mcu7t5v0__dffrnq_1
XFILLER_86_737 VDD VDD VSS VSS gf180mcu_fd_sc_mcu7t5v0__fillcap_4
X_3266_ _3266_/D _3328_/RN _3329_/CLK _3266_/Q VDD VDD VSS VSS gf180mcu_fd_sc_mcu7t5v0__dffrnq_1
XPHY_EDGE_ROW_31_Right_31 VDD VSS gf180mcu_fd_sc_mcu7t5v0__endcap
XFILLER_85_236 VDD VDD VSS VSS gf180mcu_fd_sc_mcu7t5v0__fillcap_4
X_2217_ _2438_/B2 _2217_/A2 _2217_/B _2217_/C _2228_/A1 VDD VDD VSS VSS gf180mcu_fd_sc_mcu7t5v0__oai211_1
XTAP_TAPCELL_ROW_69_957 VDD VSS gf180mcu_fd_sc_mcu7t5v0__filltie
X_3197_ _3197_/D _3328_/RN _3264_/CLK _3197_/Q VDD VDD VSS VSS gf180mcu_fd_sc_mcu7t5v0__dffrnq_1
XFILLER_66_472 VDD VDD VSS VSS gf180mcu_fd_sc_mcu7t5v0__fillcap_16
X_2148_ _3227_/Q _3077_/Q _2165_/S _3077_/D VDD VDD VSS VSS gf180mcu_fd_sc_mcu7t5v0__mux2_2
XFILLER_26_314 VDD VDD VSS VSS gf180mcu_fd_sc_mcu7t5v0__fill_1
XFILLER_81_464 VDD VDD VSS VSS gf180mcu_fd_sc_mcu7t5v0__fill_1
XFILLER_54_667 VDD VDD VSS VSS gf180mcu_fd_sc_mcu7t5v0__fillcap_8
X_2079_ _3298_/Q _2091_/A2 _2090_/A2 _3290_/Q _2080_/B2 VDD VDD VSS VSS gf180mcu_fd_sc_mcu7t5v0__aoi22_1
XFILLER_10_726 VDD VDD VSS VSS gf180mcu_fd_sc_mcu7t5v0__fillcap_8
XPHY_EDGE_ROW_40_Right_40 VDD VSS gf180mcu_fd_sc_mcu7t5v0__endcap
XFILLER_10_737 VDD VDD VSS VSS gf180mcu_fd_sc_mcu7t5v0__fillcap_16
XTAP_TAPCELL_ROW_32_570 VDD VSS gf180mcu_fd_sc_mcu7t5v0__filltie
XFILLER_108_614 VDD VDD VSS VSS gf180mcu_fd_sc_mcu7t5v0__fillcap_32
XPHY_EDGE_ROW_15_Left_124 VDD VSS gf180mcu_fd_sc_mcu7t5v0__endcap
XFILLER_30_34 VDD VDD VSS VSS gf180mcu_fd_sc_mcu7t5v0__fill_1
XFILLER_103_352 VDD VDD VSS VSS gf180mcu_fd_sc_mcu7t5v0__fillcap_32
XFILLER_77_726 VDD VDD VSS VSS gf180mcu_fd_sc_mcu7t5v0__fill_2
XFILLER_49_417 VDD VDD VSS VSS gf180mcu_fd_sc_mcu7t5v0__fill_2
XFILLER_39_76 VDD VDD VSS VSS gf180mcu_fd_sc_mcu7t5v0__fill_2
XTAP_TAPCELL_ROW_4_273 VDD VSS gf180mcu_fd_sc_mcu7t5v0__filltie
XPHY_EDGE_ROW_24_Left_133 VDD VSS gf180mcu_fd_sc_mcu7t5v0__endcap
XFILLER_84_280 VDD VDD VSS VSS gf180mcu_fd_sc_mcu7t5v0__fill_1
XFILLER_44_177 VDD VDD VSS VSS gf180mcu_fd_sc_mcu7t5v0__fillcap_64
XFILLER_60_648 VDD VDD VSS VSS gf180mcu_fd_sc_mcu7t5v0__fill_1
XFILLER_25_380 VDD VDD VSS VSS gf180mcu_fd_sc_mcu7t5v0__fill_2
XFILLER_25_391 VDD VDD VSS VSS gf180mcu_fd_sc_mcu7t5v0__fillcap_16
XFILLER_9_546 VDD VDD VSS VSS gf180mcu_fd_sc_mcu7t5v0__fillcap_8
XPHY_EDGE_ROW_33_Left_142 VDD VSS gf180mcu_fd_sc_mcu7t5v0__endcap
XTAP_TAPCELL_ROW_78_1052 VDD VSS gf180mcu_fd_sc_mcu7t5v0__filltie
XFILLER_99_339 VDD VDD VSS VSS gf180mcu_fd_sc_mcu7t5v0__fill_2
X_1450_ _3395_/Q _1450_/A2 _3395_/D VDD VDD VSS VSS gf180mcu_fd_sc_mcu7t5v0__xnor2_1
X_1381_ _3138_/Q _2262_/B2 VDD VDD VSS VSS gf180mcu_fd_sc_mcu7t5v0__clkinv_1
X_3120_ _3120_/D _3416_/RN _3423_/CLK _3120_/Q VDD VDD VSS VSS gf180mcu_fd_sc_mcu7t5v0__dffrnq_1
XFILLER_68_737 VDD VDD VSS VSS gf180mcu_fd_sc_mcu7t5v0__fillcap_8
XFILLER_95_556 VDD VDD VSS VSS gf180mcu_fd_sc_mcu7t5v0__fillcap_4
XPHY_EDGE_ROW_42_Left_151 VDD VSS gf180mcu_fd_sc_mcu7t5v0__endcap
XFILLER_36_601 VDD VDD VSS VSS gf180mcu_fd_sc_mcu7t5v0__fill_1
XFILLER_48_450 VDD VDD VSS VSS gf180mcu_fd_sc_mcu7t5v0__fillcap_4
X_3051_ _3051_/D _3303_/RN _3302_/CLK _3051_/Q VDD VDD VSS VSS gf180mcu_fd_sc_mcu7t5v0__dffrnq_1
XTAP_TAPCELL_ROW_66_927 VDD VSS gf180mcu_fd_sc_mcu7t5v0__filltie
XTAP_TAPCELL_ROW_89_1170 VDD VSS gf180mcu_fd_sc_mcu7t5v0__filltie
X_2002_ _3112_/Q _3016_/Q _2008_/S _3016_/D VDD VDD VSS VSS gf180mcu_fd_sc_mcu7t5v0__mux2_2
XFILLER_35_100 VDD VDD VSS VSS gf180mcu_fd_sc_mcu7t5v0__fill_1
XTAP_TAPCELL_ROW_38_629 VDD VSS gf180mcu_fd_sc_mcu7t5v0__filltie
XFILLER_36_656 VDD VDD VSS VSS gf180mcu_fd_sc_mcu7t5v0__fillcap_8
XFILLER_50_103 VDD VDD VSS VSS gf180mcu_fd_sc_mcu7t5v0__fill_2
XFILLER_16_380 VDD VDD VSS VSS gf180mcu_fd_sc_mcu7t5v0__fillcap_4
X_2904_ _2904_/D _3286_/CLK _2904_/Q VDD VDD VSS VSS gf180mcu_fd_sc_mcu7t5v0__dffq_1
XPHY_EDGE_ROW_51_Left_160 VDD VSS gf180mcu_fd_sc_mcu7t5v0__endcap
X_2835_ _2835_/D _2892_/CLK _2835_/Q VDD VDD VSS VSS gf180mcu_fd_sc_mcu7t5v0__dffq_1
X_2766_ _2766_/D _3369_/RN _3308_/CLK _2766_/Q VDD VDD VSS VSS gf180mcu_fd_sc_mcu7t5v0__dffrnq_1
X_2697_ _3260_/Q _2680_/C _2729_/B1 _3078_/Q _2698_/A2 VDD VDD VSS VSS gf180mcu_fd_sc_mcu7t5v0__aoi22_1
X_1717_ _2773_/Q _3286_/Q _1718_/S _2773_/D VDD VDD VSS VSS gf180mcu_fd_sc_mcu7t5v0__mux2_2
X_1648_ _2202_/A1 _2765_/Q _2249_/B VDD VDD VSS VSS gf180mcu_fd_sc_mcu7t5v0__nor2_1
XFILLER_104_138 VDD VDD VSS VSS gf180mcu_fd_sc_mcu7t5v0__fill_1
X_1579_ _1579_/A1 _1579_/A2 _1581_/A2 VDD VDD VSS VSS gf180mcu_fd_sc_mcu7t5v0__nand2_1
X_3318_ hold60/Z input1/Z _3409_/CLK _3319_/D VDD VDD VSS VSS gf180mcu_fd_sc_mcu7t5v0__dffrnq_1
XFILLER_58_247 VDD VDD VSS VSS gf180mcu_fd_sc_mcu7t5v0__fillcap_16
X_3249_ _3249_/D _3369_/RN _3270_/CLK _3249_/Q VDD VDD VSS VSS gf180mcu_fd_sc_mcu7t5v0__dffrnq_1
XTAP_TAPCELL_ROW_1_243 VDD VSS gf180mcu_fd_sc_mcu7t5v0__filltie
XFILLER_27_623 VDD VDD VSS VSS gf180mcu_fd_sc_mcu7t5v0__fillcap_4
XFILLER_27_645 VDD VDD VSS VSS gf180mcu_fd_sc_mcu7t5v0__fill_1
XFILLER_73_228 VDD VDD VSS VSS gf180mcu_fd_sc_mcu7t5v0__fill_1
XFILLER_14_317 VDD VDD VSS VSS gf180mcu_fd_sc_mcu7t5v0__fillcap_32
XFILLER_26_177 VDD VDD VSS VSS gf180mcu_fd_sc_mcu7t5v0__fillcap_16
XFILLER_27_689 VDD VDD VSS VSS gf180mcu_fd_sc_mcu7t5v0__fillcap_8
XFILLER_25_89 VDD VDD VSS VSS gf180mcu_fd_sc_mcu7t5v0__fill_1
XFILLER_6_527 VDD VDD VSS VSS gf180mcu_fd_sc_mcu7t5v0__fillcap_4
XFILLER_41_66 VDD VDD VSS VSS gf180mcu_fd_sc_mcu7t5v0__fillcap_4
XFILLER_108_444 VDD VDD VSS VSS gf180mcu_fd_sc_mcu7t5v0__fillcap_32
XFILLER_41_88 VDD VDD VSS VSS gf180mcu_fd_sc_mcu7t5v0__fillcap_4
XTAP_TAPCELL_ROW_9_332 VDD VSS gf180mcu_fd_sc_mcu7t5v0__filltie
XFILLER_9_2 VDD VDD VSS VSS gf180mcu_fd_sc_mcu7t5v0__fillcap_32
XFILLER_1_298 VDD VDD VSS VSS gf180mcu_fd_sc_mcu7t5v0__fillcap_4
XFILLER_92_515 VDD VDD VSS VSS gf180mcu_fd_sc_mcu7t5v0__fillcap_8
XFILLER_65_729 VDD VDD VSS VSS gf180mcu_fd_sc_mcu7t5v0__fill_2
Xclkbuf_leaf_1_clk_i clkbuf_leaf_5_clk_i/I clkload7/I VDD VDD VSS VSS gf180mcu_fd_sc_mcu7t5v0__clkbuf_4
XFILLER_45_486 VDD VDD VSS VSS gf180mcu_fd_sc_mcu7t5v0__fillcap_4
XTAP_TAPCELL_ROW_15_389 VDD VSS gf180mcu_fd_sc_mcu7t5v0__filltie
XTAP_TAPCELL_ROW_43_687 VDD VSS gf180mcu_fd_sc_mcu7t5v0__filltie
X_2620_ _2921_/Q _2913_/Q _2905_/Q _2897_/Q _2674_/S0 _2674_/S1 _2620_/Z VDD VDD VSS
+ VSS gf180mcu_fd_sc_mcu7t5v0__mux4_1
X_2551_ _3212_/Q _2598_/A3 _2552_/A2 VDD VDD VSS VSS gf180mcu_fd_sc_mcu7t5v0__nand2_1
X_2482_ _3157_/Q _2481_/Z _2483_/B VDD VDD VSS VSS gf180mcu_fd_sc_mcu7t5v0__and2_1
XFILLER_5_582 VDD VDD VSS VSS gf180mcu_fd_sc_mcu7t5v0__fill_2
X_1502_ _1867_/S _1506_/A2 _3367_/D VDD VDD VSS VSS gf180mcu_fd_sc_mcu7t5v0__nor2_1
X_1433_ _1433_/A1 _3340_/Q _1433_/A3 _1431_/Z _1478_/A3 VDD VDD VSS VSS gf180mcu_fd_sc_mcu7t5v0__nor4_1
XFILLER_68_501 VDD VDD VSS VSS gf180mcu_fd_sc_mcu7t5v0__fillcap_16
X_1364_ _3393_/Q _2378_/B VDD VDD VSS VSS gf180mcu_fd_sc_mcu7t5v0__clkinv_1
X_3103_ _3103_/D _3328_/RN _3326_/CLK _3103_/Q VDD VDD VSS VSS gf180mcu_fd_sc_mcu7t5v0__dffrnq_1
XFILLER_55_206 VDD VDD VSS VSS gf180mcu_fd_sc_mcu7t5v0__fillcap_4
X_3034_ _3034_/D _3416_/RN _3419_/CLK _3034_/Q VDD VDD VSS VSS gf180mcu_fd_sc_mcu7t5v0__dffrnq_1
XFILLER_36_453 VDD VDD VSS VSS gf180mcu_fd_sc_mcu7t5v0__fill_2
XFILLER_64_762 VDD VDD VSS VSS gf180mcu_fd_sc_mcu7t5v0__fill_2
XFILLER_70_209 VDD VDD VSS VSS gf180mcu_fd_sc_mcu7t5v0__fill_2
XFILLER_36_486 VDD VDD VSS VSS gf180mcu_fd_sc_mcu7t5v0__fillcap_16
XFILLER_63_261 VDD VDD VSS VSS gf180mcu_fd_sc_mcu7t5v0__fillcap_4
XFILLER_91_592 VDD VDD VSS VSS gf180mcu_fd_sc_mcu7t5v0__fillcap_4
XFILLER_23_136 VDD VDD VSS VSS gf180mcu_fd_sc_mcu7t5v0__fillcap_4
X_2818_ _2818_/D _2887_/CLK _2818_/Q VDD VDD VSS VSS gf180mcu_fd_sc_mcu7t5v0__dffq_1
XTAP_TAPCELL_ROW_98_1258 VDD VSS gf180mcu_fd_sc_mcu7t5v0__filltie
X_2749_ _3223_/Q _3289_/Q _2760_/S _3289_/D VDD VDD VSS VSS gf180mcu_fd_sc_mcu7t5v0__mux2_2
XFILLER_11_69 VDD VDD VSS VSS gf180mcu_fd_sc_mcu7t5v0__fill_1
XFILLER_105_469 VDD VDD VSS VSS gf180mcu_fd_sc_mcu7t5v0__fill_2
XTAP_TAPCELL_ROW_6_302 VDD VSS gf180mcu_fd_sc_mcu7t5v0__filltie
XFILLER_99_692 VDD VDD VSS VSS gf180mcu_fd_sc_mcu7t5v0__fill_2
XFILLER_98_191 VDD VDD VSS VSS gf180mcu_fd_sc_mcu7t5v0__fill_1
XFILLER_74_504 VDD VDD VSS VSS gf180mcu_fd_sc_mcu7t5v0__fillcap_16
XTAP_TAPCELL_ROW_107_1354 VDD VSS gf180mcu_fd_sc_mcu7t5v0__filltie
XFILLER_15_626 VDD VDD VSS VSS gf180mcu_fd_sc_mcu7t5v0__fillcap_4
XFILLER_36_88 VDD VDD VSS VSS gf180mcu_fd_sc_mcu7t5v0__fill_2
XFILLER_23_692 VDD VDD VSS VSS gf180mcu_fd_sc_mcu7t5v0__fillcap_8
XTAP_TAPCELL_ROW_12_359 VDD VSS gf180mcu_fd_sc_mcu7t5v0__filltie
XTAP_TAPCELL_ROW_40_657 VDD VSS gf180mcu_fd_sc_mcu7t5v0__filltie
XFILLER_52_98 VDD VDD VSS VSS gf180mcu_fd_sc_mcu7t5v0__fillcap_4
XFILLER_6_313 VDD VDD VSS VSS gf180mcu_fd_sc_mcu7t5v0__fill_2
XFILLER_108_274 VDD VDD VSS VSS gf180mcu_fd_sc_mcu7t5v0__fillcap_32
XTAP_TAPCELL_ROW_75_1022 VDD VSS gf180mcu_fd_sc_mcu7t5v0__filltie
XFILLER_38_729 VDD VDD VSS VSS gf180mcu_fd_sc_mcu7t5v0__fillcap_4
XFILLER_92_323 VDD VDD VSS VSS gf180mcu_fd_sc_mcu7t5v0__fill_1
XFILLER_92_301 VDD VDD VSS VSS gf180mcu_fd_sc_mcu7t5v0__fillcap_8
XTAP_TAPCELL_ROW_48_735 VDD VSS gf180mcu_fd_sc_mcu7t5v0__filltie
XFILLER_65_548 VDD VDD VSS VSS gf180mcu_fd_sc_mcu7t5v0__fillcap_8
XFILLER_93_72 VDD VDD VSS VSS gf180mcu_fd_sc_mcu7t5v0__fillcap_16
XTAP_TAPCELL_ROW_86_1140 VDD VSS gf180mcu_fd_sc_mcu7t5v0__filltie
XFILLER_80_518 VDD VDD VSS VSS gf180mcu_fd_sc_mcu7t5v0__fillcap_4
XFILLER_61_710 VDD VDD VSS VSS gf180mcu_fd_sc_mcu7t5v0__fill_2
XFILLER_33_478 VDD VDD VSS VSS gf180mcu_fd_sc_mcu7t5v0__fillcap_4
XFILLER_60_242 VDD VDD VSS VSS gf180mcu_fd_sc_mcu7t5v0__fill_2
X_1982_ _1982_/A1 _2000_/A2 _1990_/S VDD VDD VSS VSS gf180mcu_fd_sc_mcu7t5v0__nand2_1
X_2603_ _3206_/Q _2603_/A2 _2679_/A3 _2603_/Z VDD VDD VSS VSS gf180mcu_fd_sc_mcu7t5v0__and3_1
X_2534_ _3197_/Q _3189_/Q _2534_/S _3197_/D VDD VDD VSS VSS gf180mcu_fd_sc_mcu7t5v0__mux2_2
X_2465_ _3157_/Q _2465_/A2 _2465_/A3 _2469_/A1 VDD VDD VSS VSS gf180mcu_fd_sc_mcu7t5v0__nand3_1
X_2396_ _2409_/A1 _2396_/A2 _2396_/B _3138_/D VDD VDD VSS VSS gf180mcu_fd_sc_mcu7t5v0__oai21_1
X_1416_ _3043_/Q _2342_/A2 VDD VDD VSS VSS gf180mcu_fd_sc_mcu7t5v0__clkinv_1
XFILLER_29_729 VDD VDD VSS VSS gf180mcu_fd_sc_mcu7t5v0__fill_2
XFILLER_83_345 VDD VDD VSS VSS gf180mcu_fd_sc_mcu7t5v0__fillcap_4
X_3017_ _3017_/D _3022_/CLK _3017_/Q VDD VDD VSS VSS gf180mcu_fd_sc_mcu7t5v0__dffq_1
XFILLER_43_209 VDD VDD VSS VSS gf180mcu_fd_sc_mcu7t5v0__fill_1
XFILLER_51_220 VDD VDD VSS VSS gf180mcu_fd_sc_mcu7t5v0__fill_1
XFILLER_51_297 VDD VDD VSS VSS gf180mcu_fd_sc_mcu7t5v0__fillcap_4
XFILLER_47_10 VDD VDD VSS VSS gf180mcu_fd_sc_mcu7t5v0__fill_1
XFILLER_59_364 VDD VDD VSS VSS gf180mcu_fd_sc_mcu7t5v0__fillcap_8
XFILLER_74_312 VDD VDD VSS VSS gf180mcu_fd_sc_mcu7t5v0__fill_2
XFILLER_47_559 VDD VDD VSS VSS gf180mcu_fd_sc_mcu7t5v0__fill_1
XTAP_TAPCELL_ROW_45_705 VDD VSS gf180mcu_fd_sc_mcu7t5v0__filltie
XFILLER_63_42 VDD VDD VSS VSS gf180mcu_fd_sc_mcu7t5v0__fillcap_16
XFILLER_15_478 VDD VDD VSS VSS gf180mcu_fd_sc_mcu7t5v0__fillcap_8
XPHY_EDGE_ROW_69_Right_69 VDD VSS gf180mcu_fd_sc_mcu7t5v0__endcap
XTAP_TAPCELL_ROW_53_793 VDD VSS gf180mcu_fd_sc_mcu7t5v0__filltie
XTAP_TAPCELL_ROW_81_1081 VDD VSS gf180mcu_fd_sc_mcu7t5v0__filltie
XFILLER_11_640 VDD VDD VSS VSS gf180mcu_fd_sc_mcu7t5v0__fillcap_4
XFILLER_8_37 VDD VDD VSS VSS gf180mcu_fd_sc_mcu7t5v0__fillcap_16
XPHY_EDGE_ROW_7_Left_116 VDD VSS gf180mcu_fd_sc_mcu7t5v0__endcap
XTAP_TAPCELL_ROW_25_495 VDD VSS gf180mcu_fd_sc_mcu7t5v0__filltie
XFILLER_7_699 VDD VDD VSS VSS gf180mcu_fd_sc_mcu7t5v0__fill_1
XPHY_EDGE_ROW_78_Right_78 VDD VSS gf180mcu_fd_sc_mcu7t5v0__endcap
X_2250_ _2218_/B _2250_/A2 _2252_/A1 VDD VDD VSS VSS gf180mcu_fd_sc_mcu7t5v0__nand2_1
XFILLER_88_83 VDD VDD VSS VSS gf180mcu_fd_sc_mcu7t5v0__fillcap_16
XFILLER_33_6 VDD VDD VSS VSS gf180mcu_fd_sc_mcu7t5v0__fill_2
X_2181_ _3421_/D _3420_/D _3421_/Q _2182_/B VDD VDD VSS VSS gf180mcu_fd_sc_mcu7t5v0__nor3_1
XFILLER_93_632 VDD VDD VSS VSS gf180mcu_fd_sc_mcu7t5v0__fillcap_4
Xclkbuf_leaf_34_clk_i clkload4/I _3366_/CLK VDD VDD VSS VSS gf180mcu_fd_sc_mcu7t5v0__clkbuf_4
XFILLER_25_209 VDD VDD VSS VSS gf180mcu_fd_sc_mcu7t5v0__fill_1
XFILLER_53_518 VDD VDD VSS VSS gf180mcu_fd_sc_mcu7t5v0__fillcap_8
XFILLER_92_197 VDD VDD VSS VSS gf180mcu_fd_sc_mcu7t5v0__fill_2
XPHY_EDGE_ROW_87_Right_87 VDD VSS gf180mcu_fd_sc_mcu7t5v0__endcap
XFILLER_34_732 VDD VDD VSS VSS gf180mcu_fd_sc_mcu7t5v0__fill_2
Xclkbuf_leaf_49_clk_i clkload3/I _3270_/CLK VDD VDD VSS VSS gf180mcu_fd_sc_mcu7t5v0__clkbuf_4
XFILLER_21_404 VDD VDD VSS VSS gf180mcu_fd_sc_mcu7t5v0__fill_1
XFILLER_61_562 VDD VDD VSS VSS gf180mcu_fd_sc_mcu7t5v0__fillcap_4
Xclkbuf_4_2_0_host_clk_i clkbuf_0_host_clk_i/Z _3315_/CLK VDD VDD VSS VSS gf180mcu_fd_sc_mcu7t5v0__clkbuf_4
X_1965_ _3112_/Q _2984_/Q _1971_/S _2984_/D VDD VDD VSS VSS gf180mcu_fd_sc_mcu7t5v0__mux2_2
X_1896_ _3117_/Q _2925_/Q _1897_/S _2925_/D VDD VDD VSS VSS gf180mcu_fd_sc_mcu7t5v0__mux2_2
XPHY_EDGE_ROW_96_Right_96 VDD VSS gf180mcu_fd_sc_mcu7t5v0__endcap
XTAP_TAPCELL_ROW_95_1228 VDD VSS gf180mcu_fd_sc_mcu7t5v0__filltie
XFILLER_0_308 VDD VDD VSS VSS gf180mcu_fd_sc_mcu7t5v0__fillcap_32
Xclkbuf_3_4__f_clk_i clkbuf_0_clk_i/Z clkload3/I VDD VDD VSS VSS gf180mcu_fd_sc_mcu7t5v0__clkbuf_16
X_2517_ _3180_/Q _3172_/Q _2534_/S _3180_/D VDD VDD VSS VSS gf180mcu_fd_sc_mcu7t5v0__mux2_2
XFILLER_88_448 VDD VDD VSS VSS gf180mcu_fd_sc_mcu7t5v0__fillcap_4
X_2448_ _3248_/Q _1617_/Z _2466_/B1 _3272_/Q _2467_/B1 _3256_/Q _2449_/A3 VDD VDD
+ VSS VSS gf180mcu_fd_sc_mcu7t5v0__aoi222_1
XFILLER_102_247 VDD VDD VSS VSS gf180mcu_fd_sc_mcu7t5v0__fillcap_32
XFILLER_96_481 VDD VDD VSS VSS gf180mcu_fd_sc_mcu7t5v0__fill_1
X_2379_ _2379_/A1 _2379_/A2 _2379_/B _2380_/B VDD VDD VSS VSS gf180mcu_fd_sc_mcu7t5v0__aoi21_1
XFILLER_69_684 VDD VDD VSS VSS gf180mcu_fd_sc_mcu7t5v0__fillcap_16
XFILLER_83_142 VDD VDD VSS VSS gf180mcu_fd_sc_mcu7t5v0__fill_2
XTAP_TAPCELL_ROW_104_1324 VDD VSS gf180mcu_fd_sc_mcu7t5v0__filltie
XFILLER_24_286 VDD VDD VSS VSS gf180mcu_fd_sc_mcu7t5v0__fillcap_8
XFILLER_33_67 VDD VDD VSS VSS gf180mcu_fd_sc_mcu7t5v0__fill_2
XTAP_TAPCELL_ROW_22_465 VDD VSS gf180mcu_fd_sc_mcu7t5v0__filltie
XTAP_TAPCELL_ROW_50_763 VDD VSS gf180mcu_fd_sc_mcu7t5v0__filltie
XFILLER_4_603 VDD VDD VSS VSS gf180mcu_fd_sc_mcu7t5v0__fill_1
XFILLER_106_531 VDD VDD VSS VSS gf180mcu_fd_sc_mcu7t5v0__fill_2
XPHY_EDGE_ROW_89_Left_198 VDD VSS gf180mcu_fd_sc_mcu7t5v0__endcap
XFILLER_79_415 VDD VDD VSS VSS gf180mcu_fd_sc_mcu7t5v0__fillcap_4
XFILLER_3_157 VDD VDD VSS VSS gf180mcu_fd_sc_mcu7t5v0__fillcap_8
XFILLER_58_86 VDD VDD VSS VSS gf180mcu_fd_sc_mcu7t5v0__fill_1
XFILLER_59_150 VDD VDD VSS VSS gf180mcu_fd_sc_mcu7t5v0__fill_2
XFILLER_59_172 VDD VDD VSS VSS gf180mcu_fd_sc_mcu7t5v0__fillcap_8
XFILLER_87_492 VDD VDD VSS VSS gf180mcu_fd_sc_mcu7t5v0__fillcap_16
XFILLER_75_632 VDD VDD VSS VSS gf180mcu_fd_sc_mcu7t5v0__fillcap_16
XFILLER_47_356 VDD VDD VSS VSS gf180mcu_fd_sc_mcu7t5v0__fill_2
XTAP_TAPCELL_ROW_58_841 VDD VSS gf180mcu_fd_sc_mcu7t5v0__filltie
XFILLER_75_676 VDD VDD VSS VSS gf180mcu_fd_sc_mcu7t5v0__fill_1
XTAP_TAPCELL_ROW_83_1110 VDD VSS gf180mcu_fd_sc_mcu7t5v0__filltie
XFILLER_16_732 VDD VDD VSS VSS gf180mcu_fd_sc_mcu7t5v0__fill_2
XFILLER_74_63 VDD VDD VSS VSS gf180mcu_fd_sc_mcu7t5v0__fillcap_8
XFILLER_15_231 VDD VDD VSS VSS gf180mcu_fd_sc_mcu7t5v0__fillcap_4
XFILLER_31_702 VDD VDD VSS VSS gf180mcu_fd_sc_mcu7t5v0__fillcap_8
XFILLER_43_562 VDD VDD VSS VSS gf180mcu_fd_sc_mcu7t5v0__fillcap_4
XFILLER_74_96 VDD VDD VSS VSS gf180mcu_fd_sc_mcu7t5v0__fill_1
XFILLER_70_381 VDD VDD VSS VSS gf180mcu_fd_sc_mcu7t5v0__fillcap_4
X_1750_ _1458_/Z _1777_/A2 _1758_/S VDD VDD VSS VSS gf180mcu_fd_sc_mcu7t5v0__nand2_1
XFILLER_11_492 VDD VDD VSS VSS gf180mcu_fd_sc_mcu7t5v0__fillcap_64
X_1681_ _1681_/A1 _2410_/A2 _2418_/B VDD VDD VSS VSS gf180mcu_fd_sc_mcu7t5v0__nor2_1
X_3420_ _3420_/D _3416_/RN _3424_/CLK _3421_/D VDD VDD VSS VSS gf180mcu_fd_sc_mcu7t5v0__dffsnq_1
X_3351_ _3351_/D input1/Z _3352_/CLK _3351_/Q VDD VDD VSS VSS gf180mcu_fd_sc_mcu7t5v0__dffrnq_1
X_2302_ _3128_/Q _2316_/A2 _3129_/Q _2306_/A1 VDD VDD VSS VSS gf180mcu_fd_sc_mcu7t5v0__aoi21_1
XFILLER_97_212 VDD VDD VSS VSS gf180mcu_fd_sc_mcu7t5v0__fillcap_16
X_3282_ _3282_/D _3303_/RN _3286_/CLK _3282_/Q VDD VDD VSS VSS gf180mcu_fd_sc_mcu7t5v0__dffrnq_1
XFILLER_24_2 VDD VDD VSS VSS gf180mcu_fd_sc_mcu7t5v0__fillcap_32
X_2233_ _3369_/RN _1658_/Z _2410_/A2 _2242_/S VDD VDD VSS VSS gf180mcu_fd_sc_mcu7t5v0__nand3_1
X_2164_ _3243_/Q _3093_/Q _2165_/S _3093_/D VDD VDD VSS VSS gf180mcu_fd_sc_mcu7t5v0__mux2_2
XFILLER_65_164 VDD VDD VSS VSS gf180mcu_fd_sc_mcu7t5v0__fillcap_4
XFILLER_80_101 VDD VDD VSS VSS gf180mcu_fd_sc_mcu7t5v0__fillcap_4
X_2095_ _2111_/A1 _2091_/B _2119_/A2 _2096_/B VDD VDD VSS VSS gf180mcu_fd_sc_mcu7t5v0__nor3_1
XFILLER_81_668 VDD VDD VSS VSS gf180mcu_fd_sc_mcu7t5v0__fill_1
XFILLER_21_212 VDD VDD VSS VSS gf180mcu_fd_sc_mcu7t5v0__fillcap_8
X_2997_ _2997_/D _3022_/CLK _2997_/Q VDD VDD VSS VSS gf180mcu_fd_sc_mcu7t5v0__dffq_1
X_1948_ _3113_/Q _2969_/Q _1953_/S _2969_/D VDD VDD VSS VSS gf180mcu_fd_sc_mcu7t5v0__mux2_2
X_1879_ _3365_/Q _1879_/A2 _1879_/A3 _1886_/S VDD VDD VSS VSS gf180mcu_fd_sc_mcu7t5v0__nor3_1
XFILLER_89_702 VDD VDD VSS VSS gf180mcu_fd_sc_mcu7t5v0__fill_1
XFILLER_88_267 VDD VDD VSS VSS gf180mcu_fd_sc_mcu7t5v0__fillcap_8
XFILLER_0_138 VDD VDD VSS VSS gf180mcu_fd_sc_mcu7t5v0__fillcap_16
XFILLER_29_334 VDD VDD VSS VSS gf180mcu_fd_sc_mcu7t5v0__fill_1
XFILLER_57_632 VDD VDD VSS VSS gf180mcu_fd_sc_mcu7t5v0__fillcap_16
XFILLER_69_492 VDD VDD VSS VSS gf180mcu_fd_sc_mcu7t5v0__fillcap_8
XTAP_TAPCELL_ROW_27_513 VDD VSS gf180mcu_fd_sc_mcu7t5v0__filltie
XTAP_TAPCELL_ROW_55_811 VDD VSS gf180mcu_fd_sc_mcu7t5v0__filltie
XFILLER_71_101 VDD VDD VSS VSS gf180mcu_fd_sc_mcu7t5v0__fillcap_32
XFILLER_13_702 VDD VDD VSS VSS gf180mcu_fd_sc_mcu7t5v0__fillcap_4
XFILLER_25_562 VDD VDD VSS VSS gf180mcu_fd_sc_mcu7t5v0__fillcap_16
XFILLER_60_10 VDD VDD VSS VSS gf180mcu_fd_sc_mcu7t5v0__fillcap_4
XPHY_EDGE_ROW_97_Left_206 VDD VSS gf180mcu_fd_sc_mcu7t5v0__endcap
XFILLER_106_383 VDD VDD VSS VSS gf180mcu_fd_sc_mcu7t5v0__fill_2
XFILLER_79_212 VDD VDD VSS VSS gf180mcu_fd_sc_mcu7t5v0__fillcap_32
XFILLER_69_52 VDD VDD VSS VSS gf180mcu_fd_sc_mcu7t5v0__fillcap_8
XFILLER_94_215 VDD VDD VSS VSS gf180mcu_fd_sc_mcu7t5v0__fillcap_4
XFILLER_67_418 VDD VDD VSS VSS gf180mcu_fd_sc_mcu7t5v0__fill_2
XFILLER_47_142 VDD VDD VSS VSS gf180mcu_fd_sc_mcu7t5v0__fillcap_8
XFILLER_35_337 VDD VDD VSS VSS gf180mcu_fd_sc_mcu7t5v0__fill_2
XFILLER_62_123 VDD VDD VSS VSS gf180mcu_fd_sc_mcu7t5v0__fillcap_16
XFILLER_90_465 VDD VDD VSS VSS gf180mcu_fd_sc_mcu7t5v0__fillcap_4
XFILLER_63_668 VDD VDD VSS VSS gf180mcu_fd_sc_mcu7t5v0__fill_2
X_2920_ _2920_/D _2958_/CLK _2920_/Q VDD VDD VSS VSS gf180mcu_fd_sc_mcu7t5v0__dffq_1
XFILLER_31_587 VDD VDD VSS VSS gf180mcu_fd_sc_mcu7t5v0__fill_2
X_2851_ _2851_/D _2892_/CLK _2851_/Q VDD VDD VSS VSS gf180mcu_fd_sc_mcu7t5v0__dffq_1
X_2782_ _2782_/D _2828_/CLK _2782_/Q VDD VDD VSS VSS gf180mcu_fd_sc_mcu7t5v0__dffq_1
X_1802_ _3285_/Q _2844_/Q _1804_/S _2844_/D VDD VDD VSS VSS gf180mcu_fd_sc_mcu7t5v0__mux2_2
XFILLER_8_761 VDD VDD VSS VSS gf180mcu_fd_sc_mcu7t5v0__fillcap_4
X_1733_ _2785_/Q _3282_/Q _1738_/S _2785_/D VDD VDD VSS VSS gf180mcu_fd_sc_mcu7t5v0__mux2_2
XFILLER_7_282 VDD VDD VSS VSS gf180mcu_fd_sc_mcu7t5v0__fillcap_32
X_3403_ _3403_/D input1/Z _3408_/CLK _3403_/Q VDD VDD VSS VSS gf180mcu_fd_sc_mcu7t5v0__dffrnq_1
X_1664_ _2764_/Q _2765_/Q _2766_/Q _1665_/B VDD VDD VSS VSS gf180mcu_fd_sc_mcu7t5v0__or3_1
X_1595_ _3376_/Q _1467_/I _1593_/Z _1595_/B2 _1595_/C _1596_/A4 VDD VDD VSS VSS gf180mcu_fd_sc_mcu7t5v0__oai221_1
X_3334_ _3355_/Q input1/Z _3337_/CLK hold52/I VDD VDD VSS VSS gf180mcu_fd_sc_mcu7t5v0__dffrnq_1
X_3265_ _3265_/D _3328_/RN _3273_/CLK _3265_/Q VDD VDD VSS VSS gf180mcu_fd_sc_mcu7t5v0__dffrnq_1
X_2216_ _2298_/B _2227_/B _2217_/C VDD VDD VSS VSS gf180mcu_fd_sc_mcu7t5v0__nor2_1
XFILLER_39_632 VDD VDD VSS VSS gf180mcu_fd_sc_mcu7t5v0__fillcap_16
XTAP_TAPCELL_ROW_69_958 VDD VSS gf180mcu_fd_sc_mcu7t5v0__filltie
X_3196_ _3196_/D _3369_/RN _3327_/CLK _3196_/Q VDD VDD VSS VSS gf180mcu_fd_sc_mcu7t5v0__dffrnq_1
XFILLER_26_304 VDD VDD VSS VSS gf180mcu_fd_sc_mcu7t5v0__fillcap_8
XFILLER_93_292 VDD VDD VSS VSS gf180mcu_fd_sc_mcu7t5v0__fillcap_32
XFILLER_93_270 VDD VDD VSS VSS gf180mcu_fd_sc_mcu7t5v0__fillcap_8
X_2147_ _3226_/Q _3076_/Q _2166_/S _3076_/D VDD VDD VSS VSS gf180mcu_fd_sc_mcu7t5v0__mux2_2
XFILLER_38_197 VDD VDD VSS VSS gf180mcu_fd_sc_mcu7t5v0__fill_1
XFILLER_39_698 VDD VDD VSS VSS gf180mcu_fd_sc_mcu7t5v0__fill_2
XFILLER_81_454 VDD VDD VSS VSS gf180mcu_fd_sc_mcu7t5v0__fillcap_8
XFILLER_54_679 VDD VDD VSS VSS gf180mcu_fd_sc_mcu7t5v0__fill_2
X_2078_ _1548_/Z _2066_/Z _2091_/B _2089_/B1 VDD VDD VSS VSS gf180mcu_fd_sc_mcu7t5v0__aoi21_1
XFILLER_53_189 VDD VDD VSS VSS gf180mcu_fd_sc_mcu7t5v0__fillcap_16
XFILLER_22_521 VDD VDD VSS VSS gf180mcu_fd_sc_mcu7t5v0__fillcap_4
XFILLER_22_543 VDD VDD VSS VSS gf180mcu_fd_sc_mcu7t5v0__fillcap_8
XFILLER_22_587 VDD VDD VSS VSS gf180mcu_fd_sc_mcu7t5v0__fillcap_8
XTAP_TAPCELL_ROW_32_571 VDD VSS gf180mcu_fd_sc_mcu7t5v0__filltie
XFILLER_108_648 VDD VDD VSS VSS gf180mcu_fd_sc_mcu7t5v0__fillcap_32
XFILLER_91_207 VDD VDD VSS VSS gf180mcu_fd_sc_mcu7t5v0__fill_2
XFILLER_85_760 VDD VDD VSS VSS gf180mcu_fd_sc_mcu7t5v0__fillcap_4
XTAP_TAPCELL_ROW_4_274 VDD VSS gf180mcu_fd_sc_mcu7t5v0__filltie
XFILLER_55_65 VDD VDD VSS VSS gf180mcu_fd_sc_mcu7t5v0__fillcap_4
XFILLER_72_454 VDD VDD VSS VSS gf180mcu_fd_sc_mcu7t5v0__fill_1
XFILLER_72_465 VDD VDD VSS VSS gf180mcu_fd_sc_mcu7t5v0__fill_2
XPHY_EDGE_ROW_105_Right_105 VDD VSS gf180mcu_fd_sc_mcu7t5v0__endcap
XFILLER_9_558 VDD VDD VSS VSS gf180mcu_fd_sc_mcu7t5v0__fill_2
XFILLER_40_384 VDD VDD VSS VSS gf180mcu_fd_sc_mcu7t5v0__fill_1
XTAP_TAPCELL_ROW_78_1053 VDD VSS gf180mcu_fd_sc_mcu7t5v0__filltie
XFILLER_99_318 VDD VDD VSS VSS gf180mcu_fd_sc_mcu7t5v0__fill_2
XFILLER_5_764 VDD VDD VSS VSS gf180mcu_fd_sc_mcu7t5v0__fill_1
X_1380_ _3133_/Q _2263_/A1 VDD VDD VSS VSS gf180mcu_fd_sc_mcu7t5v0__clkinv_1
XFILLER_96_61 VDD VDD VSS VSS gf180mcu_fd_sc_mcu7t5v0__fill_1
X_3050_ _3050_/D _3416_/RN _3311_/CLK _3050_/Q VDD VDD VSS VSS gf180mcu_fd_sc_mcu7t5v0__dffrnq_1
X_2001_ _3111_/Q _3015_/Q _2008_/S _3015_/D VDD VDD VSS VSS gf180mcu_fd_sc_mcu7t5v0__mux2_2
XTAP_TAPCELL_ROW_66_928 VDD VSS gf180mcu_fd_sc_mcu7t5v0__filltie
XTAP_TAPCELL_ROW_89_1171 VDD VSS gf180mcu_fd_sc_mcu7t5v0__filltie
XFILLER_36_624 VDD VDD VSS VSS gf180mcu_fd_sc_mcu7t5v0__fillcap_32
XFILLER_91_2 VDD VDD VSS VSS gf180mcu_fd_sc_mcu7t5v0__fill_1
XFILLER_31_362 VDD VDD VSS VSS gf180mcu_fd_sc_mcu7t5v0__fillcap_4
X_2903_ _2903_/D _2926_/CLK _2903_/Q VDD VDD VSS VSS gf180mcu_fd_sc_mcu7t5v0__dffq_1
X_2834_ _2834_/D _2858_/CLK _2834_/Q VDD VDD VSS VSS gf180mcu_fd_sc_mcu7t5v0__dffq_1
X_2765_ _2765_/D _3369_/RN _3308_/CLK _2765_/Q VDD VDD VSS VSS gf180mcu_fd_sc_mcu7t5v0__dffrnq_1
X_2696_ _2696_/I _3259_/D VDD VDD VSS VSS gf180mcu_fd_sc_mcu7t5v0__clkinv_1
X_1716_ _2772_/Q _3285_/Q _1718_/S _2772_/D VDD VDD VSS VSS gf180mcu_fd_sc_mcu7t5v0__mux2_2
XFILLER_105_629 VDD VDD VSS VSS gf180mcu_fd_sc_mcu7t5v0__fill_1
X_1647_ _2202_/A2 _2766_/Q _2215_/A2 VDD VDD VSS VSS gf180mcu_fd_sc_mcu7t5v0__nand2_1
X_1578_ _3337_/Q _1504_/I _3368_/D _3339_/Q _1579_/A2 VDD VDD VSS VSS gf180mcu_fd_sc_mcu7t5v0__aoi22_1
X_3317_ _3317_/D input1/Z _3409_/CLK hold60/I VDD VDD VSS VSS gf180mcu_fd_sc_mcu7t5v0__dffrnq_1
X_3248_ _3248_/D _3369_/RN _3270_/CLK _3248_/Q VDD VDD VSS VSS gf180mcu_fd_sc_mcu7t5v0__dffrnq_1
X_3179_ _3179_/D _3303_/RN clkload7/I _3179_/Q VDD VDD VSS VSS gf180mcu_fd_sc_mcu7t5v0__dffrnq_1
XTAP_TAPCELL_ROW_1_244 VDD VSS gf180mcu_fd_sc_mcu7t5v0__filltie
XFILLER_42_605 VDD VDD VSS VSS gf180mcu_fd_sc_mcu7t5v0__fill_1
XFILLER_81_284 VDD VDD VSS VSS gf180mcu_fd_sc_mcu7t5v0__fill_1
XFILLER_41_137 VDD VDD VSS VSS gf180mcu_fd_sc_mcu7t5v0__fill_2
XFILLER_22_384 VDD VDD VSS VSS gf180mcu_fd_sc_mcu7t5v0__fill_1
XFILLER_22_395 VDD VDD VSS VSS gf180mcu_fd_sc_mcu7t5v0__fillcap_4
XFILLER_108_478 VDD VDD VSS VSS gf180mcu_fd_sc_mcu7t5v0__fillcap_32
XTAP_TAPCELL_ROW_9_333 VDD VSS gf180mcu_fd_sc_mcu7t5v0__filltie
XFILLER_1_244 VDD VDD VSS VSS gf180mcu_fd_sc_mcu7t5v0__fillcap_16
XFILLER_32_104 VDD VDD VSS VSS gf180mcu_fd_sc_mcu7t5v0__fill_1
Xclkbuf_4_7_0_host_clk_i clkbuf_0_host_clk_i/Z _3409_/CLK VDD VDD VSS VSS gf180mcu_fd_sc_mcu7t5v0__clkbuf_4
XTAP_TAPCELL_ROW_71_975 VDD VSS gf180mcu_fd_sc_mcu7t5v0__filltie
XFILLER_13_384 VDD VDD VSS VSS gf180mcu_fd_sc_mcu7t5v0__fillcap_32
XTAP_TAPCELL_ROW_43_688 VDD VSS gf180mcu_fd_sc_mcu7t5v0__filltie
XFILLER_9_344 VDD VDD VSS VSS gf180mcu_fd_sc_mcu7t5v0__fillcap_4
XFILLER_63_6 VDD VDD VSS VSS gf180mcu_fd_sc_mcu7t5v0__fill_2
XFILLER_5_550 VDD VDD VSS VSS gf180mcu_fd_sc_mcu7t5v0__fillcap_8
X_2550_ _3063_/Q _1517_/Z _3326_/Q _3320_/Q _2598_/A3 VDD VDD VSS VSS gf180mcu_fd_sc_mcu7t5v0__oai211_1
XFILLER_99_115 VDD VDD VSS VSS gf180mcu_fd_sc_mcu7t5v0__fillcap_16
X_2481_ _2481_/A1 _1612_/Z _2481_/Z VDD VDD VSS VSS gf180mcu_fd_sc_mcu7t5v0__or2_1
X_1501_ _3366_/Q _1490_/Z _3367_/Q _1506_/A2 VDD VDD VSS VSS gf180mcu_fd_sc_mcu7t5v0__aoi21_1
X_1432_ _3340_/Q _1433_/A3 _1431_/Z _1434_/A2 VDD VDD VSS VSS gf180mcu_fd_sc_mcu7t5v0__nor3_1
X_1363_ _3351_/Q _1433_/A1 VDD VDD VSS VSS gf180mcu_fd_sc_mcu7t5v0__clkinv_1
X_3102_ _3102_/D _3328_/RN _3222_/CLK _3102_/Q VDD VDD VSS VSS gf180mcu_fd_sc_mcu7t5v0__dffrnq_1
X_3033_ _3033_/D _3416_/RN _3419_/CLK _3033_/Q VDD VDD VSS VSS gf180mcu_fd_sc_mcu7t5v0__dffrnq_1
XFILLER_95_398 VDD VDD VSS VSS gf180mcu_fd_sc_mcu7t5v0__fillcap_4
XFILLER_48_281 VDD VDD VSS VSS gf180mcu_fd_sc_mcu7t5v0__fill_1
XFILLER_31_192 VDD VDD VSS VSS gf180mcu_fd_sc_mcu7t5v0__fill_1
XTAP_TAPCELL_ROW_98_1259 VDD VSS gf180mcu_fd_sc_mcu7t5v0__filltie
X_2817_ _2817_/D _3408_/CLK _2817_/Q VDD VDD VSS VSS gf180mcu_fd_sc_mcu7t5v0__dffq_1
XFILLER_11_26 VDD VDD VSS VSS gf180mcu_fd_sc_mcu7t5v0__fill_1
X_2748_ _3222_/Q _3288_/Q _2760_/S _3288_/D VDD VDD VSS VSS gf180mcu_fd_sc_mcu7t5v0__mux2_2
X_2679_ _3206_/Q _3313_/Q _2679_/A3 _2736_/A4 _2681_/B1 VDD VDD VSS VSS gf180mcu_fd_sc_mcu7t5v0__nand4_1
XFILLER_101_632 VDD VDD VSS VSS gf180mcu_fd_sc_mcu7t5v0__fillcap_64
XFILLER_86_310 VDD VDD VSS VSS gf180mcu_fd_sc_mcu7t5v0__fillcap_4
XFILLER_86_387 VDD VDD VSS VSS gf180mcu_fd_sc_mcu7t5v0__fillcap_16
XFILLER_74_527 VDD VDD VSS VSS gf180mcu_fd_sc_mcu7t5v0__fillcap_8
XFILLER_100_197 VDD VDD VSS VSS gf180mcu_fd_sc_mcu7t5v0__fill_2
XTAP_TAPCELL_ROW_107_1355 VDD VSS gf180mcu_fd_sc_mcu7t5v0__filltie
XFILLER_14_104 VDD VDD VSS VSS gf180mcu_fd_sc_mcu7t5v0__fill_1
XFILLER_42_402 VDD VDD VSS VSS gf180mcu_fd_sc_mcu7t5v0__fillcap_8
XFILLER_70_700 VDD VDD VSS VSS gf180mcu_fd_sc_mcu7t5v0__fill_1
XFILLER_82_593 VDD VDD VSS VSS gf180mcu_fd_sc_mcu7t5v0__fill_2
XFILLER_23_660 VDD VDD VSS VSS gf180mcu_fd_sc_mcu7t5v0__fillcap_32
XFILLER_22_192 VDD VDD VSS VSS gf180mcu_fd_sc_mcu7t5v0__fill_2
XTAP_TAPCELL_ROW_40_658 VDD VSS gf180mcu_fd_sc_mcu7t5v0__filltie
XFILLER_10_354 VDD VDD VSS VSS gf180mcu_fd_sc_mcu7t5v0__fillcap_8
XFILLER_10_387 VDD VDD VSS VSS gf180mcu_fd_sc_mcu7t5v0__fillcap_4
XTAP_TAPCELL_ROW_75_1023 VDD VSS gf180mcu_fd_sc_mcu7t5v0__filltie
XPHY_EDGE_ROW_70_Left_179 VDD VSS gf180mcu_fd_sc_mcu7t5v0__endcap
XTAP_TAPCELL_ROW_48_736 VDD VSS gf180mcu_fd_sc_mcu7t5v0__filltie
XFILLER_92_357 VDD VDD VSS VSS gf180mcu_fd_sc_mcu7t5v0__fill_2
XTAP_TAPCELL_ROW_86_1141 VDD VSS gf180mcu_fd_sc_mcu7t5v0__filltie
XFILLER_14_660 VDD VDD VSS VSS gf180mcu_fd_sc_mcu7t5v0__fillcap_4
XFILLER_20_107 VDD VDD VSS VSS gf180mcu_fd_sc_mcu7t5v0__fillcap_4
X_1981_ _2998_/Q _3118_/Q _1981_/S _2998_/D VDD VDD VSS VSS gf180mcu_fd_sc_mcu7t5v0__mux2_2
X_2602_ _3208_/Q _2602_/A2 _2679_/A3 _2687_/A2 VDD VDD VSS VSS gf180mcu_fd_sc_mcu7t5v0__nand3_1
X_2533_ _3196_/Q _3188_/Q _2539_/S _3196_/D VDD VDD VSS VSS gf180mcu_fd_sc_mcu7t5v0__mux2_2
XFILLER_54_2 VDD VDD VSS VSS gf180mcu_fd_sc_mcu7t5v0__fillcap_16
X_2464_ _3246_/Q _1617_/Z _2466_/B1 _3270_/Q _2467_/B1 _3254_/Q _2465_/A3 VDD VDD
+ VSS VSS gf180mcu_fd_sc_mcu7t5v0__aoi222_1
X_2395_ _3137_/Q _2407_/B _2395_/B _2396_/A2 VDD VDD VSS VSS gf180mcu_fd_sc_mcu7t5v0__oai21_1
X_1415_ _3042_/Q _2329_/A2 VDD VDD VSS VSS gf180mcu_fd_sc_mcu7t5v0__clkinv_1
XFILLER_56_527 VDD VDD VSS VSS gf180mcu_fd_sc_mcu7t5v0__fillcap_16
XFILLER_68_387 VDD VDD VSS VSS gf180mcu_fd_sc_mcu7t5v0__fillcap_64
XFILLER_83_368 VDD VDD VSS VSS gf180mcu_fd_sc_mcu7t5v0__fillcap_8
X_3016_ _3016_/D _3016_/CLK _3016_/Q VDD VDD VSS VSS gf180mcu_fd_sc_mcu7t5v0__dffq_1
XFILLER_24_457 VDD VDD VSS VSS gf180mcu_fd_sc_mcu7t5v0__fillcap_16
XFILLER_20_685 VDD VDD VSS VSS gf180mcu_fd_sc_mcu7t5v0__fill_1
XFILLER_22_47 VDD VDD VSS VSS gf180mcu_fd_sc_mcu7t5v0__fill_1
Xclkbuf_leaf_0_clk_i clkload0/I _3273_/CLK VDD VDD VSS VSS gf180mcu_fd_sc_mcu7t5v0__clkbuf_4
XFILLER_105_278 VDD VDD VSS VSS gf180mcu_fd_sc_mcu7t5v0__fill_2
XFILLER_78_107 VDD VDD VSS VSS gf180mcu_fd_sc_mcu7t5v0__fillcap_8
XFILLER_101_484 VDD VDD VSS VSS gf180mcu_fd_sc_mcu7t5v0__fillcap_4
XFILLER_28_752 VDD VDD VSS VSS gf180mcu_fd_sc_mcu7t5v0__fillcap_8
XFILLER_47_549 VDD VDD VSS VSS gf180mcu_fd_sc_mcu7t5v0__fillcap_8
XTAP_TAPCELL_ROW_17_408 VDD VSS gf180mcu_fd_sc_mcu7t5v0__filltie
XTAP_TAPCELL_ROW_45_706 VDD VSS gf180mcu_fd_sc_mcu7t5v0__filltie
XFILLER_103_72 VDD VDD VSS VSS gf180mcu_fd_sc_mcu7t5v0__fillcap_16
XFILLER_27_273 VDD VDD VSS VSS gf180mcu_fd_sc_mcu7t5v0__fillcap_4
XFILLER_30_427 VDD VDD VSS VSS gf180mcu_fd_sc_mcu7t5v0__fillcap_8
XTAP_TAPCELL_ROW_53_794 VDD VSS gf180mcu_fd_sc_mcu7t5v0__filltie
XFILLER_70_585 VDD VDD VSS VSS gf180mcu_fd_sc_mcu7t5v0__fillcap_8
XTAP_TAPCELL_ROW_81_1082 VDD VSS gf180mcu_fd_sc_mcu7t5v0__filltie
XTAP_TAPCELL_ROW_25_496 VDD VSS gf180mcu_fd_sc_mcu7t5v0__filltie
XFILLER_6_177 VDD VDD VSS VSS gf180mcu_fd_sc_mcu7t5v0__fillcap_32
XFILLER_6_166 VDD VDD VSS VSS gf180mcu_fd_sc_mcu7t5v0__fillcap_8
XFILLER_12_91 VDD VDD VSS VSS gf180mcu_fd_sc_mcu7t5v0__fillcap_8
X_2180_ _3421_/D _3420_/D _3421_/Q _2182_/A2 VDD VDD VSS VSS gf180mcu_fd_sc_mcu7t5v0__nand3_1
XPHY_EDGE_ROW_108_Left_217 VDD VSS gf180mcu_fd_sc_mcu7t5v0__endcap
XFILLER_38_505 VDD VDD VSS VSS gf180mcu_fd_sc_mcu7t5v0__fillcap_4
XFILLER_38_527 VDD VDD VSS VSS gf180mcu_fd_sc_mcu7t5v0__fillcap_16
XFILLER_65_346 VDD VDD VSS VSS gf180mcu_fd_sc_mcu7t5v0__fillcap_4
XFILLER_19_763 VDD VDD VSS VSS gf180mcu_fd_sc_mcu7t5v0__fill_2
XFILLER_65_368 VDD VDD VSS VSS gf180mcu_fd_sc_mcu7t5v0__fillcap_4
XFILLER_18_295 VDD VDD VSS VSS gf180mcu_fd_sc_mcu7t5v0__fillcap_8
XFILLER_33_221 VDD VDD VSS VSS gf180mcu_fd_sc_mcu7t5v0__fillcap_16
XFILLER_33_254 VDD VDD VSS VSS gf180mcu_fd_sc_mcu7t5v0__fillcap_16
XFILLER_61_596 VDD VDD VSS VSS gf180mcu_fd_sc_mcu7t5v0__fillcap_4
X_1964_ _3111_/Q _2983_/Q _1971_/S _2983_/D VDD VDD VSS VSS gf180mcu_fd_sc_mcu7t5v0__mux2_2
X_1895_ _3116_/Q _2924_/Q _1897_/S _2924_/D VDD VDD VSS VSS gf180mcu_fd_sc_mcu7t5v0__mux2_2
XTAP_TAPCELL_ROW_95_1229 VDD VSS gf180mcu_fd_sc_mcu7t5v0__filltie
X_2516_ _3179_/Q _3156_/Q _2540_/S _3179_/D VDD VDD VSS VSS gf180mcu_fd_sc_mcu7t5v0__mux2_2
X_2447_ _3249_/Q _1617_/Z _2443_/Z _3265_/Q _3157_/Q _2450_/A2 VDD VDD VSS VSS gf180mcu_fd_sc_mcu7t5v0__aoi221_1
X_2378_ _2405_/S _2377_/Z _2378_/B _2379_/A2 VDD VDD VSS VSS gf180mcu_fd_sc_mcu7t5v0__aoi21_1
XFILLER_83_132 VDD VDD VSS VSS gf180mcu_fd_sc_mcu7t5v0__fill_2
XFILLER_71_316 VDD VDD VSS VSS gf180mcu_fd_sc_mcu7t5v0__fill_1
XFILLER_17_69 VDD VDD VSS VSS gf180mcu_fd_sc_mcu7t5v0__fill_1
XFILLER_71_327 VDD VDD VSS VSS gf180mcu_fd_sc_mcu7t5v0__fillcap_16
XFILLER_71_349 VDD VDD VSS VSS gf180mcu_fd_sc_mcu7t5v0__fill_1
XTAP_TAPCELL_ROW_104_1325 VDD VSS gf180mcu_fd_sc_mcu7t5v0__filltie
XFILLER_24_221 VDD VDD VSS VSS gf180mcu_fd_sc_mcu7t5v0__fill_1
XFILLER_24_254 VDD VDD VSS VSS gf180mcu_fd_sc_mcu7t5v0__fillcap_8
XFILLER_40_714 VDD VDD VSS VSS gf180mcu_fd_sc_mcu7t5v0__fillcap_8
XTAP_TAPCELL_ROW_22_466 VDD VSS gf180mcu_fd_sc_mcu7t5v0__filltie
XTAP_TAPCELL_ROW_50_764 VDD VSS gf180mcu_fd_sc_mcu7t5v0__filltie
XFILLER_106_554 VDD VDD VSS VSS gf180mcu_fd_sc_mcu7t5v0__fill_1
XFILLER_79_438 VDD VDD VSS VSS gf180mcu_fd_sc_mcu7t5v0__fillcap_4
XFILLER_94_419 VDD VDD VSS VSS gf180mcu_fd_sc_mcu7t5v0__fillcap_16
XFILLER_87_471 VDD VDD VSS VSS gf180mcu_fd_sc_mcu7t5v0__fillcap_16
XTAP_TAPCELL_ROW_58_842 VDD VSS gf180mcu_fd_sc_mcu7t5v0__filltie
XFILLER_59_184 VDD VDD VSS VSS gf180mcu_fd_sc_mcu7t5v0__fill_1
XFILLER_74_121 VDD VDD VSS VSS gf180mcu_fd_sc_mcu7t5v0__fill_1
XFILLER_62_327 VDD VDD VSS VSS gf180mcu_fd_sc_mcu7t5v0__fillcap_16
X_1680_ _1645_/Z _2315_/A1 _2410_/A2 VDD VDD VSS VSS gf180mcu_fd_sc_mcu7t5v0__nor2_1
XFILLER_99_50 VDD VDD VSS VSS gf180mcu_fd_sc_mcu7t5v0__fillcap_8
XFILLER_7_486 VDD VDD VSS VSS gf180mcu_fd_sc_mcu7t5v0__fillcap_4
X_3350_ hold46/Z _3369_/RN _3358_/CLK _3350_/Q VDD VDD VSS VSS gf180mcu_fd_sc_mcu7t5v0__dffrnq_1
X_2301_ _2427_/B _2313_/A1 _2301_/A3 _2301_/B _3128_/D VDD VDD VSS VSS gf180mcu_fd_sc_mcu7t5v0__oai31_1
XFILLER_3_670 VDD VDD VSS VSS gf180mcu_fd_sc_mcu7t5v0__fill_1
X_3281_ _3281_/D _3369_/RN _3287_/CLK _3281_/Q VDD VDD VSS VSS gf180mcu_fd_sc_mcu7t5v0__dffrnq_1
XFILLER_97_279 VDD VDD VSS VSS gf180mcu_fd_sc_mcu7t5v0__fill_1
XFILLER_85_419 VDD VDD VSS VSS gf180mcu_fd_sc_mcu7t5v0__fill_1
X_2232_ _1658_/Z _2410_/A2 _2271_/A2 VDD VDD VSS VSS gf180mcu_fd_sc_mcu7t5v0__nand2_1
XFILLER_93_430 VDD VDD VSS VSS gf180mcu_fd_sc_mcu7t5v0__fillcap_4
X_2163_ _3242_/Q _3092_/Q _2165_/S _3092_/D VDD VDD VSS VSS gf180mcu_fd_sc_mcu7t5v0__mux2_2
XFILLER_66_688 VDD VDD VSS VSS gf180mcu_fd_sc_mcu7t5v0__fill_1
XFILLER_93_485 VDD VDD VSS VSS gf180mcu_fd_sc_mcu7t5v0__fillcap_4
X_2094_ _3060_/Q _3062_/Q _2118_/A2 _2119_/A2 VDD VDD VSS VSS gf180mcu_fd_sc_mcu7t5v0__nor3_1
XFILLER_81_658 VDD VDD VSS VSS gf180mcu_fd_sc_mcu7t5v0__fillcap_8
X_2996_ _2996_/D _3016_/CLK _2996_/Q VDD VDD VSS VSS gf180mcu_fd_sc_mcu7t5v0__dffq_1
XFILLER_21_279 VDD VDD VSS VSS gf180mcu_fd_sc_mcu7t5v0__fill_1
X_1947_ _3112_/Q _2968_/Q _1953_/S _2968_/D VDD VDD VSS VSS gf180mcu_fd_sc_mcu7t5v0__mux2_2
X_1878_ _3365_/Q _1879_/A2 _1991_/A1 VDD VDD VSS VSS gf180mcu_fd_sc_mcu7t5v0__nor2_1
XFILLER_107_329 VDD VDD VSS VSS gf180mcu_fd_sc_mcu7t5v0__fillcap_16
XFILLER_88_224 VDD VDD VSS VSS gf180mcu_fd_sc_mcu7t5v0__fillcap_4
XTAP_TAPCELL_ROW_27_514 VDD VSS gf180mcu_fd_sc_mcu7t5v0__filltie
XTAP_TAPCELL_ROW_55_812 VDD VSS gf180mcu_fd_sc_mcu7t5v0__filltie
XFILLER_25_552 VDD VDD VSS VSS gf180mcu_fd_sc_mcu7t5v0__fillcap_8
XFILLER_44_34 VDD VDD VSS VSS gf180mcu_fd_sc_mcu7t5v0__fill_1
XFILLER_40_522 VDD VDD VSS VSS gf180mcu_fd_sc_mcu7t5v0__fill_2
XFILLER_44_89 VDD VDD VSS VSS gf180mcu_fd_sc_mcu7t5v0__fill_1
XFILLER_12_279 VDD VDD VSS VSS gf180mcu_fd_sc_mcu7t5v0__fillcap_4
XFILLER_20_290 VDD VDD VSS VSS gf180mcu_fd_sc_mcu7t5v0__fillcap_8
Xclkbuf_leaf_33_clk_i clkload6/I _3337_/CLK VDD VDD VSS VSS gf180mcu_fd_sc_mcu7t5v0__clkbuf_4
XFILLER_4_434 VDD VDD VSS VSS gf180mcu_fd_sc_mcu7t5v0__fillcap_4
Xclkbuf_leaf_48_clk_i clkload0/I _3325_/CLK VDD VDD VSS VSS gf180mcu_fd_sc_mcu7t5v0__clkbuf_4
XFILLER_79_279 VDD VDD VSS VSS gf180mcu_fd_sc_mcu7t5v0__fill_1
XFILLER_102_590 VDD VDD VSS VSS gf180mcu_fd_sc_mcu7t5v0__fillcap_4
XFILLER_87_290 VDD VDD VSS VSS gf180mcu_fd_sc_mcu7t5v0__fillcap_4
XFILLER_48_622 VDD VDD VSS VSS gf180mcu_fd_sc_mcu7t5v0__fillcap_16
XFILLER_63_614 VDD VDD VSS VSS gf180mcu_fd_sc_mcu7t5v0__fill_1
XFILLER_93_6 VDD VDD VSS VSS gf180mcu_fd_sc_mcu7t5v0__fill_2
X_2850_ _2850_/D _2858_/CLK _2850_/Q VDD VDD VSS VSS gf180mcu_fd_sc_mcu7t5v0__dffq_1
XFILLER_31_555 VDD VDD VSS VSS gf180mcu_fd_sc_mcu7t5v0__fillcap_4
X_1801_ _3284_/Q _2843_/Q _1804_/S _2843_/D VDD VDD VSS VSS gf180mcu_fd_sc_mcu7t5v0__mux2_2
X_2781_ _2781_/D _2858_/CLK _2781_/Q VDD VDD VSS VSS gf180mcu_fd_sc_mcu7t5v0__dffq_1
X_1732_ _2784_/Q _3281_/Q _1738_/S _2784_/D VDD VDD VSS VSS gf180mcu_fd_sc_mcu7t5v0__mux2_2
X_1663_ _2267_/C _2316_/A1 _1679_/C VDD VDD VSS VSS gf180mcu_fd_sc_mcu7t5v0__nor2_1
X_3402_ _3402_/D _3416_/RN _3407_/CLK _3402_/Q VDD VDD VSS VSS gf180mcu_fd_sc_mcu7t5v0__dffrnq_1
XFILLER_98_511 VDD VDD VSS VSS gf180mcu_fd_sc_mcu7t5v0__fillcap_8
X_1594_ _3375_/Q _3400_/D _1595_/B2 VDD VDD VSS VSS gf180mcu_fd_sc_mcu7t5v0__nor2_1
X_3333_ _3359_/Q input1/Z _3387_/CLK hold55/I VDD VDD VSS VSS gf180mcu_fd_sc_mcu7t5v0__dffrnq_1
XFILLER_100_527 VDD VDD VSS VSS gf180mcu_fd_sc_mcu7t5v0__fillcap_64
XPHY_EDGE_ROW_7_Right_7 VDD VSS gf180mcu_fd_sc_mcu7t5v0__endcap
X_3264_ _3264_/D _3328_/RN _3264_/CLK _3264_/Q VDD VDD VSS VSS gf180mcu_fd_sc_mcu7t5v0__dffrnq_1
X_2215_ _2277_/A2 _2215_/A2 _2227_/B VDD VDD VSS VSS gf180mcu_fd_sc_mcu7t5v0__and2_1
XTAP_TAPCELL_ROW_69_959 VDD VSS gf180mcu_fd_sc_mcu7t5v0__filltie
X_3195_ _3195_/D _3328_/RN clkload8/I _3195_/Q VDD VDD VSS VSS gf180mcu_fd_sc_mcu7t5v0__dffrnq_1
XFILLER_38_143 VDD VDD VSS VSS gf180mcu_fd_sc_mcu7t5v0__fillcap_32
XFILLER_66_452 VDD VDD VSS VSS gf180mcu_fd_sc_mcu7t5v0__fill_2
XFILLER_93_282 VDD VDD VSS VSS gf180mcu_fd_sc_mcu7t5v0__fill_2
XFILLER_81_422 VDD VDD VSS VSS gf180mcu_fd_sc_mcu7t5v0__fillcap_32
X_2146_ _3225_/Q _3075_/Q _2166_/S _3075_/D VDD VDD VSS VSS gf180mcu_fd_sc_mcu7t5v0__mux2_2
X_2077_ _2342_/A2 _2091_/B _2087_/B1 _2077_/B2 _3043_/D VDD VDD VSS VSS gf180mcu_fd_sc_mcu7t5v0__aoi22_1
XFILLER_81_488 VDD VDD VSS VSS gf180mcu_fd_sc_mcu7t5v0__fill_2
XFILLER_14_37 VDD VDD VSS VSS gf180mcu_fd_sc_mcu7t5v0__fillcap_8
XFILLER_22_555 VDD VDD VSS VSS gf180mcu_fd_sc_mcu7t5v0__fill_2
X_2979_ _2979_/D _2988_/CLK _2979_/Q VDD VDD VSS VSS gf180mcu_fd_sc_mcu7t5v0__dffq_1
XTAP_TAPCELL_ROW_32_572 VDD VSS gf180mcu_fd_sc_mcu7t5v0__filltie
XFILLER_5_209 VDD VDD VSS VSS gf180mcu_fd_sc_mcu7t5v0__fill_1
XFILLER_107_104 VDD VDD VSS VSS gf180mcu_fd_sc_mcu7t5v0__fillcap_16
XFILLER_89_566 VDD VDD VSS VSS gf180mcu_fd_sc_mcu7t5v0__fill_2
XFILLER_49_419 VDD VDD VSS VSS gf180mcu_fd_sc_mcu7t5v0__fill_1
XTAP_TAPCELL_ROW_4_275 VDD VSS gf180mcu_fd_sc_mcu7t5v0__filltie
XFILLER_45_625 VDD VDD VSS VSS gf180mcu_fd_sc_mcu7t5v0__fillcap_4
XFILLER_57_474 VDD VDD VSS VSS gf180mcu_fd_sc_mcu7t5v0__fill_2
XFILLER_13_500 VDD VDD VSS VSS gf180mcu_fd_sc_mcu7t5v0__fillcap_4
XFILLER_25_360 VDD VDD VSS VSS gf180mcu_fd_sc_mcu7t5v0__fill_2
XFILLER_60_617 VDD VDD VSS VSS gf180mcu_fd_sc_mcu7t5v0__fill_2
XFILLER_25_382 VDD VDD VSS VSS gf180mcu_fd_sc_mcu7t5v0__fill_1
XFILLER_40_341 VDD VDD VSS VSS gf180mcu_fd_sc_mcu7t5v0__fillcap_16
XFILLER_5_732 VDD VDD VSS VSS gf180mcu_fd_sc_mcu7t5v0__fillcap_32
XTAP_TAPCELL_ROW_78_1054 VDD VSS gf180mcu_fd_sc_mcu7t5v0__filltie
XFILLER_4_242 VDD VDD VSS VSS gf180mcu_fd_sc_mcu7t5v0__fill_2
XFILLER_106_170 VDD VDD VSS VSS gf180mcu_fd_sc_mcu7t5v0__fillcap_4
XFILLER_4_297 VDD VDD VSS VSS gf180mcu_fd_sc_mcu7t5v0__fill_2
XFILLER_96_84 VDD VDD VSS VSS gf180mcu_fd_sc_mcu7t5v0__fillcap_16
XFILLER_67_216 VDD VDD VSS VSS gf180mcu_fd_sc_mcu7t5v0__fill_2
X_2000_ _2000_/A1 _2000_/A2 _2008_/S VDD VDD VSS VSS gf180mcu_fd_sc_mcu7t5v0__nand2_1
XTAP_TAPCELL_ROW_89_1172 VDD VSS gf180mcu_fd_sc_mcu7t5v0__filltie
XFILLER_75_282 VDD VDD VSS VSS gf180mcu_fd_sc_mcu7t5v0__fillcap_4
XFILLER_63_422 VDD VDD VSS VSS gf180mcu_fd_sc_mcu7t5v0__fillcap_4
XTAP_TAPCELL_ROW_66_929 VDD VSS gf180mcu_fd_sc_mcu7t5v0__filltie
XFILLER_90_230 VDD VDD VSS VSS gf180mcu_fd_sc_mcu7t5v0__fillcap_4
XFILLER_35_135 VDD VDD VSS VSS gf180mcu_fd_sc_mcu7t5v0__fillcap_4
XFILLER_51_628 VDD VDD VSS VSS gf180mcu_fd_sc_mcu7t5v0__fill_2
XFILLER_63_488 VDD VDD VSS VSS gf180mcu_fd_sc_mcu7t5v0__fill_2
X_2902_ _2902_/D _2926_/CLK _2902_/Q VDD VDD VSS VSS gf180mcu_fd_sc_mcu7t5v0__dffq_1
XFILLER_84_2 VDD VDD VSS VSS gf180mcu_fd_sc_mcu7t5v0__fillcap_4
X_2833_ _2833_/D _3406_/CLK _2833_/Q VDD VDD VSS VSS gf180mcu_fd_sc_mcu7t5v0__dffq_1
X_2764_ _2764_/D _3369_/RN _3308_/CLK _2764_/Q VDD VDD VSS VSS gf180mcu_fd_sc_mcu7t5v0__dffrnq_1
X_1715_ _2771_/Q _3284_/Q _1718_/S _2771_/D VDD VDD VSS VSS gf180mcu_fd_sc_mcu7t5v0__mux2_2
XFILLER_8_592 VDD VDD VSS VSS gf180mcu_fd_sc_mcu7t5v0__fill_2
X_2695_ _3259_/Q _2680_/C _2729_/B1 _3077_/Q _2696_/I VDD VDD VSS VSS gf180mcu_fd_sc_mcu7t5v0__aoi22_1
XFILLER_104_107 VDD VDD VSS VSS gf180mcu_fd_sc_mcu7t5v0__fillcap_8
X_1646_ _1708_/A1 _1645_/Z _1646_/Z VDD VDD VSS VSS gf180mcu_fd_sc_mcu7t5v0__and2_1
X_1577_ _3338_/Q _3363_/D _1581_/A1 VDD VDD VSS VSS gf180mcu_fd_sc_mcu7t5v0__xnor2_1
X_3316_ hold65/Z input1/Z _3352_/CLK _3316_/Q VDD VDD VSS VSS gf180mcu_fd_sc_mcu7t5v0__dffrnq_1
XFILLER_59_717 VDD VDD VSS VSS gf180mcu_fd_sc_mcu7t5v0__fillcap_8
XFILLER_100_313 VDD VDD VSS VSS gf180mcu_fd_sc_mcu7t5v0__fill_2
X_3247_ _3247_/D _3369_/RN _3253_/CLK _3247_/Q VDD VDD VSS VSS gf180mcu_fd_sc_mcu7t5v0__dffrnq_1
XFILLER_100_379 VDD VDD VSS VSS gf180mcu_fd_sc_mcu7t5v0__fillcap_4
XFILLER_26_102 VDD VDD VSS VSS gf180mcu_fd_sc_mcu7t5v0__fill_2
X_3178_ _3178_/D _3328_/RN clkload7/I _3178_/Q VDD VDD VSS VSS gf180mcu_fd_sc_mcu7t5v0__dffrnq_1
XFILLER_82_753 VDD VDD VSS VSS gf180mcu_fd_sc_mcu7t5v0__fillcap_8
XTAP_TAPCELL_ROW_1_245 VDD VSS gf180mcu_fd_sc_mcu7t5v0__filltie
XTAP_TAPCELL_ROW_37_620 VDD VSS gf180mcu_fd_sc_mcu7t5v0__filltie
X_2129_ _3205_/Q _3204_/Q _3207_/Q _2679_/A3 VDD VDD VSS VSS gf180mcu_fd_sc_mcu7t5v0__nor3_1
XFILLER_42_617 VDD VDD VSS VSS gf180mcu_fd_sc_mcu7t5v0__fill_2
XFILLER_104_630 VDD VDD VSS VSS gf180mcu_fd_sc_mcu7t5v0__fill_2
XFILLER_1_212 VDD VDD VSS VSS gf180mcu_fd_sc_mcu7t5v0__fillcap_32
XFILLER_89_352 VDD VDD VSS VSS gf180mcu_fd_sc_mcu7t5v0__fillcap_32
XFILLER_106_61 VDD VDD VSS VSS gf180mcu_fd_sc_mcu7t5v0__fill_2
XFILLER_77_558 VDD VDD VSS VSS gf180mcu_fd_sc_mcu7t5v0__fill_2
XFILLER_58_761 VDD VDD VSS VSS gf180mcu_fd_sc_mcu7t5v0__fillcap_4
XFILLER_45_422 VDD VDD VSS VSS gf180mcu_fd_sc_mcu7t5v0__fillcap_64
XFILLER_57_282 VDD VDD VSS VSS gf180mcu_fd_sc_mcu7t5v0__fillcap_32
XFILLER_73_764 VDD VDD VSS VSS gf180mcu_fd_sc_mcu7t5v0__fill_1
XFILLER_60_403 VDD VDD VSS VSS gf180mcu_fd_sc_mcu7t5v0__fillcap_4
XFILLER_72_263 VDD VDD VSS VSS gf180mcu_fd_sc_mcu7t5v0__fillcap_4
XFILLER_82_53 VDD VDD VSS VSS gf180mcu_fd_sc_mcu7t5v0__fill_2
XFILLER_72_296 VDD VDD VSS VSS gf180mcu_fd_sc_mcu7t5v0__fillcap_4
XFILLER_13_352 VDD VDD VSS VSS gf180mcu_fd_sc_mcu7t5v0__fillcap_16
XTAP_TAPCELL_ROW_71_976 VDD VSS gf180mcu_fd_sc_mcu7t5v0__filltie
XTAP_TAPCELL_ROW_43_689 VDD VSS gf180mcu_fd_sc_mcu7t5v0__filltie
XFILLER_9_356 VDD VDD VSS VSS gf180mcu_fd_sc_mcu7t5v0__fill_2
XFILLER_5_562 VDD VDD VSS VSS gf180mcu_fd_sc_mcu7t5v0__fillcap_16
X_2480_ _3155_/Q _3156_/Q _2480_/S _3156_/D VDD VDD VSS VSS gf180mcu_fd_sc_mcu7t5v0__mux2_2
X_1500_ _3366_/Q _3367_/Q _1490_/Z _1867_/S VDD VDD VSS VSS gf180mcu_fd_sc_mcu7t5v0__and3_1
X_1431_ hold65/I _3316_/Q _1431_/Z VDD VDD VSS VSS gf180mcu_fd_sc_mcu7t5v0__and2_1
XFILLER_95_333 VDD VDD VSS VSS gf180mcu_fd_sc_mcu7t5v0__fillcap_4
X_3101_ _3101_/D _3303_/RN _3288_/CLK _3101_/Q VDD VDD VSS VSS gf180mcu_fd_sc_mcu7t5v0__dffrnq_1
X_3032_ _3032_/D _3416_/RN _3419_/CLK _3032_/Q VDD VDD VSS VSS gf180mcu_fd_sc_mcu7t5v0__dffrnq_1
XFILLER_36_411 VDD VDD VSS VSS gf180mcu_fd_sc_mcu7t5v0__fillcap_4
XFILLER_24_628 VDD VDD VSS VSS gf180mcu_fd_sc_mcu7t5v0__fillcap_4
XFILLER_51_403 VDD VDD VSS VSS gf180mcu_fd_sc_mcu7t5v0__fill_1
XFILLER_64_764 VDD VDD VSS VSS gf180mcu_fd_sc_mcu7t5v0__fill_1
X_2816_ _2816_/D _2887_/CLK _2816_/Q VDD VDD VSS VSS gf180mcu_fd_sc_mcu7t5v0__dffq_1
XTAP_TAPCELL_ROW_14_380 VDD VSS gf180mcu_fd_sc_mcu7t5v0__filltie
X_2747_ _3206_/Q _3207_/Q _2747_/A3 _2736_/Z _2760_/S VDD VDD VSS VSS gf180mcu_fd_sc_mcu7t5v0__nand4_1
X_2678_ _2678_/A1 _2680_/C _2678_/B _3253_/D VDD VDD VSS VSS gf180mcu_fd_sc_mcu7t5v0__aoi21_1
X_1629_ _2414_/B _2424_/C _2267_/C VDD VDD VSS VSS gf180mcu_fd_sc_mcu7t5v0__nand2_1
XFILLER_74_539 VDD VDD VSS VSS gf180mcu_fd_sc_mcu7t5v0__fill_1
XFILLER_46_208 VDD VDD VSS VSS gf180mcu_fd_sc_mcu7t5v0__fill_2
XFILLER_27_422 VDD VDD VSS VSS gf180mcu_fd_sc_mcu7t5v0__fill_2
XFILLER_39_282 VDD VDD VSS VSS gf180mcu_fd_sc_mcu7t5v0__fillcap_16
XTAP_TAPCELL_ROW_107_1356 VDD VSS gf180mcu_fd_sc_mcu7t5v0__filltie
XFILLER_54_241 VDD VDD VSS VSS gf180mcu_fd_sc_mcu7t5v0__fillcap_4
XFILLER_54_263 VDD VDD VSS VSS gf180mcu_fd_sc_mcu7t5v0__fillcap_4
XFILLER_27_488 VDD VDD VSS VSS gf180mcu_fd_sc_mcu7t5v0__fill_2
XFILLER_14_149 VDD VDD VSS VSS gf180mcu_fd_sc_mcu7t5v0__fillcap_8
XFILLER_52_34 VDD VDD VSS VSS gf180mcu_fd_sc_mcu7t5v0__fill_1
XFILLER_10_322 VDD VDD VSS VSS gf180mcu_fd_sc_mcu7t5v0__fillcap_32
XTAP_TAPCELL_ROW_40_659 VDD VSS gf180mcu_fd_sc_mcu7t5v0__filltie
XFILLER_50_480 VDD VDD VSS VSS gf180mcu_fd_sc_mcu7t5v0__fill_1
XFILLER_10_377 VDD VDD VSS VSS gf180mcu_fd_sc_mcu7t5v0__fillcap_8
XFILLER_10_366 VDD VDD VSS VSS gf180mcu_fd_sc_mcu7t5v0__fill_1
XTAP_TAPCELL_ROW_75_1024 VDD VSS gf180mcu_fd_sc_mcu7t5v0__filltie
XFILLER_2_543 VDD VDD VSS VSS gf180mcu_fd_sc_mcu7t5v0__fill_1
XFILLER_104_493 VDD VDD VSS VSS gf180mcu_fd_sc_mcu7t5v0__fill_2
XFILLER_77_300 VDD VDD VSS VSS gf180mcu_fd_sc_mcu7t5v0__fill_1
XFILLER_77_388 VDD VDD VSS VSS gf180mcu_fd_sc_mcu7t5v0__fill_1
XFILLER_37_219 VDD VDD VSS VSS gf180mcu_fd_sc_mcu7t5v0__fillcap_16
XFILLER_18_422 VDD VDD VSS VSS gf180mcu_fd_sc_mcu7t5v0__fillcap_4
XTAP_TAPCELL_ROW_48_737 VDD VSS gf180mcu_fd_sc_mcu7t5v0__filltie
XTAP_TAPCELL_ROW_86_1142 VDD VSS gf180mcu_fd_sc_mcu7t5v0__filltie
XFILLER_45_252 VDD VDD VSS VSS gf180mcu_fd_sc_mcu7t5v0__fillcap_16
XFILLER_93_96 VDD VDD VSS VSS gf180mcu_fd_sc_mcu7t5v0__fillcap_4
X_1980_ _2997_/Q _3117_/Q _1981_/S _2997_/D VDD VDD VSS VSS gf180mcu_fd_sc_mcu7t5v0__mux2_2
XFILLER_60_244 VDD VDD VSS VSS gf180mcu_fd_sc_mcu7t5v0__fill_1
XFILLER_60_255 VDD VDD VSS VSS gf180mcu_fd_sc_mcu7t5v0__fillcap_4
XFILLER_14_683 VDD VDD VSS VSS gf180mcu_fd_sc_mcu7t5v0__fillcap_4
XFILLER_60_299 VDD VDD VSS VSS gf180mcu_fd_sc_mcu7t5v0__fill_2
XTAP_TAPCELL_ROW_11_350 VDD VSS gf180mcu_fd_sc_mcu7t5v0__filltie
X_2601_ _3206_/Q _2601_/A2 _2601_/A3 _2663_/B VDD VDD VSS VSS gf180mcu_fd_sc_mcu7t5v0__or3_1
X_2532_ _3195_/Q _3187_/Q _2540_/S _3195_/D VDD VDD VSS VSS gf180mcu_fd_sc_mcu7t5v0__mux2_2
X_2463_ _3262_/Q _2443_/Z _2465_/A2 VDD VDD VSS VSS gf180mcu_fd_sc_mcu7t5v0__nand2_1
XFILLER_47_2 VDD VDD VSS VSS gf180mcu_fd_sc_mcu7t5v0__fillcap_8
X_1414_ _3050_/Q _2096_/A1 VDD VDD VSS VSS gf180mcu_fd_sc_mcu7t5v0__clkinv_1
X_2394_ _2407_/A1 _2394_/A2 _2407_/B _2394_/C _2395_/B VDD VDD VSS VSS gf180mcu_fd_sc_mcu7t5v0__oai211_1
XFILLER_3_72 VDD VDD VSS VSS gf180mcu_fd_sc_mcu7t5v0__fillcap_32
XFILLER_95_174 VDD VDD VSS VSS gf180mcu_fd_sc_mcu7t5v0__fillcap_4
X_3015_ _3015_/D _3021_/CLK _3015_/Q VDD VDD VSS VSS gf180mcu_fd_sc_mcu7t5v0__dffq_1
XFILLER_37_764 VDD VDD VSS VSS gf180mcu_fd_sc_mcu7t5v0__fill_1
XFILLER_91_380 VDD VDD VSS VSS gf180mcu_fd_sc_mcu7t5v0__fill_1
XFILLER_24_425 VDD VDD VSS VSS gf180mcu_fd_sc_mcu7t5v0__fillcap_16
XFILLER_51_255 VDD VDD VSS VSS gf180mcu_fd_sc_mcu7t5v0__fillcap_16
XFILLER_22_37 VDD VDD VSS VSS gf180mcu_fd_sc_mcu7t5v0__fillcap_8
XFILLER_105_224 VDD VDD VSS VSS gf180mcu_fd_sc_mcu7t5v0__fill_2
XFILLER_74_303 VDD VDD VSS VSS gf180mcu_fd_sc_mcu7t5v0__fillcap_4
XFILLER_74_314 VDD VDD VSS VSS gf180mcu_fd_sc_mcu7t5v0__fill_1
XFILLER_86_185 VDD VDD VSS VSS gf180mcu_fd_sc_mcu7t5v0__fill_2
XFILLER_74_325 VDD VDD VSS VSS gf180mcu_fd_sc_mcu7t5v0__fillcap_4
XTAP_TAPCELL_ROW_17_409 VDD VSS gf180mcu_fd_sc_mcu7t5v0__filltie
XFILLER_28_764 VDD VDD VSS VSS gf180mcu_fd_sc_mcu7t5v0__fill_1
XTAP_TAPCELL_ROW_45_707 VDD VSS gf180mcu_fd_sc_mcu7t5v0__filltie
XFILLER_82_380 VDD VDD VSS VSS gf180mcu_fd_sc_mcu7t5v0__fillcap_4
XFILLER_42_200 VDD VDD VSS VSS gf180mcu_fd_sc_mcu7t5v0__fill_2
XFILLER_82_391 VDD VDD VSS VSS gf180mcu_fd_sc_mcu7t5v0__fill_1
XFILLER_42_255 VDD VDD VSS VSS gf180mcu_fd_sc_mcu7t5v0__fillcap_4
XFILLER_63_66 VDD VDD VSS VSS gf180mcu_fd_sc_mcu7t5v0__fillcap_4
XTAP_TAPCELL_ROW_81_1083 VDD VSS gf180mcu_fd_sc_mcu7t5v0__filltie
XFILLER_23_480 VDD VDD VSS VSS gf180mcu_fd_sc_mcu7t5v0__fill_2
XTAP_TAPCELL_ROW_25_497 VDD VSS gf180mcu_fd_sc_mcu7t5v0__filltie
XFILLER_30_439 VDD VDD VSS VSS gf180mcu_fd_sc_mcu7t5v0__fill_1
XTAP_TAPCELL_ROW_53_795 VDD VSS gf180mcu_fd_sc_mcu7t5v0__filltie
XFILLER_7_624 VDD VDD VSS VSS gf180mcu_fd_sc_mcu7t5v0__fillcap_4
XFILLER_10_163 VDD VDD VSS VSS gf180mcu_fd_sc_mcu7t5v0__fill_2
XFILLER_7_657 VDD VDD VSS VSS gf180mcu_fd_sc_mcu7t5v0__fillcap_16
XFILLER_6_123 VDD VDD VSS VSS gf180mcu_fd_sc_mcu7t5v0__fillcap_8
XFILLER_33_8 VDD VDD VSS VSS gf180mcu_fd_sc_mcu7t5v0__fill_1
XFILLER_78_686 VDD VDD VSS VSS gf180mcu_fd_sc_mcu7t5v0__fillcap_32
XFILLER_92_177 VDD VDD VSS VSS gf180mcu_fd_sc_mcu7t5v0__fillcap_16
XFILLER_80_317 VDD VDD VSS VSS gf180mcu_fd_sc_mcu7t5v0__fillcap_8
XFILLER_34_734 VDD VDD VSS VSS gf180mcu_fd_sc_mcu7t5v0__fill_1
X_1963_ _2000_/A1 _1935_/Z _1971_/S VDD VDD VSS VSS gf180mcu_fd_sc_mcu7t5v0__nand2_1
X_1894_ _3115_/Q _2923_/Q _1897_/S _2923_/D VDD VDD VSS VSS gf180mcu_fd_sc_mcu7t5v0__mux2_2
XFILLER_103_706 VDD VDD VSS VSS gf180mcu_fd_sc_mcu7t5v0__fill_2
X_2515_ _3178_/Q _3155_/Q _2540_/S _3178_/D VDD VDD VSS VSS gf180mcu_fd_sc_mcu7t5v0__mux2_2
X_2446_ _3273_/Q _2466_/B1 _2467_/B1 _3257_/Q _2450_/A1 VDD VDD VSS VSS gf180mcu_fd_sc_mcu7t5v0__aoi22_1
XFILLER_96_450 VDD VDD VSS VSS gf180mcu_fd_sc_mcu7t5v0__fillcap_4
X_2377_ _2859_/Q _2851_/Q _2843_/Q _2835_/Q _2400_/S0 _2390_/S1 _2377_/Z VDD VDD VSS
+ VSS gf180mcu_fd_sc_mcu7t5v0__mux4_1
XFILLER_56_325 VDD VDD VSS VSS gf180mcu_fd_sc_mcu7t5v0__fill_2
XFILLER_68_174 VDD VDD VSS VSS gf180mcu_fd_sc_mcu7t5v0__fill_1
XFILLER_84_667 VDD VDD VSS VSS gf180mcu_fd_sc_mcu7t5v0__fillcap_8
XFILLER_44_509 VDD VDD VSS VSS gf180mcu_fd_sc_mcu7t5v0__fill_1
XFILLER_56_358 VDD VDD VSS VSS gf180mcu_fd_sc_mcu7t5v0__fillcap_16
XFILLER_71_306 VDD VDD VSS VSS gf180mcu_fd_sc_mcu7t5v0__fillcap_8
XTAP_TAPCELL_ROW_104_1326 VDD VSS gf180mcu_fd_sc_mcu7t5v0__filltie
XFILLER_40_737 VDD VDD VSS VSS gf180mcu_fd_sc_mcu7t5v0__fillcap_4
XFILLER_40_748 VDD VDD VSS VSS gf180mcu_fd_sc_mcu7t5v0__fillcap_16
XFILLER_52_597 VDD VDD VSS VSS gf180mcu_fd_sc_mcu7t5v0__fillcap_32
XTAP_TAPCELL_ROW_22_467 VDD VSS gf180mcu_fd_sc_mcu7t5v0__filltie
XFILLER_33_69 VDD VDD VSS VSS gf180mcu_fd_sc_mcu7t5v0__fill_1
XTAP_TAPCELL_ROW_50_754 VDD VSS gf180mcu_fd_sc_mcu7t5v0__filltie
XFILLER_106_522 VDD VDD VSS VSS gf180mcu_fd_sc_mcu7t5v0__fill_2
XFILLER_3_104 VDD VDD VSS VSS gf180mcu_fd_sc_mcu7t5v0__fill_2
XFILLER_102_761 VDD VDD VSS VSS gf180mcu_fd_sc_mcu7t5v0__fillcap_4
XFILLER_101_293 VDD VDD VSS VSS gf180mcu_fd_sc_mcu7t5v0__fillcap_32
XFILLER_101_282 VDD VDD VSS VSS gf180mcu_fd_sc_mcu7t5v0__fill_2
XTAP_TAPCELL_ROW_58_843 VDD VSS gf180mcu_fd_sc_mcu7t5v0__filltie
XTAP_TAPCELL_ROW_83_1101 VDD VSS gf180mcu_fd_sc_mcu7t5v0__filltie
XFILLER_16_734 VDD VDD VSS VSS gf180mcu_fd_sc_mcu7t5v0__fill_1
XFILLER_28_583 VDD VDD VSS VSS gf180mcu_fd_sc_mcu7t5v0__fillcap_8
XFILLER_74_177 VDD VDD VSS VSS gf180mcu_fd_sc_mcu7t5v0__fill_2
XFILLER_15_222 VDD VDD VSS VSS gf180mcu_fd_sc_mcu7t5v0__fill_1
XFILLER_90_53 VDD VDD VSS VSS gf180mcu_fd_sc_mcu7t5v0__fill_2
XFILLER_23_80 VDD VDD VSS VSS gf180mcu_fd_sc_mcu7t5v0__fillcap_4
X_2300_ _2300_/A1 _2316_/A2 _2300_/B1 _2300_/B2 _2301_/A3 VDD VDD VSS VSS gf180mcu_fd_sc_mcu7t5v0__aoi22_1
XFILLER_98_737 VDD VDD VSS VSS gf180mcu_fd_sc_mcu7t5v0__fill_2
X_3280_ _3280_/D _3369_/RN _3286_/CLK _3280_/Q VDD VDD VSS VSS gf180mcu_fd_sc_mcu7t5v0__dffrnq_1
X_2231_ _2424_/A1 _2431_/B _2379_/B _2218_/B _2231_/B2 _3110_/D VDD VDD VSS VSS gf180mcu_fd_sc_mcu7t5v0__oai32_1
XFILLER_85_409 VDD VDD VSS VSS gf180mcu_fd_sc_mcu7t5v0__fillcap_8
X_2162_ _3241_/Q _3091_/Q _2165_/S _3091_/D VDD VDD VSS VSS gf180mcu_fd_sc_mcu7t5v0__mux2_2
XFILLER_66_645 VDD VDD VSS VSS gf180mcu_fd_sc_mcu7t5v0__fillcap_16
X_2093_ _3059_/Q _3061_/Q _2118_/A2 VDD VDD VSS VSS gf180mcu_fd_sc_mcu7t5v0__nand2_1
XFILLER_66_667 VDD VDD VSS VSS gf180mcu_fd_sc_mcu7t5v0__fillcap_4
XFILLER_80_169 VDD VDD VSS VSS gf180mcu_fd_sc_mcu7t5v0__fillcap_4
XFILLER_21_225 VDD VDD VSS VSS gf180mcu_fd_sc_mcu7t5v0__fillcap_4
XFILLER_22_737 VDD VDD VSS VSS gf180mcu_fd_sc_mcu7t5v0__fillcap_16
XFILLER_34_597 VDD VDD VSS VSS gf180mcu_fd_sc_mcu7t5v0__fillcap_8
X_2995_ _2995_/D _3366_/CLK _2995_/Q VDD VDD VSS VSS gf180mcu_fd_sc_mcu7t5v0__dffq_1
X_1946_ _3111_/Q _2967_/Q _1953_/S _2967_/D VDD VDD VSS VSS gf180mcu_fd_sc_mcu7t5v0__mux2_2
X_1877_ _2910_/Q _3118_/Q _1877_/S _2910_/D VDD VDD VSS VSS gf180mcu_fd_sc_mcu7t5v0__mux2_2
XFILLER_88_247 VDD VDD VSS VSS gf180mcu_fd_sc_mcu7t5v0__fillcap_8
X_2429_ _2420_/B _2429_/A2 _2429_/B _2432_/A2 VDD VDD VSS VSS gf180mcu_fd_sc_mcu7t5v0__oai21_1
XFILLER_28_14 VDD VDD VSS VSS gf180mcu_fd_sc_mcu7t5v0__fill_2
XFILLER_17_509 VDD VDD VSS VSS gf180mcu_fd_sc_mcu7t5v0__fillcap_32
XFILLER_29_347 VDD VDD VSS VSS gf180mcu_fd_sc_mcu7t5v0__fill_2
XTAP_TAPCELL_ROW_27_515 VDD VSS gf180mcu_fd_sc_mcu7t5v0__filltie
XFILLER_44_306 VDD VDD VSS VSS gf180mcu_fd_sc_mcu7t5v0__fillcap_8
XFILLER_44_317 VDD VDD VSS VSS gf180mcu_fd_sc_mcu7t5v0__fillcap_16
XFILLER_56_177 VDD VDD VSS VSS gf180mcu_fd_sc_mcu7t5v0__fill_1
XTAP_TAPCELL_ROW_55_813 VDD VSS gf180mcu_fd_sc_mcu7t5v0__filltie
XFILLER_25_586 VDD VDD VSS VSS gf180mcu_fd_sc_mcu7t5v0__fillcap_4
XFILLER_12_247 VDD VDD VSS VSS gf180mcu_fd_sc_mcu7t5v0__fillcap_32
XFILLER_95_718 VDD VDD VSS VSS gf180mcu_fd_sc_mcu7t5v0__fillcap_8
XFILLER_94_228 VDD VDD VSS VSS gf180mcu_fd_sc_mcu7t5v0__fillcap_16
XFILLER_35_306 VDD VDD VSS VSS gf180mcu_fd_sc_mcu7t5v0__fillcap_4
XFILLER_62_147 VDD VDD VSS VSS gf180mcu_fd_sc_mcu7t5v0__fillcap_4
XFILLER_62_158 VDD VDD VSS VSS gf180mcu_fd_sc_mcu7t5v0__fillcap_16
XFILLER_43_394 VDD VDD VSS VSS gf180mcu_fd_sc_mcu7t5v0__fillcap_16
X_1800_ _3283_/Q _2842_/Q _1804_/S _2842_/D VDD VDD VSS VSS gf180mcu_fd_sc_mcu7t5v0__mux2_2
XFILLER_31_589 VDD VDD VSS VSS gf180mcu_fd_sc_mcu7t5v0__fill_1
X_2780_ _2780_/D _2796_/CLK _2780_/Q VDD VDD VSS VSS gf180mcu_fd_sc_mcu7t5v0__dffq_1
X_1731_ _2783_/Q _3280_/Q _1738_/S _2783_/D VDD VDD VSS VSS gf180mcu_fd_sc_mcu7t5v0__mux2_2
X_1662_ _2292_/A1 _2214_/A2 _2316_/A1 VDD VDD VSS VSS gf180mcu_fd_sc_mcu7t5v0__nand2_1
XFILLER_7_273 VDD VDD VSS VSS gf180mcu_fd_sc_mcu7t5v0__fill_2
X_3401_ _3401_/D input1/Z _3409_/CLK _3401_/Q VDD VDD VSS VSS gf180mcu_fd_sc_mcu7t5v0__dffrnq_1
XFILLER_98_523 VDD VDD VSS VSS gf180mcu_fd_sc_mcu7t5v0__fill_2
X_1593_ _3375_/Q _3400_/D _1593_/Z VDD VDD VSS VSS gf180mcu_fd_sc_mcu7t5v0__and2_1
X_3332_ _3358_/Q input1/Z _3337_/CLK hold53/I VDD VDD VSS VSS gf180mcu_fd_sc_mcu7t5v0__dffrnq_1
X_3263_ _3263_/D _3328_/RN _3271_/CLK _3263_/Q VDD VDD VSS VSS gf180mcu_fd_sc_mcu7t5v0__dffrnq_1
X_2214_ _3139_/Q _2214_/A2 _2217_/B VDD VDD VSS VSS gf180mcu_fd_sc_mcu7t5v0__nand2_1
X_3194_ _3194_/D _3328_/RN _3328_/CLK _3194_/Q VDD VDD VSS VSS gf180mcu_fd_sc_mcu7t5v0__dffrnq_1
XFILLER_94_762 VDD VDD VSS VSS gf180mcu_fd_sc_mcu7t5v0__fill_2
X_2145_ _3224_/Q _3074_/Q _2165_/S _3074_/D VDD VDD VSS VSS gf180mcu_fd_sc_mcu7t5v0__mux2_2
XFILLER_26_317 VDD VDD VSS VSS gf180mcu_fd_sc_mcu7t5v0__fillcap_8
XFILLER_38_177 VDD VDD VSS VSS gf180mcu_fd_sc_mcu7t5v0__fillcap_16
X_2076_ _3297_/Q _2091_/A2 _2090_/A2 _3289_/Q _2076_/C _2077_/B2 VDD VDD VSS VSS gf180mcu_fd_sc_mcu7t5v0__aoi221_1
XFILLER_14_49 VDD VDD VSS VSS gf180mcu_fd_sc_mcu7t5v0__fill_2
X_2978_ _2978_/D _3016_/CLK _2978_/Q VDD VDD VSS VSS gf180mcu_fd_sc_mcu7t5v0__dffq_1
XTAP_TAPCELL_ROW_32_573 VDD VSS gf180mcu_fd_sc_mcu7t5v0__filltie
XTAP_TAPCELL_ROW_60_860 VDD VSS gf180mcu_fd_sc_mcu7t5v0__filltie
X_1929_ _3113_/Q _2953_/Q _1934_/S _2953_/D VDD VDD VSS VSS gf180mcu_fd_sc_mcu7t5v0__mux2_2
XFILLER_30_37 VDD VDD VSS VSS gf180mcu_fd_sc_mcu7t5v0__fillcap_32
XFILLER_107_138 VDD VDD VSS VSS gf180mcu_fd_sc_mcu7t5v0__fill_2
XFILLER_1_416 VDD VDD VSS VSS gf180mcu_fd_sc_mcu7t5v0__fillcap_4
XFILLER_89_556 VDD VDD VSS VSS gf180mcu_fd_sc_mcu7t5v0__fillcap_4
XFILLER_77_718 VDD VDD VSS VSS gf180mcu_fd_sc_mcu7t5v0__fillcap_8
XFILLER_49_409 VDD VDD VSS VSS gf180mcu_fd_sc_mcu7t5v0__fillcap_8
XFILLER_103_388 VDD VDD VSS VSS gf180mcu_fd_sc_mcu7t5v0__fill_2
XFILLER_29_100 VDD VDD VSS VSS gf180mcu_fd_sc_mcu7t5v0__fillcap_4
XFILLER_91_209 VDD VDD VSS VSS gf180mcu_fd_sc_mcu7t5v0__fill_1
XFILLER_84_272 VDD VDD VSS VSS gf180mcu_fd_sc_mcu7t5v0__fillcap_8
XFILLER_17_306 VDD VDD VSS VSS gf180mcu_fd_sc_mcu7t5v0__fillcap_4
XTAP_TAPCELL_ROW_4_276 VDD VSS gf180mcu_fd_sc_mcu7t5v0__filltie
XFILLER_29_155 VDD VDD VSS VSS gf180mcu_fd_sc_mcu7t5v0__fill_1
XFILLER_72_478 VDD VDD VSS VSS gf180mcu_fd_sc_mcu7t5v0__fill_2
XFILLER_25_372 VDD VDD VSS VSS gf180mcu_fd_sc_mcu7t5v0__fillcap_8
XFILLER_13_578 VDD VDD VSS VSS gf180mcu_fd_sc_mcu7t5v0__fillcap_8
XFILLER_40_364 VDD VDD VSS VSS gf180mcu_fd_sc_mcu7t5v0__fillcap_16
XFILLER_71_88 VDD VDD VSS VSS gf180mcu_fd_sc_mcu7t5v0__fillcap_4
XFILLER_71_66 VDD VDD VSS VSS gf180mcu_fd_sc_mcu7t5v0__fillcap_4
XTAP_TAPCELL_ROW_78_1055 VDD VSS gf180mcu_fd_sc_mcu7t5v0__filltie
XFILLER_106_193 VDD VDD VSS VSS gf180mcu_fd_sc_mcu7t5v0__fillcap_8
XFILLER_67_206 VDD VDD VSS VSS gf180mcu_fd_sc_mcu7t5v0__fillcap_4
XFILLER_68_729 VDD VDD VSS VSS gf180mcu_fd_sc_mcu7t5v0__fillcap_4
XFILLER_48_442 VDD VDD VSS VSS gf180mcu_fd_sc_mcu7t5v0__fillcap_8
XTAP_TAPCELL_ROW_89_1173 VDD VSS gf180mcu_fd_sc_mcu7t5v0__filltie
XFILLER_82_209 VDD VDD VSS VSS gf180mcu_fd_sc_mcu7t5v0__fillcap_4
XFILLER_48_486 VDD VDD VSS VSS gf180mcu_fd_sc_mcu7t5v0__fillcap_16
XFILLER_75_294 VDD VDD VSS VSS gf180mcu_fd_sc_mcu7t5v0__fillcap_32
XPHY_EDGE_ROW_11_Left_120 VDD VSS gf180mcu_fd_sc_mcu7t5v0__endcap
XFILLER_90_286 VDD VDD VSS VSS gf180mcu_fd_sc_mcu7t5v0__fill_2
X_2901_ _2901_/D _2954_/CLK _2901_/Q VDD VDD VSS VSS gf180mcu_fd_sc_mcu7t5v0__dffq_1
X_2832_ _2832_/D _2858_/CLK _2832_/Q VDD VDD VSS VSS gf180mcu_fd_sc_mcu7t5v0__dffq_1
X_2763_ _3221_/Q _3303_/Q _2763_/S _3303_/D VDD VDD VSS VSS gf180mcu_fd_sc_mcu7t5v0__mux2_2
X_1714_ _2770_/Q _3283_/Q _1718_/S _2770_/D VDD VDD VSS VSS gf180mcu_fd_sc_mcu7t5v0__mux2_2
X_2694_ _2694_/I _3258_/D VDD VDD VSS VSS gf180mcu_fd_sc_mcu7t5v0__clkinv_1
X_1645_ _3131_/Q _1645_/A2 _1645_/Z VDD VDD VSS VSS gf180mcu_fd_sc_mcu7t5v0__or2_1
X_1576_ _3336_/Q _3361_/D _1579_/A1 VDD VDD VSS VSS gf180mcu_fd_sc_mcu7t5v0__xnor2_1
X_3315_ hold43/Z input1/Z _3315_/CLK hold65/I VDD VDD VSS VSS gf180mcu_fd_sc_mcu7t5v0__dffrnq_1
XFILLER_59_729 VDD VDD VSS VSS gf180mcu_fd_sc_mcu7t5v0__fill_2
X_3246_ _3246_/D _3369_/RN _3270_/CLK _3246_/Q VDD VDD VSS VSS gf180mcu_fd_sc_mcu7t5v0__dffrnq_1
XFILLER_27_604 VDD VDD VSS VSS gf180mcu_fd_sc_mcu7t5v0__fill_1
XFILLER_39_486 VDD VDD VSS VSS gf180mcu_fd_sc_mcu7t5v0__fillcap_4
X_3177_ _3177_/D _3303_/RN _3293_/CLK _3177_/Q VDD VDD VSS VSS gf180mcu_fd_sc_mcu7t5v0__dffrnq_1
Xclkbuf_leaf_32_clk_i clkload6/I _3369_/CLK VDD VDD VSS VSS gf180mcu_fd_sc_mcu7t5v0__clkbuf_4
XFILLER_73_209 VDD VDD VSS VSS gf180mcu_fd_sc_mcu7t5v0__fill_1
XTAP_TAPCELL_ROW_1_246 VDD VSS gf180mcu_fd_sc_mcu7t5v0__filltie
XTAP_TAPCELL_ROW_37_621 VDD VSS gf180mcu_fd_sc_mcu7t5v0__filltie
X_2128_ _3205_/Q _3204_/Q _2747_/A3 VDD VDD VSS VSS gf180mcu_fd_sc_mcu7t5v0__nor2_1
X_2059_ _2059_/A1 _2057_/B _2059_/B _3036_/D VDD VDD VSS VSS gf180mcu_fd_sc_mcu7t5v0__oai21_1
XFILLER_41_139 VDD VDD VSS VSS gf180mcu_fd_sc_mcu7t5v0__fill_1
Xclkbuf_leaf_47_clk_i clkload0/I _3326_/CLK VDD VDD VSS VSS gf180mcu_fd_sc_mcu7t5v0__clkbuf_4
XFILLER_50_662 VDD VDD VSS VSS gf180mcu_fd_sc_mcu7t5v0__fill_2
XFILLER_41_58 VDD VDD VSS VSS gf180mcu_fd_sc_mcu7t5v0__fillcap_8
XTAP_TAPCELL_ROW_9_324 VDD VSS gf180mcu_fd_sc_mcu7t5v0__filltie
XFILLER_89_320 VDD VDD VSS VSS gf180mcu_fd_sc_mcu7t5v0__fill_2
XFILLER_103_163 VDD VDD VSS VSS gf180mcu_fd_sc_mcu7t5v0__fillcap_4
XFILLER_45_401 VDD VDD VSS VSS gf180mcu_fd_sc_mcu7t5v0__fill_1
XFILLER_18_659 VDD VDD VSS VSS gf180mcu_fd_sc_mcu7t5v0__fillcap_4
XFILLER_72_242 VDD VDD VSS VSS gf180mcu_fd_sc_mcu7t5v0__fill_2
XFILLER_33_629 VDD VDD VSS VSS gf180mcu_fd_sc_mcu7t5v0__fill_1
XFILLER_82_98 VDD VDD VSS VSS gf180mcu_fd_sc_mcu7t5v0__fillcap_4
XFILLER_13_320 VDD VDD VSS VSS gf180mcu_fd_sc_mcu7t5v0__fill_2
XTAP_TAPCELL_ROW_71_977 VDD VSS gf180mcu_fd_sc_mcu7t5v0__filltie
XFILLER_99_139 VDD VDD VSS VSS gf180mcu_fd_sc_mcu7t5v0__fill_1
X_1430_ hold65/I _3316_/Q _1433_/A3 VDD VDD VSS VSS gf180mcu_fd_sc_mcu7t5v0__nor2_1
X_3100_ _3100_/D _3328_/RN _3222_/CLK _3100_/Q VDD VDD VSS VSS gf180mcu_fd_sc_mcu7t5v0__dffrnq_1
XFILLER_68_559 VDD VDD VSS VSS gf180mcu_fd_sc_mcu7t5v0__fill_2
X_3031_ _3031_/D _3416_/RN _3419_/CLK _3031_/Q VDD VDD VSS VSS gf180mcu_fd_sc_mcu7t5v0__dffrnq_1
XFILLER_76_570 VDD VDD VSS VSS gf180mcu_fd_sc_mcu7t5v0__fill_1
XFILLER_36_445 VDD VDD VSS VSS gf180mcu_fd_sc_mcu7t5v0__fillcap_8
XFILLER_91_562 VDD VDD VSS VSS gf180mcu_fd_sc_mcu7t5v0__fill_1
XFILLER_63_231 VDD VDD VSS VSS gf180mcu_fd_sc_mcu7t5v0__fill_1
XFILLER_51_426 VDD VDD VSS VSS gf180mcu_fd_sc_mcu7t5v0__fill_2
XFILLER_51_448 VDD VDD VSS VSS gf180mcu_fd_sc_mcu7t5v0__fill_2
XFILLER_31_150 VDD VDD VSS VSS gf180mcu_fd_sc_mcu7t5v0__fillcap_4
X_2815_ _2815_/D _3408_/CLK _2815_/Q VDD VDD VSS VSS gf180mcu_fd_sc_mcu7t5v0__dffq_1
XTAP_TAPCELL_ROW_14_381 VDD VSS gf180mcu_fd_sc_mcu7t5v0__filltie
X_2746_ _3221_/Q _3287_/Q _2746_/S _3287_/D VDD VDD VSS VSS gf180mcu_fd_sc_mcu7t5v0__mux2_2
X_2677_ _3071_/Q _2658_/Z _2676_/Z _2677_/B2 _2680_/C _2678_/B VDD VDD VSS VSS gf180mcu_fd_sc_mcu7t5v0__aoi221_1
XFILLER_99_640 VDD VDD VSS VSS gf180mcu_fd_sc_mcu7t5v0__fill_2
X_1628_ _1628_/A1 _1507_/Z _1625_/Z _2413_/A1 _2218_/B VDD VDD VSS VSS gf180mcu_fd_sc_mcu7t5v0__aoi22_1
XFILLER_100_100 VDD VDD VSS VSS gf180mcu_fd_sc_mcu7t5v0__fillcap_4
X_1559_ _3057_/Q _1561_/B2 _1559_/A3 _1559_/B1 _1537_/B _1562_/B VDD VDD VSS VSS gf180mcu_fd_sc_mcu7t5v0__oai32_1
XFILLER_100_177 VDD VDD VSS VSS gf180mcu_fd_sc_mcu7t5v0__fillcap_16
X_3229_ _3229_/D _3303_/RN clkload8/I _3229_/Q VDD VDD VSS VSS gf180mcu_fd_sc_mcu7t5v0__dffrnq_1
XFILLER_67_581 VDD VDD VSS VSS gf180mcu_fd_sc_mcu7t5v0__fillcap_4
XTAP_TAPCELL_ROW_107_1357 VDD VSS gf180mcu_fd_sc_mcu7t5v0__filltie
XFILLER_15_618 VDD VDD VSS VSS gf180mcu_fd_sc_mcu7t5v0__fillcap_8
XFILLER_23_640 VDD VDD VSS VSS gf180mcu_fd_sc_mcu7t5v0__fillcap_4
XTAP_TAPCELL_ROW_40_649 VDD VSS gf180mcu_fd_sc_mcu7t5v0__filltie
XTAP_TAPCELL_ROW_75_1025 VDD VSS gf180mcu_fd_sc_mcu7t5v0__filltie
XFILLER_2_500 VDD VDD VSS VSS gf180mcu_fd_sc_mcu7t5v0__fillcap_16
XFILLER_7_2 VDD VDD VSS VSS gf180mcu_fd_sc_mcu7t5v0__fillcap_32
XFILLER_93_42 VDD VDD VSS VSS gf180mcu_fd_sc_mcu7t5v0__fillcap_16
XFILLER_92_337 VDD VDD VSS VSS gf180mcu_fd_sc_mcu7t5v0__fillcap_4
XTAP_TAPCELL_ROW_48_738 VDD VSS gf180mcu_fd_sc_mcu7t5v0__filltie
XFILLER_92_359 VDD VDD VSS VSS gf180mcu_fd_sc_mcu7t5v0__fill_1
XTAP_TAPCELL_ROW_86_1132 VDD VSS gf180mcu_fd_sc_mcu7t5v0__filltie
XFILLER_61_702 VDD VDD VSS VSS gf180mcu_fd_sc_mcu7t5v0__fillcap_8
XFILLER_73_562 VDD VDD VSS VSS gf180mcu_fd_sc_mcu7t5v0__fillcap_4
XFILLER_33_404 VDD VDD VSS VSS gf180mcu_fd_sc_mcu7t5v0__fill_2
XFILLER_60_201 VDD VDD VSS VSS gf180mcu_fd_sc_mcu7t5v0__fill_2
XFILLER_73_573 VDD VDD VSS VSS gf180mcu_fd_sc_mcu7t5v0__fillcap_32
XFILLER_60_234 VDD VDD VSS VSS gf180mcu_fd_sc_mcu7t5v0__fillcap_8
XFILLER_41_492 VDD VDD VSS VSS gf180mcu_fd_sc_mcu7t5v0__fill_2
XTAP_TAPCELL_ROW_97_1250 VDD VSS gf180mcu_fd_sc_mcu7t5v0__filltie
XTAP_TAPCELL_ROW_11_351 VDD VSS gf180mcu_fd_sc_mcu7t5v0__filltie
X_2600_ _3206_/Q _2601_/A2 _2601_/A3 _2683_/C VDD VDD VSS VSS gf180mcu_fd_sc_mcu7t5v0__nor3_1
X_2531_ _3194_/Q _3186_/Q _2539_/S _3194_/D VDD VDD VSS VSS gf180mcu_fd_sc_mcu7t5v0__mux2_2
X_2462_ _2462_/A1 _2462_/A2 _2462_/B1 _2462_/B2 _3159_/Q _2469_/C VDD VDD VSS VSS
+ gf180mcu_fd_sc_mcu7t5v0__aoi221_1
X_2393_ _2378_/B _2387_/Z _2393_/B _2406_/C _2394_/C VDD VDD VSS VSS gf180mcu_fd_sc_mcu7t5v0__oai211_1
X_1413_ _3060_/Q _2118_/A1 VDD VDD VSS VSS gf180mcu_fd_sc_mcu7t5v0__clkinv_1
XFILLER_95_142 VDD VDD VSS VSS gf180mcu_fd_sc_mcu7t5v0__fillcap_32
XFILLER_83_337 VDD VDD VSS VSS gf180mcu_fd_sc_mcu7t5v0__fillcap_8
X_3014_ _3014_/D _3366_/CLK _3014_/Q VDD VDD VSS VSS gf180mcu_fd_sc_mcu7t5v0__dffq_1
Xwire13 wire13/I wire13/Z VDD VDD VSS VSS gf180mcu_fd_sc_mcu7t5v0__buf_4
XFILLER_36_231 VDD VDD VSS VSS gf180mcu_fd_sc_mcu7t5v0__fillcap_8
XFILLER_51_212 VDD VDD VSS VSS gf180mcu_fd_sc_mcu7t5v0__fillcap_8
XFILLER_64_573 VDD VDD VSS VSS gf180mcu_fd_sc_mcu7t5v0__fillcap_4
XFILLER_22_27 VDD VDD VSS VSS gf180mcu_fd_sc_mcu7t5v0__fillcap_8
X_2729_ _3276_/Q _2680_/C _2729_/B1 _3094_/Q _2730_/I VDD VDD VSS VSS gf180mcu_fd_sc_mcu7t5v0__aoi22_1
XFILLER_106_737 VDD VDD VSS VSS gf180mcu_fd_sc_mcu7t5v0__fill_2
XFILLER_87_632 VDD VDD VSS VSS gf180mcu_fd_sc_mcu7t5v0__fillcap_4
XFILLER_86_131 VDD VDD VSS VSS gf180mcu_fd_sc_mcu7t5v0__fillcap_4
XFILLER_19_209 VDD VDD VSS VSS gf180mcu_fd_sc_mcu7t5v0__fill_1
XFILLER_28_732 VDD VDD VSS VSS gf180mcu_fd_sc_mcu7t5v0__fill_2
XPHY_EDGE_ROW_29_Right_29 VDD VSS gf180mcu_fd_sc_mcu7t5v0__endcap
XFILLER_47_68 VDD VDD VSS VSS gf180mcu_fd_sc_mcu7t5v0__fill_2
XFILLER_43_702 VDD VDD VSS VSS gf180mcu_fd_sc_mcu7t5v0__fillcap_4
XTAP_TAPCELL_ROW_45_708 VDD VSS gf180mcu_fd_sc_mcu7t5v0__filltie
XFILLER_55_595 VDD VDD VSS VSS gf180mcu_fd_sc_mcu7t5v0__fill_2
XFILLER_103_96 VDD VDD VSS VSS gf180mcu_fd_sc_mcu7t5v0__fill_1
XTAP_TAPCELL_ROW_81_1084 VDD VSS gf180mcu_fd_sc_mcu7t5v0__filltie
XFILLER_11_632 VDD VDD VSS VSS gf180mcu_fd_sc_mcu7t5v0__fillcap_8
XTAP_TAPCELL_ROW_25_498 VDD VSS gf180mcu_fd_sc_mcu7t5v0__filltie
XFILLER_11_676 VDD VDD VSS VSS gf180mcu_fd_sc_mcu7t5v0__fillcap_16
XPHY_EDGE_ROW_38_Right_38 VDD VSS gf180mcu_fd_sc_mcu7t5v0__endcap
XFILLER_88_53 VDD VDD VSS VSS gf180mcu_fd_sc_mcu7t5v0__fillcap_8
XFILLER_77_120 VDD VDD VSS VSS gf180mcu_fd_sc_mcu7t5v0__fillcap_16
XFILLER_93_613 VDD VDD VSS VSS gf180mcu_fd_sc_mcu7t5v0__fillcap_16
XFILLER_77_142 VDD VDD VSS VSS gf180mcu_fd_sc_mcu7t5v0__fillcap_4
XPHY_EDGE_ROW_47_Right_47 VDD VSS gf180mcu_fd_sc_mcu7t5v0__endcap
XFILLER_18_242 VDD VDD VSS VSS gf180mcu_fd_sc_mcu7t5v0__fill_2
XFILLER_80_329 VDD VDD VSS VSS gf180mcu_fd_sc_mcu7t5v0__fill_1
XFILLER_61_543 VDD VDD VSS VSS gf180mcu_fd_sc_mcu7t5v0__fillcap_16
XFILLER_73_392 VDD VDD VSS VSS gf180mcu_fd_sc_mcu7t5v0__fillcap_4
XFILLER_33_278 VDD VDD VSS VSS gf180mcu_fd_sc_mcu7t5v0__fill_2
X_1962_ _3118_/Q _2982_/Q _1962_/S _2982_/D VDD VDD VSS VSS gf180mcu_fd_sc_mcu7t5v0__mux2_2
XPHY_EDGE_ROW_56_Right_56 VDD VSS gf180mcu_fd_sc_mcu7t5v0__endcap
X_1893_ _3114_/Q _2922_/Q _1897_/S _2922_/D VDD VDD VSS VSS gf180mcu_fd_sc_mcu7t5v0__mux2_2
X_2514_ _3177_/Q _3154_/Q _2540_/S _3177_/D VDD VDD VSS VSS gf180mcu_fd_sc_mcu7t5v0__mux2_2
X_2445_ _3161_/Q _3160_/Q _2445_/A3 _2467_/B1 VDD VDD VSS VSS gf180mcu_fd_sc_mcu7t5v0__nor3_1
XPHY_EDGE_ROW_65_Right_65 VDD VSS gf180mcu_fd_sc_mcu7t5v0__endcap
XFILLER_69_621 VDD VDD VSS VSS gf180mcu_fd_sc_mcu7t5v0__fillcap_8
XFILLER_96_473 VDD VDD VSS VSS gf180mcu_fd_sc_mcu7t5v0__fillcap_8
X_2376_ _3394_/Q _2375_/Z _2379_/A1 VDD VDD VSS VSS gf180mcu_fd_sc_mcu7t5v0__nand2_1
XFILLER_96_495 VDD VDD VSS VSS gf180mcu_fd_sc_mcu7t5v0__fill_2
XFILLER_83_112 VDD VDD VSS VSS gf180mcu_fd_sc_mcu7t5v0__fillcap_16
XPHY_EDGE_ROW_3_Left_112 VDD VSS gf180mcu_fd_sc_mcu7t5v0__endcap
XFILLER_84_679 VDD VDD VSS VSS gf180mcu_fd_sc_mcu7t5v0__fill_1
XFILLER_83_134 VDD VDD VSS VSS gf180mcu_fd_sc_mcu7t5v0__fill_1
XFILLER_83_178 VDD VDD VSS VSS gf180mcu_fd_sc_mcu7t5v0__fillcap_16
XFILLER_25_702 VDD VDD VSS VSS gf180mcu_fd_sc_mcu7t5v0__fill_1
XTAP_TAPCELL_ROW_104_1327 VDD VSS gf180mcu_fd_sc_mcu7t5v0__filltie
XFILLER_25_757 VDD VDD VSS VSS gf180mcu_fd_sc_mcu7t5v0__fillcap_8
XFILLER_52_521 VDD VDD VSS VSS gf180mcu_fd_sc_mcu7t5v0__fillcap_4
XPHY_EDGE_ROW_74_Right_74 VDD VSS gf180mcu_fd_sc_mcu7t5v0__endcap
XFILLER_33_59 VDD VDD VSS VSS gf180mcu_fd_sc_mcu7t5v0__fillcap_8
XTAP_TAPCELL_ROW_22_468 VDD VSS gf180mcu_fd_sc_mcu7t5v0__filltie
XTAP_TAPCELL_ROW_50_755 VDD VSS gf180mcu_fd_sc_mcu7t5v0__filltie
XFILLER_20_473 VDD VDD VSS VSS gf180mcu_fd_sc_mcu7t5v0__fill_2
XPHY_EDGE_ROW_49_Left_158 VDD VSS gf180mcu_fd_sc_mcu7t5v0__endcap
XPHY_EDGE_ROW_83_Right_83 VDD VSS gf180mcu_fd_sc_mcu7t5v0__endcap
XFILLER_79_407 VDD VDD VSS VSS gf180mcu_fd_sc_mcu7t5v0__fillcap_8
XPHY_EDGE_ROW_58_Left_167 VDD VSS gf180mcu_fd_sc_mcu7t5v0__endcap
XFILLER_58_78 VDD VDD VSS VSS gf180mcu_fd_sc_mcu7t5v0__fillcap_8
XFILLER_59_142 VDD VDD VSS VSS gf180mcu_fd_sc_mcu7t5v0__fillcap_8
XFILLER_59_164 VDD VDD VSS VSS gf180mcu_fd_sc_mcu7t5v0__fill_2
XFILLER_101_272 VDD VDD VSS VSS gf180mcu_fd_sc_mcu7t5v0__fillcap_8
XTAP_TAPCELL_ROW_58_844 VDD VSS gf180mcu_fd_sc_mcu7t5v0__filltie
XFILLER_90_638 VDD VDD VSS VSS gf180mcu_fd_sc_mcu7t5v0__fillcap_4
XTAP_TAPCELL_ROW_83_1102 VDD VSS gf180mcu_fd_sc_mcu7t5v0__filltie
XPHY_EDGE_ROW_92_Right_92 VDD VSS gf180mcu_fd_sc_mcu7t5v0__endcap
XFILLER_15_212 VDD VDD VSS VSS gf180mcu_fd_sc_mcu7t5v0__fill_1
XFILLER_30_226 VDD VDD VSS VSS gf180mcu_fd_sc_mcu7t5v0__fillcap_16
XPHY_EDGE_ROW_67_Left_176 VDD VSS gf180mcu_fd_sc_mcu7t5v0__endcap
XFILLER_70_373 VDD VDD VSS VSS gf180mcu_fd_sc_mcu7t5v0__fillcap_8
XFILLER_70_395 VDD VDD VSS VSS gf180mcu_fd_sc_mcu7t5v0__fillcap_4
XFILLER_90_98 VDD VDD VSS VSS gf180mcu_fd_sc_mcu7t5v0__fillcap_4
XFILLER_7_422 VDD VDD VSS VSS gf180mcu_fd_sc_mcu7t5v0__fillcap_64
XFILLER_7_400 VDD VDD VSS VSS gf180mcu_fd_sc_mcu7t5v0__fillcap_4
XTAP_TAPCELL_ROW_94_1220 VDD VSS gf180mcu_fd_sc_mcu7t5v0__filltie
X_2230_ _3109_/Q _2230_/I1 _2230_/S _3109_/D VDD VDD VSS VSS gf180mcu_fd_sc_mcu7t5v0__mux2_2
XFILLER_97_259 VDD VDD VSS VSS gf180mcu_fd_sc_mcu7t5v0__fill_2
XPHY_EDGE_ROW_76_Left_185 VDD VSS gf180mcu_fd_sc_mcu7t5v0__endcap
XFILLER_38_304 VDD VDD VSS VSS gf180mcu_fd_sc_mcu7t5v0__fillcap_4
XFILLER_78_473 VDD VDD VSS VSS gf180mcu_fd_sc_mcu7t5v0__fillcap_8
X_2161_ _3240_/Q _3090_/Q _2165_/S _3090_/D VDD VDD VSS VSS gf180mcu_fd_sc_mcu7t5v0__mux2_2
X_2092_ _2092_/A1 _2091_/B _2092_/B1 _2092_/B2 _3049_/D VDD VDD VSS VSS gf180mcu_fd_sc_mcu7t5v0__aoi22_1
XFILLER_81_627 VDD VDD VSS VSS gf180mcu_fd_sc_mcu7t5v0__fill_2
XFILLER_19_562 VDD VDD VSS VSS gf180mcu_fd_sc_mcu7t5v0__fillcap_8
XFILLER_53_329 VDD VDD VSS VSS gf180mcu_fd_sc_mcu7t5v0__fillcap_4
XFILLER_34_521 VDD VDD VSS VSS gf180mcu_fd_sc_mcu7t5v0__fillcap_4
XFILLER_46_381 VDD VDD VSS VSS gf180mcu_fd_sc_mcu7t5v0__fillcap_4
XPHY_EDGE_ROW_85_Left_194 VDD VSS gf180mcu_fd_sc_mcu7t5v0__endcap
XPHY_EDGE_ROW_100_Right_100 VDD VSS gf180mcu_fd_sc_mcu7t5v0__endcap
X_2994_ _2994_/D _3021_/CLK _2994_/Q VDD VDD VSS VSS gf180mcu_fd_sc_mcu7t5v0__dffq_1
XFILLER_21_204 VDD VDD VSS VSS gf180mcu_fd_sc_mcu7t5v0__fillcap_4
X_1945_ _1982_/A1 _1935_/Z _1953_/S VDD VDD VSS VSS gf180mcu_fd_sc_mcu7t5v0__nand2_1
X_1876_ _2909_/Q _3117_/Q _1876_/S _2909_/D VDD VDD VSS VSS gf180mcu_fd_sc_mcu7t5v0__mux2_2
XFILLER_103_559 VDD VDD VSS VSS gf180mcu_fd_sc_mcu7t5v0__fill_1
XFILLER_88_259 VDD VDD VSS VSS gf180mcu_fd_sc_mcu7t5v0__fill_2
X_2428_ _3415_/D _1637_/Z _1706_/Z _2428_/B2 _2429_/A2 VDD VDD VSS VSS gf180mcu_fd_sc_mcu7t5v0__aoi22_1
XFILLER_69_462 VDD VDD VSS VSS gf180mcu_fd_sc_mcu7t5v0__fill_2
X_2359_ _2890_/Q _2882_/Q _2874_/Q _2866_/Q _2400_/S0 _2390_/S1 _2359_/Z VDD VDD VSS
+ VSS gf180mcu_fd_sc_mcu7t5v0__mux4_1
XFILLER_96_281 VDD VDD VSS VSS gf180mcu_fd_sc_mcu7t5v0__fill_2
XFILLER_28_37 VDD VDD VSS VSS gf180mcu_fd_sc_mcu7t5v0__fillcap_64
XFILLER_96_292 VDD VDD VSS VSS gf180mcu_fd_sc_mcu7t5v0__fill_2
XFILLER_84_465 VDD VDD VSS VSS gf180mcu_fd_sc_mcu7t5v0__fill_1
XFILLER_84_454 VDD VDD VSS VSS gf180mcu_fd_sc_mcu7t5v0__fill_1
XFILLER_56_156 VDD VDD VSS VSS gf180mcu_fd_sc_mcu7t5v0__fillcap_16
XTAP_TAPCELL_ROW_27_516 VDD VSS gf180mcu_fd_sc_mcu7t5v0__filltie
XTAP_TAPCELL_ROW_55_814 VDD VSS gf180mcu_fd_sc_mcu7t5v0__filltie
XFILLER_71_137 VDD VDD VSS VSS gf180mcu_fd_sc_mcu7t5v0__fill_2
XFILLER_72_649 VDD VDD VSS VSS gf180mcu_fd_sc_mcu7t5v0__fillcap_16
XFILLER_13_738 VDD VDD VSS VSS gf180mcu_fd_sc_mcu7t5v0__fillcap_16
XFILLER_40_524 VDD VDD VSS VSS gf180mcu_fd_sc_mcu7t5v0__fill_1
XTAP_TAPCELL_ROW_63_891 VDD VSS gf180mcu_fd_sc_mcu7t5v0__filltie
XFILLER_100_53 VDD VDD VSS VSS gf180mcu_fd_sc_mcu7t5v0__fillcap_4
XFILLER_4_403 VDD VDD VSS VSS gf180mcu_fd_sc_mcu7t5v0__fill_2
XFILLER_107_2 VDD VDD VSS VSS gf180mcu_fd_sc_mcu7t5v0__fillcap_64
XFILLER_69_88 VDD VDD VSS VSS gf180mcu_fd_sc_mcu7t5v0__fillcap_8
XFILLER_102_570 VDD VDD VSS VSS gf180mcu_fd_sc_mcu7t5v0__fillcap_4
XFILLER_47_112 VDD VDD VSS VSS gf180mcu_fd_sc_mcu7t5v0__fillcap_16
XFILLER_75_487 VDD VDD VSS VSS gf180mcu_fd_sc_mcu7t5v0__fill_2
XFILLER_62_104 VDD VDD VSS VSS gf180mcu_fd_sc_mcu7t5v0__fill_1
XFILLER_90_457 VDD VDD VSS VSS gf180mcu_fd_sc_mcu7t5v0__fillcap_8
XFILLER_62_115 VDD VDD VSS VSS gf180mcu_fd_sc_mcu7t5v0__fill_2
XFILLER_71_693 VDD VDD VSS VSS gf180mcu_fd_sc_mcu7t5v0__fillcap_4
XFILLER_8_731 VDD VDD VSS VSS gf180mcu_fd_sc_mcu7t5v0__fillcap_4
X_1730_ _3406_/Q _3407_/Q _1842_/A1 _1738_/S VDD VDD VSS VSS gf180mcu_fd_sc_mcu7t5v0__and3_1
XFILLER_8_753 VDD VDD VSS VSS gf180mcu_fd_sc_mcu7t5v0__fillcap_8
X_1661_ _2764_/Q _2765_/Q _2286_/B _3148_/Q _2214_/A2 VDD VDD VSS VSS gf180mcu_fd_sc_mcu7t5v0__nor4_1
X_3400_ _3400_/D input1/Z _3407_/CLK _3400_/Q VDD VDD VSS VSS gf180mcu_fd_sc_mcu7t5v0__dffrnq_1
X_1592_ _3376_/Q _1467_/I _1595_/C VDD VDD VSS VSS gf180mcu_fd_sc_mcu7t5v0__nand2_1
X_3331_ _3357_/Q input1/Z _3337_/CLK hold62/I VDD VDD VSS VSS gf180mcu_fd_sc_mcu7t5v0__dffrnq_1
X_3262_ _3262_/D _3369_/RN _3270_/CLK _3262_/Q VDD VDD VSS VSS gf180mcu_fd_sc_mcu7t5v0__dffrnq_1
XFILLER_39_602 VDD VDD VSS VSS gf180mcu_fd_sc_mcu7t5v0__fill_1
X_2213_ _3142_/Q _3049_/Q _2406_/C _2213_/B2 _2217_/A2 VDD VDD VSS VSS gf180mcu_fd_sc_mcu7t5v0__aoi22_1
X_3193_ _3193_/D _3328_/RN _3328_/CLK _3193_/Q VDD VDD VSS VSS gf180mcu_fd_sc_mcu7t5v0__dffrnq_1
XFILLER_22_2 VDD VDD VSS VSS gf180mcu_fd_sc_mcu7t5v0__fillcap_8
XFILLER_38_123 VDD VDD VSS VSS gf180mcu_fd_sc_mcu7t5v0__fillcap_4
X_2144_ _3223_/Q _3073_/Q _2166_/S _3073_/D VDD VDD VSS VSS gf180mcu_fd_sc_mcu7t5v0__mux2_2
XFILLER_66_454 VDD VDD VSS VSS gf180mcu_fd_sc_mcu7t5v0__fill_1
XFILLER_54_605 VDD VDD VSS VSS gf180mcu_fd_sc_mcu7t5v0__fill_2
XFILLER_54_638 VDD VDD VSS VSS gf180mcu_fd_sc_mcu7t5v0__fillcap_16
XPHY_EDGE_ROW_93_Left_202 VDD VSS gf180mcu_fd_sc_mcu7t5v0__endcap
XFILLER_19_392 VDD VDD VSS VSS gf180mcu_fd_sc_mcu7t5v0__fillcap_8
X_2075_ _1548_/Z _2075_/A2 _2091_/B _2087_/B1 VDD VDD VSS VSS gf180mcu_fd_sc_mcu7t5v0__aoi21_1
XFILLER_34_384 VDD VDD VSS VSS gf180mcu_fd_sc_mcu7t5v0__fill_1
XFILLER_34_395 VDD VDD VSS VSS gf180mcu_fd_sc_mcu7t5v0__fill_1
XFILLER_22_557 VDD VDD VSS VSS gf180mcu_fd_sc_mcu7t5v0__fill_1
X_2977_ _2977_/D _3020_/CLK _2977_/Q VDD VDD VSS VSS gf180mcu_fd_sc_mcu7t5v0__dffq_1
XTAP_TAPCELL_ROW_32_574 VDD VSS gf180mcu_fd_sc_mcu7t5v0__filltie
XTAP_TAPCELL_ROW_60_861 VDD VSS gf180mcu_fd_sc_mcu7t5v0__filltie
X_1928_ _3112_/Q _2952_/Q _1934_/S _2952_/D VDD VDD VSS VSS gf180mcu_fd_sc_mcu7t5v0__mux2_2
XFILLER_107_128 VDD VDD VSS VSS gf180mcu_fd_sc_mcu7t5v0__fill_2
X_1859_ _3287_/Q _2894_/Q _1859_/S _2894_/D VDD VDD VSS VSS gf180mcu_fd_sc_mcu7t5v0__mux2_2
XFILLER_103_323 VDD VDD VSS VSS gf180mcu_fd_sc_mcu7t5v0__fillcap_4
XTAP_TAPCELL_ROW_68_950 VDD VSS gf180mcu_fd_sc_mcu7t5v0__filltie
XTAP_TAPCELL_ROW_4_277 VDD VSS gf180mcu_fd_sc_mcu7t5v0__filltie
XFILLER_55_57 VDD VDD VSS VSS gf180mcu_fd_sc_mcu7t5v0__fillcap_8
XFILLER_25_340 VDD VDD VSS VSS gf180mcu_fd_sc_mcu7t5v0__fill_1
XFILLER_72_457 VDD VDD VSS VSS gf180mcu_fd_sc_mcu7t5v0__fillcap_8
XFILLER_52_170 VDD VDD VSS VSS gf180mcu_fd_sc_mcu7t5v0__fillcap_4
XFILLER_40_387 VDD VDD VSS VSS gf180mcu_fd_sc_mcu7t5v0__fillcap_32
XTAP_TAPCELL_ROW_78_1056 VDD VSS gf180mcu_fd_sc_mcu7t5v0__filltie
XFILLER_4_244 VDD VDD VSS VSS gf180mcu_fd_sc_mcu7t5v0__fill_1
XFILLER_4_299 VDD VDD VSS VSS gf180mcu_fd_sc_mcu7t5v0__fill_1
XFILLER_48_454 VDD VDD VSS VSS gf180mcu_fd_sc_mcu7t5v0__fill_1
XFILLER_63_413 VDD VDD VSS VSS gf180mcu_fd_sc_mcu7t5v0__fillcap_4
XFILLER_29_690 VDD VDD VSS VSS gf180mcu_fd_sc_mcu7t5v0__fillcap_8
XFILLER_16_351 VDD VDD VSS VSS gf180mcu_fd_sc_mcu7t5v0__fill_1
XFILLER_16_384 VDD VDD VSS VSS gf180mcu_fd_sc_mcu7t5v0__fill_1
X_2900_ _2900_/D _3119_/CLK _2900_/Q VDD VDD VSS VSS gf180mcu_fd_sc_mcu7t5v0__dffq_1
XFILLER_50_107 VDD VDD VSS VSS gf180mcu_fd_sc_mcu7t5v0__fill_2
XFILLER_16_395 VDD VDD VSS VSS gf180mcu_fd_sc_mcu7t5v0__fillcap_4
XFILLER_31_343 VDD VDD VSS VSS gf180mcu_fd_sc_mcu7t5v0__fillcap_4
X_2831_ _2831_/D _3314_/CLK _2831_/Q VDD VDD VSS VSS gf180mcu_fd_sc_mcu7t5v0__dffq_1
X_2762_ _3220_/Q _3302_/Q _2763_/S _3302_/D VDD VDD VSS VSS gf180mcu_fd_sc_mcu7t5v0__mux2_2
X_1713_ _2769_/Q _3282_/Q _1718_/S _2769_/D VDD VDD VSS VSS gf180mcu_fd_sc_mcu7t5v0__mux2_2
XFILLER_8_594 VDD VDD VSS VSS gf180mcu_fd_sc_mcu7t5v0__fill_1
X_2693_ _3258_/Q _2680_/C _2729_/B1 _3076_/Q _2694_/I VDD VDD VSS VSS gf180mcu_fd_sc_mcu7t5v0__aoi22_1
X_1644_ _3131_/Q _1645_/A2 _2312_/A1 VDD VDD VSS VSS gf180mcu_fd_sc_mcu7t5v0__nor2_1
X_1575_ _3335_/Q _3360_/D _1580_/B2 VDD VDD VSS VSS gf180mcu_fd_sc_mcu7t5v0__nor2_1
XFILLER_98_343 VDD VDD VSS VSS gf180mcu_fd_sc_mcu7t5v0__fillcap_8
X_3314_ _3314_/D input1/Z _3314_/CLK hold43/I VDD VDD VSS VSS gf180mcu_fd_sc_mcu7t5v0__dffrnq_1
XFILLER_98_387 VDD VDD VSS VSS gf180mcu_fd_sc_mcu7t5v0__fill_1
XFILLER_86_527 VDD VDD VSS VSS gf180mcu_fd_sc_mcu7t5v0__fillcap_4
X_3245_ _3245_/D _3328_/RN clkload8/I _3245_/Q VDD VDD VSS VSS gf180mcu_fd_sc_mcu7t5v0__dffrnq_1
XFILLER_58_229 VDD VDD VSS VSS gf180mcu_fd_sc_mcu7t5v0__fillcap_16
XFILLER_27_627 VDD VDD VSS VSS gf180mcu_fd_sc_mcu7t5v0__fill_2
X_3176_ _3176_/D _3303_/RN _3292_/CLK _3176_/Q VDD VDD VSS VSS gf180mcu_fd_sc_mcu7t5v0__dffrnq_1
XFILLER_82_733 VDD VDD VSS VSS gf180mcu_fd_sc_mcu7t5v0__fill_2
XTAP_TAPCELL_ROW_1_247 VDD VSS gf180mcu_fd_sc_mcu7t5v0__filltie
XFILLER_26_104 VDD VDD VSS VSS gf180mcu_fd_sc_mcu7t5v0__fill_1
XFILLER_26_115 VDD VDD VSS VSS gf180mcu_fd_sc_mcu7t5v0__fill_2
XTAP_TAPCELL_ROW_37_622 VDD VSS gf180mcu_fd_sc_mcu7t5v0__filltie
X_2127_ _3208_/Q _1517_/Z _2603_/A2 VDD VDD VSS VSS gf180mcu_fd_sc_mcu7t5v0__nor2_1
XTAP_TAPCELL_ROW_65_920 VDD VSS gf180mcu_fd_sc_mcu7t5v0__filltie
XFILLER_66_295 VDD VDD VSS VSS gf180mcu_fd_sc_mcu7t5v0__fill_2
X_2058_ _2059_/A1 _3035_/Q _3034_/Q _2058_/A4 _2059_/B VDD VDD VSS VSS gf180mcu_fd_sc_mcu7t5v0__nand4_1
XFILLER_22_310 VDD VDD VSS VSS gf180mcu_fd_sc_mcu7t5v0__fillcap_4
XFILLER_25_38 VDD VDD VSS VSS gf180mcu_fd_sc_mcu7t5v0__fillcap_32
XFILLER_35_693 VDD VDD VSS VSS gf180mcu_fd_sc_mcu7t5v0__fillcap_4
XFILLER_41_129 VDD VDD VSS VSS gf180mcu_fd_sc_mcu7t5v0__fillcap_8
XFILLER_10_505 VDD VDD VSS VSS gf180mcu_fd_sc_mcu7t5v0__fillcap_16
XFILLER_10_527 VDD VDD VSS VSS gf180mcu_fd_sc_mcu7t5v0__fillcap_16
XFILLER_22_387 VDD VDD VSS VSS gf180mcu_fd_sc_mcu7t5v0__fillcap_8
XTAP_TAPCELL_ROW_9_325 VDD VSS gf180mcu_fd_sc_mcu7t5v0__filltie
XFILLER_104_632 VDD VDD VSS VSS gf180mcu_fd_sc_mcu7t5v0__fill_1
XFILLER_1_203 VDD VDD VSS VSS gf180mcu_fd_sc_mcu7t5v0__fillcap_4
XFILLER_2_737 VDD VDD VSS VSS gf180mcu_fd_sc_mcu7t5v0__fillcap_16
XFILLER_103_142 VDD VDD VSS VSS gf180mcu_fd_sc_mcu7t5v0__fill_1
XFILLER_106_63 VDD VDD VSS VSS gf180mcu_fd_sc_mcu7t5v0__fill_1
XFILLER_104_698 VDD VDD VSS VSS gf180mcu_fd_sc_mcu7t5v0__fillcap_8
XFILLER_66_34 VDD VDD VSS VSS gf180mcu_fd_sc_mcu7t5v0__fill_1
XFILLER_18_605 VDD VDD VSS VSS gf180mcu_fd_sc_mcu7t5v0__fill_2
XFILLER_82_55 VDD VDD VSS VSS gf180mcu_fd_sc_mcu7t5v0__fill_1
XFILLER_82_33 VDD VDD VSS VSS gf180mcu_fd_sc_mcu7t5v0__fill_2
XFILLER_32_107 VDD VDD VSS VSS gf180mcu_fd_sc_mcu7t5v0__fillcap_64
XFILLER_60_449 VDD VDD VSS VSS gf180mcu_fd_sc_mcu7t5v0__fillcap_4
XFILLER_13_376 VDD VDD VSS VSS gf180mcu_fd_sc_mcu7t5v0__fill_2
XTAP_TAPCELL_ROW_71_978 VDD VSS gf180mcu_fd_sc_mcu7t5v0__filltie
XFILLER_9_358 VDD VDD VSS VSS gf180mcu_fd_sc_mcu7t5v0__fill_1
XFILLER_107_492 VDD VDD VSS VSS gf180mcu_fd_sc_mcu7t5v0__fillcap_64
XFILLER_68_527 VDD VDD VSS VSS gf180mcu_fd_sc_mcu7t5v0__fillcap_32
X_3030_ _3030_/D _3416_/RN _3416_/CLK _3030_/Q VDD VDD VSS VSS gf180mcu_fd_sc_mcu7t5v0__dffrnq_1
XFILLER_48_240 VDD VDD VSS VSS gf180mcu_fd_sc_mcu7t5v0__fillcap_4
XFILLER_48_273 VDD VDD VSS VSS gf180mcu_fd_sc_mcu7t5v0__fillcap_8
XFILLER_91_596 VDD VDD VSS VSS gf180mcu_fd_sc_mcu7t5v0__fill_1
XFILLER_16_170 VDD VDD VSS VSS gf180mcu_fd_sc_mcu7t5v0__fillcap_4
XFILLER_32_663 VDD VDD VSS VSS gf180mcu_fd_sc_mcu7t5v0__fill_2
X_2814_ _2814_/D _2887_/CLK _2814_/Q VDD VDD VSS VSS gf180mcu_fd_sc_mcu7t5v0__dffq_1
XTAP_TAPCELL_ROW_14_382 VDD VSS gf180mcu_fd_sc_mcu7t5v0__filltie
XTAP_TAPCELL_ROW_42_680 VDD VSS gf180mcu_fd_sc_mcu7t5v0__filltie
XFILLER_11_18 VDD VDD VSS VSS gf180mcu_fd_sc_mcu7t5v0__fillcap_8
X_2745_ _3220_/Q _3286_/Q _2746_/S _3286_/D VDD VDD VSS VSS gf180mcu_fd_sc_mcu7t5v0__mux2_2
X_2676_ _2673_/Z _2675_/Z _2672_/Z _2674_/Z _3354_/Q _3353_/Q _2676_/Z VDD VDD VSS
+ VSS gf180mcu_fd_sc_mcu7t5v0__mux4_1
X_1627_ _2413_/A1 _1625_/Z _2424_/C VDD VDD VSS VSS gf180mcu_fd_sc_mcu7t5v0__nand2_1
XFILLER_98_173 VDD VDD VSS VSS gf180mcu_fd_sc_mcu7t5v0__fill_2
XFILLER_98_151 VDD VDD VSS VSS gf180mcu_fd_sc_mcu7t5v0__fillcap_4
Xclkbuf_3_7__f_clk_i clkbuf_0_clk_i/Z clkload6/I VDD VDD VSS VSS gf180mcu_fd_sc_mcu7t5v0__clkbuf_16
X_1558_ _3056_/Q _1558_/A2 _1559_/A3 VDD VDD VSS VSS gf180mcu_fd_sc_mcu7t5v0__nand2_1
X_1489_ _3365_/Q _1494_/A2 _1869_/A2 VDD VDD VSS VSS gf180mcu_fd_sc_mcu7t5v0__nand2_1
XFILLER_86_368 VDD VDD VSS VSS gf180mcu_fd_sc_mcu7t5v0__fillcap_16
X_3228_ _3228_/D _3328_/RN _3264_/CLK _3228_/Q VDD VDD VSS VSS gf180mcu_fd_sc_mcu7t5v0__dffrnq_1
X_3159_ _3159_/D _3369_/RN _3325_/CLK _3159_/Q VDD VDD VSS VSS gf180mcu_fd_sc_mcu7t5v0__dffrnq_1
XFILLER_36_37 VDD VDD VSS VSS gf180mcu_fd_sc_mcu7t5v0__fillcap_16
XTAP_TAPCELL_ROW_107_1358 VDD VSS gf180mcu_fd_sc_mcu7t5v0__filltie
XFILLER_27_468 VDD VDD VSS VSS gf180mcu_fd_sc_mcu7t5v0__fillcap_16
XFILLER_82_574 VDD VDD VSS VSS gf180mcu_fd_sc_mcu7t5v0__fillcap_4
XFILLER_14_107 VDD VDD VSS VSS gf180mcu_fd_sc_mcu7t5v0__fillcap_8
XFILLER_42_449 VDD VDD VSS VSS gf180mcu_fd_sc_mcu7t5v0__fillcap_4
XPHY_EDGE_ROW_30_Left_139 VDD VSS gf180mcu_fd_sc_mcu7t5v0__endcap
XFILLER_52_58 VDD VDD VSS VSS gf180mcu_fd_sc_mcu7t5v0__fillcap_32
XFILLER_6_317 VDD VDD VSS VSS gf180mcu_fd_sc_mcu7t5v0__fillcap_64
XTAP_TAPCELL_ROW_75_1026 VDD VSS gf180mcu_fd_sc_mcu7t5v0__filltie
XFILLER_2_589 VDD VDD VSS VSS gf180mcu_fd_sc_mcu7t5v0__fillcap_4
XFILLER_104_495 VDD VDD VSS VSS gf180mcu_fd_sc_mcu7t5v0__fill_1
XFILLER_77_88 VDD VDD VSS VSS gf180mcu_fd_sc_mcu7t5v0__fillcap_32
XFILLER_92_349 VDD VDD VSS VSS gf180mcu_fd_sc_mcu7t5v0__fillcap_8
XTAP_TAPCELL_ROW_48_739 VDD VSS gf180mcu_fd_sc_mcu7t5v0__filltie
XFILLER_58_593 VDD VDD VSS VSS gf180mcu_fd_sc_mcu7t5v0__fill_2
XTAP_TAPCELL_ROW_86_1133 VDD VSS gf180mcu_fd_sc_mcu7t5v0__filltie
XFILLER_18_457 VDD VDD VSS VSS gf180mcu_fd_sc_mcu7t5v0__fillcap_16
XFILLER_45_276 VDD VDD VSS VSS gf180mcu_fd_sc_mcu7t5v0__fillcap_4
XFILLER_61_725 VDD VDD VSS VSS gf180mcu_fd_sc_mcu7t5v0__fillcap_4
XTAP_TAPCELL_ROW_11_352 VDD VSS gf180mcu_fd_sc_mcu7t5v0__filltie
XTAP_TAPCELL_ROW_97_1251 VDD VSS gf180mcu_fd_sc_mcu7t5v0__filltie
X_2530_ _3193_/Q _3185_/Q _2540_/S _3193_/D VDD VDD VSS VSS gf180mcu_fd_sc_mcu7t5v0__mux2_2
Xclkbuf_leaf_31_clk_i clkload6/I _3367_/CLK VDD VDD VSS VSS gf180mcu_fd_sc_mcu7t5v0__clkbuf_4
X_2461_ _3251_/Q _1617_/Z _2466_/B1 _3275_/Q _2443_/Z _3267_/Q _2462_/B2 VDD VDD VSS
+ VSS gf180mcu_fd_sc_mcu7t5v0__aoi222_1
X_1412_ _3025_/Q _2022_/A1 VDD VDD VSS VSS gf180mcu_fd_sc_mcu7t5v0__clkinv_1
X_2392_ _2378_/B _2392_/A2 _2392_/A3 _2393_/B VDD VDD VSS VSS gf180mcu_fd_sc_mcu7t5v0__nand3_1
Xclkbuf_leaf_46_clk_i clkload5/I _3119_/CLK VDD VDD VSS VSS gf180mcu_fd_sc_mcu7t5v0__clkbuf_4
XFILLER_83_349 VDD VDD VSS VSS gf180mcu_fd_sc_mcu7t5v0__fill_1
XFILLER_83_327 VDD VDD VSS VSS gf180mcu_fd_sc_mcu7t5v0__fillcap_4
X_3013_ _3013_/D _3022_/CLK _3013_/Q VDD VDD VSS VSS gf180mcu_fd_sc_mcu7t5v0__dffq_1
XTAP_TAPCELL_ROW_19_430 VDD VSS gf180mcu_fd_sc_mcu7t5v0__filltie
XFILLER_36_243 VDD VDD VSS VSS gf180mcu_fd_sc_mcu7t5v0__fill_2
XFILLER_24_449 VDD VDD VSS VSS gf180mcu_fd_sc_mcu7t5v0__fillcap_4
XFILLER_51_279 VDD VDD VSS VSS gf180mcu_fd_sc_mcu7t5v0__fill_1
X_2728_ _2687_/Z _2728_/A2 _3275_/D VDD VDD VSS VSS gf180mcu_fd_sc_mcu7t5v0__nand2_1
X_2659_ _3251_/Q _2680_/C _2661_/B VDD VDD VSS VSS gf180mcu_fd_sc_mcu7t5v0__nand2_1
XFILLER_59_324 VDD VDD VSS VSS gf180mcu_fd_sc_mcu7t5v0__fillcap_16
XFILLER_101_454 VDD VDD VSS VSS gf180mcu_fd_sc_mcu7t5v0__fillcap_4
XFILLER_86_143 VDD VDD VSS VSS gf180mcu_fd_sc_mcu7t5v0__fillcap_32
XFILLER_47_508 VDD VDD VSS VSS gf180mcu_fd_sc_mcu7t5v0__fillcap_4
XFILLER_101_476 VDD VDD VSS VSS gf180mcu_fd_sc_mcu7t5v0__fillcap_8
XTAP_TAPCELL_ROW_45_709 VDD VSS gf180mcu_fd_sc_mcu7t5v0__filltie
XFILLER_27_265 VDD VDD VSS VSS gf180mcu_fd_sc_mcu7t5v0__fillcap_8
XFILLER_42_202 VDD VDD VSS VSS gf180mcu_fd_sc_mcu7t5v0__fill_1
XFILLER_70_522 VDD VDD VSS VSS gf180mcu_fd_sc_mcu7t5v0__fill_2
XTAP_TAPCELL_ROW_81_1085 VDD VSS gf180mcu_fd_sc_mcu7t5v0__filltie
XFILLER_23_482 VDD VDD VSS VSS gf180mcu_fd_sc_mcu7t5v0__fill_1
XTAP_TAPCELL_ROW_25_499 VDD VSS gf180mcu_fd_sc_mcu7t5v0__filltie
XTAP_TAPCELL_ROW_53_786 VDD VSS gf180mcu_fd_sc_mcu7t5v0__filltie
XFILLER_10_165 VDD VDD VSS VSS gf180mcu_fd_sc_mcu7t5v0__fill_1
XFILLER_78_677 VDD VDD VSS VSS gf180mcu_fd_sc_mcu7t5v0__fill_2
XFILLER_93_636 VDD VDD VSS VSS gf180mcu_fd_sc_mcu7t5v0__fill_2
XFILLER_92_124 VDD VDD VSS VSS gf180mcu_fd_sc_mcu7t5v0__fill_2
XFILLER_18_232 VDD VDD VSS VSS gf180mcu_fd_sc_mcu7t5v0__fill_2
XFILLER_19_755 VDD VDD VSS VSS gf180mcu_fd_sc_mcu7t5v0__fillcap_8
XFILLER_92_168 VDD VDD VSS VSS gf180mcu_fd_sc_mcu7t5v0__fillcap_4
XTAP_TAPCELL_ROW_16_400 VDD VSS gf180mcu_fd_sc_mcu7t5v0__filltie
XFILLER_61_566 VDD VDD VSS VSS gf180mcu_fd_sc_mcu7t5v0__fill_1
X_1961_ _3117_/Q _2981_/Q _1962_/S _2981_/D VDD VDD VSS VSS gf180mcu_fd_sc_mcu7t5v0__mux2_2
X_1892_ _3113_/Q _2921_/Q _1897_/S _2921_/D VDD VDD VSS VSS gf180mcu_fd_sc_mcu7t5v0__mux2_2
X_2513_ _3176_/Q _3153_/Q _2534_/S _3176_/D VDD VDD VSS VSS gf180mcu_fd_sc_mcu7t5v0__mux2_2
XFILLER_52_2 VDD VDD VSS VSS gf180mcu_fd_sc_mcu7t5v0__fillcap_32
XFILLER_88_408 VDD VDD VSS VSS gf180mcu_fd_sc_mcu7t5v0__fillcap_32
X_2444_ _3264_/Q _2443_/Z _2449_/A2 VDD VDD VSS VSS gf180mcu_fd_sc_mcu7t5v0__nand2_1
X_2375_ _2795_/Q _2787_/Q _2779_/Q _2771_/Q _2404_/S0 _2404_/S1 _2375_/Z VDD VDD VSS
+ VSS gf180mcu_fd_sc_mcu7t5v0__mux4_1
XFILLER_29_508 VDD VDD VSS VSS gf180mcu_fd_sc_mcu7t5v0__fill_1
XFILLER_37_585 VDD VDD VSS VSS gf180mcu_fd_sc_mcu7t5v0__fill_1
XTAP_TAPCELL_ROW_104_1328 VDD VSS gf180mcu_fd_sc_mcu7t5v0__filltie
XTAP_TAPCELL_ROW_50_756 VDD VSS gf180mcu_fd_sc_mcu7t5v0__filltie
XPHY_EDGE_ROW_104_Left_213 VDD VSS gf180mcu_fd_sc_mcu7t5v0__endcap
XFILLER_20_452 VDD VDD VSS VSS gf180mcu_fd_sc_mcu7t5v0__fill_2
XTAP_TAPCELL_ROW_22_469 VDD VSS gf180mcu_fd_sc_mcu7t5v0__filltie
XFILLER_106_524 VDD VDD VSS VSS gf180mcu_fd_sc_mcu7t5v0__fill_1
XFILLER_79_419 VDD VDD VSS VSS gf180mcu_fd_sc_mcu7t5v0__fill_1
XFILLER_102_730 VDD VDD VSS VSS gf180mcu_fd_sc_mcu7t5v0__fillcap_4
XFILLER_101_284 VDD VDD VSS VSS gf180mcu_fd_sc_mcu7t5v0__fill_1
XFILLER_75_658 VDD VDD VSS VSS gf180mcu_fd_sc_mcu7t5v0__fillcap_16
XTAP_TAPCELL_ROW_58_845 VDD VSS gf180mcu_fd_sc_mcu7t5v0__filltie
XTAP_TAPCELL_ROW_83_1103 VDD VSS gf180mcu_fd_sc_mcu7t5v0__filltie
XFILLER_74_45 VDD VDD VSS VSS gf180mcu_fd_sc_mcu7t5v0__fill_2
XFILLER_15_235 VDD VDD VSS VSS gf180mcu_fd_sc_mcu7t5v0__fill_1
XFILLER_55_393 VDD VDD VSS VSS gf180mcu_fd_sc_mcu7t5v0__fill_2
XFILLER_74_78 VDD VDD VSS VSS gf180mcu_fd_sc_mcu7t5v0__fillcap_16
XFILLER_43_555 VDD VDD VSS VSS gf180mcu_fd_sc_mcu7t5v0__fillcap_4
XFILLER_43_566 VDD VDD VSS VSS gf180mcu_fd_sc_mcu7t5v0__fill_2
XFILLER_70_341 VDD VDD VSS VSS gf180mcu_fd_sc_mcu7t5v0__fillcap_4
XFILLER_90_55 VDD VDD VSS VSS gf180mcu_fd_sc_mcu7t5v0__fill_1
XFILLER_31_728 VDD VDD VSS VSS gf180mcu_fd_sc_mcu7t5v0__fill_2
XFILLER_11_430 VDD VDD VSS VSS gf180mcu_fd_sc_mcu7t5v0__fill_2
XTAP_TAPCELL_ROW_94_1221 VDD VSS gf180mcu_fd_sc_mcu7t5v0__filltie
XFILLER_97_205 VDD VDD VSS VSS gf180mcu_fd_sc_mcu7t5v0__fillcap_4
XFILLER_3_662 VDD VDD VSS VSS gf180mcu_fd_sc_mcu7t5v0__fillcap_8
XFILLER_93_422 VDD VDD VSS VSS gf180mcu_fd_sc_mcu7t5v0__fillcap_8
XFILLER_93_411 VDD VDD VSS VSS gf180mcu_fd_sc_mcu7t5v0__fillcap_8
X_2160_ _3239_/Q _3089_/Q _2165_/S _3089_/D VDD VDD VSS VSS gf180mcu_fd_sc_mcu7t5v0__mux2_2
X_2091_ _3303_/Q _2091_/A2 _2091_/B _2092_/B2 VDD VDD VSS VSS gf180mcu_fd_sc_mcu7t5v0__aoi21_1
XFILLER_65_124 VDD VDD VSS VSS gf180mcu_fd_sc_mcu7t5v0__fillcap_4
XFILLER_93_477 VDD VDD VSS VSS gf180mcu_fd_sc_mcu7t5v0__fillcap_8
XFILLER_65_168 VDD VDD VSS VSS gf180mcu_fd_sc_mcu7t5v0__fill_2
XFILLER_80_116 VDD VDD VSS VSS gf180mcu_fd_sc_mcu7t5v0__fill_1
X_2993_ _2993_/D _3022_/CLK _2993_/Q VDD VDD VSS VSS gf180mcu_fd_sc_mcu7t5v0__dffq_1
XFILLER_9_62 VDD VDD VSS VSS gf180mcu_fd_sc_mcu7t5v0__fillcap_8
X_1944_ _2966_/Q _3118_/Q _1944_/S _2966_/D VDD VDD VSS VSS gf180mcu_fd_sc_mcu7t5v0__mux2_2
XFILLER_30_761 VDD VDD VSS VSS gf180mcu_fd_sc_mcu7t5v0__fillcap_4
X_1875_ _2908_/Q _3116_/Q _1877_/S _2908_/D VDD VDD VSS VSS gf180mcu_fd_sc_mcu7t5v0__mux2_2
X_2427_ _2427_/A1 _2427_/A2 _2427_/B _3145_/D VDD VDD VSS VSS gf180mcu_fd_sc_mcu7t5v0__aoi21_1
XFILLER_96_271 VDD VDD VSS VSS gf180mcu_fd_sc_mcu7t5v0__fill_2
X_2358_ _3136_/Q _2409_/A1 _2370_/B VDD VDD VSS VSS gf180mcu_fd_sc_mcu7t5v0__nand2_1
XFILLER_69_474 VDD VDD VSS VSS gf180mcu_fd_sc_mcu7t5v0__fillcap_16
X_2289_ _2289_/A1 _2289_/A2 _2289_/B1 _2289_/B2 _3126_/D VDD VDD VSS VSS gf180mcu_fd_sc_mcu7t5v0__aoi22_1
XFILLER_29_349 VDD VDD VSS VSS gf180mcu_fd_sc_mcu7t5v0__fill_1
XFILLER_56_124 VDD VDD VSS VSS gf180mcu_fd_sc_mcu7t5v0__fillcap_32
XFILLER_25_500 VDD VDD VSS VSS gf180mcu_fd_sc_mcu7t5v0__fillcap_4
XTAP_TAPCELL_ROW_27_517 VDD VSS gf180mcu_fd_sc_mcu7t5v0__filltie
XTAP_TAPCELL_ROW_55_815 VDD VSS gf180mcu_fd_sc_mcu7t5v0__filltie
XTAP_TAPCELL_ROW_63_892 VDD VSS gf180mcu_fd_sc_mcu7t5v0__filltie
XFILLER_60_14 VDD VDD VSS VSS gf180mcu_fd_sc_mcu7t5v0__fill_2
XFILLER_94_219 VDD VDD VSS VSS gf180mcu_fd_sc_mcu7t5v0__fill_1
XFILLER_87_271 VDD VDD VSS VSS gf180mcu_fd_sc_mcu7t5v0__fill_1
XFILLER_75_422 VDD VDD VSS VSS gf180mcu_fd_sc_mcu7t5v0__fill_2
XFILLER_87_282 VDD VDD VSS VSS gf180mcu_fd_sc_mcu7t5v0__fillcap_8
XFILLER_18_71 VDD VDD VSS VSS gf180mcu_fd_sc_mcu7t5v0__fillcap_8
XFILLER_90_469 VDD VDD VSS VSS gf180mcu_fd_sc_mcu7t5v0__fill_2
XFILLER_43_352 VDD VDD VSS VSS gf180mcu_fd_sc_mcu7t5v0__fillcap_8
XFILLER_70_193 VDD VDD VSS VSS gf180mcu_fd_sc_mcu7t5v0__fill_2
XFILLER_12_761 VDD VDD VSS VSS gf180mcu_fd_sc_mcu7t5v0__fillcap_4
XFILLER_11_282 VDD VDD VSS VSS gf180mcu_fd_sc_mcu7t5v0__fillcap_16
XFILLER_11_260 VDD VDD VSS VSS gf180mcu_fd_sc_mcu7t5v0__fillcap_8
X_1660_ _2202_/A1 _2202_/A2 _2766_/Q _2218_/A1 VDD VDD VSS VSS gf180mcu_fd_sc_mcu7t5v0__nand3_1
XFILLER_7_275 VDD VDD VSS VSS gf180mcu_fd_sc_mcu7t5v0__fill_1
XFILLER_7_253 VDD VDD VSS VSS gf180mcu_fd_sc_mcu7t5v0__fillcap_16
X_1591_ _3377_/Q _3402_/D _1591_/Z VDD VDD VSS VSS gf180mcu_fd_sc_mcu7t5v0__xor2_1
X_3330_ _3356_/Q _3369_/RN _3387_/CLK hold51/I VDD VDD VSS VSS gf180mcu_fd_sc_mcu7t5v0__dffrnq_1
XFILLER_3_492 VDD VDD VSS VSS gf180mcu_fd_sc_mcu7t5v0__fillcap_4
X_3261_ _3261_/D _3328_/RN _3325_/CLK _3261_/Q VDD VDD VSS VSS gf180mcu_fd_sc_mcu7t5v0__dffrnq_1
X_2212_ _2212_/A1 _2212_/A2 _2212_/B1 _2212_/B2 _2213_/B2 VDD VDD VSS VSS gf180mcu_fd_sc_mcu7t5v0__aoi22_1
XFILLER_78_271 VDD VDD VSS VSS gf180mcu_fd_sc_mcu7t5v0__fill_1
X_3192_ _3192_/D _3328_/RN _3276_/CLK _3192_/Q VDD VDD VSS VSS gf180mcu_fd_sc_mcu7t5v0__dffrnq_1
XFILLER_94_764 VDD VDD VSS VSS gf180mcu_fd_sc_mcu7t5v0__fill_1
XFILLER_78_293 VDD VDD VSS VSS gf180mcu_fd_sc_mcu7t5v0__fillcap_8
XFILLER_15_2 VDD VDD VSS VSS gf180mcu_fd_sc_mcu7t5v0__fillcap_4
X_2143_ _3222_/Q _3072_/Q _2166_/S _3072_/D VDD VDD VSS VSS gf180mcu_fd_sc_mcu7t5v0__mux2_2
XFILLER_66_488 VDD VDD VSS VSS gf180mcu_fd_sc_mcu7t5v0__fillcap_4
X_2074_ _2118_/A1 _2066_/Z _2075_/A2 VDD VDD VSS VSS gf180mcu_fd_sc_mcu7t5v0__nor2_1
X_2976_ _2976_/D _2984_/CLK _2976_/Q VDD VDD VSS VSS gf180mcu_fd_sc_mcu7t5v0__dffq_1
XTAP_TAPCELL_ROW_32_575 VDD VSS gf180mcu_fd_sc_mcu7t5v0__filltie
XTAP_TAPCELL_ROW_60_862 VDD VSS gf180mcu_fd_sc_mcu7t5v0__filltie
X_1927_ _3111_/Q _2951_/Q _1934_/S _2951_/D VDD VDD VSS VSS gf180mcu_fd_sc_mcu7t5v0__mux2_2
X_1858_ _3286_/Q _2893_/Q _1859_/S _2893_/D VDD VDD VSS VSS gf180mcu_fd_sc_mcu7t5v0__mux2_2
X_1789_ _3281_/Q _2832_/Q _1795_/S _2832_/D VDD VDD VSS VSS gf180mcu_fd_sc_mcu7t5v0__mux2_2
XFILLER_57_422 VDD VDD VSS VSS gf180mcu_fd_sc_mcu7t5v0__fillcap_4
XFILLER_69_282 VDD VDD VSS VSS gf180mcu_fd_sc_mcu7t5v0__fillcap_4
XFILLER_85_764 VDD VDD VSS VSS gf180mcu_fd_sc_mcu7t5v0__fill_1
XFILLER_84_263 VDD VDD VSS VSS gf180mcu_fd_sc_mcu7t5v0__fill_1
XTAP_TAPCELL_ROW_4_278 VDD VSS gf180mcu_fd_sc_mcu7t5v0__filltie
XTAP_TAPCELL_ROW_68_951 VDD VSS gf180mcu_fd_sc_mcu7t5v0__filltie
XFILLER_84_285 VDD VDD VSS VSS gf180mcu_fd_sc_mcu7t5v0__fillcap_16
XFILLER_55_69 VDD VDD VSS VSS gf180mcu_fd_sc_mcu7t5v0__fill_1
XFILLER_25_352 VDD VDD VSS VSS gf180mcu_fd_sc_mcu7t5v0__fillcap_8
XFILLER_52_193 VDD VDD VSS VSS gf180mcu_fd_sc_mcu7t5v0__fillcap_8
XFILLER_5_702 VDD VDD VSS VSS gf180mcu_fd_sc_mcu7t5v0__fill_1
XTAP_TAPCELL_ROW_78_1057 VDD VSS gf180mcu_fd_sc_mcu7t5v0__filltie
XFILLER_4_234 VDD VDD VSS VSS gf180mcu_fd_sc_mcu7t5v0__fillcap_8
XFILLER_107_696 VDD VDD VSS VSS gf180mcu_fd_sc_mcu7t5v0__fillcap_4
XFILLER_106_162 VDD VDD VSS VSS gf180mcu_fd_sc_mcu7t5v0__fillcap_8
XFILLER_20_83 VDD VDD VSS VSS gf180mcu_fd_sc_mcu7t5v0__fillcap_8
XFILLER_48_411 VDD VDD VSS VSS gf180mcu_fd_sc_mcu7t5v0__fill_2
XTAP_TAPCELL_ROW_89_1164 VDD VSS gf180mcu_fd_sc_mcu7t5v0__filltie
XFILLER_29_92 VDD VDD VSS VSS gf180mcu_fd_sc_mcu7t5v0__fillcap_8
Xclkbuf_4_12_0_host_clk_i clkbuf_0_host_clk_i/Z _2828_/CLK VDD VDD VSS VSS gf180mcu_fd_sc_mcu7t5v0__clkbuf_4
XFILLER_16_341 VDD VDD VSS VSS gf180mcu_fd_sc_mcu7t5v0__fillcap_8
XFILLER_31_300 VDD VDD VSS VSS gf180mcu_fd_sc_mcu7t5v0__fill_1
XFILLER_45_80 VDD VDD VSS VSS gf180mcu_fd_sc_mcu7t5v0__fillcap_4
XFILLER_44_683 VDD VDD VSS VSS gf180mcu_fd_sc_mcu7t5v0__fill_1
X_2830_ _2830_/D _3408_/CLK _2830_/Q VDD VDD VSS VSS gf180mcu_fd_sc_mcu7t5v0__dffq_1
XFILLER_31_366 VDD VDD VSS VSS gf180mcu_fd_sc_mcu7t5v0__fill_2
XFILLER_12_580 VDD VDD VSS VSS gf180mcu_fd_sc_mcu7t5v0__fillcap_8
X_2761_ _3219_/Q _3301_/Q _2763_/S _3301_/D VDD VDD VSS VSS gf180mcu_fd_sc_mcu7t5v0__mux2_2
X_2692_ _2692_/A1 _2692_/A2 _3257_/D VDD VDD VSS VSS gf180mcu_fd_sc_mcu7t5v0__nand2_1
X_1712_ _2768_/Q _3281_/Q _1718_/S _2768_/D VDD VDD VSS VSS gf180mcu_fd_sc_mcu7t5v0__mux2_2
X_1643_ _3129_/Q _3128_/Q _3130_/Q _1645_/A2 VDD VDD VSS VSS gf180mcu_fd_sc_mcu7t5v0__nand3_1
XFILLER_8_584 VDD VDD VSS VSS gf180mcu_fd_sc_mcu7t5v0__fillcap_8
XFILLER_6_85 VDD VDD VSS VSS gf180mcu_fd_sc_mcu7t5v0__fillcap_4
XFILLER_98_311 VDD VDD VSS VSS gf180mcu_fd_sc_mcu7t5v0__fillcap_4
X_1574_ _3335_/Q _3360_/D _1574_/Z VDD VDD VSS VSS gf180mcu_fd_sc_mcu7t5v0__and2_1
X_3313_ _3313_/D _3369_/RN _3313_/CLK _3313_/Q VDD VDD VSS VSS gf180mcu_fd_sc_mcu7t5v0__dffsnq_1
X_3244_ _3244_/D _3328_/RN _3276_/CLK _3244_/Q VDD VDD VSS VSS gf180mcu_fd_sc_mcu7t5v0__dffrnq_1
XFILLER_79_591 VDD VDD VSS VSS gf180mcu_fd_sc_mcu7t5v0__fillcap_8
XFILLER_39_422 VDD VDD VSS VSS gf180mcu_fd_sc_mcu7t5v0__fillcap_64
X_3175_ _3175_/D _3303_/RN clkload9/I _3175_/Q VDD VDD VSS VSS gf180mcu_fd_sc_mcu7t5v0__dffrnq_1
XTAP_TAPCELL_ROW_1_248 VDD VSS gf180mcu_fd_sc_mcu7t5v0__filltie
X_2126_ _2126_/A1 _3320_/Q _2126_/B _3063_/D VDD VDD VSS VSS gf180mcu_fd_sc_mcu7t5v0__aoi21_1
XTAP_TAPCELL_ROW_37_623 VDD VSS gf180mcu_fd_sc_mcu7t5v0__filltie
XTAP_TAPCELL_ROW_65_921 VDD VSS gf180mcu_fd_sc_mcu7t5v0__filltie
X_2057_ _1606_/B _2057_/A2 _2057_/B _3035_/D VDD VDD VSS VSS gf180mcu_fd_sc_mcu7t5v0__aoi21_1
XFILLER_81_244 VDD VDD VSS VSS gf180mcu_fd_sc_mcu7t5v0__fillcap_16
XFILLER_81_277 VDD VDD VSS VSS gf180mcu_fd_sc_mcu7t5v0__fill_2
XFILLER_34_193 VDD VDD VSS VSS gf180mcu_fd_sc_mcu7t5v0__fillcap_4
XFILLER_50_664 VDD VDD VSS VSS gf180mcu_fd_sc_mcu7t5v0__fill_1
X_2959_ _2959_/D _2988_/CLK _2959_/Q VDD VDD VSS VSS gf180mcu_fd_sc_mcu7t5v0__dffq_1
XFILLER_22_399 VDD VDD VSS VSS gf180mcu_fd_sc_mcu7t5v0__fill_2
XTAP_TAPCELL_ROW_9_326 VDD VSS gf180mcu_fd_sc_mcu7t5v0__filltie
XFILLER_106_53 VDD VDD VSS VSS gf180mcu_fd_sc_mcu7t5v0__fillcap_8
XFILLER_58_753 VDD VDD VSS VSS gf180mcu_fd_sc_mcu7t5v0__fillcap_8
XFILLER_66_57 VDD VDD VSS VSS gf180mcu_fd_sc_mcu7t5v0__fillcap_4
XFILLER_72_244 VDD VDD VSS VSS gf180mcu_fd_sc_mcu7t5v0__fill_1
XFILLER_25_160 VDD VDD VSS VSS gf180mcu_fd_sc_mcu7t5v0__fill_1
XFILLER_13_322 VDD VDD VSS VSS gf180mcu_fd_sc_mcu7t5v0__fill_1
XFILLER_15_72 VDD VDD VSS VSS gf180mcu_fd_sc_mcu7t5v0__fillcap_4
XFILLER_9_304 VDD VDD VSS VSS gf180mcu_fd_sc_mcu7t5v0__fillcap_4
XTAP_TAPCELL_ROW_71_979 VDD VSS gf180mcu_fd_sc_mcu7t5v0__filltie
XFILLER_9_348 VDD VDD VSS VSS gf180mcu_fd_sc_mcu7t5v0__fill_2
XFILLER_40_174 VDD VDD VSS VSS gf180mcu_fd_sc_mcu7t5v0__fill_1
XFILLER_107_471 VDD VDD VSS VSS gf180mcu_fd_sc_mcu7t5v0__fillcap_4
XFILLER_68_517 VDD VDD VSS VSS gf180mcu_fd_sc_mcu7t5v0__fillcap_8
XFILLER_95_358 VDD VDD VSS VSS gf180mcu_fd_sc_mcu7t5v0__fillcap_32
XFILLER_76_594 VDD VDD VSS VSS gf180mcu_fd_sc_mcu7t5v0__fill_1
XFILLER_36_403 VDD VDD VSS VSS gf180mcu_fd_sc_mcu7t5v0__fillcap_8
XFILLER_51_428 VDD VDD VSS VSS gf180mcu_fd_sc_mcu7t5v0__fill_1
XFILLER_32_675 VDD VDD VSS VSS gf180mcu_fd_sc_mcu7t5v0__fill_1
X_2813_ _2813_/D _2893_/CLK _2813_/Q VDD VDD VSS VSS gf180mcu_fd_sc_mcu7t5v0__dffq_1
XFILLER_82_2 VDD VDD VSS VSS gf180mcu_fd_sc_mcu7t5v0__fillcap_4
XTAP_TAPCELL_ROW_42_670 VDD VSS gf180mcu_fd_sc_mcu7t5v0__filltie
XTAP_TAPCELL_ROW_14_383 VDD VSS gf180mcu_fd_sc_mcu7t5v0__filltie
XFILLER_8_381 VDD VDD VSS VSS gf180mcu_fd_sc_mcu7t5v0__fillcap_4
X_2744_ _3219_/Q _3285_/Q _2746_/S _3285_/D VDD VDD VSS VSS gf180mcu_fd_sc_mcu7t5v0__mux2_2
X_2675_ _2958_/Q _2950_/Q _2942_/Q _2934_/Q _2675_/S0 _2675_/S1 _2675_/Z VDD VDD VSS
+ VSS gf180mcu_fd_sc_mcu7t5v0__mux4_1
X_1626_ _1628_/A1 _3415_/D _2197_/A1 _2427_/B VDD VDD VSS VSS gf180mcu_fd_sc_mcu7t5v0__nor3_1
X_1557_ _3052_/Q _1556_/Z _1562_/C VDD VDD VSS VSS gf180mcu_fd_sc_mcu7t5v0__nor2_1
XFILLER_86_314 VDD VDD VSS VSS gf180mcu_fd_sc_mcu7t5v0__fill_1
XFILLER_98_196 VDD VDD VSS VSS gf180mcu_fd_sc_mcu7t5v0__fillcap_16
XFILLER_86_336 VDD VDD VSS VSS gf180mcu_fd_sc_mcu7t5v0__fillcap_32
XFILLER_86_325 VDD VDD VSS VSS gf180mcu_fd_sc_mcu7t5v0__fill_2
X_1488_ _3364_/Q _1494_/A2 _1879_/A2 VDD VDD VSS VSS gf180mcu_fd_sc_mcu7t5v0__nand2_1
X_3227_ _3227_/D _3328_/RN _3240_/CLK _3227_/Q VDD VDD VSS VSS gf180mcu_fd_sc_mcu7t5v0__dffrnq_1
X_3158_ _3158_/D _3369_/RN _3329_/CLK _3158_/Q VDD VDD VSS VSS gf180mcu_fd_sc_mcu7t5v0__dffrnq_1
XFILLER_36_27 VDD VDD VSS VSS gf180mcu_fd_sc_mcu7t5v0__fillcap_8
XFILLER_82_542 VDD VDD VSS VSS gf180mcu_fd_sc_mcu7t5v0__fillcap_32
X_2109_ _3308_/Q _3311_/Q _2420_/B _2110_/A3 VDD VDD VSS VSS gf180mcu_fd_sc_mcu7t5v0__nor3_1
XTAP_TAPCELL_ROW_107_1359 VDD VSS gf180mcu_fd_sc_mcu7t5v0__filltie
XFILLER_82_597 VDD VDD VSS VSS gf180mcu_fd_sc_mcu7t5v0__fillcap_8
X_3089_ _3089_/D _3328_/RN _3271_/CLK _3089_/Q VDD VDD VSS VSS gf180mcu_fd_sc_mcu7t5v0__dffrnq_1
XFILLER_70_737 VDD VDD VSS VSS gf180mcu_fd_sc_mcu7t5v0__fillcap_16
XFILLER_52_37 VDD VDD VSS VSS gf180mcu_fd_sc_mcu7t5v0__fillcap_4
XFILLER_50_472 VDD VDD VSS VSS gf180mcu_fd_sc_mcu7t5v0__fillcap_8
XFILLER_2_524 VDD VDD VSS VSS gf180mcu_fd_sc_mcu7t5v0__fill_1
XFILLER_77_347 VDD VDD VSS VSS gf180mcu_fd_sc_mcu7t5v0__fill_2
XFILLER_92_317 VDD VDD VSS VSS gf180mcu_fd_sc_mcu7t5v0__fillcap_4
XFILLER_18_403 VDD VDD VSS VSS gf180mcu_fd_sc_mcu7t5v0__fillcap_4
XFILLER_93_66 VDD VDD VSS VSS gf180mcu_fd_sc_mcu7t5v0__fillcap_4
XTAP_TAPCELL_ROW_86_1134 VDD VSS gf180mcu_fd_sc_mcu7t5v0__filltie
XFILLER_46_745 VDD VDD VSS VSS gf180mcu_fd_sc_mcu7t5v0__fillcap_16
XFILLER_93_88 VDD VDD VSS VSS gf180mcu_fd_sc_mcu7t5v0__fillcap_8
XFILLER_26_60 VDD VDD VSS VSS gf180mcu_fd_sc_mcu7t5v0__fillcap_4
XFILLER_60_247 VDD VDD VSS VSS gf180mcu_fd_sc_mcu7t5v0__fillcap_8
XFILLER_14_664 VDD VDD VSS VSS gf180mcu_fd_sc_mcu7t5v0__fill_1
XTAP_TAPCELL_ROW_11_353 VDD VSS gf180mcu_fd_sc_mcu7t5v0__filltie
XTAP_TAPCELL_ROW_97_1252 VDD VSS gf180mcu_fd_sc_mcu7t5v0__filltie
X_2460_ _3259_/Q _2467_/B1 _3157_/Q _2462_/B1 VDD VDD VSS VSS gf180mcu_fd_sc_mcu7t5v0__aoi21_1
XFILLER_107_290 VDD VDD VSS VSS gf180mcu_fd_sc_mcu7t5v0__fill_1
X_1411_ _3104_/Q _2179_/A1 VDD VDD VSS VSS gf180mcu_fd_sc_mcu7t5v0__clkinv_1
X_2391_ _2405_/S _2390_/Z _2392_/A3 VDD VDD VSS VSS gf180mcu_fd_sc_mcu7t5v0__nand2_1
XFILLER_96_634 VDD VDD VSS VSS gf180mcu_fd_sc_mcu7t5v0__fillcap_16
XFILLER_96_667 VDD VDD VSS VSS gf180mcu_fd_sc_mcu7t5v0__fill_2
XFILLER_95_133 VDD VDD VSS VSS gf180mcu_fd_sc_mcu7t5v0__fillcap_4
XFILLER_83_306 VDD VDD VSS VSS gf180mcu_fd_sc_mcu7t5v0__fill_2
X_3012_ _3012_/D _3021_/CLK _3012_/Q VDD VDD VSS VSS gf180mcu_fd_sc_mcu7t5v0__dffq_1
XFILLER_49_583 VDD VDD VSS VSS gf180mcu_fd_sc_mcu7t5v0__fill_1
XTAP_TAPCELL_ROW_19_431 VDD VSS gf180mcu_fd_sc_mcu7t5v0__filltie
XFILLER_64_597 VDD VDD VSS VSS gf180mcu_fd_sc_mcu7t5v0__fillcap_8
XFILLER_20_601 VDD VDD VSS VSS gf180mcu_fd_sc_mcu7t5v0__fill_1
XFILLER_20_667 VDD VDD VSS VSS gf180mcu_fd_sc_mcu7t5v0__fillcap_16
X_2727_ _3275_/Q _2680_/C _2729_/B1 _3093_/Q _2728_/A2 VDD VDD VSS VSS gf180mcu_fd_sc_mcu7t5v0__aoi22_1
XFILLER_106_739 VDD VDD VSS VSS gf180mcu_fd_sc_mcu7t5v0__fill_1
X_2658_ _2132_/I _2680_/A1 _2658_/Z VDD VDD VSS VSS gf180mcu_fd_sc_mcu7t5v0__and2_1
X_1609_ _3322_/Q _1609_/A2 _3327_/Q _2481_/A1 VDD VDD VSS VSS gf180mcu_fd_sc_mcu7t5v0__nor3_1
X_2589_ _3340_/Q _2734_/A3 _2677_/B2 VDD VDD VSS VSS gf180mcu_fd_sc_mcu7t5v0__nor2_1
XFILLER_101_422 VDD VDD VSS VSS gf180mcu_fd_sc_mcu7t5v0__fillcap_32
XFILLER_59_314 VDD VDD VSS VSS gf180mcu_fd_sc_mcu7t5v0__fill_2
XFILLER_101_488 VDD VDD VSS VSS gf180mcu_fd_sc_mcu7t5v0__fill_2
XFILLER_86_177 VDD VDD VSS VSS gf180mcu_fd_sc_mcu7t5v0__fillcap_8
XFILLER_74_317 VDD VDD VSS VSS gf180mcu_fd_sc_mcu7t5v0__fillcap_8
XFILLER_28_734 VDD VDD VSS VSS gf180mcu_fd_sc_mcu7t5v0__fill_1
XFILLER_55_531 VDD VDD VSS VSS gf180mcu_fd_sc_mcu7t5v0__fillcap_16
XFILLER_27_277 VDD VDD VSS VSS gf180mcu_fd_sc_mcu7t5v0__fill_2
XFILLER_63_58 VDD VDD VSS VSS gf180mcu_fd_sc_mcu7t5v0__fillcap_8
XFILLER_42_247 VDD VDD VSS VSS gf180mcu_fd_sc_mcu7t5v0__fillcap_8
XFILLER_11_623 VDD VDD VSS VSS gf180mcu_fd_sc_mcu7t5v0__fillcap_4
XTAP_TAPCELL_ROW_53_787 VDD VSS gf180mcu_fd_sc_mcu7t5v0__filltie
XTAP_TAPCELL_ROW_81_1086 VDD VSS gf180mcu_fd_sc_mcu7t5v0__filltie
XFILLER_7_616 VDD VDD VSS VSS gf180mcu_fd_sc_mcu7t5v0__fillcap_8
XFILLER_10_177 VDD VDD VSS VSS gf180mcu_fd_sc_mcu7t5v0__fill_1
XFILLER_10_155 VDD VDD VSS VSS gf180mcu_fd_sc_mcu7t5v0__fillcap_8
XFILLER_6_148 VDD VDD VSS VSS gf180mcu_fd_sc_mcu7t5v0__fillcap_4
XFILLER_88_33 VDD VDD VSS VSS gf180mcu_fd_sc_mcu7t5v0__fill_2
XFILLER_105_761 VDD VDD VSS VSS gf180mcu_fd_sc_mcu7t5v0__fillcap_4
XFILLER_104_271 VDD VDD VSS VSS gf180mcu_fd_sc_mcu7t5v0__fillcap_4
XFILLER_88_99 VDD VDD VSS VSS gf180mcu_fd_sc_mcu7t5v0__fillcap_4
XFILLER_78_634 VDD VDD VSS VSS gf180mcu_fd_sc_mcu7t5v0__fillcap_4
XFILLER_2_387 VDD VDD VSS VSS gf180mcu_fd_sc_mcu7t5v0__fillcap_16
XFILLER_38_509 VDD VDD VSS VSS gf180mcu_fd_sc_mcu7t5v0__fill_1
XFILLER_77_199 VDD VDD VSS VSS gf180mcu_fd_sc_mcu7t5v0__fillcap_4
XFILLER_18_244 VDD VDD VSS VSS gf180mcu_fd_sc_mcu7t5v0__fill_1
XFILLER_61_512 VDD VDD VSS VSS gf180mcu_fd_sc_mcu7t5v0__fill_2
XTAP_TAPCELL_ROW_16_401 VDD VSS gf180mcu_fd_sc_mcu7t5v0__filltie
XFILLER_46_597 VDD VDD VSS VSS gf180mcu_fd_sc_mcu7t5v0__fillcap_8
X_1960_ _3116_/Q _2980_/Q _1962_/S _2980_/D VDD VDD VSS VSS gf180mcu_fd_sc_mcu7t5v0__mux2_2
X_1891_ _3112_/Q _2920_/Q _1897_/S _2920_/D VDD VDD VSS VSS gf180mcu_fd_sc_mcu7t5v0__mux2_2
X_2512_ _3175_/Q _3152_/Q _2540_/S _3175_/D VDD VDD VSS VSS gf180mcu_fd_sc_mcu7t5v0__mux2_2
X_2443_ _3161_/Q _3160_/Q _2445_/A3 _2443_/Z VDD VDD VSS VSS gf180mcu_fd_sc_mcu7t5v0__and3_1
XFILLER_45_2 VDD VDD VSS VSS gf180mcu_fd_sc_mcu7t5v0__fillcap_16
X_2374_ _2372_/Z _2373_/Z _3394_/Q _2374_/Z VDD VDD VSS VSS gf180mcu_fd_sc_mcu7t5v0__mux2_2
XFILLER_96_442 VDD VDD VSS VSS gf180mcu_fd_sc_mcu7t5v0__fillcap_8
XFILLER_96_497 VDD VDD VSS VSS gf180mcu_fd_sc_mcu7t5v0__fill_1
XFILLER_84_626 VDD VDD VSS VSS gf180mcu_fd_sc_mcu7t5v0__fill_2
XFILLER_56_317 VDD VDD VSS VSS gf180mcu_fd_sc_mcu7t5v0__fillcap_8
XFILLER_68_177 VDD VDD VSS VSS gf180mcu_fd_sc_mcu7t5v0__fillcap_16
XFILLER_25_726 VDD VDD VSS VSS gf180mcu_fd_sc_mcu7t5v0__fill_2
XTAP_TAPCELL_ROW_104_1329 VDD VSS gf180mcu_fd_sc_mcu7t5v0__filltie
XFILLER_92_681 VDD VDD VSS VSS gf180mcu_fd_sc_mcu7t5v0__fillcap_16
XFILLER_32_280 VDD VDD VSS VSS gf180mcu_fd_sc_mcu7t5v0__fill_1
XTAP_TAPCELL_ROW_50_757 VDD VSS gf180mcu_fd_sc_mcu7t5v0__filltie
XFILLER_102_753 VDD VDD VSS VSS gf180mcu_fd_sc_mcu7t5v0__fillcap_8
XFILLER_75_626 VDD VDD VSS VSS gf180mcu_fd_sc_mcu7t5v0__fillcap_4
XFILLER_59_166 VDD VDD VSS VSS gf180mcu_fd_sc_mcu7t5v0__fill_1
XFILLER_75_648 VDD VDD VSS VSS gf180mcu_fd_sc_mcu7t5v0__fillcap_4
XTAP_TAPCELL_ROW_58_846 VDD VSS gf180mcu_fd_sc_mcu7t5v0__filltie
Xclkbuf_leaf_30_clk_i clkload5/I _2958_/CLK VDD VDD VSS VSS gf180mcu_fd_sc_mcu7t5v0__clkbuf_4
XTAP_TAPCELL_ROW_83_1104 VDD VSS gf180mcu_fd_sc_mcu7t5v0__filltie
XFILLER_16_737 VDD VDD VSS VSS gf180mcu_fd_sc_mcu7t5v0__fillcap_16
XFILLER_28_597 VDD VDD VSS VSS gf180mcu_fd_sc_mcu7t5v0__fillcap_8
XFILLER_90_34 VDD VDD VSS VSS gf180mcu_fd_sc_mcu7t5v0__fill_1
Xclkbuf_leaf_45_clk_i clkload3/I _3313_/CLK VDD VDD VSS VSS gf180mcu_fd_sc_mcu7t5v0__clkbuf_4
XFILLER_23_72 VDD VDD VSS VSS gf180mcu_fd_sc_mcu7t5v0__fillcap_8
XTAP_TAPCELL_ROW_94_1222 VDD VSS gf180mcu_fd_sc_mcu7t5v0__filltie
XFILLER_98_729 VDD VDD VSS VSS gf180mcu_fd_sc_mcu7t5v0__fillcap_4
XFILLER_105_580 VDD VDD VSS VSS gf180mcu_fd_sc_mcu7t5v0__fill_2
XFILLER_97_239 VDD VDD VSS VSS gf180mcu_fd_sc_mcu7t5v0__fillcap_16
XFILLER_97_228 VDD VDD VSS VSS gf180mcu_fd_sc_mcu7t5v0__fill_2
XFILLER_38_317 VDD VDD VSS VSS gf180mcu_fd_sc_mcu7t5v0__fillcap_4
X_2090_ _3295_/Q _2090_/A2 _2092_/B1 VDD VDD VSS VSS gf180mcu_fd_sc_mcu7t5v0__nand2_1
XFILLER_93_489 VDD VDD VSS VSS gf180mcu_fd_sc_mcu7t5v0__fill_1
XFILLER_81_629 VDD VDD VSS VSS gf180mcu_fd_sc_mcu7t5v0__fill_1
XFILLER_19_553 VDD VDD VSS VSS gf180mcu_fd_sc_mcu7t5v0__fillcap_4
X_2992_ _2992_/D _3016_/CLK _2992_/Q VDD VDD VSS VSS gf180mcu_fd_sc_mcu7t5v0__dffq_1
X_1943_ _2965_/Q _3117_/Q _1944_/S _2965_/D VDD VDD VSS VSS gf180mcu_fd_sc_mcu7t5v0__mux2_2
X_1874_ _2907_/Q _3115_/Q _1877_/S _2907_/D VDD VDD VSS VSS gf180mcu_fd_sc_mcu7t5v0__mux2_2
X_2426_ _2426_/A1 _2198_/B _2427_/A2 VDD VDD VSS VSS gf180mcu_fd_sc_mcu7t5v0__nand2_1
XFILLER_88_239 VDD VDD VSS VSS gf180mcu_fd_sc_mcu7t5v0__fill_1
XFILLER_88_228 VDD VDD VSS VSS gf180mcu_fd_sc_mcu7t5v0__fill_1
XFILLER_29_328 VDD VDD VSS VSS gf180mcu_fd_sc_mcu7t5v0__fillcap_4
X_2357_ _2409_/A1 _2357_/A2 _2357_/B _3135_/D VDD VDD VSS VSS gf180mcu_fd_sc_mcu7t5v0__oai21_1
X_2288_ _3415_/D _1702_/C _2288_/A3 _2288_/B _3125_/D VDD VDD VSS VSS gf180mcu_fd_sc_mcu7t5v0__oai31_1
XFILLER_57_648 VDD VDD VSS VSS gf180mcu_fd_sc_mcu7t5v0__fill_2
XTAP_TAPCELL_ROW_55_816 VDD VSS gf180mcu_fd_sc_mcu7t5v0__filltie
XTAP_TAPCELL_ROW_27_518 VDD VSS gf180mcu_fd_sc_mcu7t5v0__filltie
XFILLER_71_139 VDD VDD VSS VSS gf180mcu_fd_sc_mcu7t5v0__fill_1
XFILLER_25_578 VDD VDD VSS VSS gf180mcu_fd_sc_mcu7t5v0__fillcap_8
XTAP_TAPCELL_ROW_63_893 VDD VSS gf180mcu_fd_sc_mcu7t5v0__filltie
XFILLER_21_762 VDD VDD VSS VSS gf180mcu_fd_sc_mcu7t5v0__fill_2
XFILLER_60_37 VDD VDD VSS VSS gf180mcu_fd_sc_mcu7t5v0__fill_1
XFILLER_106_333 VDD VDD VSS VSS gf180mcu_fd_sc_mcu7t5v0__fillcap_4
XFILLER_4_438 VDD VDD VSS VSS gf180mcu_fd_sc_mcu7t5v0__fill_2
XFILLER_79_206 VDD VDD VSS VSS gf180mcu_fd_sc_mcu7t5v0__fillcap_4
XFILLER_0_699 VDD VDD VSS VSS gf180mcu_fd_sc_mcu7t5v0__fillcap_8
XFILLER_102_594 VDD VDD VSS VSS gf180mcu_fd_sc_mcu7t5v0__fill_1
XFILLER_87_294 VDD VDD VSS VSS gf180mcu_fd_sc_mcu7t5v0__fill_2
XFILLER_85_45 VDD VDD VSS VSS gf180mcu_fd_sc_mcu7t5v0__fillcap_4
XFILLER_47_136 VDD VDD VSS VSS gf180mcu_fd_sc_mcu7t5v0__fillcap_4
XFILLER_75_489 VDD VDD VSS VSS gf180mcu_fd_sc_mcu7t5v0__fill_1
XFILLER_16_523 VDD VDD VSS VSS gf180mcu_fd_sc_mcu7t5v0__fill_2
XFILLER_62_117 VDD VDD VSS VSS gf180mcu_fd_sc_mcu7t5v0__fill_1
XFILLER_62_139 VDD VDD VSS VSS gf180mcu_fd_sc_mcu7t5v0__fillcap_8
XFILLER_70_150 VDD VDD VSS VSS gf180mcu_fd_sc_mcu7t5v0__fill_2
XFILLER_31_559 VDD VDD VSS VSS gf180mcu_fd_sc_mcu7t5v0__fill_1
XFILLER_11_250 VDD VDD VSS VSS gf180mcu_fd_sc_mcu7t5v0__fill_2
X_1590_ _3378_/Q _3403_/D _1596_/A2 VDD VDD VSS VSS gf180mcu_fd_sc_mcu7t5v0__xnor2_1
X_3260_ _3260_/D _3328_/RN _3271_/CLK _3260_/Q VDD VDD VSS VSS gf180mcu_fd_sc_mcu7t5v0__dffrnq_1
XFILLER_94_721 VDD VDD VSS VSS gf180mcu_fd_sc_mcu7t5v0__fillcap_8
X_2211_ _2405_/S _2210_/Z _2378_/B _2212_/B2 VDD VDD VSS VSS gf180mcu_fd_sc_mcu7t5v0__aoi21_1
X_3191_ _3191_/D _3328_/RN clkload7/I _3191_/Q VDD VDD VSS VSS gf180mcu_fd_sc_mcu7t5v0__dffrnq_1
XFILLER_38_103 VDD VDD VSS VSS gf180mcu_fd_sc_mcu7t5v0__fill_2
XFILLER_39_648 VDD VDD VSS VSS gf180mcu_fd_sc_mcu7t5v0__fillcap_8
X_2142_ _3221_/Q _3071_/Q _2166_/S _3071_/D VDD VDD VSS VSS gf180mcu_fd_sc_mcu7t5v0__mux2_2
XFILLER_54_607 VDD VDD VSS VSS gf180mcu_fd_sc_mcu7t5v0__fill_1
X_2073_ _2329_/A2 _2091_/B _2085_/B1 _2073_/B2 _3042_/D VDD VDD VSS VSS gf180mcu_fd_sc_mcu7t5v0__aoi22_1
XFILLER_81_415 VDD VDD VSS VSS gf180mcu_fd_sc_mcu7t5v0__fillcap_4
XFILLER_62_640 VDD VDD VSS VSS gf180mcu_fd_sc_mcu7t5v0__fillcap_16
XFILLER_62_684 VDD VDD VSS VSS gf180mcu_fd_sc_mcu7t5v0__fillcap_16
X_2975_ _2975_/D _3016_/CLK _2975_/Q VDD VDD VSS VSS gf180mcu_fd_sc_mcu7t5v0__dffq_1
XTAP_TAPCELL_ROW_32_565 VDD VSS gf180mcu_fd_sc_mcu7t5v0__filltie
XTAP_TAPCELL_ROW_60_863 VDD VSS gf180mcu_fd_sc_mcu7t5v0__filltie
X_1926_ _2000_/A1 _1926_/A2 _1934_/S VDD VDD VSS VSS gf180mcu_fd_sc_mcu7t5v0__nand2_1
X_1857_ _3285_/Q _2892_/Q _1859_/S _2892_/D VDD VDD VSS VSS gf180mcu_fd_sc_mcu7t5v0__mux2_2
X_1788_ _3280_/Q _2831_/Q _1795_/S _2831_/D VDD VDD VSS VSS gf180mcu_fd_sc_mcu7t5v0__mux2_2
X_3389_ hold61/Z input1/Z _3399_/CLK _3389_/Q VDD VDD VSS VSS gf180mcu_fd_sc_mcu7t5v0__dffrnq_1
XFILLER_85_710 VDD VDD VSS VSS gf180mcu_fd_sc_mcu7t5v0__fillcap_4
XFILLER_76_209 VDD VDD VSS VSS gf180mcu_fd_sc_mcu7t5v0__fill_2
X_2409_ _2409_/A1 _2409_/A2 _2409_/B _3139_/D VDD VDD VSS VSS gf180mcu_fd_sc_mcu7t5v0__oai21_1
XTAP_TAPCELL_ROW_4_279 VDD VSS gf180mcu_fd_sc_mcu7t5v0__filltie
XTAP_TAPCELL_ROW_68_952 VDD VSS gf180mcu_fd_sc_mcu7t5v0__filltie
XFILLER_38_681 VDD VDD VSS VSS gf180mcu_fd_sc_mcu7t5v0__fill_1
XFILLER_45_629 VDD VDD VSS VSS gf180mcu_fd_sc_mcu7t5v0__fill_1
XFILLER_13_504 VDD VDD VSS VSS gf180mcu_fd_sc_mcu7t5v0__fill_2
XFILLER_13_559 VDD VDD VSS VSS gf180mcu_fd_sc_mcu7t5v0__fill_1
XFILLER_40_312 VDD VDD VSS VSS gf180mcu_fd_sc_mcu7t5v0__fill_2
XTAP_TAPCELL_ROW_78_1058 VDD VSS gf180mcu_fd_sc_mcu7t5v0__filltie
XFILLER_20_51 VDD VDD VSS VSS gf180mcu_fd_sc_mcu7t5v0__fillcap_32
XFILLER_106_174 VDD VDD VSS VSS gf180mcu_fd_sc_mcu7t5v0__fill_1
XFILLER_96_22 VDD VDD VSS VSS gf180mcu_fd_sc_mcu7t5v0__fill_2
XFILLER_88_592 VDD VDD VSS VSS gf180mcu_fd_sc_mcu7t5v0__fill_2
XFILLER_91_702 VDD VDD VSS VSS gf180mcu_fd_sc_mcu7t5v0__fill_2
XFILLER_75_253 VDD VDD VSS VSS gf180mcu_fd_sc_mcu7t5v0__fillcap_16
Xhold60 hold60/I hold60/Z VDD VDD VSS VSS gf180mcu_fd_sc_mcu7t5v0__dlyc_1
XFILLER_90_201 VDD VDD VSS VSS gf180mcu_fd_sc_mcu7t5v0__fill_2
XTAP_TAPCELL_ROW_89_1165 VDD VSS gf180mcu_fd_sc_mcu7t5v0__filltie
XFILLER_75_286 VDD VDD VSS VSS gf180mcu_fd_sc_mcu7t5v0__fill_2
XFILLER_63_426 VDD VDD VSS VSS gf180mcu_fd_sc_mcu7t5v0__fill_2
XFILLER_90_234 VDD VDD VSS VSS gf180mcu_fd_sc_mcu7t5v0__fill_1
XFILLER_35_139 VDD VDD VSS VSS gf180mcu_fd_sc_mcu7t5v0__fill_1
XFILLER_71_492 VDD VDD VSS VSS gf180mcu_fd_sc_mcu7t5v0__fill_2
XFILLER_84_6 VDD VDD VSS VSS gf180mcu_fd_sc_mcu7t5v0__fill_2
X_2760_ _3218_/Q _3300_/Q _2760_/S _3300_/D VDD VDD VSS VSS gf180mcu_fd_sc_mcu7t5v0__mux2_2
XFILLER_12_592 VDD VDD VSS VSS gf180mcu_fd_sc_mcu7t5v0__fill_2
X_2691_ _3146_/Q _2732_/A3 _2603_/Z _2692_/A2 VDD VDD VSS VSS gf180mcu_fd_sc_mcu7t5v0__nand3_1
X_1711_ _2767_/Q _3280_/Q _1718_/S _2767_/D VDD VDD VSS VSS gf180mcu_fd_sc_mcu7t5v0__mux2_2
X_1642_ _3128_/Q _3130_/Q _2227_/A2 VDD VDD VSS VSS gf180mcu_fd_sc_mcu7t5v0__nand2_1
X_1573_ _1520_/I _2585_/S _3326_/D VDD VDD VSS VSS gf180mcu_fd_sc_mcu7t5v0__nand2_1
X_3312_ _3340_/Q _3369_/RN _3326_/CLK _3313_/D VDD VDD VSS VSS gf180mcu_fd_sc_mcu7t5v0__dffsnq_1
XFILLER_100_317 VDD VDD VSS VSS gf180mcu_fd_sc_mcu7t5v0__fillcap_8
X_3243_ _3243_/D _3328_/RN _3328_/CLK _3243_/Q VDD VDD VSS VSS gf180mcu_fd_sc_mcu7t5v0__dffrnq_1
X_3174_ _3174_/D _3303_/RN _3293_/CLK _3174_/Q VDD VDD VSS VSS gf180mcu_fd_sc_mcu7t5v0__dffrnq_1
XFILLER_94_573 VDD VDD VSS VSS gf180mcu_fd_sc_mcu7t5v0__fillcap_8
XFILLER_82_713 VDD VDD VSS VSS gf180mcu_fd_sc_mcu7t5v0__fillcap_16
XFILLER_81_212 VDD VDD VSS VSS gf180mcu_fd_sc_mcu7t5v0__fillcap_32
XTAP_TAPCELL_ROW_1_249 VDD VSS gf180mcu_fd_sc_mcu7t5v0__filltie
XFILLER_27_629 VDD VDD VSS VSS gf180mcu_fd_sc_mcu7t5v0__fill_1
X_2125_ _3212_/Q _2602_/A2 _2126_/B VDD VDD VSS VSS gf180mcu_fd_sc_mcu7t5v0__nand2_1
XTAP_TAPCELL_ROW_37_624 VDD VSS gf180mcu_fd_sc_mcu7t5v0__filltie
XFILLER_54_437 VDD VDD VSS VSS gf180mcu_fd_sc_mcu7t5v0__fill_2
X_2056_ _2023_/B _2055_/Z _2057_/B VDD VDD VSS VSS gf180mcu_fd_sc_mcu7t5v0__nand2_1
XFILLER_34_172 VDD VDD VSS VSS gf180mcu_fd_sc_mcu7t5v0__fill_2
X_2958_ _2958_/D _2958_/CLK _2958_/Q VDD VDD VSS VSS gf180mcu_fd_sc_mcu7t5v0__dffq_1
X_1909_ _3111_/Q _2935_/Q _1916_/S _2935_/D VDD VDD VSS VSS gf180mcu_fd_sc_mcu7t5v0__mux2_2
X_2889_ _2889_/D _2891_/CLK _2889_/Q VDD VDD VSS VSS gf180mcu_fd_sc_mcu7t5v0__dffq_1
XTAP_TAPCELL_ROW_9_327 VDD VSS gf180mcu_fd_sc_mcu7t5v0__filltie
XFILLER_103_133 VDD VDD VSS VSS gf180mcu_fd_sc_mcu7t5v0__fillcap_4
XFILLER_89_345 VDD VDD VSS VSS gf180mcu_fd_sc_mcu7t5v0__fillcap_4
XFILLER_85_562 VDD VDD VSS VSS gf180mcu_fd_sc_mcu7t5v0__fillcap_4
XFILLER_73_702 VDD VDD VSS VSS gf180mcu_fd_sc_mcu7t5v0__fillcap_8
XFILLER_57_275 VDD VDD VSS VSS gf180mcu_fd_sc_mcu7t5v0__fillcap_4
XFILLER_17_139 VDD VDD VSS VSS gf180mcu_fd_sc_mcu7t5v0__fill_1
XFILLER_72_267 VDD VDD VSS VSS gf180mcu_fd_sc_mcu7t5v0__fill_1
XFILLER_41_632 VDD VDD VSS VSS gf180mcu_fd_sc_mcu7t5v0__fillcap_8
XFILLER_53_492 VDD VDD VSS VSS gf180mcu_fd_sc_mcu7t5v0__fillcap_8
XFILLER_13_345 VDD VDD VSS VSS gf180mcu_fd_sc_mcu7t5v0__fillcap_4
XFILLER_41_654 VDD VDD VSS VSS gf180mcu_fd_sc_mcu7t5v0__fill_2
XFILLER_13_378 VDD VDD VSS VSS gf180mcu_fd_sc_mcu7t5v0__fill_1
XFILLER_5_500 VDD VDD VSS VSS gf180mcu_fd_sc_mcu7t5v0__fillcap_4
XFILLER_95_304 VDD VDD VSS VSS gf180mcu_fd_sc_mcu7t5v0__fillcap_8
XFILLER_1_750 VDD VDD VSS VSS gf180mcu_fd_sc_mcu7t5v0__fillcap_8
XFILLER_95_348 VDD VDD VSS VSS gf180mcu_fd_sc_mcu7t5v0__fill_2
XFILLER_95_337 VDD VDD VSS VSS gf180mcu_fd_sc_mcu7t5v0__fill_2
XFILLER_0_282 VDD VDD VSS VSS gf180mcu_fd_sc_mcu7t5v0__fill_1
XFILLER_36_415 VDD VDD VSS VSS gf180mcu_fd_sc_mcu7t5v0__fill_1
XFILLER_48_297 VDD VDD VSS VSS gf180mcu_fd_sc_mcu7t5v0__fillcap_16
XFILLER_31_142 VDD VDD VSS VSS gf180mcu_fd_sc_mcu7t5v0__fillcap_8
X_2812_ _2812_/D _2828_/CLK _2812_/Q VDD VDD VSS VSS gf180mcu_fd_sc_mcu7t5v0__dffq_1
XTAP_TAPCELL_ROW_42_671 VDD VSS gf180mcu_fd_sc_mcu7t5v0__filltie
XFILLER_75_2 VDD VDD VSS VSS gf180mcu_fd_sc_mcu7t5v0__fill_1
XTAP_TAPCELL_ROW_14_384 VDD VSS gf180mcu_fd_sc_mcu7t5v0__filltie
X_2743_ _3218_/Q _3284_/Q _2746_/S _3284_/D VDD VDD VSS VSS gf180mcu_fd_sc_mcu7t5v0__mux2_2
X_2674_ _2926_/Q _2918_/Q _2910_/Q _2902_/Q _2674_/S0 _2674_/S1 _2674_/Z VDD VDD VSS
+ VSS gf180mcu_fd_sc_mcu7t5v0__mux4_1
X_1625_ _3415_/Q _3418_/Q _1625_/Z VDD VDD VSS VSS gf180mcu_fd_sc_mcu7t5v0__and2_1
XFILLER_99_632 VDD VDD VSS VSS gf180mcu_fd_sc_mcu7t5v0__fillcap_8
X_1556_ _3053_/Q _3054_/Q _1559_/B1 _1556_/Z VDD VDD VSS VSS gf180mcu_fd_sc_mcu7t5v0__or3_1
XFILLER_99_676 VDD VDD VSS VSS gf180mcu_fd_sc_mcu7t5v0__fillcap_16
XFILLER_101_626 VDD VDD VSS VSS gf180mcu_fd_sc_mcu7t5v0__fillcap_4
X_1487_ _2245_/A1 _3369_/Q _1494_/A2 VDD VDD VSS VSS gf180mcu_fd_sc_mcu7t5v0__nor2_1
X_3226_ _3226_/D _3328_/RN _3273_/CLK _3226_/Q VDD VDD VSS VSS gf180mcu_fd_sc_mcu7t5v0__dffrnq_1
XFILLER_55_702 VDD VDD VSS VSS gf180mcu_fd_sc_mcu7t5v0__fill_1
XFILLER_67_562 VDD VDD VSS VSS gf180mcu_fd_sc_mcu7t5v0__fillcap_4
XFILLER_82_510 VDD VDD VSS VSS gf180mcu_fd_sc_mcu7t5v0__fill_1
X_3157_ _3157_/D _3369_/RN _3325_/CLK _3157_/Q VDD VDD VSS VSS gf180mcu_fd_sc_mcu7t5v0__dffrnq_1
XFILLER_27_404 VDD VDD VSS VSS gf180mcu_fd_sc_mcu7t5v0__fill_1
XFILLER_67_573 VDD VDD VSS VSS gf180mcu_fd_sc_mcu7t5v0__fillcap_8
X_2108_ _3123_/Q _1548_/Z _2108_/B _2110_/A2 VDD VDD VSS VSS gf180mcu_fd_sc_mcu7t5v0__aoi21_1
X_3088_ _3088_/D _3369_/RN _3270_/CLK _3088_/Q VDD VDD VSS VSS gf180mcu_fd_sc_mcu7t5v0__dffrnq_1
XFILLER_54_267 VDD VDD VSS VSS gf180mcu_fd_sc_mcu7t5v0__fill_2
X_2039_ _2039_/A1 _2039_/A2 _2048_/A4 VDD VDD VSS VSS gf180mcu_fd_sc_mcu7t5v0__nor2_1
XFILLER_23_632 VDD VDD VSS VSS gf180mcu_fd_sc_mcu7t5v0__fillcap_8
XFILLER_35_492 VDD VDD VSS VSS gf180mcu_fd_sc_mcu7t5v0__fillcap_8
XFILLER_10_304 VDD VDD VSS VSS gf180mcu_fd_sc_mcu7t5v0__fillcap_4
XTAP_TAPCELL_ROW_75_1017 VDD VSS gf180mcu_fd_sc_mcu7t5v0__filltie
XFILLER_104_453 VDD VDD VSS VSS gf180mcu_fd_sc_mcu7t5v0__fill_2
XFILLER_89_142 VDD VDD VSS VSS gf180mcu_fd_sc_mcu7t5v0__fill_1
XFILLER_77_68 VDD VDD VSS VSS gf180mcu_fd_sc_mcu7t5v0__fill_2
XFILLER_92_329 VDD VDD VSS VSS gf180mcu_fd_sc_mcu7t5v0__fillcap_8
XTAP_TAPCELL_ROW_86_1135 VDD VSS gf180mcu_fd_sc_mcu7t5v0__filltie
XFILLER_45_212 VDD VDD VSS VSS gf180mcu_fd_sc_mcu7t5v0__fillcap_4
XFILLER_45_234 VDD VDD VSS VSS gf180mcu_fd_sc_mcu7t5v0__fill_2
XFILLER_13_142 VDD VDD VSS VSS gf180mcu_fd_sc_mcu7t5v0__fillcap_64
XFILLER_60_259 VDD VDD VSS VSS gf180mcu_fd_sc_mcu7t5v0__fill_2
XFILLER_14_687 VDD VDD VSS VSS gf180mcu_fd_sc_mcu7t5v0__fill_2
XTAP_TAPCELL_ROW_11_354 VDD VSS gf180mcu_fd_sc_mcu7t5v0__filltie
XTAP_TAPCELL_ROW_97_1253 VDD VSS gf180mcu_fd_sc_mcu7t5v0__filltie
XFILLER_5_352 VDD VDD VSS VSS gf180mcu_fd_sc_mcu7t5v0__fillcap_16
X_1410_ _3305_/Q _2431_/A2 VDD VDD VSS VSS gf180mcu_fd_sc_mcu7t5v0__clkinv_1
X_2390_ _2892_/Q _2884_/Q _2876_/Q _2868_/Q _2400_/S0 _2390_/S1 _2390_/Z VDD VDD VSS
+ VSS gf180mcu_fd_sc_mcu7t5v0__mux4_1
XFILLER_95_189 VDD VDD VSS VSS gf180mcu_fd_sc_mcu7t5v0__fillcap_16
XFILLER_95_178 VDD VDD VSS VSS gf180mcu_fd_sc_mcu7t5v0__fill_2
X_3011_ _3011_/D _3022_/CLK _3011_/Q VDD VDD VSS VSS gf180mcu_fd_sc_mcu7t5v0__dffq_1
XFILLER_37_702 VDD VDD VSS VSS gf180mcu_fd_sc_mcu7t5v0__fillcap_16
XFILLER_49_562 VDD VDD VSS VSS gf180mcu_fd_sc_mcu7t5v0__fill_2
XFILLER_76_381 VDD VDD VSS VSS gf180mcu_fd_sc_mcu7t5v0__fillcap_4
XTAP_TAPCELL_ROW_19_432 VDD VSS gf180mcu_fd_sc_mcu7t5v0__filltie
XTAP_TAPCELL_ROW_47_730 VDD VSS gf180mcu_fd_sc_mcu7t5v0__filltie
XFILLER_24_407 VDD VDD VSS VSS gf180mcu_fd_sc_mcu7t5v0__fill_2
XFILLER_17_492 VDD VDD VSS VSS gf180mcu_fd_sc_mcu7t5v0__fill_2
XFILLER_9_680 VDD VDD VSS VSS gf180mcu_fd_sc_mcu7t5v0__fillcap_16
X_2726_ _2726_/I _3274_/D VDD VDD VSS VSS gf180mcu_fd_sc_mcu7t5v0__clkinv_1
X_2657_ _2670_/A1 _2656_/Z _2661_/C VDD VDD VSS VSS gf180mcu_fd_sc_mcu7t5v0__nand2_1
X_1608_ _3039_/Q _2031_/A2 _3416_/D VDD VDD VSS VSS gf180mcu_fd_sc_mcu7t5v0__nor2_1
X_2588_ _3206_/Q _2679_/A3 _2736_/A4 _2734_/A3 VDD VDD VSS VSS gf180mcu_fd_sc_mcu7t5v0__nand3_1
XFILLER_86_123 VDD VDD VSS VSS gf180mcu_fd_sc_mcu7t5v0__fillcap_8
X_1539_ _3308_/Q _2420_/B _1568_/B _1541_/A2 VDD VDD VSS VSS gf180mcu_fd_sc_mcu7t5v0__nor3_1
XFILLER_87_668 VDD VDD VSS VSS gf180mcu_fd_sc_mcu7t5v0__fillcap_32
XFILLER_59_348 VDD VDD VSS VSS gf180mcu_fd_sc_mcu7t5v0__fill_2
XFILLER_74_329 VDD VDD VSS VSS gf180mcu_fd_sc_mcu7t5v0__fill_2
X_3209_ _3209_/D _3328_/RN _3257_/CLK _3209_/Q VDD VDD VSS VSS gf180mcu_fd_sc_mcu7t5v0__dffrnq_1
XFILLER_67_370 VDD VDD VSS VSS gf180mcu_fd_sc_mcu7t5v0__fillcap_32
XFILLER_103_66 VDD VDD VSS VSS gf180mcu_fd_sc_mcu7t5v0__fillcap_4
XFILLER_103_88 VDD VDD VSS VSS gf180mcu_fd_sc_mcu7t5v0__fillcap_8
XFILLER_82_384 VDD VDD VSS VSS gf180mcu_fd_sc_mcu7t5v0__fill_1
XFILLER_42_237 VDD VDD VSS VSS gf180mcu_fd_sc_mcu7t5v0__fillcap_8
XFILLER_70_524 VDD VDD VSS VSS gf180mcu_fd_sc_mcu7t5v0__fill_1
XFILLER_42_259 VDD VDD VSS VSS gf180mcu_fd_sc_mcu7t5v0__fill_2
XFILLER_10_101 VDD VDD VSS VSS gf180mcu_fd_sc_mcu7t5v0__fillcap_4
XTAP_TAPCELL_ROW_53_788 VDD VSS gf180mcu_fd_sc_mcu7t5v0__filltie
XTAP_TAPCELL_ROW_81_1087 VDD VSS gf180mcu_fd_sc_mcu7t5v0__filltie
XFILLER_7_628 VDD VDD VSS VSS gf180mcu_fd_sc_mcu7t5v0__fill_2
XFILLER_2_333 VDD VDD VSS VSS gf180mcu_fd_sc_mcu7t5v0__fill_2
XFILLER_5_2 VDD VDD VSS VSS gf180mcu_fd_sc_mcu7t5v0__fillcap_64
XFILLER_77_167 VDD VDD VSS VSS gf180mcu_fd_sc_mcu7t5v0__fillcap_32
XFILLER_46_521 VDD VDD VSS VSS gf180mcu_fd_sc_mcu7t5v0__fillcap_4
XPHY_EDGE_ROW_16_Right_16 VDD VSS gf180mcu_fd_sc_mcu7t5v0__endcap
XTAP_TAPCELL_ROW_16_402 VDD VSS gf180mcu_fd_sc_mcu7t5v0__filltie
XTAP_TAPCELL_ROW_44_700 VDD VSS gf180mcu_fd_sc_mcu7t5v0__filltie
XFILLER_73_384 VDD VDD VSS VSS gf180mcu_fd_sc_mcu7t5v0__fillcap_8
XFILLER_33_237 VDD VDD VSS VSS gf180mcu_fd_sc_mcu7t5v0__fill_2
XFILLER_14_473 VDD VDD VSS VSS gf180mcu_fd_sc_mcu7t5v0__fillcap_4
XTAP_TAPCELL_ROW_24_490 VDD VSS gf180mcu_fd_sc_mcu7t5v0__filltie
X_1890_ _3111_/Q _2919_/Q _1897_/S _2919_/D VDD VDD VSS VSS gf180mcu_fd_sc_mcu7t5v0__mux2_2
XTAP_TAPCELL_ROW_101_1290 VDD VSS gf180mcu_fd_sc_mcu7t5v0__filltie
XFILLER_10_690 VDD VDD VSS VSS gf180mcu_fd_sc_mcu7t5v0__fillcap_4
XPHY_EDGE_ROW_25_Right_25 VDD VSS gf180mcu_fd_sc_mcu7t5v0__endcap
X_2511_ _3174_/Q _3151_/Q _2540_/S _3174_/D VDD VDD VSS VSS gf180mcu_fd_sc_mcu7t5v0__mux2_2
XFILLER_5_193 VDD VDD VSS VSS gf180mcu_fd_sc_mcu7t5v0__fillcap_16
X_2442_ _2492_/A1 _3160_/Q _3162_/Q _2466_/B1 VDD VDD VSS VSS gf180mcu_fd_sc_mcu7t5v0__nor3_1
X_2373_ _2827_/Q _2819_/Q _2811_/Q _2803_/Q _1439_/B _2373_/S1 _2373_/Z VDD VDD VSS
+ VSS gf180mcu_fd_sc_mcu7t5v0__mux4_1
XFILLER_38_2 VDD VDD VSS VSS gf180mcu_fd_sc_mcu7t5v0__fillcap_8
XFILLER_96_454 VDD VDD VSS VSS gf180mcu_fd_sc_mcu7t5v0__fill_1
XFILLER_68_145 VDD VDD VSS VSS gf180mcu_fd_sc_mcu7t5v0__fill_1
XFILLER_96_487 VDD VDD VSS VSS gf180mcu_fd_sc_mcu7t5v0__fillcap_8
XPHY_EDGE_ROW_34_Right_34 VDD VSS gf180mcu_fd_sc_mcu7t5v0__endcap
XTAP_TAPCELL_ROW_50_758 VDD VSS gf180mcu_fd_sc_mcu7t5v0__filltie
XFILLER_20_454 VDD VDD VSS VSS gf180mcu_fd_sc_mcu7t5v0__fill_1
XPHY_EDGE_ROW_43_Right_43 VDD VSS gf180mcu_fd_sc_mcu7t5v0__endcap
X_2709_ _3266_/Q _2680_/C _2729_/B1 _3084_/Q _2710_/A2 VDD VDD VSS VSS gf180mcu_fd_sc_mcu7t5v0__aoi22_1
XFILLER_106_548 VDD VDD VSS VSS gf180mcu_fd_sc_mcu7t5v0__fillcap_4
XPHY_EDGE_ROW_18_Left_127 VDD VSS gf180mcu_fd_sc_mcu7t5v0__endcap
XFILLER_58_37 VDD VDD VSS VSS gf180mcu_fd_sc_mcu7t5v0__fillcap_16
XFILLER_59_112 VDD VDD VSS VSS gf180mcu_fd_sc_mcu7t5v0__fillcap_4
XFILLER_87_487 VDD VDD VSS VSS gf180mcu_fd_sc_mcu7t5v0__fill_2
XPHY_EDGE_ROW_52_Right_52 VDD VSS gf180mcu_fd_sc_mcu7t5v0__endcap
XFILLER_59_156 VDD VDD VSS VSS gf180mcu_fd_sc_mcu7t5v0__fillcap_8
XTAP_TAPCELL_ROW_58_847 VDD VSS gf180mcu_fd_sc_mcu7t5v0__filltie
XFILLER_16_716 VDD VDD VSS VSS gf180mcu_fd_sc_mcu7t5v0__fillcap_16
XPHY_EDGE_ROW_27_Left_136 VDD VSS gf180mcu_fd_sc_mcu7t5v0__endcap
XTAP_TAPCELL_ROW_83_1105 VDD VSS gf180mcu_fd_sc_mcu7t5v0__filltie
XFILLER_82_170 VDD VDD VSS VSS gf180mcu_fd_sc_mcu7t5v0__fill_1
XFILLER_55_395 VDD VDD VSS VSS gf180mcu_fd_sc_mcu7t5v0__fill_1
XFILLER_70_387 VDD VDD VSS VSS gf180mcu_fd_sc_mcu7t5v0__fillcap_8
XPHY_EDGE_ROW_61_Right_61 VDD VSS gf180mcu_fd_sc_mcu7t5v0__endcap
XFILLER_11_487 VDD VDD VSS VSS gf180mcu_fd_sc_mcu7t5v0__fill_2
XFILLER_23_84 VDD VDD VSS VSS gf180mcu_fd_sc_mcu7t5v0__fill_1
XTAP_TAPCELL_ROW_94_1223 VDD VSS gf180mcu_fd_sc_mcu7t5v0__filltie
XPHY_EDGE_ROW_36_Left_145 VDD VSS gf180mcu_fd_sc_mcu7t5v0__endcap
XFILLER_2_174 VDD VDD VSS VSS gf180mcu_fd_sc_mcu7t5v0__fill_1
XPHY_EDGE_ROW_70_Right_70 VDD VSS gf180mcu_fd_sc_mcu7t5v0__endcap
XFILLER_38_329 VDD VDD VSS VSS gf180mcu_fd_sc_mcu7t5v0__fillcap_32
XPHY_EDGE_ROW_45_Left_154 VDD VSS gf180mcu_fd_sc_mcu7t5v0__endcap
XFILLER_80_107 VDD VDD VSS VSS gf180mcu_fd_sc_mcu7t5v0__fillcap_4
XFILLER_46_395 VDD VDD VSS VSS gf180mcu_fd_sc_mcu7t5v0__fill_2
X_2991_ _2991_/D _3021_/CLK _2991_/Q VDD VDD VSS VSS gf180mcu_fd_sc_mcu7t5v0__dffq_1
XFILLER_14_270 VDD VDD VSS VSS gf180mcu_fd_sc_mcu7t5v0__fill_2
XFILLER_9_42 VDD VDD VSS VSS gf180mcu_fd_sc_mcu7t5v0__fillcap_4
X_1942_ _2964_/Q _3116_/Q _1944_/S _2964_/D VDD VDD VSS VSS gf180mcu_fd_sc_mcu7t5v0__mux2_2
XFILLER_21_229 VDD VDD VSS VSS gf180mcu_fd_sc_mcu7t5v0__fill_2
XFILLER_42_590 VDD VDD VSS VSS gf180mcu_fd_sc_mcu7t5v0__fillcap_4
XFILLER_9_86 VDD VDD VSS VSS gf180mcu_fd_sc_mcu7t5v0__fill_2
X_1873_ _2906_/Q _3114_/Q _1877_/S _2906_/D VDD VDD VSS VSS gf180mcu_fd_sc_mcu7t5v0__mux2_2
XPHY_EDGE_ROW_54_Left_163 VDD VSS gf180mcu_fd_sc_mcu7t5v0__endcap
X_2425_ _2425_/A1 _2425_/A2 _3144_/D VDD VDD VSS VSS gf180mcu_fd_sc_mcu7t5v0__nand2_1
XFILLER_97_763 VDD VDD VSS VSS gf180mcu_fd_sc_mcu7t5v0__fill_2
XFILLER_69_454 VDD VDD VSS VSS gf180mcu_fd_sc_mcu7t5v0__fillcap_8
XFILLER_96_262 VDD VDD VSS VSS gf180mcu_fd_sc_mcu7t5v0__fill_1
XFILLER_56_104 VDD VDD VSS VSS gf180mcu_fd_sc_mcu7t5v0__fill_1
XPHY_EDGE_ROW_63_Left_172 VDD VSS gf180mcu_fd_sc_mcu7t5v0__endcap
X_2356_ _3134_/Q _2407_/B _2356_/B _2357_/A2 VDD VDD VSS VSS gf180mcu_fd_sc_mcu7t5v0__oai21_1
X_2287_ _2764_/Q _2288_/A3 _2287_/A3 _3125_/Q _2288_/B VDD VDD VSS VSS gf180mcu_fd_sc_mcu7t5v0__oai31_1
XFILLER_84_446 VDD VDD VSS VSS gf180mcu_fd_sc_mcu7t5v0__fillcap_8
XFILLER_84_457 VDD VDD VSS VSS gf180mcu_fd_sc_mcu7t5v0__fillcap_8
XTAP_TAPCELL_ROW_27_519 VDD VSS gf180mcu_fd_sc_mcu7t5v0__filltie
XFILLER_64_170 VDD VDD VSS VSS gf180mcu_fd_sc_mcu7t5v0__fillcap_4
XFILLER_40_527 VDD VDD VSS VSS gf180mcu_fd_sc_mcu7t5v0__fillcap_64
XFILLER_52_365 VDD VDD VSS VSS gf180mcu_fd_sc_mcu7t5v0__fillcap_4
XFILLER_52_387 VDD VDD VSS VSS gf180mcu_fd_sc_mcu7t5v0__fillcap_4
XFILLER_100_34 VDD VDD VSS VSS gf180mcu_fd_sc_mcu7t5v0__fill_1
XTAP_TAPCELL_ROW_63_894 VDD VSS gf180mcu_fd_sc_mcu7t5v0__filltie
XPHY_EDGE_ROW_72_Left_181 VDD VSS gf180mcu_fd_sc_mcu7t5v0__endcap
XFILLER_69_36 VDD VDD VSS VSS gf180mcu_fd_sc_mcu7t5v0__fillcap_16
XPHY_EDGE_ROW_81_Left_190 VDD VSS gf180mcu_fd_sc_mcu7t5v0__endcap
XFILLER_87_251 VDD VDD VSS VSS gf180mcu_fd_sc_mcu7t5v0__fillcap_4
XFILLER_75_413 VDD VDD VSS VSS gf180mcu_fd_sc_mcu7t5v0__fillcap_4
XFILLER_48_605 VDD VDD VSS VSS gf180mcu_fd_sc_mcu7t5v0__fill_2
XFILLER_48_638 VDD VDD VSS VSS gf180mcu_fd_sc_mcu7t5v0__fillcap_4
XFILLER_90_449 VDD VDD VSS VSS gf180mcu_fd_sc_mcu7t5v0__fillcap_4
XFILLER_28_395 VDD VDD VSS VSS gf180mcu_fd_sc_mcu7t5v0__fillcap_4
XFILLER_34_61 VDD VDD VSS VSS gf180mcu_fd_sc_mcu7t5v0__fillcap_4
XFILLER_70_195 VDD VDD VSS VSS gf180mcu_fd_sc_mcu7t5v0__fill_1
X_2210_ _2862_/Q _2854_/Q _2846_/Q _2838_/Q _2400_/S0 _2390_/S1 _2210_/Z VDD VDD VSS
+ VSS gf180mcu_fd_sc_mcu7t5v0__mux4_1
X_3190_ _3190_/D _3328_/RN _3240_/CLK _3190_/Q VDD VDD VSS VSS gf180mcu_fd_sc_mcu7t5v0__dffrnq_1
XFILLER_94_733 VDD VDD VSS VSS gf180mcu_fd_sc_mcu7t5v0__fill_2
X_2141_ _3220_/Q _3070_/Q _2166_/S _3070_/D VDD VDD VSS VSS gf180mcu_fd_sc_mcu7t5v0__mux2_2
XFILLER_93_254 VDD VDD VSS VSS gf180mcu_fd_sc_mcu7t5v0__fillcap_16
X_2072_ _3296_/Q _2091_/A2 _2090_/A2 _3288_/Q _2076_/C _2073_/B2 VDD VDD VSS VSS gf180mcu_fd_sc_mcu7t5v0__aoi221_1
XFILLER_22_505 VDD VDD VSS VSS gf180mcu_fd_sc_mcu7t5v0__fillcap_16
XFILLER_22_527 VDD VDD VSS VSS gf180mcu_fd_sc_mcu7t5v0__fillcap_16
X_2974_ _2974_/D _2982_/CLK _2974_/Q VDD VDD VSS VSS gf180mcu_fd_sc_mcu7t5v0__dffq_1
XFILLER_34_387 VDD VDD VSS VSS gf180mcu_fd_sc_mcu7t5v0__fillcap_8
XTAP_TAPCELL_ROW_32_566 VDD VSS gf180mcu_fd_sc_mcu7t5v0__filltie
X_1925_ _3118_/Q _2950_/Q _1925_/S _2950_/D VDD VDD VSS VSS gf180mcu_fd_sc_mcu7t5v0__mux2_2
XTAP_TAPCELL_ROW_60_864 VDD VSS gf180mcu_fd_sc_mcu7t5v0__filltie
X_1856_ _3284_/Q _2891_/Q _1859_/S _2891_/D VDD VDD VSS VSS gf180mcu_fd_sc_mcu7t5v0__mux2_2
X_1787_ _1458_/Z _1786_/Z _1795_/S VDD VDD VSS VSS gf180mcu_fd_sc_mcu7t5v0__nand2_1
XFILLER_103_315 VDD VDD VSS VSS gf180mcu_fd_sc_mcu7t5v0__fillcap_8
X_3388_ hold44/Z _3416_/RN _3399_/CLK _3388_/Q VDD VDD VSS VSS gf180mcu_fd_sc_mcu7t5v0__dffrnq_1
Xclkbuf_leaf_44_clk_i clkload3/I _2954_/CLK VDD VDD VSS VSS gf180mcu_fd_sc_mcu7t5v0__clkbuf_4
X_2408_ _3138_/Q _2407_/B _2408_/B _2409_/A2 VDD VDD VSS VSS gf180mcu_fd_sc_mcu7t5v0__oai21_1
XFILLER_29_104 VDD VDD VSS VSS gf180mcu_fd_sc_mcu7t5v0__fill_2
X_2339_ _2405_/S _2338_/Z _2340_/A3 VDD VDD VSS VSS gf180mcu_fd_sc_mcu7t5v0__nand2_1
XPHY_EDGE_ROW_2_Right_2 VDD VSS gf180mcu_fd_sc_mcu7t5v0__endcap
XTAP_TAPCELL_ROW_68_953 VDD VSS gf180mcu_fd_sc_mcu7t5v0__filltie
XFILLER_44_107 VDD VDD VSS VSS gf180mcu_fd_sc_mcu7t5v0__fill_2
XFILLER_72_438 VDD VDD VSS VSS gf180mcu_fd_sc_mcu7t5v0__fill_1
XFILLER_53_652 VDD VDD VSS VSS gf180mcu_fd_sc_mcu7t5v0__fill_2
XFILLER_40_357 VDD VDD VSS VSS gf180mcu_fd_sc_mcu7t5v0__fill_2
XFILLER_107_632 VDD VDD VSS VSS gf180mcu_fd_sc_mcu7t5v0__fillcap_64
XTAP_TAPCELL_ROW_78_1048 VDD VSS gf180mcu_fd_sc_mcu7t5v0__filltie
XFILLER_105_2 VDD VDD VSS VSS gf180mcu_fd_sc_mcu7t5v0__fillcap_64
XFILLER_4_247 VDD VDD VSS VSS gf180mcu_fd_sc_mcu7t5v0__fillcap_16
XFILLER_88_571 VDD VDD VSS VSS gf180mcu_fd_sc_mcu7t5v0__fill_2
XFILLER_102_370 VDD VDD VSS VSS gf180mcu_fd_sc_mcu7t5v0__fillcap_8
XFILLER_76_733 VDD VDD VSS VSS gf180mcu_fd_sc_mcu7t5v0__fill_2
Xhold50 hold50/I hold50/Z VDD VDD VSS VSS gf180mcu_fd_sc_mcu7t5v0__dlyc_1
Xhold61 hold61/I hold61/Z VDD VDD VSS VSS gf180mcu_fd_sc_mcu7t5v0__dlyc_1
XFILLER_29_72 VDD VDD VSS VSS gf180mcu_fd_sc_mcu7t5v0__fillcap_4
XFILLER_90_213 VDD VDD VSS VSS gf180mcu_fd_sc_mcu7t5v0__fill_2
XTAP_TAPCELL_ROW_89_1166 VDD VSS gf180mcu_fd_sc_mcu7t5v0__filltie
XFILLER_28_192 VDD VDD VSS VSS gf180mcu_fd_sc_mcu7t5v0__fillcap_8
XFILLER_90_257 VDD VDD VSS VSS gf180mcu_fd_sc_mcu7t5v0__fillcap_8
XFILLER_44_663 VDD VDD VSS VSS gf180mcu_fd_sc_mcu7t5v0__fill_2
XFILLER_16_387 VDD VDD VSS VSS gf180mcu_fd_sc_mcu7t5v0__fillcap_8
XFILLER_31_335 VDD VDD VSS VSS gf180mcu_fd_sc_mcu7t5v0__fillcap_8
XFILLER_8_564 VDD VDD VSS VSS gf180mcu_fd_sc_mcu7t5v0__fillcap_4
X_2690_ _3257_/Q _2680_/C _2731_/B1 _3075_/Q _2692_/A1 VDD VDD VSS VSS gf180mcu_fd_sc_mcu7t5v0__aoi22_1
X_1710_ _1710_/I0 _2766_/Q _1710_/S _2766_/D VDD VDD VSS VSS gf180mcu_fd_sc_mcu7t5v0__mux2_2
X_1641_ _2766_/Q _1671_/A2 _1708_/A1 VDD VDD VSS VSS gf180mcu_fd_sc_mcu7t5v0__nor2_1
X_3311_ _3311_/D _3416_/RN _3311_/CLK _3311_/Q VDD VDD VSS VSS gf180mcu_fd_sc_mcu7t5v0__dffrnq_1
X_1572_ _1572_/A1 _3325_/Q _2585_/S VDD VDD VSS VSS gf180mcu_fd_sc_mcu7t5v0__nand2_2
X_3242_ _3242_/D _3369_/RN _3329_/CLK _3242_/Q VDD VDD VSS VSS gf180mcu_fd_sc_mcu7t5v0__dffrnq_1
XFILLER_20_2 VDD VDD VSS VSS gf180mcu_fd_sc_mcu7t5v0__fillcap_8
X_3173_ _3173_/D _3303_/RN _3292_/CLK _3173_/Q VDD VDD VSS VSS gf180mcu_fd_sc_mcu7t5v0__dffrnq_1
X_2124_ _2124_/A1 _2124_/A2 _2124_/B _3062_/D VDD VDD VSS VSS gf180mcu_fd_sc_mcu7t5v0__aoi21_1
XFILLER_66_221 VDD VDD VSS VSS gf180mcu_fd_sc_mcu7t5v0__fillcap_8
XFILLER_26_107 VDD VDD VSS VSS gf180mcu_fd_sc_mcu7t5v0__fillcap_8
XTAP_TAPCELL_ROW_65_912 VDD VSS gf180mcu_fd_sc_mcu7t5v0__filltie
X_2055_ _1606_/B _1606_/C _2061_/A2 _2055_/A4 _2055_/Z VDD VDD VSS VSS gf180mcu_fd_sc_mcu7t5v0__or4_1
XTAP_TAPCELL_ROW_37_625 VDD VSS gf180mcu_fd_sc_mcu7t5v0__filltie
XFILLER_81_268 VDD VDD VSS VSS gf180mcu_fd_sc_mcu7t5v0__fill_1
XFILLER_81_279 VDD VDD VSS VSS gf180mcu_fd_sc_mcu7t5v0__fill_1
XFILLER_35_652 VDD VDD VSS VSS gf180mcu_fd_sc_mcu7t5v0__fill_2
X_2957_ _2957_/D _2982_/CLK _2957_/Q VDD VDD VSS VSS gf180mcu_fd_sc_mcu7t5v0__dffq_1
XFILLER_50_699 VDD VDD VSS VSS gf180mcu_fd_sc_mcu7t5v0__fillcap_4
XFILLER_108_407 VDD VDD VSS VSS gf180mcu_fd_sc_mcu7t5v0__fill_1
X_2888_ _2888_/D _2894_/CLK _2888_/Q VDD VDD VSS VSS gf180mcu_fd_sc_mcu7t5v0__dffq_1
X_1908_ _1982_/A1 _1926_/A2 _1916_/S VDD VDD VSS VSS gf180mcu_fd_sc_mcu7t5v0__nand2_1
X_1839_ _3285_/Q _2876_/Q _1841_/S _2876_/D VDD VDD VSS VSS gf180mcu_fd_sc_mcu7t5v0__mux2_2
XTAP_TAPCELL_ROW_9_328 VDD VSS gf180mcu_fd_sc_mcu7t5v0__filltie
XFILLER_103_167 VDD VDD VSS VSS gf180mcu_fd_sc_mcu7t5v0__fill_2
XFILLER_58_733 VDD VDD VSS VSS gf180mcu_fd_sc_mcu7t5v0__fill_2
XFILLER_97_390 VDD VDD VSS VSS gf180mcu_fd_sc_mcu7t5v0__fill_1
XFILLER_57_232 VDD VDD VSS VSS gf180mcu_fd_sc_mcu7t5v0__fill_1
XFILLER_66_37 VDD VDD VSS VSS gf180mcu_fd_sc_mcu7t5v0__fillcap_4
XFILLER_85_596 VDD VDD VSS VSS gf180mcu_fd_sc_mcu7t5v0__fill_2
XFILLER_17_107 VDD VDD VSS VSS gf180mcu_fd_sc_mcu7t5v0__fillcap_32
XFILLER_45_416 VDD VDD VSS VSS gf180mcu_fd_sc_mcu7t5v0__fillcap_4
XFILLER_26_630 VDD VDD VSS VSS gf180mcu_fd_sc_mcu7t5v0__fillcap_4
XFILLER_41_611 VDD VDD VSS VSS gf180mcu_fd_sc_mcu7t5v0__fillcap_4
XFILLER_13_368 VDD VDD VSS VSS gf180mcu_fd_sc_mcu7t5v0__fillcap_8
XFILLER_41_699 VDD VDD VSS VSS gf180mcu_fd_sc_mcu7t5v0__fill_1
XFILLER_5_534 VDD VDD VSS VSS gf180mcu_fd_sc_mcu7t5v0__fillcap_16
XFILLER_31_95 VDD VDD VSS VSS gf180mcu_fd_sc_mcu7t5v0__fill_2
XFILLER_5_578 VDD VDD VSS VSS gf180mcu_fd_sc_mcu7t5v0__fillcap_4
XFILLER_1_762 VDD VDD VSS VSS gf180mcu_fd_sc_mcu7t5v0__fill_2
XFILLER_48_232 VDD VDD VSS VSS gf180mcu_fd_sc_mcu7t5v0__fillcap_8
XFILLER_51_419 VDD VDD VSS VSS gf180mcu_fd_sc_mcu7t5v0__fill_1
XFILLER_44_471 VDD VDD VSS VSS gf180mcu_fd_sc_mcu7t5v0__fill_1
X_2811_ _2811_/D _2894_/CLK _2811_/Q VDD VDD VSS VSS gf180mcu_fd_sc_mcu7t5v0__dffq_1
XTAP_TAPCELL_ROW_42_672 VDD VSS gf180mcu_fd_sc_mcu7t5v0__filltie
XTAP_TAPCELL_ROW_70_970 VDD VSS gf180mcu_fd_sc_mcu7t5v0__filltie
XTAP_TAPCELL_ROW_14_385 VDD VSS gf180mcu_fd_sc_mcu7t5v0__filltie
X_2742_ _3217_/Q _3283_/Q _2746_/S _3283_/D VDD VDD VSS VSS gf180mcu_fd_sc_mcu7t5v0__mux2_2
X_2673_ _3022_/Q _3014_/Q _3006_/Q _2998_/Q _2673_/S0 _2673_/S1 _2673_/Z VDD VDD VSS
+ VSS gf180mcu_fd_sc_mcu7t5v0__mux4_1
XFILLER_68_2 VDD VDD VSS VSS gf180mcu_fd_sc_mcu7t5v0__fillcap_16
X_1624_ _3041_/Q _3411_/Q _1624_/B _3425_/D VDD VDD VSS VSS gf180mcu_fd_sc_mcu7t5v0__aoi21_1
XPHY_EDGE_ROW_99_Right_99 VDD VSS gf180mcu_fd_sc_mcu7t5v0__endcap
X_1555_ _1562_/A1 _1566_/A1 _2108_/B _3311_/D VDD VDD VSS VSS gf180mcu_fd_sc_mcu7t5v0__oai21_1
XFILLER_98_143 VDD VDD VSS VSS gf180mcu_fd_sc_mcu7t5v0__fillcap_8
XFILLER_100_104 VDD VDD VSS VSS gf180mcu_fd_sc_mcu7t5v0__fill_1
XFILLER_86_327 VDD VDD VSS VSS gf180mcu_fd_sc_mcu7t5v0__fill_1
X_1486_ _3355_/Q _1486_/A2 _3359_/D VDD VDD VSS VSS gf180mcu_fd_sc_mcu7t5v0__xnor2_1
X_3225_ _3225_/D _3303_/RN clkload9/I _3225_/Q VDD VDD VSS VSS gf180mcu_fd_sc_mcu7t5v0__dffrnq_1
X_3156_ _3156_/D _3328_/RN clkload7/I _3156_/Q VDD VDD VSS VSS gf180mcu_fd_sc_mcu7t5v0__dffrnq_1
XFILLER_39_276 VDD VDD VSS VSS gf180mcu_fd_sc_mcu7t5v0__fillcap_4
XFILLER_94_382 VDD VDD VSS VSS gf180mcu_fd_sc_mcu7t5v0__fill_2
X_3087_ _3087_/D _3328_/RN clkload8/I _3087_/Q VDD VDD VSS VSS gf180mcu_fd_sc_mcu7t5v0__dffrnq_1
XFILLER_39_298 VDD VDD VSS VSS gf180mcu_fd_sc_mcu7t5v0__fillcap_8
X_2107_ _3118_/Q _3058_/Q _2107_/S _3058_/D VDD VDD VSS VSS gf180mcu_fd_sc_mcu7t5v0__mux2_2
X_2038_ _2039_/A1 _2050_/C _2036_/B _2037_/Z _2051_/A1 _3030_/D VDD VDD VSS VSS gf180mcu_fd_sc_mcu7t5v0__oai32_1
XFILLER_23_644 VDD VDD VSS VSS gf180mcu_fd_sc_mcu7t5v0__fill_1
XTAP_TAPCELL_ROW_75_1018 VDD VSS gf180mcu_fd_sc_mcu7t5v0__filltie
XFILLER_89_154 VDD VDD VSS VSS gf180mcu_fd_sc_mcu7t5v0__fillcap_8
XFILLER_77_36 VDD VDD VSS VSS gf180mcu_fd_sc_mcu7t5v0__fillcap_32
XFILLER_89_176 VDD VDD VSS VSS gf180mcu_fd_sc_mcu7t5v0__fillcap_32
XFILLER_77_349 VDD VDD VSS VSS gf180mcu_fd_sc_mcu7t5v0__fill_1
XTAP_TAPCELL_ROW_86_1136 VDD VSS gf180mcu_fd_sc_mcu7t5v0__filltie
XFILLER_85_393 VDD VDD VSS VSS gf180mcu_fd_sc_mcu7t5v0__fillcap_16
XFILLER_45_268 VDD VDD VSS VSS gf180mcu_fd_sc_mcu7t5v0__fillcap_8
XFILLER_14_644 VDD VDD VSS VSS gf180mcu_fd_sc_mcu7t5v0__fillcap_16
XTAP_TAPCELL_ROW_97_1254 VDD VSS gf180mcu_fd_sc_mcu7t5v0__filltie
XFILLER_96_669 VDD VDD VSS VSS gf180mcu_fd_sc_mcu7t5v0__fill_1
XFILLER_96_658 VDD VDD VSS VSS gf180mcu_fd_sc_mcu7t5v0__fill_2
XFILLER_3_66 VDD VDD VSS VSS gf180mcu_fd_sc_mcu7t5v0__fillcap_4
XFILLER_83_308 VDD VDD VSS VSS gf180mcu_fd_sc_mcu7t5v0__fill_1
X_3010_ _3010_/D _3021_/CLK _3010_/Q VDD VDD VSS VSS gf180mcu_fd_sc_mcu7t5v0__dffq_1
XTAP_TAPCELL_ROW_47_731 VDD VSS gf180mcu_fd_sc_mcu7t5v0__filltie
XFILLER_64_522 VDD VDD VSS VSS gf180mcu_fd_sc_mcu7t5v0__fill_2
XFILLER_91_352 VDD VDD VSS VSS gf180mcu_fd_sc_mcu7t5v0__fillcap_16
XTAP_TAPCELL_ROW_19_433 VDD VSS gf180mcu_fd_sc_mcu7t5v0__filltie
XFILLER_64_577 VDD VDD VSS VSS gf180mcu_fd_sc_mcu7t5v0__fill_2
XTAP_TAPCELL_ROW_106_1350 VDD VSS gf180mcu_fd_sc_mcu7t5v0__filltie
XFILLER_17_482 VDD VDD VSS VSS gf180mcu_fd_sc_mcu7t5v0__fillcap_8
XFILLER_44_290 VDD VDD VSS VSS gf180mcu_fd_sc_mcu7t5v0__fillcap_16
X_2725_ _3274_/Q _2680_/C _2729_/B1 _3092_/Q _2726_/I VDD VDD VSS VSS gf180mcu_fd_sc_mcu7t5v0__aoi22_1
X_2656_ _2653_/Z _2655_/Z _2652_/Z _2654_/Z _3354_/Q _3353_/Q _2656_/Z VDD VDD VSS
+ VSS gf180mcu_fd_sc_mcu7t5v0__mux4_1
X_1607_ _3036_/Q _1607_/A2 _3037_/Q _3038_/Q _2031_/A2 VDD VDD VSS VSS gf180mcu_fd_sc_mcu7t5v0__aoi211_1
X_2587_ _2587_/A1 _3210_/Q _3211_/Q _3208_/Q _2736_/A4 VDD VDD VSS VSS gf180mcu_fd_sc_mcu7t5v0__nor4_1
XFILLER_86_102 VDD VDD VSS VSS gf180mcu_fd_sc_mcu7t5v0__fill_2
X_1538_ _3121_/Q _3309_/Q _1568_/B VDD VDD VSS VSS gf180mcu_fd_sc_mcu7t5v0__nand2_1
XFILLER_86_135 VDD VDD VSS VSS gf180mcu_fd_sc_mcu7t5v0__fill_1
X_1469_ _3406_/Q _1458_/Z _3407_/Q _1473_/A2 VDD VDD VSS VSS gf180mcu_fd_sc_mcu7t5v0__aoi21_1
X_3208_ _3208_/D _3328_/RN _3257_/CLK _3208_/Q VDD VDD VSS VSS gf180mcu_fd_sc_mcu7t5v0__dffrnq_1
XFILLER_55_500 VDD VDD VSS VSS gf180mcu_fd_sc_mcu7t5v0__fill_2
X_3139_ _3139_/D _3369_/RN _3148_/CLK _3139_/Q VDD VDD VSS VSS gf180mcu_fd_sc_mcu7t5v0__dffrnq_1
XFILLER_82_352 VDD VDD VSS VSS gf180mcu_fd_sc_mcu7t5v0__fillcap_4
XFILLER_55_555 VDD VDD VSS VSS gf180mcu_fd_sc_mcu7t5v0__fillcap_4
XFILLER_27_279 VDD VDD VSS VSS gf180mcu_fd_sc_mcu7t5v0__fill_1
XFILLER_70_514 VDD VDD VSS VSS gf180mcu_fd_sc_mcu7t5v0__fillcap_8
XFILLER_23_430 VDD VDD VSS VSS gf180mcu_fd_sc_mcu7t5v0__fill_2
XFILLER_35_290 VDD VDD VSS VSS gf180mcu_fd_sc_mcu7t5v0__fillcap_16
XFILLER_51_761 VDD VDD VSS VSS gf180mcu_fd_sc_mcu7t5v0__fillcap_4
XTAP_TAPCELL_ROW_53_789 VDD VSS gf180mcu_fd_sc_mcu7t5v0__filltie
XTAP_TAPCELL_ROW_81_1088 VDD VSS gf180mcu_fd_sc_mcu7t5v0__filltie
XFILLER_12_53 VDD VDD VSS VSS gf180mcu_fd_sc_mcu7t5v0__fillcap_4
XFILLER_12_75 VDD VDD VSS VSS gf180mcu_fd_sc_mcu7t5v0__fillcap_16
XTAP_TAPCELL_ROW_92_1195 VDD VSS gf180mcu_fd_sc_mcu7t5v0__filltie
XFILLER_77_146 VDD VDD VSS VSS gf180mcu_fd_sc_mcu7t5v0__fill_2
XFILLER_92_116 VDD VDD VSS VSS gf180mcu_fd_sc_mcu7t5v0__fillcap_8
XFILLER_86_680 VDD VDD VSS VSS gf180mcu_fd_sc_mcu7t5v0__fillcap_4
XFILLER_19_725 VDD VDD VSS VSS gf180mcu_fd_sc_mcu7t5v0__fill_1
XFILLER_37_72 VDD VDD VSS VSS gf180mcu_fd_sc_mcu7t5v0__fillcap_16
XFILLER_73_352 VDD VDD VSS VSS gf180mcu_fd_sc_mcu7t5v0__fill_1
XFILLER_18_279 VDD VDD VSS VSS gf180mcu_fd_sc_mcu7t5v0__fillcap_16
XTAP_TAPCELL_ROW_16_403 VDD VSS gf180mcu_fd_sc_mcu7t5v0__filltie
XTAP_TAPCELL_ROW_44_701 VDD VSS gf180mcu_fd_sc_mcu7t5v0__filltie
XFILLER_73_396 VDD VDD VSS VSS gf180mcu_fd_sc_mcu7t5v0__fill_2
XFILLER_41_282 VDD VDD VSS VSS gf180mcu_fd_sc_mcu7t5v0__fill_2
XTAP_TAPCELL_ROW_101_1291 VDD VSS gf180mcu_fd_sc_mcu7t5v0__filltie
XTAP_TAPCELL_ROW_24_491 VDD VSS gf180mcu_fd_sc_mcu7t5v0__filltie
X_2510_ _3173_/Q _3150_/Q _2534_/S _3173_/D VDD VDD VSS VSS gf180mcu_fd_sc_mcu7t5v0__mux2_2
X_2441_ _3329_/Q _2470_/A3 _3149_/Q _2472_/B VDD VDD VSS VSS gf180mcu_fd_sc_mcu7t5v0__oai21_1
XFILLER_6_695 VDD VDD VSS VSS gf180mcu_fd_sc_mcu7t5v0__fill_1
XFILLER_5_150 VDD VDD VSS VSS gf180mcu_fd_sc_mcu7t5v0__fill_2
X_2372_ _2891_/Q _2883_/Q _2875_/Q _2867_/Q _1439_/B _2373_/S1 _2372_/Z VDD VDD VSS
+ VSS gf180mcu_fd_sc_mcu7t5v0__mux4_1
XFILLER_96_411 VDD VDD VSS VSS gf180mcu_fd_sc_mcu7t5v0__fill_2
XFILLER_68_102 VDD VDD VSS VSS gf180mcu_fd_sc_mcu7t5v0__fill_2
XFILLER_68_113 VDD VDD VSS VSS gf180mcu_fd_sc_mcu7t5v0__fillcap_32
XFILLER_69_647 VDD VDD VSS VSS gf180mcu_fd_sc_mcu7t5v0__fillcap_8
XFILLER_37_577 VDD VDD VSS VSS gf180mcu_fd_sc_mcu7t5v0__fillcap_8
XFILLER_33_761 VDD VDD VSS VSS gf180mcu_fd_sc_mcu7t5v0__fillcap_4
XFILLER_60_591 VDD VDD VSS VSS gf180mcu_fd_sc_mcu7t5v0__fillcap_4
XFILLER_20_444 VDD VDD VSS VSS gf180mcu_fd_sc_mcu7t5v0__fillcap_8
XTAP_TAPCELL_ROW_50_759 VDD VSS gf180mcu_fd_sc_mcu7t5v0__filltie
X_2708_ _2708_/I _3265_/D VDD VDD VSS VSS gf180mcu_fd_sc_mcu7t5v0__clkinv_1
XFILLER_106_527 VDD VDD VSS VSS gf180mcu_fd_sc_mcu7t5v0__fillcap_4
X_2639_ _3067_/Q _2132_/I _2664_/B1 _3099_/Q _2683_/C _2640_/B1 VDD VDD VSS VSS gf180mcu_fd_sc_mcu7t5v0__aoi221_1
XFILLER_102_722 VDD VDD VSS VSS gf180mcu_fd_sc_mcu7t5v0__fillcap_8
XFILLER_99_271 VDD VDD VSS VSS gf180mcu_fd_sc_mcu7t5v0__fill_1
XFILLER_99_282 VDD VDD VSS VSS gf180mcu_fd_sc_mcu7t5v0__fillcap_16
XFILLER_87_422 VDD VDD VSS VSS gf180mcu_fd_sc_mcu7t5v0__fillcap_16
XFILLER_28_522 VDD VDD VSS VSS gf180mcu_fd_sc_mcu7t5v0__fill_2
XTAP_TAPCELL_ROW_58_848 VDD VSS gf180mcu_fd_sc_mcu7t5v0__filltie
XFILLER_68_691 VDD VDD VSS VSS gf180mcu_fd_sc_mcu7t5v0__fill_1
XFILLER_55_341 VDD VDD VSS VSS gf180mcu_fd_sc_mcu7t5v0__fillcap_8
XFILLER_55_352 VDD VDD VSS VSS gf180mcu_fd_sc_mcu7t5v0__fillcap_16
XFILLER_83_694 VDD VDD VSS VSS gf180mcu_fd_sc_mcu7t5v0__fillcap_4
XTAP_TAPCELL_ROW_83_1106 VDD VSS gf180mcu_fd_sc_mcu7t5v0__filltie
XFILLER_82_182 VDD VDD VSS VSS gf180mcu_fd_sc_mcu7t5v0__fillcap_4
XFILLER_43_547 VDD VDD VSS VSS gf180mcu_fd_sc_mcu7t5v0__fillcap_8
XFILLER_70_333 VDD VDD VSS VSS gf180mcu_fd_sc_mcu7t5v0__fillcap_8
XFILLER_24_761 VDD VDD VSS VSS gf180mcu_fd_sc_mcu7t5v0__fillcap_4
Xclkbuf_3_0__f_clk_i clkbuf_0_clk_i/Z clkbuf_leaf_5_clk_i/I VDD VDD VSS VSS gf180mcu_fd_sc_mcu7t5v0__clkbuf_16
XFILLER_11_422 VDD VDD VSS VSS gf180mcu_fd_sc_mcu7t5v0__fillcap_8
XFILLER_23_30 VDD VDD VSS VSS gf180mcu_fd_sc_mcu7t5v0__fill_2
XFILLER_23_282 VDD VDD VSS VSS gf180mcu_fd_sc_mcu7t5v0__fillcap_4
XFILLER_51_591 VDD VDD VSS VSS gf180mcu_fd_sc_mcu7t5v0__fillcap_8
XFILLER_70_399 VDD VDD VSS VSS gf180mcu_fd_sc_mcu7t5v0__fill_1
XFILLER_7_404 VDD VDD VSS VSS gf180mcu_fd_sc_mcu7t5v0__fill_2
XTAP_TAPCELL_ROW_21_450 VDD VSS gf180mcu_fd_sc_mcu7t5v0__filltie
XFILLER_99_34 VDD VDD VSS VSS gf180mcu_fd_sc_mcu7t5v0__fillcap_16
XTAP_TAPCELL_ROW_94_1224 VDD VSS gf180mcu_fd_sc_mcu7t5v0__filltie
XFILLER_38_308 VDD VDD VSS VSS gf180mcu_fd_sc_mcu7t5v0__fill_2
XFILLER_65_105 VDD VDD VSS VSS gf180mcu_fd_sc_mcu7t5v0__fill_1
XFILLER_19_500 VDD VDD VSS VSS gf180mcu_fd_sc_mcu7t5v0__fillcap_4
XFILLER_65_116 VDD VDD VSS VSS gf180mcu_fd_sc_mcu7t5v0__fillcap_8
XFILLER_46_352 VDD VDD VSS VSS gf180mcu_fd_sc_mcu7t5v0__fillcap_4
XFILLER_74_683 VDD VDD VSS VSS gf180mcu_fd_sc_mcu7t5v0__fill_1
XFILLER_19_588 VDD VDD VSS VSS gf180mcu_fd_sc_mcu7t5v0__fill_2
XFILLER_73_160 VDD VDD VSS VSS gf180mcu_fd_sc_mcu7t5v0__fill_1
XTAP_TAPCELL_ROW_103_1320 VDD VSS gf180mcu_fd_sc_mcu7t5v0__filltie
XFILLER_15_750 VDD VDD VSS VSS gf180mcu_fd_sc_mcu7t5v0__fillcap_8
XFILLER_21_208 VDD VDD VSS VSS gf180mcu_fd_sc_mcu7t5v0__fill_2
X_2990_ _2990_/D _3020_/CLK _2990_/Q VDD VDD VSS VSS gf180mcu_fd_sc_mcu7t5v0__dffq_1
X_1941_ _2963_/Q _3115_/Q _1944_/S _2963_/D VDD VDD VSS VSS gf180mcu_fd_sc_mcu7t5v0__mux2_2
XFILLER_30_731 VDD VDD VSS VSS gf180mcu_fd_sc_mcu7t5v0__fillcap_4
XFILLER_30_753 VDD VDD VSS VSS gf180mcu_fd_sc_mcu7t5v0__fillcap_8
X_1872_ _2905_/Q _3113_/Q _1876_/S _2905_/D VDD VDD VSS VSS gf180mcu_fd_sc_mcu7t5v0__mux2_2
XFILLER_50_2 VDD VDD VSS VSS gf180mcu_fd_sc_mcu7t5v0__fillcap_8
XFILLER_88_208 VDD VDD VSS VSS gf180mcu_fd_sc_mcu7t5v0__fillcap_16
X_2424_ _2424_/A1 _2428_/B2 _3144_/Q _2424_/C _2425_/A2 VDD VDD VSS VSS gf180mcu_fd_sc_mcu7t5v0__oai211_1
X_2355_ _2407_/A1 _2355_/A2 _2407_/B _2355_/C _2356_/B VDD VDD VSS VSS gf180mcu_fd_sc_mcu7t5v0__oai211_1
XFILLER_69_422 VDD VDD VSS VSS gf180mcu_fd_sc_mcu7t5v0__fill_1
X_2286_ _2413_/A1 _1702_/C _2286_/B _2287_/A3 VDD VDD VSS VSS gf180mcu_fd_sc_mcu7t5v0__oai21_1
XTAP_TAPCELL_ROW_55_807 VDD VSS gf180mcu_fd_sc_mcu7t5v0__filltie
XFILLER_37_352 VDD VDD VSS VSS gf180mcu_fd_sc_mcu7t5v0__fillcap_32
XFILLER_80_653 VDD VDD VSS VSS gf180mcu_fd_sc_mcu7t5v0__fillcap_4
XFILLER_80_664 VDD VDD VSS VSS gf180mcu_fd_sc_mcu7t5v0__fill_1
XFILLER_80_675 VDD VDD VSS VSS gf180mcu_fd_sc_mcu7t5v0__fillcap_4
XTAP_TAPCELL_ROW_35_597 VDD VSS gf180mcu_fd_sc_mcu7t5v0__filltie
XTAP_TAPCELL_ROW_63_895 VDD VSS gf180mcu_fd_sc_mcu7t5v0__filltie
XFILLER_100_57 VDD VDD VSS VSS gf180mcu_fd_sc_mcu7t5v0__fill_1
XFILLER_20_241 VDD VDD VSS VSS gf180mcu_fd_sc_mcu7t5v0__fillcap_4
XFILLER_21_764 VDD VDD VSS VSS gf180mcu_fd_sc_mcu7t5v0__fill_1
XFILLER_106_313 VDD VDD VSS VSS gf180mcu_fd_sc_mcu7t5v0__fill_2
XFILLER_106_379 VDD VDD VSS VSS gf180mcu_fd_sc_mcu7t5v0__fillcap_4
XFILLER_102_574 VDD VDD VSS VSS gf180mcu_fd_sc_mcu7t5v0__fill_1
XFILLER_87_296 VDD VDD VSS VSS gf180mcu_fd_sc_mcu7t5v0__fill_1
XFILLER_18_96 VDD VDD VSS VSS gf180mcu_fd_sc_mcu7t5v0__fillcap_8
XFILLER_43_344 VDD VDD VSS VSS gf180mcu_fd_sc_mcu7t5v0__fillcap_4
XFILLER_55_182 VDD VDD VSS VSS gf180mcu_fd_sc_mcu7t5v0__fillcap_16
XFILLER_24_591 VDD VDD VSS VSS gf180mcu_fd_sc_mcu7t5v0__fillcap_4
XFILLER_31_539 VDD VDD VSS VSS gf180mcu_fd_sc_mcu7t5v0__fillcap_16
XFILLER_70_174 VDD VDD VSS VSS gf180mcu_fd_sc_mcu7t5v0__fill_1
XFILLER_71_697 VDD VDD VSS VSS gf180mcu_fd_sc_mcu7t5v0__fill_2
XFILLER_12_753 VDD VDD VSS VSS gf180mcu_fd_sc_mcu7t5v0__fillcap_8
XFILLER_7_212 VDD VDD VSS VSS gf180mcu_fd_sc_mcu7t5v0__fillcap_4
Xclkbuf_4_3_0_host_clk_i clkbuf_0_host_clk_i/Z _2796_/CLK VDD VDD VSS VSS gf180mcu_fd_sc_mcu7t5v0__clkbuf_4
XFILLER_79_764 VDD VDD VSS VSS gf180mcu_fd_sc_mcu7t5v0__fill_1
XFILLER_78_263 VDD VDD VSS VSS gf180mcu_fd_sc_mcu7t5v0__fillcap_8
XFILLER_78_241 VDD VDD VSS VSS gf180mcu_fd_sc_mcu7t5v0__fillcap_4
XPHY_EDGE_ROW_0_Left_109 VDD VSS gf180mcu_fd_sc_mcu7t5v0__endcap
XFILLER_66_403 VDD VDD VSS VSS gf180mcu_fd_sc_mcu7t5v0__fillcap_4
XFILLER_38_127 VDD VDD VSS VSS gf180mcu_fd_sc_mcu7t5v0__fill_1
X_2140_ _3219_/Q _3069_/Q _2166_/S _3069_/D VDD VDD VSS VSS gf180mcu_fd_sc_mcu7t5v0__mux2_2
XFILLER_66_436 VDD VDD VSS VSS gf180mcu_fd_sc_mcu7t5v0__fillcap_16
XFILLER_93_233 VDD VDD VSS VSS gf180mcu_fd_sc_mcu7t5v0__fillcap_4
X_2071_ _3053_/Q _1544_/Z _2090_/A2 VDD VDD VSS VSS gf180mcu_fd_sc_mcu7t5v0__nor2_1
XFILLER_75_91 VDD VDD VSS VSS gf180mcu_fd_sc_mcu7t5v0__fill_1
XFILLER_75_80 VDD VDD VSS VSS gf180mcu_fd_sc_mcu7t5v0__fill_2
XFILLER_19_352 VDD VDD VSS VSS gf180mcu_fd_sc_mcu7t5v0__fillcap_4
XFILLER_46_171 VDD VDD VSS VSS gf180mcu_fd_sc_mcu7t5v0__fillcap_4
XFILLER_34_344 VDD VDD VSS VSS gf180mcu_fd_sc_mcu7t5v0__fill_2
XFILLER_62_664 VDD VDD VSS VSS gf180mcu_fd_sc_mcu7t5v0__fill_1
XFILLER_98_2 VDD VDD VSS VSS gf180mcu_fd_sc_mcu7t5v0__fillcap_32
X_2973_ _2973_/D _2982_/CLK _2973_/Q VDD VDD VSS VSS gf180mcu_fd_sc_mcu7t5v0__dffq_1
XFILLER_61_196 VDD VDD VSS VSS gf180mcu_fd_sc_mcu7t5v0__fillcap_8
X_1924_ _3117_/Q _2949_/Q _1925_/S _2949_/D VDD VDD VSS VSS gf180mcu_fd_sc_mcu7t5v0__mux2_2
XTAP_TAPCELL_ROW_60_865 VDD VSS gf180mcu_fd_sc_mcu7t5v0__filltie
XTAP_TAPCELL_ROW_32_567 VDD VSS gf180mcu_fd_sc_mcu7t5v0__filltie
X_1855_ _3283_/Q _2890_/Q _1859_/S _2890_/D VDD VDD VSS VSS gf180mcu_fd_sc_mcu7t5v0__mux2_2
X_1786_ _3406_/Q _1786_/A2 _1786_/Z VDD VDD VSS VSS gf180mcu_fd_sc_mcu7t5v0__and2_1
XFILLER_103_349 VDD VDD VSS VSS gf180mcu_fd_sc_mcu7t5v0__fill_1
XFILLER_103_327 VDD VDD VSS VSS gf180mcu_fd_sc_mcu7t5v0__fill_2
X_2407_ _2407_/A1 _2407_/A2 _2407_/B _2407_/C _2408_/B VDD VDD VSS VSS gf180mcu_fd_sc_mcu7t5v0__oai211_1
X_3387_ hold64/Z input1/Z _3387_/CLK _3387_/Q VDD VDD VSS VSS gf180mcu_fd_sc_mcu7t5v0__dffrnq_1
XFILLER_84_211 VDD VDD VSS VSS gf180mcu_fd_sc_mcu7t5v0__fillcap_16
X_2338_ _2856_/Q _2848_/Q _2840_/Q _2832_/Q _2404_/S0 _2404_/S1 _2338_/Z VDD VDD VSS
+ VSS gf180mcu_fd_sc_mcu7t5v0__mux4_1
X_2269_ _3131_/Q _2267_/C _2422_/S _2268_/Z _2269_/B2 _3120_/D VDD VDD VSS VSS gf180mcu_fd_sc_mcu7t5v0__oai32_1
XFILLER_84_244 VDD VDD VSS VSS gf180mcu_fd_sc_mcu7t5v0__fill_1
XFILLER_45_609 VDD VDD VSS VSS gf180mcu_fd_sc_mcu7t5v0__fillcap_16
XFILLER_57_458 VDD VDD VSS VSS gf180mcu_fd_sc_mcu7t5v0__fillcap_16
XTAP_TAPCELL_ROW_68_943 VDD VSS gf180mcu_fd_sc_mcu7t5v0__filltie
XFILLER_37_193 VDD VDD VSS VSS gf180mcu_fd_sc_mcu7t5v0__fillcap_8
XFILLER_80_494 VDD VDD VSS VSS gf180mcu_fd_sc_mcu7t5v0__fillcap_16
XFILLER_40_314 VDD VDD VSS VSS gf180mcu_fd_sc_mcu7t5v0__fill_1
XFILLER_52_174 VDD VDD VSS VSS gf180mcu_fd_sc_mcu7t5v0__fill_1
XFILLER_53_697 VDD VDD VSS VSS gf180mcu_fd_sc_mcu7t5v0__fill_2
XTAP_TAPCELL_ROW_78_1049 VDD VSS gf180mcu_fd_sc_mcu7t5v0__filltie
XFILLER_96_24 VDD VDD VSS VSS gf180mcu_fd_sc_mcu7t5v0__fill_1
XFILLER_0_410 VDD VDD VSS VSS gf180mcu_fd_sc_mcu7t5v0__fillcap_32
XFILLER_20_97 VDD VDD VSS VSS gf180mcu_fd_sc_mcu7t5v0__fillcap_8
XFILLER_96_57 VDD VDD VSS VSS gf180mcu_fd_sc_mcu7t5v0__fillcap_4
XFILLER_102_382 VDD VDD VSS VSS gf180mcu_fd_sc_mcu7t5v0__fill_2
Xhold40 rst_ni input1/I VDD VDD VSS VSS gf180mcu_fd_sc_mcu7t5v0__dlyc_1
XFILLER_88_594 VDD VDD VSS VSS gf180mcu_fd_sc_mcu7t5v0__fill_1
XFILLER_48_403 VDD VDD VSS VSS gf180mcu_fd_sc_mcu7t5v0__fillcap_8
Xhold62 hold62/I hold62/Z VDD VDD VSS VSS gf180mcu_fd_sc_mcu7t5v0__dlyc_1
Xhold51 hold51/I hold51/Z VDD VDD VSS VSS gf180mcu_fd_sc_mcu7t5v0__dlyc_1
XFILLER_90_203 VDD VDD VSS VSS gf180mcu_fd_sc_mcu7t5v0__fill_1
XTAP_TAPCELL_ROW_89_1167 VDD VSS gf180mcu_fd_sc_mcu7t5v0__filltie
XFILLER_75_277 VDD VDD VSS VSS gf180mcu_fd_sc_mcu7t5v0__fill_2
XFILLER_75_288 VDD VDD VSS VSS gf180mcu_fd_sc_mcu7t5v0__fill_1
XTAP_TAPCELL_ROW_3_270 VDD VSS gf180mcu_fd_sc_mcu7t5v0__filltie
XFILLER_63_417 VDD VDD VSS VSS gf180mcu_fd_sc_mcu7t5v0__fill_2
XFILLER_90_247 VDD VDD VSS VSS gf180mcu_fd_sc_mcu7t5v0__fillcap_4
XFILLER_28_171 VDD VDD VSS VSS gf180mcu_fd_sc_mcu7t5v0__fillcap_4
XFILLER_45_72 VDD VDD VSS VSS gf180mcu_fd_sc_mcu7t5v0__fillcap_8
XFILLER_16_399 VDD VDD VSS VSS gf180mcu_fd_sc_mcu7t5v0__fill_2
XFILLER_71_483 VDD VDD VSS VSS gf180mcu_fd_sc_mcu7t5v0__fillcap_4
XFILLER_71_494 VDD VDD VSS VSS gf180mcu_fd_sc_mcu7t5v0__fill_1
XFILLER_31_347 VDD VDD VSS VSS gf180mcu_fd_sc_mcu7t5v0__fill_2
XFILLER_8_521 VDD VDD VSS VSS gf180mcu_fd_sc_mcu7t5v0__fillcap_4
XFILLER_12_594 VDD VDD VSS VSS gf180mcu_fd_sc_mcu7t5v0__fill_1
X_1640_ _2764_/Q _2765_/Q _1671_/A2 VDD VDD VSS VSS gf180mcu_fd_sc_mcu7t5v0__nand2_1
X_1571_ _1553_/B _1571_/A2 _1571_/A3 _1571_/B _3308_/D VDD VDD VSS VSS gf180mcu_fd_sc_mcu7t5v0__oai31_1
X_3310_ _3310_/D _3416_/RN _3311_/CLK _3310_/Q VDD VDD VSS VSS gf180mcu_fd_sc_mcu7t5v0__dffrnq_1
X_3241_ _3241_/D _3328_/RN clkload7/I _3241_/Q VDD VDD VSS VSS gf180mcu_fd_sc_mcu7t5v0__dffrnq_1
XFILLER_39_414 VDD VDD VSS VSS gf180mcu_fd_sc_mcu7t5v0__fillcap_4
X_3172_ _3172_/D _3303_/RN _3215_/CLK _3172_/Q VDD VDD VSS VSS gf180mcu_fd_sc_mcu7t5v0__dffrnq_1
X_2123_ _3311_/Q _2414_/B _2123_/A3 _2124_/A2 VDD VDD VSS VSS gf180mcu_fd_sc_mcu7t5v0__nand3_1
XFILLER_13_2 VDD VDD VSS VSS gf180mcu_fd_sc_mcu7t5v0__fillcap_16
XFILLER_94_597 VDD VDD VSS VSS gf180mcu_fd_sc_mcu7t5v0__fillcap_16
XFILLER_82_737 VDD VDD VSS VSS gf180mcu_fd_sc_mcu7t5v0__fillcap_16
XTAP_TAPCELL_ROW_65_913 VDD VSS gf180mcu_fd_sc_mcu7t5v0__filltie
X_2054_ _3034_/Q _2050_/B _2057_/A2 VDD VDD VSS VSS gf180mcu_fd_sc_mcu7t5v0__nand2_1
XTAP_TAPCELL_ROW_37_626 VDD VSS gf180mcu_fd_sc_mcu7t5v0__filltie
XFILLER_54_439 VDD VDD VSS VSS gf180mcu_fd_sc_mcu7t5v0__fill_1
XFILLER_22_314 VDD VDD VSS VSS gf180mcu_fd_sc_mcu7t5v0__fill_1
XFILLER_34_174 VDD VDD VSS VSS gf180mcu_fd_sc_mcu7t5v0__fill_1
XFILLER_35_697 VDD VDD VSS VSS gf180mcu_fd_sc_mcu7t5v0__fill_2
XFILLER_50_634 VDD VDD VSS VSS gf180mcu_fd_sc_mcu7t5v0__fillcap_4
XFILLER_50_667 VDD VDD VSS VSS gf180mcu_fd_sc_mcu7t5v0__fillcap_32
X_2956_ _2956_/D _3324_/CLK _2956_/Q VDD VDD VSS VSS gf180mcu_fd_sc_mcu7t5v0__dffq_1
X_2887_ _2887_/D _2887_/CLK _2887_/Q VDD VDD VSS VSS gf180mcu_fd_sc_mcu7t5v0__dffq_1
X_1907_ _2934_/Q _3118_/Q _1907_/S _2934_/D VDD VDD VSS VSS gf180mcu_fd_sc_mcu7t5v0__mux2_2
X_1838_ _3284_/Q _2875_/Q _1841_/S _2875_/D VDD VDD VSS VSS gf180mcu_fd_sc_mcu7t5v0__mux2_2
X_1769_ _3280_/Q _2815_/Q _1776_/S _2815_/D VDD VDD VSS VSS gf180mcu_fd_sc_mcu7t5v0__mux2_2
XTAP_TAPCELL_ROW_9_329 VDD VSS gf180mcu_fd_sc_mcu7t5v0__filltie
XFILLER_1_207 VDD VDD VSS VSS gf180mcu_fd_sc_mcu7t5v0__fill_2
XFILLER_106_34 VDD VDD VSS VSS gf180mcu_fd_sc_mcu7t5v0__fill_1
XFILLER_58_701 VDD VDD VSS VSS gf180mcu_fd_sc_mcu7t5v0__fillcap_32
XFILLER_97_380 VDD VDD VSS VSS gf180mcu_fd_sc_mcu7t5v0__fillcap_8
XFILLER_57_200 VDD VDD VSS VSS gf180mcu_fd_sc_mcu7t5v0__fillcap_8
XFILLER_66_49 VDD VDD VSS VSS gf180mcu_fd_sc_mcu7t5v0__fillcap_8
XFILLER_73_748 VDD VDD VSS VSS gf180mcu_fd_sc_mcu7t5v0__fillcap_16
XFILLER_82_37 VDD VDD VSS VSS gf180mcu_fd_sc_mcu7t5v0__fillcap_16
XFILLER_72_247 VDD VDD VSS VSS gf180mcu_fd_sc_mcu7t5v0__fillcap_16
XFILLER_15_64 VDD VDD VSS VSS gf180mcu_fd_sc_mcu7t5v0__fillcap_4
XFILLER_41_656 VDD VDD VSS VSS gf180mcu_fd_sc_mcu7t5v0__fill_1
XFILLER_40_166 VDD VDD VSS VSS gf180mcu_fd_sc_mcu7t5v0__fillcap_8
Xoutput6 _2764_/Q irq_o VDD VDD VSS VSS gf180mcu_fd_sc_mcu7t5v0__dlyb_1
XFILLER_95_339 VDD VDD VSS VSS gf180mcu_fd_sc_mcu7t5v0__fill_1
XFILLER_95_317 VDD VDD VSS VSS gf180mcu_fd_sc_mcu7t5v0__fillcap_16
XFILLER_0_240 VDD VDD VSS VSS gf180mcu_fd_sc_mcu7t5v0__fillcap_32
XFILLER_48_200 VDD VDD VSS VSS gf180mcu_fd_sc_mcu7t5v0__fillcap_32
XFILLER_88_391 VDD VDD VSS VSS gf180mcu_fd_sc_mcu7t5v0__fill_2
XFILLER_76_542 VDD VDD VSS VSS gf180mcu_fd_sc_mcu7t5v0__fillcap_16
XFILLER_48_244 VDD VDD VSS VSS gf180mcu_fd_sc_mcu7t5v0__fill_1
XFILLER_76_586 VDD VDD VSS VSS gf180mcu_fd_sc_mcu7t5v0__fillcap_8
XFILLER_48_255 VDD VDD VSS VSS gf180mcu_fd_sc_mcu7t5v0__fill_2
XFILLER_64_704 VDD VDD VSS VSS gf180mcu_fd_sc_mcu7t5v0__fill_1
XFILLER_16_174 VDD VDD VSS VSS gf180mcu_fd_sc_mcu7t5v0__fill_1
XFILLER_16_185 VDD VDD VSS VSS gf180mcu_fd_sc_mcu7t5v0__fill_1
XFILLER_32_667 VDD VDD VSS VSS gf180mcu_fd_sc_mcu7t5v0__fillcap_8
X_2810_ _2810_/D _2894_/CLK _2810_/Q VDD VDD VSS VSS gf180mcu_fd_sc_mcu7t5v0__dffq_1
XTAP_TAPCELL_ROW_42_673 VDD VSS gf180mcu_fd_sc_mcu7t5v0__filltie
XTAP_TAPCELL_ROW_70_971 VDD VSS gf180mcu_fd_sc_mcu7t5v0__filltie
XTAP_TAPCELL_ROW_14_386 VDD VSS gf180mcu_fd_sc_mcu7t5v0__filltie
Xclkbuf_leaf_43_clk_i clkload3/I _2982_/CLK VDD VDD VSS VSS gf180mcu_fd_sc_mcu7t5v0__clkbuf_4
XFILLER_31_188 VDD VDD VSS VSS gf180mcu_fd_sc_mcu7t5v0__fillcap_4
X_2741_ _3216_/Q _3282_/Q _2746_/S _3282_/D VDD VDD VSS VSS gf180mcu_fd_sc_mcu7t5v0__mux2_2
X_2672_ _2990_/Q _2982_/Q _2974_/Q _2966_/Q _2672_/S0 _2675_/S1 _2672_/Z VDD VDD VSS
+ VSS gf180mcu_fd_sc_mcu7t5v0__mux4_1
X_1623_ _3040_/Q _3410_/Q _3425_/Q _1624_/B VDD VDD VSS VSS gf180mcu_fd_sc_mcu7t5v0__aoi21_1
X_1554_ _3310_/Q _2414_/B _1566_/A1 VDD VDD VSS VSS gf180mcu_fd_sc_mcu7t5v0__nand2_1
XFILLER_98_155 VDD VDD VSS VSS gf180mcu_fd_sc_mcu7t5v0__fill_2
X_1485_ _3355_/Q _1485_/A2 _3355_/D VDD VDD VSS VSS gf180mcu_fd_sc_mcu7t5v0__xnor2_1
XFILLER_98_177 VDD VDD VSS VSS gf180mcu_fd_sc_mcu7t5v0__fillcap_4
XFILLER_86_317 VDD VDD VSS VSS gf180mcu_fd_sc_mcu7t5v0__fillcap_8
X_3224_ _3224_/D _3303_/RN _3293_/CLK _3224_/Q VDD VDD VSS VSS gf180mcu_fd_sc_mcu7t5v0__dffrnq_1
.ends
