* NGSPICE file created from spi_opentarget_i3c_top.ext - technology: gf180mcuD

.subckt gf180mcu_fd_sc_mcu7t5v0__fillcap_64 VDD VSS VNW VPW
X0 a_4604_375# a_4516_472# VSS VPW nfet_05v0 ad=0.3608p pd=2.52u as=0.3608p ps=2.52u w=0.82u l=1u
X1 VDD a_572_375# a_484_472# VNW pfet_05v0 ad=0.5368p pd=3.32u as=0.5368p ps=3.32u w=1.22u l=1u
X2 VDD a_2364_375# a_2276_472# VNW pfet_05v0 ad=0.5368p pd=3.32u as=0.5368p ps=3.32u w=1.22u l=1u
X3 a_4156_375# a_4068_472# VSS VPW nfet_05v0 ad=0.3608p pd=2.52u as=0.3608p ps=2.52u w=0.82u l=1u
X4 a_5500_375# a_5412_472# VSS VPW nfet_05v0 ad=0.3608p pd=2.52u as=0.3608p ps=2.52u w=0.82u l=1u
X5 a_572_375# a_484_472# VSS VPW nfet_05v0 ad=0.3608p pd=2.52u as=0.3608p ps=2.52u w=0.82u l=1u
X6 VDD a_5052_375# a_4964_472# VNW pfet_05v0 ad=0.5368p pd=3.32u as=0.5368p ps=3.32u w=1.22u l=1u
X7 VDD a_6844_375# a_6756_472# VNW pfet_05v0 ad=0.5368p pd=3.32u as=0.5368p ps=3.32u w=1.22u l=1u
X8 VDD a_1916_375# a_1828_472# VNW pfet_05v0 ad=0.5368p pd=3.32u as=0.5368p ps=3.32u w=1.22u l=1u
X9 a_124_375# a_36_472# VSS VPW nfet_05v0 ad=0.3608p pd=2.52u as=0.3608p ps=2.52u w=0.82u l=1u
X10 a_5052_375# a_4964_472# VSS VPW nfet_05v0 ad=0.3608p pd=2.52u as=0.3608p ps=2.52u w=0.82u l=1u
X11 a_1916_375# a_1828_472# VSS VPW nfet_05v0 ad=0.3608p pd=2.52u as=0.3608p ps=2.52u w=0.82u l=1u
X12 VDD a_4604_375# a_4516_472# VNW pfet_05v0 ad=0.5368p pd=3.32u as=0.5368p ps=3.32u w=1.22u l=1u
X13 a_1468_375# a_1380_472# VSS VPW nfet_05v0 ad=0.3608p pd=2.52u as=0.3608p ps=2.52u w=0.82u l=1u
X14 a_2812_375# a_2724_472# VSS VPW nfet_05v0 ad=0.3608p pd=2.52u as=0.3608p ps=2.52u w=0.82u l=1u
X15 VDD a_3260_375# a_3172_472# VNW pfet_05v0 ad=0.5368p pd=3.32u as=0.5368p ps=3.32u w=1.22u l=1u
X16 a_2364_375# a_2276_472# VSS VPW nfet_05v0 ad=0.3608p pd=2.52u as=0.3608p ps=2.52u w=0.82u l=1u
X17 a_5948_375# a_5860_472# VSS VPW nfet_05v0 ad=0.3608p pd=2.52u as=0.3608p ps=2.52u w=0.82u l=1u
X18 VDD a_2812_375# a_2724_472# VNW pfet_05v0 ad=0.5368p pd=3.32u as=0.5368p ps=3.32u w=1.22u l=1u
X19 a_3260_375# a_3172_472# VSS VPW nfet_05v0 ad=0.3608p pd=2.52u as=0.3608p ps=2.52u w=0.82u l=1u
X20 VDD a_1020_375# a_932_472# VNW pfet_05v0 ad=0.5368p pd=3.32u as=0.5368p ps=3.32u w=1.22u l=1u
X21 VDD a_5500_375# a_5412_472# VNW pfet_05v0 ad=0.5368p pd=3.32u as=0.5368p ps=3.32u w=1.22u l=1u
X22 a_6844_375# a_6756_472# VSS VPW nfet_05v0 ad=0.3608p pd=2.52u as=0.3608p ps=2.52u w=0.82u l=1u
X23 a_6396_375# a_6308_472# VSS VPW nfet_05v0 ad=0.3608p pd=2.52u as=0.3608p ps=2.52u w=0.82u l=1u
X24 VDD a_6396_375# a_6308_472# VNW pfet_05v0 ad=0.5368p pd=3.32u as=0.5368p ps=3.32u w=1.22u l=1u
X25 VDD a_1468_375# a_1380_472# VNW pfet_05v0 ad=0.5368p pd=3.32u as=0.5368p ps=3.32u w=1.22u l=1u
X26 VDD a_4156_375# a_4068_472# VNW pfet_05v0 ad=0.5368p pd=3.32u as=0.5368p ps=3.32u w=1.22u l=1u
X27 VDD a_5948_375# a_5860_472# VNW pfet_05v0 ad=0.5368p pd=3.32u as=0.5368p ps=3.32u w=1.22u l=1u
X28 VDD a_124_375# a_36_472# VNW pfet_05v0 ad=0.5368p pd=3.32u as=0.5368p ps=3.32u w=1.22u l=1u
X29 a_3708_375# a_3620_472# VSS VPW nfet_05v0 ad=0.3608p pd=2.52u as=0.3608p ps=2.52u w=0.82u l=1u
X30 VDD a_3708_375# a_3620_472# VNW pfet_05v0 ad=0.5368p pd=3.32u as=0.5368p ps=3.32u w=1.22u l=1u
X31 a_1020_375# a_932_472# VSS VPW nfet_05v0 ad=0.3608p pd=2.52u as=0.3608p ps=2.52u w=0.82u l=1u
.ends

.subckt gf180mcu_fd_sc_mcu7t5v0__dffrnq_1 D Q RN VSS CLK VDD VNW VPW
X0 VSS CLK a_36_151# VPW nfet_05v0 ad=0.1053p pd=0.925u as=0.1782p ps=1.69u w=0.405u l=0.6u
X1 VSS RN a_1456_156# VPW nfet_05v0 ad=0.2016p pd=1.48u as=43.2f ps=0.6u w=0.36u l=0.6u
X2 Q a_2665_112# VDD VNW pfet_05v0 ad=0.5346p pd=3.31u as=0.5346p ps=3.31u w=1.215u l=0.5u
X3 a_796_472# D VSS VPW nfet_05v0 ad=93.59999f pd=0.88u as=0.1584p ps=1.6u w=0.36u l=0.6u
X4 VSS a_2665_112# a_2560_156# VPW nfet_05v0 ad=0.1224p pd=1.04u as=94.5f ps=0.885u w=0.36u l=0.6u
X5 a_2665_112# a_2248_156# a_3041_156# VPW nfet_05v0 ad=0.176p pd=1.68u as=0.134p ps=1.1u w=0.4u l=0.6u
X6 a_1000_472# a_448_472# a_796_472# VNW pfet_05v0 ad=0.2028p pd=1.3u as=0.2028p ps=1.3u w=0.78u l=0.5u
X7 a_2248_156# a_36_151# a_1308_423# VNW pfet_05v0 ad=0.25375p pd=1.51u as=0.2424p ps=1.465u w=0.505u l=0.5u
X8 a_2248_156# a_448_472# a_1308_423# VPW nfet_05v0 ad=0.2007p pd=1.475u as=0.2007p ps=1.475u w=0.36u l=0.6u
X9 VDD CLK a_36_151# VNW pfet_05v0 ad=0.2249p pd=1.385u as=0.3806p ps=2.61u w=0.865u l=0.5u
X10 a_1456_156# a_1308_423# a_1288_156# VPW nfet_05v0 ad=43.2f pd=0.6u as=43.2f ps=0.6u w=0.36u l=0.6u
X11 a_1308_423# a_1000_472# VSS VPW nfet_05v0 ad=0.2007p pd=1.475u as=0.2016p ps=1.48u w=0.36u l=0.6u
X12 Q a_2665_112# VSS VPW nfet_05v0 ad=0.3586p pd=2.51u as=0.3586p ps=2.51u w=0.815u l=0.6u
X13 a_448_472# a_36_151# VDD VNW pfet_05v0 ad=0.3806p pd=2.61u as=0.2249p ps=1.385u w=0.865u l=0.5u
X14 a_1204_472# a_36_151# a_1000_472# VNW pfet_05v0 ad=0.2028p pd=1.3u as=0.2028p ps=1.3u w=0.78u l=0.5u
X15 a_1204_472# RN VDD VNW pfet_05v0 ad=0.3432p pd=2.44u as=0.45p ps=2.02u w=0.78u l=0.5u
X16 a_2665_112# RN VDD VNW pfet_05v0 ad=0.26p pd=1.52u as=0.29465p ps=1.74u w=1u l=0.5u
X17 a_2560_156# a_36_151# a_2248_156# VPW nfet_05v0 ad=94.5f pd=0.885u as=0.2007p ps=1.475u w=0.36u l=0.6u
X18 VDD a_2248_156# a_2665_112# VNW pfet_05v0 ad=0.44p pd=2.88u as=0.26p ps=1.52u w=1u l=0.5u
X19 a_1288_156# a_448_472# a_1000_472# VPW nfet_05v0 ad=43.2f pd=0.6u as=93.59999f ps=0.88u w=0.36u l=0.6u
X20 VDD a_1308_423# a_1204_472# VNW pfet_05v0 ad=0.45p pd=2.02u as=0.2028p ps=1.3u w=0.78u l=0.5u
X21 a_2560_156# a_448_472# a_2248_156# VNW pfet_05v0 ad=0.1313p pd=1.025u as=0.25375p ps=1.51u w=0.505u l=0.5u
X22 a_448_472# a_36_151# VSS VPW nfet_05v0 ad=0.1782p pd=1.69u as=0.1053p ps=0.925u w=0.405u l=0.6u
X23 a_3041_156# RN VSS VPW nfet_05v0 ad=0.134p pd=1.1u as=0.1224p ps=1.04u w=0.36u l=0.6u
X24 VDD a_2665_112# a_2560_156# VNW pfet_05v0 ad=0.29465p pd=1.74u as=0.1313p ps=1.025u w=0.505u l=0.5u
X25 a_1308_423# a_1000_472# VDD VNW pfet_05v0 ad=0.2424p pd=1.465u as=0.2222p ps=1.89u w=0.505u l=0.5u
X26 a_1000_472# a_36_151# a_796_472# VPW nfet_05v0 ad=93.59999f pd=0.88u as=93.59999f ps=0.88u w=0.36u l=0.6u
X27 a_796_472# D VDD VNW pfet_05v0 ad=0.2028p pd=1.3u as=0.3432p ps=2.44u w=0.78u l=0.5u
.ends

.subckt gf180mcu_fd_sc_mcu7t5v0__fillcap_16 VDD VSS VNW VPW
X0 VDD a_572_375# a_484_472# VNW pfet_05v0 ad=0.5368p pd=3.32u as=0.5368p ps=3.32u w=1.22u l=1u
X1 a_572_375# a_484_472# VSS VPW nfet_05v0 ad=0.3608p pd=2.52u as=0.3608p ps=2.52u w=0.82u l=1u
X2 a_124_375# a_36_472# VSS VPW nfet_05v0 ad=0.3608p pd=2.52u as=0.3608p ps=2.52u w=0.82u l=1u
X3 a_1468_375# a_1380_472# VSS VPW nfet_05v0 ad=0.3608p pd=2.52u as=0.3608p ps=2.52u w=0.82u l=1u
X4 VDD a_1020_375# a_932_472# VNW pfet_05v0 ad=0.5368p pd=3.32u as=0.5368p ps=3.32u w=1.22u l=1u
X5 VDD a_1468_375# a_1380_472# VNW pfet_05v0 ad=0.5368p pd=3.32u as=0.5368p ps=3.32u w=1.22u l=1u
X6 VDD a_124_375# a_36_472# VNW pfet_05v0 ad=0.5368p pd=3.32u as=0.5368p ps=3.32u w=1.22u l=1u
X7 a_1020_375# a_932_472# VSS VPW nfet_05v0 ad=0.3608p pd=2.52u as=0.3608p ps=2.52u w=0.82u l=1u
.ends

.subckt gf180mcu_fd_sc_mcu7t5v0__nand2_1 VDD VSS ZN A1 A2 VNW VPW
X0 ZN A2 VDD VNW pfet_05v0 ad=0.2938p pd=1.65u as=0.4972p ps=3.14u w=1.13u l=0.5u
X1 ZN A1 a_245_68# VPW nfet_05v0 ad=0.3608p pd=2.52u as=0.1312p ps=1.14u w=0.82u l=0.6u
X2 VDD A1 ZN VNW pfet_05v0 ad=0.4972p pd=3.14u as=0.2938p ps=1.65u w=1.13u l=0.5u
X3 a_245_68# A2 VSS VPW nfet_05v0 ad=0.1312p pd=1.14u as=0.3608p ps=2.52u w=0.82u l=0.6u
.ends

.subckt gf180mcu_fd_sc_mcu7t5v0__mux2_2 S VDD VSS Z I0 I1 VNW VPW
X0 a_1152_472# S a_124_24# VNW pfet_05v0 ad=0.1464p pd=1.46u as=0.3172p ps=1.74u w=1.22u l=0.5u
X1 a_692_68# I1 VSS VPW nfet_05v0 ad=98.39999f pd=1.06u as=0.2132p ps=1.34u w=0.82u l=0.6u
X2 a_124_24# S a_692_68# VPW nfet_05v0 ad=0.2132p pd=1.34u as=98.39999f ps=1.06u w=0.82u l=0.6u
X3 Z a_124_24# VSS VPW nfet_05v0 ad=0.2132p pd=1.34u as=0.3608p ps=2.52u w=0.82u l=0.6u
X4 a_848_380# S VSS VPW nfet_05v0 ad=0.3608p pd=2.52u as=0.2132p ps=1.34u w=0.82u l=0.6u
X5 VDD a_124_24# Z VNW pfet_05v0 ad=0.4392p pd=1.94u as=0.3477p ps=1.79u w=1.22u l=0.5u
X6 VDD I0 a_1152_472# VNW pfet_05v0 ad=0.3172p pd=1.74u as=0.1464p ps=1.46u w=1.22u l=0.5u
X7 a_692_472# I1 VDD VNW pfet_05v0 ad=0.4758p pd=2u as=0.4392p ps=1.94u w=1.22u l=0.5u
X8 a_848_380# S VDD VNW pfet_05v0 ad=0.5368p pd=3.32u as=0.3172p ps=1.74u w=1.22u l=0.5u
X9 Z a_124_24# VDD VNW pfet_05v0 ad=0.3477p pd=1.79u as=0.5368p ps=3.32u w=1.22u l=0.5u
X10 VSS I0 a_1084_68# VPW nfet_05v0 ad=0.2132p pd=1.34u as=0.1968p ps=1.3u w=0.82u l=0.6u
X11 a_1084_68# a_848_380# a_124_24# VPW nfet_05v0 ad=0.1968p pd=1.3u as=0.2132p ps=1.34u w=0.82u l=0.6u
X12 VSS a_124_24# Z VPW nfet_05v0 ad=0.2132p pd=1.34u as=0.2132p ps=1.34u w=0.82u l=0.6u
X13 a_124_24# a_848_380# a_692_472# VNW pfet_05v0 ad=0.3172p pd=1.74u as=0.4758p ps=2u w=1.22u l=0.5u
.ends

.subckt gf180mcu_fd_sc_mcu7t5v0__fillcap_32 VDD VSS VNW VPW
X0 VDD a_572_375# a_484_472# VNW pfet_05v0 ad=0.5368p pd=3.32u as=0.5368p ps=3.32u w=1.22u l=1u
X1 VDD a_2364_375# a_2276_472# VNW pfet_05v0 ad=0.5368p pd=3.32u as=0.5368p ps=3.32u w=1.22u l=1u
X2 a_572_375# a_484_472# VSS VPW nfet_05v0 ad=0.3608p pd=2.52u as=0.3608p ps=2.52u w=0.82u l=1u
X3 VDD a_1916_375# a_1828_472# VNW pfet_05v0 ad=0.5368p pd=3.32u as=0.5368p ps=3.32u w=1.22u l=1u
X4 a_124_375# a_36_472# VSS VPW nfet_05v0 ad=0.3608p pd=2.52u as=0.3608p ps=2.52u w=0.82u l=1u
X5 a_1916_375# a_1828_472# VSS VPW nfet_05v0 ad=0.3608p pd=2.52u as=0.3608p ps=2.52u w=0.82u l=1u
X6 a_1468_375# a_1380_472# VSS VPW nfet_05v0 ad=0.3608p pd=2.52u as=0.3608p ps=2.52u w=0.82u l=1u
X7 a_2812_375# a_2724_472# VSS VPW nfet_05v0 ad=0.3608p pd=2.52u as=0.3608p ps=2.52u w=0.82u l=1u
X8 VDD a_3260_375# a_3172_472# VNW pfet_05v0 ad=0.5368p pd=3.32u as=0.5368p ps=3.32u w=1.22u l=1u
X9 a_2364_375# a_2276_472# VSS VPW nfet_05v0 ad=0.3608p pd=2.52u as=0.3608p ps=2.52u w=0.82u l=1u
X10 VDD a_2812_375# a_2724_472# VNW pfet_05v0 ad=0.5368p pd=3.32u as=0.5368p ps=3.32u w=1.22u l=1u
X11 a_3260_375# a_3172_472# VSS VPW nfet_05v0 ad=0.3608p pd=2.52u as=0.3608p ps=2.52u w=0.82u l=1u
X12 VDD a_1020_375# a_932_472# VNW pfet_05v0 ad=0.5368p pd=3.32u as=0.5368p ps=3.32u w=1.22u l=1u
X13 VDD a_1468_375# a_1380_472# VNW pfet_05v0 ad=0.5368p pd=3.32u as=0.5368p ps=3.32u w=1.22u l=1u
X14 VDD a_124_375# a_36_472# VNW pfet_05v0 ad=0.5368p pd=3.32u as=0.5368p ps=3.32u w=1.22u l=1u
X15 a_1020_375# a_932_472# VSS VPW nfet_05v0 ad=0.3608p pd=2.52u as=0.3608p ps=2.52u w=0.82u l=1u
.ends

.subckt gf180mcu_fd_sc_mcu7t5v0__fillcap_4 VDD VSS VNW VPW
X0 a_124_375# a_36_472# VSS VPW nfet_05v0 ad=0.3608p pd=2.52u as=0.3608p ps=2.52u w=0.82u l=1u
X1 VDD a_124_375# a_36_472# VNW pfet_05v0 ad=0.5368p pd=3.32u as=0.5368p ps=3.32u w=1.22u l=1u
.ends

.subckt gf180mcu_fd_sc_mcu7t5v0__dffq_1 VDD Q CLK VSS D VNW VPW
X0 VSS CLK a_36_151# VPW nfet_05v0 ad=0.1053p pd=0.925u as=0.1782p ps=1.69u w=0.405u l=0.6u
X1 Q a_2304_115# VSS VPW nfet_05v0 ad=0.3608p pd=2.52u as=0.3608p ps=2.52u w=0.82u l=0.6u
X2 a_2304_115# a_2011_527# VSS VPW nfet_05v0 ad=0.176p pd=1.68u as=0.142p ps=1.14u w=0.4u l=0.6u
X3 a_1004_159# D a_836_159# VPW nfet_05v0 ad=0.207p pd=1.51u as=43.2f ps=0.6u w=0.36u l=0.6u
X4 a_1004_159# D a_880_527# VNW pfet_05v0 ad=0.1872p pd=1.4u as=54f ps=0.66u w=0.36u l=0.5u
X5 a_2011_527# a_36_151# a_1376_115# VNW pfet_05v0 ad=0.1665p pd=1.285u as=0.1791p ps=1.355u w=0.36u l=0.5u
X6 a_2296_527# a_448_472# a_2011_527# VNW pfet_05v0 ad=50.4f pd=0.64u as=0.1665p ps=1.285u w=0.36u l=0.5u
X7 a_1376_115# a_1004_159# VDD VNW pfet_05v0 ad=0.1791p pd=1.355u as=0.1044p ps=0.94u w=0.36u l=0.5u
X8 VDD CLK a_36_151# VNW pfet_05v0 ad=0.2249p pd=1.385u as=0.3806p ps=2.61u w=0.865u l=0.5u
X9 VSS a_1376_115# a_1328_159# VPW nfet_05v0 ad=0.2637p pd=1.825u as=43.2f ps=0.6u w=0.36u l=0.6u
X10 a_2011_527# a_448_472# a_1376_115# VPW nfet_05v0 ad=93.59999f pd=0.88u as=93.59999f ps=0.88u w=0.36u l=0.6u
X11 a_448_472# a_36_151# VDD VNW pfet_05v0 ad=0.3806p pd=2.61u as=0.2249p ps=1.385u w=0.865u l=0.5u
X12 Q a_2304_115# VDD VNW pfet_05v0 ad=0.5368p pd=3.32u as=0.5368p ps=3.32u w=1.22u l=0.5u
X13 a_1376_115# a_1004_159# VSS VPW nfet_05v0 ad=93.59999f pd=0.88u as=0.2637p ps=1.825u w=0.36u l=0.6u
X14 VSS a_2304_115# a_2256_159# VPW nfet_05v0 ad=0.142p pd=1.14u as=43.2f ps=0.6u w=0.36u l=0.6u
X15 a_836_159# a_36_151# VSS VPW nfet_05v0 ad=43.2f pd=0.6u as=0.1584p ps=1.6u w=0.36u l=0.6u
X16 a_448_472# a_36_151# VSS VPW nfet_05v0 ad=0.1782p pd=1.69u as=0.1053p ps=0.925u w=0.405u l=0.6u
X17 a_2256_159# a_36_151# a_2011_527# VPW nfet_05v0 ad=43.2f pd=0.6u as=93.59999f ps=0.88u w=0.36u l=0.6u
X18 a_880_527# a_448_472# VDD VNW pfet_05v0 ad=54f pd=0.66u as=0.4554p ps=3.25u w=0.36u l=0.5u
X19 a_1348_527# a_36_151# a_1004_159# VNW pfet_05v0 ad=43.2f pd=0.6u as=0.1872p ps=1.4u w=0.36u l=0.5u
X20 a_1328_159# a_448_472# a_1004_159# VPW nfet_05v0 ad=43.2f pd=0.6u as=0.207p ps=1.51u w=0.36u l=0.6u
X21 VDD a_1376_115# a_1348_527# VNW pfet_05v0 ad=0.1044p pd=0.94u as=43.2f ps=0.6u w=0.36u l=0.5u
X22 VDD a_2304_115# a_2296_527# VNW pfet_05v0 ad=0.23p pd=1.54u as=50.4f ps=0.64u w=0.36u l=0.5u
X23 a_2304_115# a_2011_527# VDD VNW pfet_05v0 ad=0.352p pd=2.48u as=0.23p ps=1.54u w=0.8u l=0.5u
.ends

.subckt gf180mcu_fd_sc_mcu7t5v0__fillcap_8 VDD VSS VNW VPW
X0 VDD a_572_375# a_484_472# VNW pfet_05v0 ad=0.5368p pd=3.32u as=0.5368p ps=3.32u w=1.22u l=1u
X1 a_572_375# a_484_472# VSS VPW nfet_05v0 ad=0.3608p pd=2.52u as=0.3608p ps=2.52u w=0.82u l=1u
X2 a_124_375# a_36_472# VSS VPW nfet_05v0 ad=0.3608p pd=2.52u as=0.3608p ps=2.52u w=0.82u l=1u
X3 VDD a_124_375# a_36_472# VNW pfet_05v0 ad=0.5368p pd=3.32u as=0.5368p ps=3.32u w=1.22u l=1u
.ends

.subckt gf180mcu_fd_sc_mcu7t5v0__oai211_1 B C VDD VSS ZN A1 A2 VNW VPW
X0 a_692_68# B a_36_68# VPW nfet_05v0 ad=0.2132p pd=1.34u as=0.2132p ps=1.34u w=0.82u l=0.6u
X1 ZN A2 a_36_68# VPW nfet_05v0 ad=0.2132p pd=1.34u as=0.3608p ps=2.52u w=0.82u l=0.6u
X2 a_244_472# A2 VDD VNW pfet_05v0 ad=0.3172p pd=1.74u as=0.5978p ps=3.42u w=1.22u l=0.5u
X3 VDD B ZN VNW pfet_05v0 ad=0.2561p pd=1.505u as=0.4016p ps=1.94u w=0.985u l=0.5u
X4 ZN A1 a_244_472# VNW pfet_05v0 ad=0.4016p pd=1.94u as=0.3172p ps=1.74u w=1.22u l=0.5u
X5 ZN C VDD VNW pfet_05v0 ad=0.44325p pd=2.87u as=0.2561p ps=1.505u w=0.985u l=0.5u
X6 VSS C a_692_68# VPW nfet_05v0 ad=0.3608p pd=2.52u as=0.2132p ps=1.34u w=0.82u l=0.6u
X7 a_36_68# A1 ZN VPW nfet_05v0 ad=0.2132p pd=1.34u as=0.2132p ps=1.34u w=0.82u l=0.6u
.ends

.subckt gf180mcu_fd_sc_mcu7t5v0__aoi22_1 B1 B2 VDD VSS ZN A1 A2 VNW VPW
X0 ZN B1 a_257_69# VPW nfet_05v0 ad=0.2119p pd=1.335u as=0.1304p ps=1.135u w=0.815u l=0.6u
X1 VDD B2 a_49_472# VNW pfet_05v0 ad=0.3159p pd=1.735u as=0.5346p ps=3.31u w=1.215u l=0.5u
X2 a_49_472# B1 VDD VNW pfet_05v0 ad=0.3159p pd=1.735u as=0.3159p ps=1.735u w=1.215u l=0.5u
X3 ZN A1 a_49_472# VNW pfet_05v0 ad=0.3159p pd=1.735u as=0.3159p ps=1.735u w=1.215u l=0.5u
X4 a_49_472# A2 ZN VNW pfet_05v0 ad=0.5346p pd=3.31u as=0.3159p ps=1.735u w=1.215u l=0.5u
X5 a_257_69# B2 VSS VPW nfet_05v0 ad=0.1304p pd=1.135u as=0.3586p ps=2.51u w=0.815u l=0.6u
X6 a_665_69# A1 ZN VPW nfet_05v0 ad=0.1304p pd=1.135u as=0.2119p ps=1.335u w=0.815u l=0.6u
X7 VSS A2 a_665_69# VPW nfet_05v0 ad=0.3586p pd=2.51u as=0.1304p ps=1.135u w=0.815u l=0.6u
.ends

.subckt gf180mcu_fd_sc_mcu7t5v0__xor2_1 VDD VSS Z A1 A2 VNW VPW
X0 a_728_472# a_56_604# VDD VNW pfet_05v0 ad=0.3172p pd=1.74u as=0.4005p ps=2.12u w=1.22u l=0.5u
X1 Z A1 a_728_472# VNW pfet_05v0 ad=0.3172p pd=1.74u as=0.3172p ps=1.74u w=1.22u l=0.5u
X2 VSS A1 a_56_604# VPW nfet_05v0 ad=0.218p pd=1.52u as=93.59999f ps=0.88u w=0.36u l=0.6u
X3 a_728_472# A2 Z VNW pfet_05v0 ad=0.5368p pd=3.32u as=0.3172p ps=1.74u w=1.22u l=0.5u
X4 Z a_56_604# VSS VPW nfet_05v0 ad=0.2132p pd=1.34u as=0.218p ps=1.52u w=0.82u l=0.6u
X5 VSS A2 a_952_68# VPW nfet_05v0 ad=0.3608p pd=2.52u as=0.1312p ps=1.14u w=0.82u l=0.6u
X6 a_244_604# A2 a_56_604# VNW pfet_05v0 ad=0.1456p pd=1.08u as=0.2464p ps=2u w=0.56u l=0.5u
X7 a_56_604# A2 VSS VPW nfet_05v0 ad=93.59999f pd=0.88u as=0.1584p ps=1.6u w=0.36u l=0.6u
X8 a_952_68# A1 Z VPW nfet_05v0 ad=0.1312p pd=1.14u as=0.2132p ps=1.34u w=0.82u l=0.6u
X9 VDD A1 a_244_604# VNW pfet_05v0 ad=0.4005p pd=2.12u as=0.1456p ps=1.08u w=0.56u l=0.5u
.ends

.subckt gf180mcu_fd_sc_mcu7t5v0__aoi21_1 B VDD VSS ZN A1 A2 VNW VPW
X0 a_244_68# A2 VSS VPW nfet_05v0 ad=0.1312p pd=1.14u as=0.3608p ps=2.52u w=0.82u l=0.6u
X1 ZN A1 a_244_68# VPW nfet_05v0 ad=0.2569p pd=1.56u as=0.1312p ps=1.14u w=0.82u l=0.6u
X2 VDD B a_36_472# VNW pfet_05v0 ad=0.5346p pd=3.31u as=0.44955p ps=1.955u w=1.215u l=0.5u
X3 ZN A2 a_36_472# VNW pfet_05v0 ad=0.3159p pd=1.735u as=0.5346p ps=3.31u w=1.215u l=0.5u
X4 a_36_472# A1 ZN VNW pfet_05v0 ad=0.44955p pd=1.955u as=0.3159p ps=1.735u w=1.215u l=0.5u
X5 VSS B ZN VPW nfet_05v0 ad=0.2244p pd=1.9u as=0.2569p ps=1.56u w=0.51u l=0.6u
.ends

.subckt gf180mcu_fd_sc_mcu7t5v0__nor2_1 VDD VSS ZN A1 A2 VNW VPW
X0 ZN A1 a_224_472# VNW pfet_05v0 ad=0.5368p pd=3.32u as=0.4087p ps=1.89u w=1.22u l=0.5u
X1 VSS A1 ZN VPW nfet_05v0 ad=0.2486p pd=2.01u as=0.1469p ps=1.085u w=0.565u l=0.6u
X2 a_224_472# A2 VDD VNW pfet_05v0 ad=0.4087p pd=1.89u as=0.5368p ps=3.32u w=1.22u l=0.5u
X3 ZN A2 VSS VPW nfet_05v0 ad=0.1469p pd=1.085u as=0.2486p ps=2.01u w=0.565u l=0.6u
.ends

.subckt gf180mcu_fd_sc_mcu7t5v0__clkinv_1 VDD VSS I ZN VNW VPW
X0 ZN I VSS VPW nfet_05v0 ad=0.2112p pd=1.84u as=0.2112p ps=1.84u w=0.48u l=0.6u
X1 ZN I VDD VNW pfet_05v0 ad=0.5368p pd=3.32u as=0.5368p ps=3.32u w=1.22u l=0.5u
.ends

.subckt gf180mcu_fd_sc_mcu7t5v0__buf_2 VSS Z I VDD VNW VPW
X0 Z a_36_68# VDD VNW pfet_05v0 ad=0.3782p pd=1.84u as=0.4941p ps=2.03u w=1.22u l=0.5u
X1 VSS I a_36_68# VPW nfet_05v0 ad=0.2911p pd=1.53u as=0.3608p ps=2.52u w=0.82u l=0.6u
X2 Z a_36_68# VSS VPW nfet_05v0 ad=0.2132p pd=1.34u as=0.2911p ps=1.53u w=0.82u l=0.6u
X3 VDD I a_36_68# VNW pfet_05v0 ad=0.4941p pd=2.03u as=0.5368p ps=3.32u w=1.22u l=0.5u
X4 VSS a_36_68# Z VPW nfet_05v0 ad=0.3608p pd=2.52u as=0.2132p ps=1.34u w=0.82u l=0.6u
X5 VDD a_36_68# Z VNW pfet_05v0 ad=0.5368p pd=3.32u as=0.3782p ps=1.84u w=1.22u l=0.5u
.ends

.subckt gf180mcu_fd_sc_mcu7t5v0__buf_8 Z I VDD VSS VNW VPW
X0 a_224_472# I VDD VNW pfet_05v0 ad=0.3782p pd=1.84u as=0.3782p ps=1.84u w=1.22u l=0.5u
X1 Z a_224_472# VDD VNW pfet_05v0 ad=0.3782p pd=1.84u as=0.3782p ps=1.84u w=1.22u l=0.5u
X2 a_224_472# I VSS VPW nfet_05v0 ad=0.2132p pd=1.34u as=0.2132p ps=1.34u w=0.82u l=0.6u
X3 VSS a_224_472# Z VPW nfet_05v0 ad=0.3608p pd=2.52u as=0.2132p ps=1.34u w=0.82u l=0.6u
X4 VDD a_224_472# Z VNW pfet_05v0 ad=0.3782p pd=1.84u as=0.3782p ps=1.84u w=1.22u l=0.5u
X5 Z a_224_472# VDD VNW pfet_05v0 ad=0.3782p pd=1.84u as=0.3782p ps=1.84u w=1.22u l=0.5u
X6 a_224_472# I VSS VPW nfet_05v0 ad=0.2132p pd=1.34u as=0.3608p ps=2.52u w=0.82u l=0.6u
X7 Z a_224_472# VSS VPW nfet_05v0 ad=0.2132p pd=1.34u as=0.2132p ps=1.34u w=0.82u l=0.6u
X8 VDD a_224_472# Z VNW pfet_05v0 ad=0.3782p pd=1.84u as=0.3782p ps=1.84u w=1.22u l=0.5u
X9 Z a_224_472# VSS VPW nfet_05v0 ad=0.2132p pd=1.34u as=0.2132p ps=1.34u w=0.82u l=0.6u
X10 Z a_224_472# VSS VPW nfet_05v0 ad=0.2132p pd=1.34u as=0.2132p ps=1.34u w=0.82u l=0.6u
X11 VDD I a_224_472# VNW pfet_05v0 ad=0.3782p pd=1.84u as=0.3782p ps=1.84u w=1.22u l=0.5u
X12 VDD a_224_472# Z VNW pfet_05v0 ad=0.3782p pd=1.84u as=0.3782p ps=1.84u w=1.22u l=0.5u
X13 Z a_224_472# VDD VNW pfet_05v0 ad=0.3782p pd=1.84u as=0.3782p ps=1.84u w=1.22u l=0.5u
X14 VSS a_224_472# Z VPW nfet_05v0 ad=0.2132p pd=1.34u as=0.2132p ps=1.34u w=0.82u l=0.6u
X15 VDD I a_224_472# VNW pfet_05v0 ad=0.3782p pd=1.84u as=0.3782p ps=1.84u w=1.22u l=0.5u
X16 VSS a_224_472# Z VPW nfet_05v0 ad=0.2132p pd=1.34u as=0.2132p ps=1.34u w=0.82u l=0.6u
X17 VDD a_224_472# Z VNW pfet_05v0 ad=0.5368p pd=3.32u as=0.3782p ps=1.84u w=1.22u l=0.5u
X18 VSS a_224_472# Z VPW nfet_05v0 ad=0.2132p pd=1.34u as=0.2132p ps=1.34u w=0.82u l=0.6u
X19 Z a_224_472# VDD VNW pfet_05v0 ad=0.3782p pd=1.84u as=0.3782p ps=1.84u w=1.22u l=0.5u
X20 VSS I a_224_472# VPW nfet_05v0 ad=0.2132p pd=1.34u as=0.2132p ps=1.34u w=0.82u l=0.6u
X21 a_224_472# I VDD VNW pfet_05v0 ad=0.3782p pd=1.84u as=0.5368p ps=3.32u w=1.22u l=0.5u
X22 VSS I a_224_472# VPW nfet_05v0 ad=0.2132p pd=1.34u as=0.2132p ps=1.34u w=0.82u l=0.6u
X23 Z a_224_472# VSS VPW nfet_05v0 ad=0.2132p pd=1.34u as=0.2132p ps=1.34u w=0.82u l=0.6u
.ends

.subckt gf180mcu_fd_sc_mcu7t5v0__clkbuf_2 Z VSS VDD I VNW VPW
X0 VDD I a_36_160# VNW pfet_05v0 ad=0.458p pd=2.02u as=0.4488p ps=2.92u w=1.02u l=0.5u
X1 VSS I a_36_160# VPW nfet_05v0 ad=0.151p pd=1.185u as=0.1584p ps=1.6u w=0.36u l=0.6u
X2 VDD a_36_160# Z VNW pfet_05v0 ad=0.5368p pd=3.32u as=0.3782p ps=1.84u w=1.22u l=0.5u
X3 Z a_36_160# VDD VNW pfet_05v0 ad=0.3782p pd=1.84u as=0.458p ps=2.02u w=1.22u l=0.5u
X4 VSS a_36_160# Z VPW nfet_05v0 ad=0.2134p pd=1.85u as=0.1261p ps=1.005u w=0.485u l=0.6u
X5 Z a_36_160# VSS VPW nfet_05v0 ad=0.1261p pd=1.005u as=0.151p ps=1.185u w=0.485u l=0.6u
.ends

.subckt gf180mcu_fd_sc_mcu7t5v0__mux4_1 I0 VSS VDD I2 I1 S0 I3 S1 Z VNW VPW
X0 VDD S1 a_1525_369# VNW pfet_05v0 ad=0.17515p pd=1.185u as=0.2486p ps=2.01u w=0.565u l=0.5u
X1 a_2929_515# S0 a_1901_156# VNW pfet_05v0 ad=0.2034p pd=1.285u as=0.1469p ps=1.085u w=0.565u l=0.5u
X2 Z a_1081_112# VSS VPW nfet_05v0 ad=0.1672p pd=1.64u as=0.13075p ps=1.08u w=0.38u l=0.6u
X3 VSS I3 a_712_156# VPW nfet_05v0 ad=0.13075p pd=1.08u as=99.45f ps=0.91u w=0.365u l=0.6u
X4 Z a_1081_112# VDD VNW pfet_05v0 ad=0.3432p pd=2.44u as=0.24075p ps=1.48u w=0.78u l=0.5u
X5 VSS I0 a_2929_515# VPW nfet_05v0 ad=94.89999f pd=0.885u as=94.89999f ps=0.885u w=0.365u l=0.6u
X6 VDD I3 a_712_156# VNW pfet_05v0 ad=0.24075p pd=1.48u as=0.1596p ps=1.13u w=0.565u l=0.5u
X7 a_1901_156# S0 a_2521_156# VPW nfet_05v0 ad=94.89999f pd=0.885u as=94.89999f ps=0.885u w=0.365u l=0.6u
X8 a_468_156# a_348_112# a_224_515# VPW nfet_05v0 ad=0.11315p pd=0.985u as=94.89999f ps=0.885u w=0.365u l=0.6u
X9 a_468_156# S0 a_224_515# VNW pfet_05v0 ad=0.18645p pd=1.225u as=0.24295p ps=1.425u w=0.565u l=0.5u
X10 a_224_515# I2 VDD VNW pfet_05v0 ad=0.24295p pd=1.425u as=0.2486p ps=2.01u w=0.565u l=0.5u
X11 a_1901_156# S1 a_1081_112# VNW pfet_05v0 ad=0.2486p pd=2.01u as=0.2486p ps=1.445u w=0.565u l=0.5u
X12 a_712_156# S0 a_468_156# VPW nfet_05v0 ad=99.45f pd=0.91u as=0.11315p ps=0.985u w=0.365u l=0.6u
X13 a_348_112# S0 VDD VNW pfet_05v0 ad=0.2486p pd=2.01u as=0.17515p ps=1.185u w=0.565u l=0.5u
X14 a_1081_112# a_1525_369# a_468_156# VNW pfet_05v0 ad=0.2486p pd=1.445u as=0.36725p ps=2.43u w=0.565u l=0.5u
X15 a_712_156# a_348_112# a_468_156# VNW pfet_05v0 ad=0.1596p pd=1.13u as=0.18645p ps=1.225u w=0.565u l=0.5u
X16 a_2521_156# I1 VSS VPW nfet_05v0 ad=94.89999f pd=0.885u as=94.89999f ps=0.885u w=0.365u l=0.6u
X17 a_224_515# I2 VSS VPW nfet_05v0 ad=94.89999f pd=0.885u as=0.1606p ps=1.61u w=0.365u l=0.6u
X18 a_348_112# S0 VSS VPW nfet_05v0 ad=0.1606p pd=1.61u as=94.89999f ps=0.885u w=0.365u l=0.6u
X19 a_2521_156# I1 VDD VNW pfet_05v0 ad=0.1469p pd=1.085u as=0.17515p ps=1.185u w=0.565u l=0.5u
X20 VSS S1 a_1525_369# VPW nfet_05v0 ad=94.89999f pd=0.885u as=0.1606p ps=1.61u w=0.365u l=0.6u
X21 VDD I0 a_2929_515# VNW pfet_05v0 ad=0.17515p pd=1.185u as=0.2034p ps=1.285u w=0.565u l=0.5u
X22 a_2929_515# a_348_112# a_1901_156# VPW nfet_05v0 ad=94.89999f pd=0.885u as=94.89999f ps=0.885u w=0.365u l=0.6u
X23 a_1081_112# S1 a_468_156# VPW nfet_05v0 ad=0.11315p pd=0.985u as=0.26462p ps=2.18u w=0.365u l=0.6u
X24 a_1901_156# a_348_112# a_2521_156# VNW pfet_05v0 ad=0.1469p pd=1.085u as=0.1469p ps=1.085u w=0.565u l=0.5u
X25 a_1901_156# a_1525_369# a_1081_112# VPW nfet_05v0 ad=0.1606p pd=1.61u as=0.11315p ps=0.985u w=0.365u l=0.6u
.ends

.subckt gf180mcu_fd_sc_mcu7t5v0__aoi221_1 B2 C VDD VSS ZN A1 A2 B1 VNW VPW
X0 a_672_472# C a_56_472# VNW pfet_05v0 ad=0.3402p pd=1.775u as=0.37665p ps=1.835u w=1.215u l=0.5u
X1 VDD B2 a_56_472# VNW pfet_05v0 ad=0.3159p pd=1.735u as=0.5346p ps=3.31u w=1.215u l=0.5u
X2 ZN A1 a_940_90# VPW nfet_05v0 ad=0.3124p pd=2.3u as=85.2f ps=0.95u w=0.71u l=0.6u
X3 a_56_472# B1 VDD VNW pfet_05v0 ad=0.37665p pd=1.835u as=0.3159p ps=1.735u w=1.215u l=0.5u
X4 a_672_472# A1 ZN VNW pfet_05v0 ad=0.5346p pd=3.31u as=0.37665p ps=1.835u w=1.215u l=0.5u
X5 ZN A2 a_672_472# VNW pfet_05v0 ad=0.37665p pd=1.835u as=0.3402p ps=1.775u w=1.215u l=0.5u
X6 a_244_90# B2 VSS VPW nfet_05v0 ad=85.2f pd=0.95u as=0.3124p ps=2.3u w=0.71u l=0.6u
X7 ZN B1 a_244_90# VPW nfet_05v0 ad=0.21175p pd=1.41u as=85.2f ps=0.95u w=0.71u l=0.6u
X8 a_940_90# A2 VSS VPW nfet_05v0 ad=85.2f pd=0.95u as=0.22595p ps=1.45u w=0.71u l=0.6u
X9 VSS C ZN VPW nfet_05v0 ad=0.22595p pd=1.45u as=0.21175p ps=1.41u w=0.465u l=0.6u
.ends

.subckt gf180mcu_fd_sc_mcu7t5v0__oai21_1 VDD B A2 ZN A1 VSS VNW VPW
X0 VSS B a_36_68# VPW nfet_05v0 ad=0.3608p pd=2.52u as=0.2132p ps=1.34u w=0.82u l=0.6u
X1 ZN A2 a_36_68# VPW nfet_05v0 ad=0.2132p pd=1.34u as=0.3608p ps=2.52u w=0.82u l=0.6u
X2 VDD B ZN VNW pfet_05v0 ad=0.4972p pd=3.14u as=0.4248p ps=1.94u w=1.13u l=0.5u
X3 a_244_472# A2 VDD VNW pfet_05v0 ad=0.3172p pd=1.74u as=0.5978p ps=3.42u w=1.22u l=0.5u
X4 ZN A1 a_244_472# VNW pfet_05v0 ad=0.4248p pd=1.94u as=0.3172p ps=1.74u w=1.22u l=0.5u
X5 a_36_68# A1 ZN VPW nfet_05v0 ad=0.2132p pd=1.34u as=0.2132p ps=1.34u w=0.82u l=0.6u
.ends

.subckt gf180mcu_fd_sc_mcu7t5v0__tiel ZN VDD VSS VNW VPW
X0 ZN a_124_24# VSS VPW nfet_05v0 ad=0.3608p pd=2.52u as=0.3608p ps=2.52u w=0.82u l=0.6u
X1 a_124_24# a_124_24# VDD VNW pfet_05v0 ad=0.5368p pd=3.32u as=0.5368p ps=3.32u w=1.22u l=0.5u
.ends

.subckt gf180mcu_fd_sc_mcu7t5v0__clkbuf_1 VSS Z I VDD VNW VPW
X0 VDD I a_36_113# VNW pfet_05v0 ad=0.4015p pd=1.92u as=0.462p ps=2.98u w=1.05u l=0.5u
X1 Z a_36_113# VDD VNW pfet_05v0 ad=0.5368p pd=3.32u as=0.4015p ps=1.92u w=1.22u l=0.5u
X2 Z a_36_113# VSS VPW nfet_05v0 ad=0.2178p pd=1.87u as=0.153p ps=1.195u w=0.495u l=0.6u
X3 VSS I a_36_113# VPW nfet_05v0 ad=0.153p pd=1.195u as=0.1584p ps=1.6u w=0.36u l=0.6u
.ends

.subckt gf180mcu_fd_sc_mcu7t5v0__buf_4 Z I VDD VSS VNW VPW
X0 Z a_224_472# VDD VNW pfet_05v0 ad=0.3782p pd=1.84u as=0.3782p ps=1.84u w=1.22u l=0.5u
X1 Z a_224_472# VSS VPW nfet_05v0 ad=0.2132p pd=1.34u as=0.2132p ps=1.34u w=0.82u l=0.6u
X2 VDD a_224_472# Z VNW pfet_05v0 ad=0.5368p pd=3.32u as=0.3782p ps=1.84u w=1.22u l=0.5u
X3 a_224_472# I VSS VPW nfet_05v0 ad=0.2132p pd=1.34u as=0.3608p ps=2.52u w=0.82u l=0.6u
X4 VDD I a_224_472# VNW pfet_05v0 ad=0.3782p pd=1.84u as=0.3782p ps=1.84u w=1.22u l=0.5u
X5 Z a_224_472# VDD VNW pfet_05v0 ad=0.3782p pd=1.84u as=0.3782p ps=1.84u w=1.22u l=0.5u
X6 VDD a_224_472# Z VNW pfet_05v0 ad=0.3782p pd=1.84u as=0.3782p ps=1.84u w=1.22u l=0.5u
X7 VSS a_224_472# Z VPW nfet_05v0 ad=0.3608p pd=2.52u as=0.2132p ps=1.34u w=0.82u l=0.6u
X8 VSS a_224_472# Z VPW nfet_05v0 ad=0.2132p pd=1.34u as=0.2132p ps=1.34u w=0.82u l=0.6u
X9 a_224_472# I VDD VNW pfet_05v0 ad=0.3782p pd=1.84u as=0.5368p ps=3.32u w=1.22u l=0.5u
X10 VSS I a_224_472# VPW nfet_05v0 ad=0.2132p pd=1.34u as=0.2132p ps=1.34u w=0.82u l=0.6u
X11 Z a_224_472# VSS VPW nfet_05v0 ad=0.2132p pd=1.34u as=0.2132p ps=1.34u w=0.82u l=0.6u
.ends

.subckt gf180mcu_fd_sc_mcu7t5v0__nand3_1 A3 VDD VSS ZN A1 A2 VNW VPW
X0 ZN A1 a_455_68# VPW nfet_05v0 ad=0.3608p pd=2.52u as=0.1722p ps=1.24u w=0.82u l=0.6u
X1 ZN A3 VDD VNW pfet_05v0 ad=0.2561p pd=1.505u as=0.4334p ps=2.85u w=0.985u l=0.5u
X2 VDD A2 ZN VNW pfet_05v0 ad=0.2561p pd=1.505u as=0.2561p ps=1.505u w=0.985u l=0.5u
X3 ZN A1 VDD VNW pfet_05v0 ad=0.4334p pd=2.85u as=0.2561p ps=1.505u w=0.985u l=0.5u
X4 a_271_68# A3 VSS VPW nfet_05v0 ad=0.1312p pd=1.14u as=0.3608p ps=2.52u w=0.82u l=0.6u
X5 a_455_68# A2 a_271_68# VPW nfet_05v0 ad=0.1722p pd=1.24u as=0.1312p ps=1.14u w=0.82u l=0.6u
.ends

.subckt gf180mcu_fd_sc_mcu7t5v0__aoi211_1 B C VDD VSS ZN A1 A2 VNW VPW
X0 ZN A2 a_37_472# VNW pfet_05v0 ad=0.3159p pd=1.735u as=0.5346p ps=3.31u w=1.215u l=0.5u
X1 VSS B ZN VPW nfet_05v0 ad=0.1209p pd=0.985u as=0.21175p ps=1.41u w=0.465u l=0.6u
X2 a_37_472# A1 ZN VNW pfet_05v0 ad=0.37665p pd=1.835u as=0.3159p ps=1.735u w=1.215u l=0.5u
X3 VDD C a_653_472# VNW pfet_05v0 ad=0.5346p pd=3.31u as=0.37665p ps=1.835u w=1.215u l=0.5u
X4 a_245_90# A2 VSS VPW nfet_05v0 ad=85.2f pd=0.95u as=0.3124p ps=2.3u w=0.71u l=0.6u
X5 ZN A1 a_245_90# VPW nfet_05v0 ad=0.21175p pd=1.41u as=85.2f ps=0.95u w=0.71u l=0.6u
X6 a_653_472# B a_37_472# VNW pfet_05v0 ad=0.37665p pd=1.835u as=0.37665p ps=1.835u w=1.215u l=0.5u
X7 ZN C VSS VPW nfet_05v0 ad=0.2046p pd=1.81u as=0.1209p ps=0.985u w=0.465u l=0.6u
.ends

.subckt gf180mcu_fd_sc_mcu7t5v0__and2_1 VDD VSS Z A1 A2 VNW VPW
X0 VDD A2 a_36_159# VNW pfet_05v0 ad=0.40575p pd=2.055u as=0.156p ps=1.12u w=0.6u l=0.5u
X1 Z a_36_159# VDD VNW pfet_05v0 ad=0.5346p pd=3.31u as=0.40575p ps=2.055u w=1.215u l=0.5u
X2 Z a_36_159# VSS VPW nfet_05v0 ad=0.3586p pd=2.51u as=0.23405p ps=1.555u w=0.815u l=0.6u
X3 VSS A2 a_244_159# VPW nfet_05v0 ad=0.23405p pd=1.555u as=58.39999f ps=0.685u w=0.365u l=0.6u
X4 a_244_159# A1 a_36_159# VPW nfet_05v0 ad=58.39999f pd=0.685u as=0.1606p ps=1.61u w=0.365u l=0.6u
X5 a_36_159# A1 VDD VNW pfet_05v0 ad=0.156p pd=1.12u as=0.264p ps=2.08u w=0.6u l=0.5u
.ends

.subckt gf180mcu_fd_sc_mcu7t5v0__dlyb_1 VDD I VSS Z VNW VPW
X0 a_523_68# a_47_68# VSS VPW nfet_05v0 ad=43.2f pd=0.6u as=93.59999f ps=0.88u w=0.36u l=0.6u
X1 a_671_644# a_47_68# a_523_68# VPW nfet_05v0 ad=0.369p pd=2.77u as=43.2f ps=0.6u w=0.36u l=0.6u
X2 a_503_644# a_47_68# VDD VNW pfet_05v0 ad=61.19999f pd=0.7u as=0.1116p ps=0.98u w=0.36u l=0.5u
X3 VDD a_671_644# a_1127_622# VNW pfet_05v0 ad=0.379p pd=2.37u as=61.19999f ps=0.7u w=0.36u l=0.5u
X4 VDD I a_47_68# VNW pfet_05v0 ad=0.1116p pd=0.98u as=0.3852p ps=2.86u w=0.36u l=0.5u
X5 Z a_895_68# VSS VPW nfet_05v0 ad=0.3608p pd=2.52u as=0.28262p ps=1.87u w=0.82u l=0.6u
X6 a_1147_68# a_671_644# a_895_68# VPW nfet_05v0 ad=43.8f pd=0.605u as=0.3705p ps=2.77u w=0.365u l=0.6u
X7 a_1127_622# a_671_644# a_895_68# VNW pfet_05v0 ad=61.19999f pd=0.7u as=0.3456p ps=2.64u w=0.36u l=0.5u
X8 VSS a_671_644# a_1147_68# VPW nfet_05v0 ad=0.28262p pd=1.87u as=43.8f ps=0.605u w=0.365u l=0.6u
X9 a_671_644# a_47_68# a_503_644# VNW pfet_05v0 ad=0.3852p pd=2.86u as=61.19999f ps=0.7u w=0.36u l=0.5u
X10 VSS I a_47_68# VPW nfet_05v0 ad=93.59999f pd=0.88u as=0.333p ps=2.57u w=0.36u l=0.6u
X11 Z a_895_68# VDD VNW pfet_05v0 ad=0.5368p pd=3.32u as=0.379p ps=2.37u w=1.22u l=0.5u
.ends

.subckt gf180mcu_fd_sc_mcu7t5v0__and3_1 A3 VDD VSS Z A1 A2 VNW VPW
X0 Z a_36_148# VDD VNW pfet_05v0 ad=0.5346p pd=3.31u as=0.4268p ps=2.175u w=1.215u l=0.5u
X1 a_428_148# A2 a_244_148# VPW nfet_05v0 ad=79.8f pd=0.8u as=60.8f ps=0.7u w=0.38u l=0.6u
X2 Z a_36_148# VSS VPW nfet_05v0 ad=0.341p pd=2.43u as=0.2424p ps=1.635u w=0.775u l=0.6u
X3 VSS A3 a_428_148# VPW nfet_05v0 ad=0.2424p pd=1.635u as=79.8f ps=0.8u w=0.38u l=0.6u
X4 a_244_148# A1 a_36_148# VPW nfet_05v0 ad=60.8f pd=0.7u as=0.1672p ps=1.64u w=0.38u l=0.6u
X5 VDD A1 a_36_148# VNW pfet_05v0 ad=0.1391p pd=1.055u as=0.2354p ps=1.95u w=0.535u l=0.5u
X6 a_36_148# A2 VDD VNW pfet_05v0 ad=0.1391p pd=1.055u as=0.1391p ps=1.055u w=0.535u l=0.5u
X7 VDD A3 a_36_148# VNW pfet_05v0 ad=0.4268p pd=2.175u as=0.1391p ps=1.055u w=0.535u l=0.5u
.ends

.subckt gf180mcu_fd_sc_mcu7t5v0__nor3_1 A3 VDD VSS ZN A1 A2 VNW VPW
X0 ZN A1 a_448_472# VNW pfet_05v0 ad=0.5368p pd=3.32u as=0.3782p ps=1.84u w=1.22u l=0.5u
X1 ZN A1 VSS VPW nfet_05v0 ad=0.2046p pd=1.81u as=0.1209p ps=0.985u w=0.465u l=0.6u
X2 a_244_472# A3 VDD VNW pfet_05v0 ad=0.3172p pd=1.74u as=0.5368p ps=3.32u w=1.22u l=0.5u
X3 a_448_472# A2 a_244_472# VNW pfet_05v0 ad=0.3782p pd=1.84u as=0.3172p ps=1.74u w=1.22u l=0.5u
X4 VSS A2 ZN VPW nfet_05v0 ad=0.1209p pd=0.985u as=0.1209p ps=0.985u w=0.465u l=0.6u
X5 ZN A3 VSS VPW nfet_05v0 ad=0.1209p pd=0.985u as=0.2046p ps=1.81u w=0.465u l=0.6u
.ends

.subckt gf180mcu_fd_sc_mcu7t5v0__clkbuf_3 Z VSS VDD I VNW VPW
X0 VDD a_224_552# Z VNW pfet_05v0 ad=0.3782p pd=1.84u as=0.3782p ps=1.84u w=1.22u l=0.5u
X1 a_224_552# I VDD VNW pfet_05v0 ad=0.2542p pd=1.44u as=0.3608p ps=2.52u w=0.82u l=0.5u
X2 VSS a_224_552# Z VPW nfet_05v0 ad=0.1183p pd=0.975u as=0.1183p ps=0.975u w=0.455u l=0.6u
X3 VDD a_224_552# Z VNW pfet_05v0 ad=0.5368p pd=3.32u as=0.3782p ps=1.84u w=1.22u l=0.5u
X4 VSS a_224_552# Z VPW nfet_05v0 ad=0.2002p pd=1.79u as=0.1183p ps=0.975u w=0.455u l=0.6u
X5 Z a_224_552# VDD VNW pfet_05v0 ad=0.3782p pd=1.84u as=0.428p ps=2.02u w=1.22u l=0.5u
X6 Z a_224_552# VSS VPW nfet_05v0 ad=0.1183p pd=0.975u as=0.23432p ps=1.94u w=0.455u l=0.6u
X7 VDD I a_224_552# VNW pfet_05v0 ad=0.428p pd=2.02u as=0.2542p ps=1.44u w=0.82u l=0.5u
X8 Z a_224_552# VDD VNW pfet_05v0 ad=0.3782p pd=1.84u as=0.3782p ps=1.84u w=1.22u l=0.5u
X9 a_224_552# I VSS VPW nfet_05v0 ad=0.51425p pd=2.91u as=0.2662p ps=2.09u w=0.605u l=0.6u
X10 Z a_224_552# VSS VPW nfet_05v0 ad=0.1183p pd=0.975u as=0.1183p ps=0.975u w=0.455u l=0.6u
.ends

.subckt gf180mcu_fd_sc_mcu7t5v0__nor4_1 A3 A4 VDD VSS ZN A1 A2 VNW VPW
X0 a_672_472# A2 a_448_472# VNW pfet_05v0 ad=0.3782p pd=1.84u as=0.3782p ps=1.84u w=1.22u l=0.5u
X1 VSS A1 ZN VPW nfet_05v0 ad=0.1584p pd=1.6u as=93.59999f ps=0.88u w=0.36u l=0.6u
X2 VSS A3 ZN VPW nfet_05v0 ad=93.59999f pd=0.88u as=93.59999f ps=0.88u w=0.36u l=0.6u
X3 a_244_472# A4 VDD VNW pfet_05v0 ad=0.3172p pd=1.74u as=0.5368p ps=3.32u w=1.22u l=0.5u
X4 a_448_472# A3 a_244_472# VNW pfet_05v0 ad=0.3782p pd=1.84u as=0.3172p ps=1.74u w=1.22u l=0.5u
X5 ZN A2 VSS VPW nfet_05v0 ad=93.59999f pd=0.88u as=93.59999f ps=0.88u w=0.36u l=0.6u
X6 ZN A4 VSS VPW nfet_05v0 ad=93.59999f pd=0.88u as=0.1584p ps=1.6u w=0.36u l=0.6u
X7 ZN A1 a_672_472# VNW pfet_05v0 ad=0.5368p pd=3.32u as=0.3782p ps=1.84u w=1.22u l=0.5u
.ends

.subckt gf180mcu_fd_sc_mcu7t5v0__clkinv_8 VDD VSS ZN I VNW VPW
X0 ZN I VDD VNW pfet_05v0 ad=0.3782p pd=1.84u as=0.3782p ps=1.84u w=1.22u l=0.5u
X1 ZN I VSS VPW nfet_05v0 ad=0.1248p pd=1u as=0.1248p ps=1u w=0.48u l=0.6u
X2 VSS I ZN VPW nfet_05v0 ad=0.1248p pd=1u as=0.1248p ps=1u w=0.48u l=0.6u
X3 VDD I ZN VNW pfet_05v0 ad=0.3782p pd=1.84u as=0.3782p ps=1.84u w=1.22u l=0.5u
X4 ZN I VSS VPW nfet_05v0 ad=0.1248p pd=1u as=0.1248p ps=1u w=0.48u l=0.6u
X5 VDD I ZN VNW pfet_05v0 ad=0.5368p pd=3.32u as=0.3782p ps=1.84u w=1.22u l=0.5u
X6 ZN I VSS VPW nfet_05v0 ad=0.1248p pd=1u as=0.2112p ps=1.84u w=0.48u l=0.6u
X7 VDD I ZN VNW pfet_05v0 ad=0.3782p pd=1.84u as=0.3782p ps=1.84u w=1.22u l=0.5u
X8 ZN I VSS VPW nfet_05v0 ad=0.1248p pd=1u as=0.1248p ps=1u w=0.48u l=0.6u
X9 ZN I VDD VNW pfet_05v0 ad=0.3782p pd=1.84u as=0.3782p ps=1.84u w=1.22u l=0.5u
X10 VDD I ZN VNW pfet_05v0 ad=0.3782p pd=1.84u as=0.3782p ps=1.84u w=1.22u l=0.5u
X11 VSS I ZN VPW nfet_05v0 ad=0.1248p pd=1u as=0.1248p ps=1u w=0.48u l=0.6u
X12 ZN I VDD VNW pfet_05v0 ad=0.3782p pd=1.84u as=0.3782p ps=1.84u w=1.22u l=0.5u
X13 VSS I ZN VPW nfet_05v0 ad=0.2112p pd=1.84u as=0.1248p ps=1u w=0.48u l=0.6u
X14 ZN I VDD VNW pfet_05v0 ad=0.3782p pd=1.84u as=0.5368p ps=3.32u w=1.22u l=0.5u
X15 VSS I ZN VPW nfet_05v0 ad=0.1248p pd=1u as=0.1248p ps=1u w=0.48u l=0.6u
.ends

.subckt gf180mcu_fd_sc_mcu7t5v0__dffsnq_1 VSS CLK VDD D Q SETN VNW VPW
X0 VSS CLK a_36_151# VPW nfet_05v0 ad=0.1053p pd=0.925u as=0.1782p ps=1.69u w=0.405u l=0.6u
X1 a_1353_112# SETN a_1697_156# VPW nfet_05v0 ad=0.1989p pd=1.465u as=86.39999f ps=0.84u w=0.36u l=0.6u
X2 a_836_156# D VDD VNW pfet_05v0 ad=0.1313p pd=1.025u as=0.22725p ps=1.91u w=0.505u l=0.5u
X3 a_1040_527# a_36_151# a_836_156# VPW nfet_05v0 ad=93.59999f pd=0.88u as=93.59999f ps=0.88u w=0.36u l=0.6u
X4 a_1040_527# a_448_472# a_836_156# VNW pfet_05v0 ad=0.19315p pd=1.27u as=0.1313p ps=1.025u w=0.505u l=0.5u
X5 a_2225_156# a_36_151# a_1353_112# VNW pfet_05v0 ad=0.1079p pd=0.935u as=0.27805p ps=2.17u w=0.415u l=0.5u
X6 VSS a_1353_112# a_1284_156# VPW nfet_05v0 ad=93.59999f pd=0.88u as=62.1f ps=0.705u w=0.36u l=0.6u
X7 a_2225_156# a_448_472# a_1353_112# VPW nfet_05v0 ad=93.59999f pd=0.88u as=0.1989p ps=1.465u w=0.36u l=0.6u
X8 VDD CLK a_36_151# VNW pfet_05v0 ad=0.2249p pd=1.385u as=0.3806p ps=2.61u w=0.865u l=0.5u
X9 a_2449_156# a_448_472# a_2225_156# VNW pfet_05v0 ad=0.1826p pd=1.71u as=0.1079p ps=0.935u w=0.415u l=0.5u
X10 VDD a_3129_107# a_2449_156# VNW pfet_05v0 ad=0.3276p pd=1.62u as=0.2028p ps=1.3u w=0.78u l=0.5u
X11 Q a_3129_107# VSS VPW nfet_05v0 ad=0.3586p pd=2.51u as=0.3586p ps=2.51u w=0.815u l=0.6u
X12 a_448_472# a_36_151# VDD VNW pfet_05v0 ad=0.3806p pd=2.61u as=0.2249p ps=1.385u w=0.865u l=0.5u
X13 a_2449_156# SETN VDD VNW pfet_05v0 ad=0.2028p pd=1.3u as=0.3432p ps=2.44u w=0.78u l=0.5u
X14 VSS a_3129_107# a_3081_151# VPW nfet_05v0 ad=0.14985p pd=1.145u as=48.6f ps=0.645u w=0.405u l=0.6u
X15 a_836_156# D VSS VPW nfet_05v0 ad=93.59999f pd=0.88u as=0.1584p ps=1.6u w=0.36u l=0.6u
X16 a_448_472# a_36_151# VSS VPW nfet_05v0 ad=0.1782p pd=1.69u as=0.1053p ps=0.925u w=0.405u l=0.6u
X17 a_1353_112# a_1040_527# VDD VNW pfet_05v0 ad=0.1521p pd=1.105u as=0.3975p ps=2.185u w=0.585u l=0.5u
X18 a_3129_107# a_2225_156# VSS VPW nfet_05v0 ad=0.1782p pd=1.69u as=0.14985p ps=1.145u w=0.405u l=0.6u
X19 VDD SETN a_1353_112# VNW pfet_05v0 ad=0.4149p pd=2.65u as=0.1521p ps=1.105u w=0.585u l=0.5u
X20 a_1284_156# a_448_472# a_1040_527# VPW nfet_05v0 ad=62.1f pd=0.705u as=93.59999f ps=0.88u w=0.36u l=0.6u
X21 VDD a_1353_112# a_1293_527# VNW pfet_05v0 ad=0.3975p pd=2.185u as=0.101p ps=0.905u w=0.505u l=0.5u
X22 Q a_3129_107# VDD VNW pfet_05v0 ad=0.6561p pd=3.51u as=0.5346p ps=3.31u w=1.215u l=0.5u
X23 a_3129_107# a_2225_156# VDD VNW pfet_05v0 ad=0.3432p pd=2.44u as=0.3276p ps=1.62u w=0.78u l=0.5u
X24 a_2449_156# a_36_151# a_2225_156# VPW nfet_05v0 ad=0.2898p pd=2.33u as=93.59999f ps=0.88u w=0.36u l=0.6u
X25 a_1293_527# a_36_151# a_1040_527# VNW pfet_05v0 ad=0.101p pd=0.905u as=0.19315p ps=1.27u w=0.505u l=0.5u
X26 a_1697_156# a_1040_527# VSS VPW nfet_05v0 ad=86.39999f pd=0.84u as=93.59999f ps=0.88u w=0.36u l=0.6u
X27 a_3081_151# SETN a_2449_156# VPW nfet_05v0 ad=48.6f pd=0.645u as=0.3123p ps=2.38u w=0.405u l=0.6u
.ends

.subckt gf180mcu_fd_sc_mcu7t5v0__nand4_1 A3 A4 VDD VSS ZN A1 A2 VNW VPW
X0 ZN A4 VDD VNW pfet_05v0 ad=0.2197p pd=1.365u as=0.3718p ps=2.57u w=0.845u l=0.5u
X1 VDD A3 ZN VNW pfet_05v0 ad=0.2197p pd=1.365u as=0.2197p ps=1.365u w=0.845u l=0.5u
X2 ZN A2 VDD VNW pfet_05v0 ad=0.2197p pd=1.365u as=0.2197p ps=1.365u w=0.845u l=0.5u
X3 VDD A1 ZN VNW pfet_05v0 ad=0.3718p pd=2.57u as=0.2197p ps=1.365u w=0.845u l=0.5u
X4 a_275_68# A4 VSS VPW nfet_05v0 ad=0.1517p pd=1.19u as=0.3608p ps=2.52u w=0.82u l=0.6u
X5 a_673_68# A2 a_469_68# VPW nfet_05v0 ad=0.1517p pd=1.19u as=0.1722p ps=1.24u w=0.82u l=0.6u
X6 a_469_68# A3 a_275_68# VPW nfet_05v0 ad=0.1722p pd=1.24u as=0.1517p ps=1.19u w=0.82u l=0.6u
X7 ZN A1 a_673_68# VPW nfet_05v0 ad=0.3608p pd=2.52u as=0.1517p ps=1.19u w=0.82u l=0.6u
.ends

.subckt gf180mcu_fd_sc_mcu7t5v0__aoi222_1 VSS VDD C2 C1 B2 B1 A2 A1 ZN VNW VPW
X0 a_291_68# C2 VSS VPW nfet_05v0 ad=98.39999f pd=1.06u as=0.3608p ps=2.52u w=0.82u l=0.6u
X1 a_1235_68# A2 VSS VPW nfet_05v0 ad=0.1722p pd=1.24u as=0.2132p ps=1.34u w=0.82u l=0.6u
X2 a_619_484# A1 ZN VNW pfet_05v0 ad=0.5104p pd=3.2u as=0.3596p ps=1.78u w=1.16u l=0.5u
X3 a_255_484# B1 a_619_484# VNW pfet_05v0 ad=0.3016p pd=1.68u as=0.5104p ps=3.2u w=1.16u l=0.5u
X4 a_619_484# B2 a_255_484# VNW pfet_05v0 ad=0.3016p pd=1.68u as=0.3016p ps=1.68u w=1.16u l=0.5u
X5 a_255_484# C2 VDD VNW pfet_05v0 ad=0.3016p pd=1.68u as=0.5104p ps=3.2u w=1.16u l=0.5u
X6 ZN C1 a_291_68# VPW nfet_05v0 ad=0.33825p pd=1.645u as=98.39999f ps=1.06u w=0.82u l=0.6u
X7 ZN A1 a_1235_68# VPW nfet_05v0 ad=0.3608p pd=2.52u as=0.1722p ps=1.24u w=0.82u l=0.6u
X8 VSS B2 a_744_68# VPW nfet_05v0 ad=0.2132p pd=1.34u as=0.30135p ps=1.555u w=0.82u l=0.6u
X9 VDD C1 a_255_484# VNW pfet_05v0 ad=0.5104p pd=3.2u as=0.3016p ps=1.68u w=1.16u l=0.5u
X10 ZN A2 a_619_484# VNW pfet_05v0 ad=0.3596p pd=1.78u as=0.3016p ps=1.68u w=1.16u l=0.5u
X11 a_744_68# B1 ZN VPW nfet_05v0 ad=0.30135p pd=1.555u as=0.33825p ps=1.645u w=0.82u l=0.6u
.ends

.subckt gf180mcu_fd_sc_mcu7t5v0__xnor2_1 VDD VSS ZN A1 A2 VNW VPW
X0 ZN a_64_93# VDD VNW pfet_05v0 ad=0.31207p pd=1.665u as=0.34437p ps=1.895u w=1.095u l=0.5u
X1 a_272_93# A2 a_64_93# VPW nfet_05v0 ad=57.59999f pd=0.68u as=0.1584p ps=1.6u w=0.36u l=0.6u
X2 VSS A1 a_272_93# VPW nfet_05v0 ad=0.218p pd=1.52u as=57.59999f ps=0.68u w=0.36u l=0.6u
X3 a_716_68# a_64_93# VSS VPW nfet_05v0 ad=0.2132p pd=1.34u as=0.218p ps=1.52u w=0.82u l=0.6u
X4 VDD A2 a_930_497# VNW pfet_05v0 ad=0.4818p pd=3.07u as=0.55297p ps=2.105u w=1.095u l=0.5u
X5 ZN A1 a_716_68# VPW nfet_05v0 ad=0.4161p pd=1.905u as=0.2132p ps=1.34u w=0.82u l=0.6u
X6 a_64_93# A2 VDD VNW pfet_05v0 ad=0.1456p pd=1.08u as=0.2464p ps=2u w=0.56u l=0.5u
X7 a_716_68# A2 ZN VPW nfet_05v0 ad=0.3608p pd=2.52u as=0.4161p ps=1.905u w=0.82u l=0.6u
X8 VDD A1 a_64_93# VNW pfet_05v0 ad=0.34437p pd=1.895u as=0.1456p ps=1.08u w=0.56u l=0.5u
X9 a_930_497# A1 ZN VNW pfet_05v0 ad=0.55297p pd=2.105u as=0.31207p ps=1.665u w=1.095u l=0.5u
.ends

.subckt gf180mcu_fd_sc_mcu7t5v0__oai21_2 A2 ZN A1 VSS B VDD VNW VPW
X0 ZN A1 a_692_497# VNW pfet_05v0 ad=0.2847p pd=1.615u as=0.4599p ps=1.935u w=1.095u l=0.5u
X1 ZN A2 a_36_68# VPW nfet_05v0 ad=0.30965p pd=1.685u as=0.2132p ps=1.34u w=0.82u l=0.6u
X2 VSS B a_36_68# VPW nfet_05v0 ad=0.2132p pd=1.34u as=0.3608p ps=2.52u w=0.82u l=0.6u
X3 a_36_68# A2 ZN VPW nfet_05v0 ad=0.3608p pd=2.52u as=0.31215p ps=1.685u w=0.82u l=0.6u
X4 a_36_68# A1 ZN VPW nfet_05v0 ad=0.2132p pd=1.34u as=0.30965p ps=1.685u w=0.82u l=0.6u
X5 a_1164_497# A1 ZN VNW pfet_05v0 ad=0.4599p pd=1.935u as=0.2847p ps=1.615u w=1.095u l=0.5u
X6 ZN B VDD VNW pfet_05v0 ad=0.2483p pd=1.475u as=0.4202p ps=2.79u w=0.955u l=0.5u
X7 a_692_497# A2 VDD VNW pfet_05v0 ad=0.4599p pd=1.935u as=0.3718p ps=1.815u w=1.095u l=0.5u
X8 VDD B ZN VNW pfet_05v0 ad=0.3718p pd=1.815u as=0.2483p ps=1.475u w=0.955u l=0.5u
X9 VDD A2 a_1164_497# VNW pfet_05v0 ad=0.4818p pd=3.07u as=0.4599p ps=1.935u w=1.095u l=0.5u
X10 a_36_68# B VSS VPW nfet_05v0 ad=0.2132p pd=1.34u as=0.2132p ps=1.34u w=0.82u l=0.6u
X11 ZN A1 a_36_68# VPW nfet_05v0 ad=0.31215p pd=1.685u as=0.2132p ps=1.34u w=0.82u l=0.6u
.ends

.subckt gf180mcu_fd_sc_mcu7t5v0__oai221_1 B1 C VDD VSS ZN A1 A2 B2 VNW VPW
X0 a_692_68# C a_36_68# VPW nfet_05v0 ad=0.246p pd=1.42u as=0.2132p ps=1.34u w=0.82u l=0.6u
X1 a_932_472# A2 VDD VNW pfet_05v0 ad=0.3172p pd=1.74u as=0.38575p ps=1.92u w=1.22u l=0.5u
X2 VSS B2 a_36_68# VPW nfet_05v0 ad=0.2132p pd=1.34u as=0.3608p ps=2.52u w=0.82u l=0.6u
X3 ZN A2 a_692_68# VPW nfet_05v0 ad=0.2132p pd=1.34u as=0.246p ps=1.42u w=0.82u l=0.6u
X4 a_244_472# B2 VDD VNW pfet_05v0 ad=0.3172p pd=1.74u as=0.6588p ps=3.52u w=1.22u l=0.5u
X5 ZN A1 a_932_472# VNW pfet_05v0 ad=0.5368p pd=3.32u as=0.3172p ps=1.74u w=1.22u l=0.5u
X6 VDD C ZN VNW pfet_05v0 ad=0.38575p pd=1.92u as=0.3952p ps=1.94u w=0.945u l=0.5u
X7 ZN B1 a_244_472# VNW pfet_05v0 ad=0.3952p pd=1.94u as=0.3172p ps=1.74u w=1.22u l=0.5u
X8 a_36_68# B1 VSS VPW nfet_05v0 ad=0.2132p pd=1.34u as=0.2132p ps=1.34u w=0.82u l=0.6u
X9 a_692_68# A1 ZN VPW nfet_05v0 ad=0.3608p pd=2.52u as=0.2132p ps=1.34u w=0.82u l=0.6u
.ends

.subckt gf180mcu_fd_sc_mcu7t5v0__inv_2 VSS ZN I VDD VNW VPW
X0 VDD I ZN VNW pfet_05v0 ad=0.5368p pd=3.32u as=0.4575p ps=1.97u w=1.22u l=0.5u
X1 ZN I VSS VPW nfet_05v0 ad=0.2255p pd=1.37u as=0.3608p ps=2.52u w=0.82u l=0.6u
X2 VSS I ZN VPW nfet_05v0 ad=0.3608p pd=2.52u as=0.2255p ps=1.37u w=0.82u l=0.6u
X3 ZN I VDD VNW pfet_05v0 ad=0.4575p pd=1.97u as=0.5368p ps=3.32u w=1.22u l=0.5u
.ends

.subckt gf180mcu_fd_sc_mcu7t5v0__clkbuf_16 VDD VSS Z I VNW VPW
X0 VSS I a_224_552# VPW nfet_05v0 ad=0.1053p pd=0.925u as=0.1053p ps=0.925u w=0.405u l=0.6u
X1 VSS a_224_552# Z VPW nfet_05v0 ad=0.1261p pd=1.005u as=0.1261p ps=1.005u w=0.485u l=0.6u
X2 a_224_552# I VDD VNW pfet_05v0 ad=0.2542p pd=1.44u as=0.2542p ps=1.44u w=0.82u l=0.5u
X3 Z a_224_552# VDD VNW pfet_05v0 ad=0.3782p pd=1.84u as=0.3782p ps=1.84u w=1.22u l=0.5u
X4 Z a_224_552# VSS VPW nfet_05v0 ad=0.1261p pd=1.005u as=0.1261p ps=1.005u w=0.485u l=0.6u
X5 VDD a_224_552# Z VNW pfet_05v0 ad=0.3782p pd=1.84u as=0.3782p ps=1.84u w=1.22u l=0.5u
X6 VDD a_224_552# Z VNW pfet_05v0 ad=0.3782p pd=1.84u as=0.3782p ps=1.84u w=1.22u l=0.5u
X7 Z a_224_552# VDD VNW pfet_05v0 ad=0.3782p pd=1.84u as=0.3782p ps=1.84u w=1.22u l=0.5u
X8 a_224_552# I VDD VNW pfet_05v0 ad=0.2542p pd=1.44u as=0.3608p ps=2.52u w=0.82u l=0.5u
X9 VDD a_224_552# Z VNW pfet_05v0 ad=0.3782p pd=1.84u as=0.3782p ps=1.84u w=1.22u l=0.5u
X10 Z a_224_552# VSS VPW nfet_05v0 ad=0.1261p pd=1.005u as=0.1261p ps=1.005u w=0.485u l=0.6u
X11 VSS a_224_552# Z VPW nfet_05v0 ad=0.1261p pd=1.005u as=0.1261p ps=1.005u w=0.485u l=0.6u
X12 VSS a_224_552# Z VPW nfet_05v0 ad=0.1261p pd=1.005u as=0.1261p ps=1.005u w=0.485u l=0.6u
X13 VDD a_224_552# Z VNW pfet_05v0 ad=0.5368p pd=3.32u as=0.3782p ps=1.84u w=1.22u l=0.5u
X14 Z a_224_552# VSS VPW nfet_05v0 ad=0.1261p pd=1.005u as=0.1261p ps=1.005u w=0.485u l=0.6u
X15 VSS I a_224_552# VPW nfet_05v0 ad=0.1053p pd=0.925u as=0.1782p ps=1.69u w=0.405u l=0.6u
X16 a_224_552# I VDD VNW pfet_05v0 ad=0.2542p pd=1.44u as=0.2542p ps=1.44u w=0.82u l=0.5u
X17 a_224_552# I VSS VPW nfet_05v0 ad=0.1053p pd=0.925u as=0.1053p ps=0.925u w=0.405u l=0.6u
X18 VSS a_224_552# Z VPW nfet_05v0 ad=0.1261p pd=1.005u as=0.1261p ps=1.005u w=0.485u l=0.6u
X19 Z a_224_552# VDD VNW pfet_05v0 ad=0.3782p pd=1.84u as=0.428p ps=2.02u w=1.22u l=0.5u
X20 VDD I a_224_552# VNW pfet_05v0 ad=0.2542p pd=1.44u as=0.2542p ps=1.44u w=0.82u l=0.5u
X21 Z a_224_552# VDD VNW pfet_05v0 ad=0.3782p pd=1.84u as=0.3782p ps=1.84u w=1.22u l=0.5u
X22 Z a_224_552# VDD VNW pfet_05v0 ad=0.3782p pd=1.84u as=0.3782p ps=1.84u w=1.22u l=0.5u
X23 VSS I a_224_552# VPW nfet_05v0 ad=0.1053p pd=0.925u as=0.1053p ps=0.925u w=0.405u l=0.6u
X24 VDD a_224_552# Z VNW pfet_05v0 ad=0.3782p pd=1.84u as=0.3782p ps=1.84u w=1.22u l=0.5u
X25 Z a_224_552# VSS VPW nfet_05v0 ad=0.1261p pd=1.005u as=0.1261p ps=1.005u w=0.485u l=0.6u
X26 VSS a_224_552# Z VPW nfet_05v0 ad=0.1261p pd=1.005u as=0.1261p ps=1.005u w=0.485u l=0.6u
X27 VSS a_224_552# Z VPW nfet_05v0 ad=0.1261p pd=1.005u as=0.1261p ps=1.005u w=0.485u l=0.6u
X28 VDD I a_224_552# VNW pfet_05v0 ad=0.428p pd=2.02u as=0.2542p ps=1.44u w=0.82u l=0.5u
X29 Z a_224_552# VDD VNW pfet_05v0 ad=0.3782p pd=1.84u as=0.3782p ps=1.84u w=1.22u l=0.5u
X30 a_224_552# I VSS VPW nfet_05v0 ad=0.1782p pd=1.69u as=0.1053p ps=0.925u w=0.405u l=0.6u
X31 Z a_224_552# VSS VPW nfet_05v0 ad=0.1261p pd=1.005u as=0.1261p ps=1.005u w=0.485u l=0.6u
X32 VSS a_224_552# Z VPW nfet_05v0 ad=0.1261p pd=1.005u as=0.1261p ps=1.005u w=0.485u l=0.6u
X33 Z a_224_552# VDD VNW pfet_05v0 ad=0.3782p pd=1.84u as=0.3782p ps=1.84u w=1.22u l=0.5u
X34 VSS a_224_552# Z VPW nfet_05v0 ad=0.2134p pd=1.85u as=0.1261p ps=1.005u w=0.485u l=0.6u
X35 VDD I a_224_552# VNW pfet_05v0 ad=0.2542p pd=1.44u as=0.2542p ps=1.44u w=0.82u l=0.5u
X36 VDD a_224_552# Z VNW pfet_05v0 ad=0.3782p pd=1.84u as=0.3782p ps=1.84u w=1.22u l=0.5u
X37 VDD a_224_552# Z VNW pfet_05v0 ad=0.3782p pd=1.84u as=0.3782p ps=1.84u w=1.22u l=0.5u
X38 Z a_224_552# VDD VNW pfet_05v0 ad=0.3782p pd=1.84u as=0.3782p ps=1.84u w=1.22u l=0.5u
X39 a_224_552# I VDD VNW pfet_05v0 ad=0.2542p pd=1.44u as=0.2542p ps=1.44u w=0.82u l=0.5u
X40 a_224_552# I VSS VPW nfet_05v0 ad=0.1053p pd=0.925u as=0.1053p ps=0.925u w=0.405u l=0.6u
X41 Z a_224_552# VSS VPW nfet_05v0 ad=0.1261p pd=1.005u as=0.2134p ps=1.85u w=0.485u l=0.6u
X42 VDD I a_224_552# VNW pfet_05v0 ad=0.2542p pd=1.44u as=0.2542p ps=1.44u w=0.82u l=0.5u
X43 VDD a_224_552# Z VNW pfet_05v0 ad=0.3782p pd=1.84u as=0.3782p ps=1.84u w=1.22u l=0.5u
X44 Z a_224_552# VSS VPW nfet_05v0 ad=0.1261p pd=1.005u as=0.1261p ps=1.005u w=0.485u l=0.6u
X45 Z a_224_552# VSS VPW nfet_05v0 ad=0.1261p pd=1.005u as=0.1261p ps=1.005u w=0.485u l=0.6u
.ends

.subckt gf180mcu_fd_sc_mcu7t5v0__and4_1 A3 A4 VDD VSS Z A1 A2 VNW VPW
X0 a_48_148# A1 VDD VNW pfet_05v0 ad=0.156p pd=1.12u as=0.264p ps=2.08u w=0.6u l=0.5u
X1 a_440_148# A2 a_256_148# VPW nfet_05v0 ad=88.2f pd=0.84u as=67.2f ps=0.74u w=0.42u l=0.6u
X2 Z a_48_148# VSS VPW nfet_05v0 ad=0.3586p pd=2.51u as=0.226p ps=1.515u w=0.815u l=0.6u
X3 VDD A2 a_48_148# VNW pfet_05v0 ad=0.156p pd=1.12u as=0.156p ps=1.12u w=0.6u l=0.5u
X4 Z a_48_148# VDD VNW pfet_05v0 ad=0.5368p pd=3.32u as=0.395p ps=2.02u w=1.22u l=0.5u
X5 a_644_148# A3 a_440_148# VPW nfet_05v0 ad=88.2f pd=0.84u as=88.2f ps=0.84u w=0.42u l=0.6u
X6 a_48_148# A3 VDD VNW pfet_05v0 ad=0.156p pd=1.12u as=0.156p ps=1.12u w=0.6u l=0.5u
X7 VSS A4 a_644_148# VPW nfet_05v0 ad=0.226p pd=1.515u as=88.2f ps=0.84u w=0.42u l=0.6u
X8 VDD A4 a_48_148# VNW pfet_05v0 ad=0.395p pd=2.02u as=0.156p ps=1.12u w=0.6u l=0.5u
X9 a_256_148# A1 a_48_148# VPW nfet_05v0 ad=67.2f pd=0.74u as=0.1848p ps=1.72u w=0.42u l=0.6u
.ends

.subckt gf180mcu_fd_sc_mcu7t5v0__tieh Z VDD VSS VNW VPW
X0 Z a_125_24# VDD VNW pfet_05v0 ad=0.5368p pd=3.32u as=0.5368p ps=3.32u w=1.22u l=0.5u
X1 a_125_24# a_125_24# VSS VPW nfet_05v0 ad=0.3608p pd=2.52u as=0.3608p ps=2.52u w=0.82u l=0.6u
.ends

.subckt gf180mcu_fd_sc_mcu7t5v0__clkbuf_8 Z VSS VDD I VNW VPW
X0 Z a_224_552# VSS VPW nfet_05v0 ad=0.1118p pd=0.95u as=0.1892p ps=1.74u w=0.43u l=0.6u
X1 VSS a_224_552# Z VPW nfet_05v0 ad=0.1118p pd=0.95u as=0.1118p ps=0.95u w=0.43u l=0.6u
X2 VDD a_224_552# Z VNW pfet_05v0 ad=0.3172p pd=1.74u as=0.4392p ps=1.94u w=1.22u l=0.5u
X3 a_224_552# I VDD VNW pfet_05v0 ad=0.2952p pd=1.54u as=0.3608p ps=2.52u w=0.82u l=0.5u
X4 VDD I a_224_552# VNW pfet_05v0 ad=0.2132p pd=1.34u as=0.2952p ps=1.54u w=0.82u l=0.5u
X5 Z a_224_552# VDD VNW pfet_05v0 ad=0.4392p pd=1.94u as=0.3172p ps=1.74u w=1.22u l=0.5u
X6 VDD a_224_552# Z VNW pfet_05v0 ad=0.3172p pd=1.74u as=0.4392p ps=1.94u w=1.22u l=0.5u
X7 VSS I a_224_552# VPW nfet_05v0 ad=0.1053p pd=0.925u as=0.1053p ps=0.925u w=0.405u l=0.6u
X8 a_224_552# I VDD VNW pfet_05v0 ad=0.2952p pd=1.54u as=0.2132p ps=1.34u w=0.82u l=0.5u
X9 VDD a_224_552# Z VNW pfet_05v0 ad=0.3172p pd=1.74u as=0.4392p ps=1.94u w=1.22u l=0.5u
X10 VSS a_224_552# Z VPW nfet_05v0 ad=0.1892p pd=1.74u as=0.1118p ps=0.95u w=0.43u l=0.6u
X11 Z a_224_552# VDD VNW pfet_05v0 ad=0.4392p pd=1.94u as=0.3172p ps=1.74u w=1.22u l=0.5u
X12 Z a_224_552# VSS VPW nfet_05v0 ad=0.1118p pd=0.95u as=0.1118p ps=0.95u w=0.43u l=0.6u
X13 VSS a_224_552# Z VPW nfet_05v0 ad=0.1118p pd=0.95u as=0.1118p ps=0.95u w=0.43u l=0.6u
X14 Z a_224_552# VSS VPW nfet_05v0 ad=0.1118p pd=0.95u as=0.1118p ps=0.95u w=0.43u l=0.6u
X15 Z a_224_552# VDD VNW pfet_05v0 ad=0.4392p pd=1.94u as=0.3172p ps=1.74u w=1.22u l=0.5u
X16 VDD I a_224_552# VNW pfet_05v0 ad=0.367p pd=1.92u as=0.2952p ps=1.54u w=0.82u l=0.5u
X17 VDD a_224_552# Z VNW pfet_05v0 ad=0.5368p pd=3.32u as=0.4392p ps=1.94u w=1.22u l=0.5u
X18 a_224_552# I VSS VPW nfet_05v0 ad=0.1053p pd=0.925u as=0.1782p ps=1.69u w=0.405u l=0.6u
X19 Z a_224_552# VSS VPW nfet_05v0 ad=0.1118p pd=0.95u as=0.1118p ps=0.95u w=0.43u l=0.6u
X20 Z a_224_552# VDD VNW pfet_05v0 ad=0.4392p pd=1.94u as=0.367p ps=1.92u w=1.22u l=0.5u
X21 a_224_552# I VSS VPW nfet_05v0 ad=0.1782p pd=1.69u as=0.1053p ps=0.925u w=0.405u l=0.6u
X22 VSS a_224_552# Z VPW nfet_05v0 ad=0.1118p pd=0.95u as=0.1118p ps=0.95u w=0.43u l=0.6u
.ends

.subckt gf180mcu_fd_sc_mcu7t5v0__oai32_1 A3 B1 B2 VDD VSS ZN A1 A2 VNW VPW
X0 ZN A1 a_468_472# VNW pfet_05v0 ad=0.4392p pd=1.94u as=0.3172p ps=1.74u w=1.22u l=0.5u
X1 a_244_68# A1 VSS VPW nfet_05v0 ad=0.2132p pd=1.34u as=0.2132p ps=1.34u w=0.82u l=0.6u
X2 a_244_68# A3 VSS VPW nfet_05v0 ad=0.2132p pd=1.34u as=0.3608p ps=2.52u w=0.82u l=0.6u
X3 a_916_472# B1 ZN VNW pfet_05v0 ad=0.3172p pd=1.74u as=0.4392p ps=1.94u w=1.22u l=0.5u
X4 VDD B2 a_916_472# VNW pfet_05v0 ad=0.5368p pd=3.32u as=0.3172p ps=1.74u w=1.22u l=0.5u
X5 ZN B1 a_244_68# VPW nfet_05v0 ad=0.2132p pd=1.34u as=0.2132p ps=1.34u w=0.82u l=0.6u
X6 a_224_472# A3 VDD VNW pfet_05v0 ad=0.4392p pd=1.94u as=0.5368p ps=3.32u w=1.22u l=0.5u
X7 VSS A2 a_244_68# VPW nfet_05v0 ad=0.2132p pd=1.34u as=0.2132p ps=1.34u w=0.82u l=0.6u
X8 a_244_68# B2 ZN VPW nfet_05v0 ad=0.3608p pd=2.52u as=0.2132p ps=1.34u w=0.82u l=0.6u
X9 a_468_472# A2 a_224_472# VNW pfet_05v0 ad=0.3172p pd=1.74u as=0.4392p ps=1.94u w=1.22u l=0.5u
.ends

.subckt gf180mcu_fd_sc_mcu7t5v0__nor4_2 A3 A4 VDD VSS ZN A1 A2 VNW VPW
X0 VSS A3 ZN VPW nfet_05v0 ad=0.126p pd=1.06u as=0.126p ps=1.06u w=0.36u l=0.6u
X1 a_1213_472# A2 a_943_472# VNW pfet_05v0 ad=0.3477p pd=1.79u as=0.5185p ps=2.07u w=1.22u l=0.5u
X2 VSS A2 ZN VPW nfet_05v0 ad=0.1584p pd=1.6u as=93.59999f ps=0.88u w=0.36u l=0.6u
X3 a_943_472# A3 a_683_472# VNW pfet_05v0 ad=0.5185p pd=2.07u as=0.488p ps=2.02u w=1.22u l=0.5u
X4 VSS A1 ZN VPW nfet_05v0 ad=93.59999f pd=0.88u as=93.59999f ps=0.88u w=0.36u l=0.6u
X5 a_1661_472# A1 ZN VNW pfet_05v0 ad=0.3172p pd=1.74u as=0.4087p ps=1.89u w=1.22u l=0.5u
X6 VSS A4 ZN VPW nfet_05v0 ad=93.59999f pd=0.88u as=93.59999f ps=0.88u w=0.36u l=0.6u
X7 a_57_472# A2 a_1661_472# VNW pfet_05v0 ad=0.5368p pd=3.32u as=0.3172p ps=1.74u w=1.22u l=0.5u
X8 ZN A1 VSS VPW nfet_05v0 ad=93.59999f pd=0.88u as=93.59999f ps=0.88u w=0.36u l=0.6u
X9 VDD A4 a_245_472# VNW pfet_05v0 ad=0.3782p pd=1.84u as=0.3477p ps=1.79u w=1.22u l=0.5u
X10 ZN A2 VSS VPW nfet_05v0 ad=93.59999f pd=0.88u as=0.126p ps=1.06u w=0.36u l=0.6u
X11 ZN A4 VSS VPW nfet_05v0 ad=0.126p pd=1.06u as=93.59999f ps=0.88u w=0.36u l=0.6u
X12 a_245_472# A3 a_57_472# VNW pfet_05v0 ad=0.3477p pd=1.79u as=0.5368p ps=3.32u w=1.22u l=0.5u
X13 ZN A3 VSS VPW nfet_05v0 ad=93.59999f pd=0.88u as=0.1584p ps=1.6u w=0.36u l=0.6u
X14 ZN A1 a_1213_472# VNW pfet_05v0 ad=0.4087p pd=1.89u as=0.3477p ps=1.79u w=1.22u l=0.5u
X15 a_683_472# A4 VDD VNW pfet_05v0 ad=0.488p pd=2.02u as=0.3782p ps=1.84u w=1.22u l=0.5u
.ends

.subckt gf180mcu_fd_sc_mcu7t5v0__clkinv_3 VDD ZN I VSS VNW VPW
X0 ZN I VDD VNW pfet_05v0 ad=0.5368p pd=3.32u as=0.3782p ps=1.84u w=1.22u l=0.5u
X1 ZN I VSS VPW nfet_05v0 ad=0.1248p pd=1u as=0.2112p ps=1.84u w=0.48u l=0.6u
X2 VDD I ZN VNW pfet_05v0 ad=0.3782p pd=1.84u as=0.3782p ps=1.84u w=1.22u l=0.5u
X3 ZN I VSS VPW nfet_05v0 ad=0.2112p pd=1.84u as=0.1248p ps=1u w=0.48u l=0.6u
X4 ZN I VDD VNW pfet_05v0 ad=0.3782p pd=1.84u as=0.5368p ps=3.32u w=1.22u l=0.5u
X5 VSS I ZN VPW nfet_05v0 ad=0.1248p pd=1u as=0.1248p ps=1u w=0.48u l=0.6u
.ends

.subckt gf180mcu_fd_sc_mcu7t5v0__or2_1 VDD VSS Z A1 A2 VNW VPW
X0 a_255_603# A1 a_67_603# VNW pfet_05v0 ad=0.1469p pd=1.085u as=0.2486p ps=2.01u w=0.565u l=0.5u
X1 Z a_67_603# VSS VPW nfet_05v0 ad=0.3608p pd=2.52u as=0.2288p ps=1.58u w=0.82u l=0.6u
X2 VDD A2 a_255_603# VNW pfet_05v0 ad=0.38705p pd=2.08u as=0.1469p ps=1.085u w=0.565u l=0.5u
X3 VSS A2 a_67_603# VPW nfet_05v0 ad=0.2288p pd=1.58u as=93.59999f ps=0.88u w=0.36u l=0.6u
X4 Z a_67_603# VDD VNW pfet_05v0 ad=0.5368p pd=3.32u as=0.38705p ps=2.08u w=1.22u l=0.5u
X5 a_67_603# A1 VSS VPW nfet_05v0 ad=93.59999f pd=0.88u as=0.1584p ps=1.6u w=0.36u l=0.6u
.ends

.subckt gf180mcu_fd_sc_mcu7t5v0__clkinv_2 VDD VSS I ZN VNW VPW
X0 ZN I VSS VPW nfet_05v0 ad=0.1248p pd=1u as=0.2112p ps=1.84u w=0.48u l=0.6u
X1 VDD I ZN VNW pfet_05v0 ad=0.5368p pd=3.32u as=0.3782p ps=1.84u w=1.22u l=0.5u
X2 ZN I VDD VNW pfet_05v0 ad=0.3782p pd=1.84u as=0.5368p ps=3.32u w=1.22u l=0.5u
X3 VSS I ZN VPW nfet_05v0 ad=0.2112p pd=1.84u as=0.1248p ps=1u w=0.48u l=0.6u
.ends

.subckt gf180mcu_fd_sc_mcu7t5v0__inv_1 VSS ZN I VDD VNW VPW
X0 ZN I VSS VPW nfet_05v0 ad=0.3608p pd=2.52u as=0.3608p ps=2.52u w=0.82u l=0.6u
X1 ZN I VDD VNW pfet_05v0 ad=0.5368p pd=3.32u as=0.5368p ps=3.32u w=1.22u l=0.5u
.ends

.subckt gf180mcu_fd_sc_mcu7t5v0__oai31_1 VDD ZN B A1 A2 VSS A3 VNW VPW
X0 a_468_497# A1 ZN VNW pfet_05v0 ad=0.58035p pd=2.155u as=0.4012p ps=1.85u w=1.095u l=0.5u
X1 a_244_69# A2 ZN VPW nfet_05v0 ad=0.2119p pd=1.335u as=0.4137p ps=1.9u w=0.815u l=0.6u
X2 a_780_497# A2 a_468_497# VNW pfet_05v0 ad=0.2847p pd=1.615u as=0.58035p ps=2.155u w=1.095u l=0.5u
X3 ZN A1 a_244_69# VPW nfet_05v0 ad=0.4137p pd=1.9u as=0.2119p ps=1.335u w=0.815u l=0.6u
X4 VDD A3 a_780_497# VNW pfet_05v0 ad=0.5913p pd=3.27u as=0.2847p ps=1.615u w=1.095u l=0.5u
X5 a_244_69# B VSS VPW nfet_05v0 ad=0.2119p pd=1.335u as=0.3586p ps=2.51u w=0.815u l=0.6u
X6 ZN B VDD VNW pfet_05v0 ad=0.4012p pd=1.85u as=0.4972p ps=3.14u w=1.13u l=0.5u
X7 ZN A3 a_244_69# VPW nfet_05v0 ad=0.3586p pd=2.51u as=0.2119p ps=1.335u w=0.815u l=0.6u
.ends

.subckt gf180mcu_fd_sc_mcu7t5v0__buf_1 VSS Z I VDD VNW VPW
X0 Z a_36_160# VSS VPW nfet_05v0 ad=0.3608p pd=2.52u as=0.2344p ps=1.56u w=0.82u l=0.6u
X1 Z a_36_160# VDD VNW pfet_05v0 ad=0.5368p pd=3.32u as=0.35315p ps=1.96u w=1.22u l=0.5u
X2 VDD I a_36_160# VNW pfet_05v0 ad=0.35315p pd=1.96u as=0.2486p ps=2.01u w=0.565u l=0.5u
X3 VSS I a_36_160# VPW nfet_05v0 ad=0.2344p pd=1.56u as=0.1584p ps=1.6u w=0.36u l=0.6u
.ends

.subckt gf180mcu_fd_sc_mcu7t5v0__inv_3 VSS ZN I VDD VNW VPW
X0 ZN I VDD VNW pfet_05v0 ad=0.5368p pd=3.32u as=0.3172p ps=1.74u w=1.22u l=0.5u
X1 ZN I VSS VPW nfet_05v0 ad=0.3608p pd=2.52u as=0.2132p ps=1.34u w=0.82u l=0.6u
X2 ZN I VSS VPW nfet_05v0 ad=0.2132p pd=1.34u as=0.3608p ps=2.52u w=0.82u l=0.6u
X3 ZN I VDD VNW pfet_05v0 ad=0.4392p pd=1.94u as=0.5368p ps=3.32u w=1.22u l=0.5u
X4 VSS I ZN VPW nfet_05v0 ad=0.2132p pd=1.34u as=0.2132p ps=1.34u w=0.82u l=0.6u
X5 VDD I ZN VNW pfet_05v0 ad=0.3172p pd=1.74u as=0.4392p ps=1.94u w=1.22u l=0.5u
.ends

.subckt gf180mcu_fd_sc_mcu7t5v0__inv_4 VSS ZN I VDD VNW VPW
X0 ZN I VDD VNW pfet_05v0 ad=0.4392p pd=1.94u as=0.3172p ps=1.74u w=1.22u l=0.5u
X1 ZN I VSS VPW nfet_05v0 ad=0.2132p pd=1.34u as=0.2132p ps=1.34u w=0.82u l=0.6u
X2 ZN I VSS VPW nfet_05v0 ad=0.2132p pd=1.34u as=0.3608p ps=2.52u w=0.82u l=0.6u
X3 VDD I ZN VNW pfet_05v0 ad=0.5368p pd=3.32u as=0.4392p ps=1.94u w=1.22u l=0.5u
X4 VSS I ZN VPW nfet_05v0 ad=0.3608p pd=2.52u as=0.2132p ps=1.34u w=0.82u l=0.6u
X5 ZN I VDD VNW pfet_05v0 ad=0.4392p pd=1.94u as=0.5368p ps=3.32u w=1.22u l=0.5u
X6 VSS I ZN VPW nfet_05v0 ad=0.2132p pd=1.34u as=0.2132p ps=1.34u w=0.82u l=0.6u
X7 VDD I ZN VNW pfet_05v0 ad=0.3172p pd=1.74u as=0.4392p ps=1.94u w=1.22u l=0.5u
.ends

.subckt gf180mcu_fd_sc_mcu7t5v0__or3_1 A3 VDD VSS Z A1 A2 VNW VPW
X0 a_224_604# A1 a_36_88# VNW pfet_05v0 ad=0.1736p pd=1.18u as=0.2464p ps=2u w=0.56u l=0.5u
X1 a_36_88# A2 VSS VPW nfet_05v0 ad=0.14p pd=1.1u as=0.104p ps=0.92u w=0.4u l=0.6u
X2 Z a_36_88# VDD VNW pfet_05v0 ad=0.5368p pd=3.32u as=0.389p ps=2.02u w=1.22u l=0.5u
X3 VSS A1 a_36_88# VPW nfet_05v0 ad=0.104p pd=0.92u as=0.176p ps=1.68u w=0.4u l=0.6u
X4 a_448_604# A2 a_224_604# VNW pfet_05v0 ad=0.224p pd=1.36u as=0.1736p ps=1.18u w=0.56u l=0.5u
X5 VSS A3 a_36_88# VPW nfet_05v0 ad=0.224p pd=1.52u as=0.14p ps=1.1u w=0.4u l=0.6u
X6 VDD A3 a_448_604# VNW pfet_05v0 ad=0.389p pd=2.02u as=0.224p ps=1.36u w=0.56u l=0.5u
X7 Z a_36_88# VSS VPW nfet_05v0 ad=0.3608p pd=2.52u as=0.224p ps=1.52u w=0.82u l=0.6u
.ends

.subckt gf180mcu_fd_sc_mcu7t5v0__clkinv_4 VDD VSS ZN I VNW VPW
X0 ZN I VDD VNW pfet_05v0 ad=0.4392p pd=1.94u as=0.3172p ps=1.74u w=1.22u l=0.5u
X1 VSS I ZN VPW nfet_05v0 ad=0.2112p pd=1.84u as=0.1248p ps=1u w=0.48u l=0.6u
X2 ZN I VSS VPW nfet_05v0 ad=0.1248p pd=1u as=0.2112p ps=1.84u w=0.48u l=0.6u
X3 VDD I ZN VNW pfet_05v0 ad=0.5368p pd=3.32u as=0.4392p ps=1.94u w=1.22u l=0.5u
X4 ZN I VSS VPW nfet_05v0 ad=0.1248p pd=1u as=0.1248p ps=1u w=0.48u l=0.6u
X5 ZN I VDD VNW pfet_05v0 ad=0.4392p pd=1.94u as=0.5368p ps=3.32u w=1.22u l=0.5u
X6 VDD I ZN VNW pfet_05v0 ad=0.3172p pd=1.74u as=0.4392p ps=1.94u w=1.22u l=0.5u
X7 VSS I ZN VPW nfet_05v0 ad=0.1248p pd=1u as=0.1248p ps=1u w=0.48u l=0.6u
.ends

.subckt gf180mcu_fd_sc_mcu7t5v0__oai22_1 A2 B1 B2 VDD VSS ZN A1 VNW VPW
X0 ZN A1 a_36_68# VPW nfet_05v0 ad=0.2132p pd=1.34u as=0.2132p ps=1.34u w=0.82u l=0.6u
X1 VSS B2 a_36_68# VPW nfet_05v0 ad=0.2132p pd=1.34u as=0.3608p ps=2.52u w=0.82u l=0.6u
X2 a_244_472# B2 VDD VNW pfet_05v0 ad=0.3782p pd=1.84u as=0.6588p ps=3.52u w=1.22u l=0.5u
X3 a_692_472# A1 ZN VNW pfet_05v0 ad=0.3172p pd=1.74u as=0.3782p ps=1.84u w=1.22u l=0.5u
X4 VDD A2 a_692_472# VNW pfet_05v0 ad=0.5368p pd=3.32u as=0.3172p ps=1.74u w=1.22u l=0.5u
X5 a_36_68# A2 ZN VPW nfet_05v0 ad=0.3608p pd=2.52u as=0.2132p ps=1.34u w=0.82u l=0.6u
X6 a_36_68# B1 VSS VPW nfet_05v0 ad=0.2132p pd=1.34u as=0.2132p ps=1.34u w=0.82u l=0.6u
X7 ZN B1 a_244_472# VNW pfet_05v0 ad=0.3782p pd=1.84u as=0.3782p ps=1.84u w=1.22u l=0.5u
.ends

.subckt gf180mcu_fd_sc_mcu7t5v0__buf_3 VSS Z I VDD VNW VPW
X0 Z a_36_68# VDD VNW pfet_05v0 ad=0.3782p pd=1.84u as=0.4941p ps=2.03u w=1.22u l=0.5u
X1 VSS I a_36_68# VPW nfet_05v0 ad=0.2911p pd=1.53u as=0.3608p ps=2.52u w=0.82u l=0.6u
X2 Z a_36_68# VDD VNW pfet_05v0 ad=0.5368p pd=3.32u as=0.3782p ps=1.84u w=1.22u l=0.5u
X3 Z a_36_68# VSS VPW nfet_05v0 ad=0.3608p pd=2.52u as=0.2132p ps=1.34u w=0.82u l=0.6u
X4 Z a_36_68# VSS VPW nfet_05v0 ad=0.2132p pd=1.34u as=0.2911p ps=1.53u w=0.82u l=0.6u
X5 VDD I a_36_68# VNW pfet_05v0 ad=0.4941p pd=2.03u as=0.5368p ps=3.32u w=1.22u l=0.5u
X6 VSS a_36_68# Z VPW nfet_05v0 ad=0.2132p pd=1.34u as=0.2132p ps=1.34u w=0.82u l=0.6u
X7 VDD a_36_68# Z VNW pfet_05v0 ad=0.3782p pd=1.84u as=0.3782p ps=1.84u w=1.22u l=0.5u
.ends

.subckt gf180mcu_fd_sc_mcu7t5v0__inv_8 VSS ZN I VDD VNW VPW
X0 ZN I VDD VNW pfet_05v0 ad=0.4392p pd=1.94u as=0.3172p ps=1.74u w=1.22u l=0.5u
X1 VDD I ZN VNW pfet_05v0 ad=0.5368p pd=3.32u as=0.4392p ps=1.94u w=1.22u l=0.5u
X2 ZN I VSS VPW nfet_05v0 ad=0.2132p pd=1.34u as=0.2132p ps=1.34u w=0.82u l=0.6u
X3 ZN I VSS VPW nfet_05v0 ad=0.2132p pd=1.34u as=0.3608p ps=2.52u w=0.82u l=0.6u
X4 ZN I VSS VPW nfet_05v0 ad=0.2132p pd=1.34u as=0.2132p ps=1.34u w=0.82u l=0.6u
X5 VDD I ZN VNW pfet_05v0 ad=0.3172p pd=1.74u as=0.4392p ps=1.94u w=1.22u l=0.5u
X6 ZN I VDD VNW pfet_05v0 ad=0.4392p pd=1.94u as=0.3172p ps=1.74u w=1.22u l=0.5u
X7 VSS I ZN VPW nfet_05v0 ad=0.3608p pd=2.52u as=0.2132p ps=1.34u w=0.82u l=0.6u
X8 VDD I ZN VNW pfet_05v0 ad=0.3172p pd=1.74u as=0.4392p ps=1.94u w=1.22u l=0.5u
X9 VSS I ZN VPW nfet_05v0 ad=0.2132p pd=1.34u as=0.2132p ps=1.34u w=0.82u l=0.6u
X10 ZN I VDD VNW pfet_05v0 ad=0.4392p pd=1.94u as=0.3172p ps=1.74u w=1.22u l=0.5u
X11 VSS I ZN VPW nfet_05v0 ad=0.2132p pd=1.34u as=0.2132p ps=1.34u w=0.82u l=0.6u
X12 ZN I VDD VNW pfet_05v0 ad=0.4392p pd=1.94u as=0.5368p ps=3.32u w=1.22u l=0.5u
X13 VSS I ZN VPW nfet_05v0 ad=0.2132p pd=1.34u as=0.2132p ps=1.34u w=0.82u l=0.6u
X14 ZN I VSS VPW nfet_05v0 ad=0.2132p pd=1.34u as=0.2132p ps=1.34u w=0.82u l=0.6u
X15 VDD I ZN VNW pfet_05v0 ad=0.3172p pd=1.74u as=0.4392p ps=1.94u w=1.22u l=0.5u
.ends

.subckt gf180mcu_fd_sc_mcu7t5v0__or2_2 VDD VSS Z A1 A2 VNW VPW
X0 Z a_56_472# VSS VPW nfet_05v0 ad=0.2132p pd=1.34u as=0.2132p ps=1.34u w=0.82u l=0.6u
X1 a_56_472# A1 VSS VPW nfet_05v0 ad=0.2132p pd=1.34u as=0.3608p ps=2.52u w=0.82u l=0.6u
X2 a_244_472# A1 a_56_472# VNW pfet_05v0 ad=0.3172p pd=1.74u as=0.5368p ps=3.32u w=1.22u l=0.5u
X3 VDD A2 a_244_472# VNW pfet_05v0 ad=0.4087p pd=1.89u as=0.3172p ps=1.74u w=1.22u l=0.5u
X4 VDD a_56_472# Z VNW pfet_05v0 ad=0.5368p pd=3.32u as=0.3477p ps=1.79u w=1.22u l=0.5u
X5 Z a_56_472# VDD VNW pfet_05v0 ad=0.3477p pd=1.79u as=0.4087p ps=1.89u w=1.22u l=0.5u
X6 VSS a_56_472# Z VPW nfet_05v0 ad=0.3608p pd=2.52u as=0.2132p ps=1.34u w=0.82u l=0.6u
X7 VSS A2 a_56_472# VPW nfet_05v0 ad=0.2132p pd=1.34u as=0.2132p ps=1.34u w=0.82u l=0.6u
.ends

.subckt gf180mcu_fd_sc_mcu7t5v0__nand4_2 A3 A4 VDD VSS ZN A1 A2 VNW VPW
X0 a_1458_68# A3 a_1254_68# VPW nfet_05v0 ad=0.1517p pd=1.19u as=0.1722p ps=1.24u w=0.82u l=0.6u
X1 a_632_68# A2 a_438_68# VPW nfet_05v0 ad=0.1722p pd=1.24u as=0.1517p ps=1.19u w=0.82u l=0.6u
X2 VDD A4 ZN VNW pfet_05v0 ad=0.2197p pd=1.365u as=0.3718p ps=2.57u w=0.845u l=0.5u
X3 a_244_68# A4 VSS VPW nfet_05v0 ad=0.1517p pd=1.19u as=0.3608p ps=2.52u w=0.82u l=0.6u
X4 ZN A3 VDD VNW pfet_05v0 ad=0.2197p pd=1.365u as=0.2197p ps=1.365u w=0.845u l=0.5u
X5 a_438_68# A3 a_244_68# VPW nfet_05v0 ad=0.1517p pd=1.19u as=0.1517p ps=1.19u w=0.82u l=0.6u
X6 VDD A2 ZN VNW pfet_05v0 ad=0.2197p pd=1.365u as=0.2197p ps=1.365u w=0.845u l=0.5u
X7 ZN A1 a_632_68# VPW nfet_05v0 ad=0.2132p pd=1.34u as=0.1722p ps=1.24u w=0.82u l=0.6u
X8 ZN A1 VDD VNW pfet_05v0 ad=0.2197p pd=1.365u as=0.2197p ps=1.365u w=0.845u l=0.5u
X9 VDD A1 ZN VNW pfet_05v0 ad=0.2197p pd=1.365u as=0.2197p ps=1.365u w=0.845u l=0.5u
X10 a_1060_68# A1 ZN VPW nfet_05v0 ad=0.1517p pd=1.19u as=0.2132p ps=1.34u w=0.82u l=0.6u
X11 a_1254_68# A2 a_1060_68# VPW nfet_05v0 ad=0.1722p pd=1.24u as=0.1517p ps=1.19u w=0.82u l=0.6u
X12 ZN A2 VDD VNW pfet_05v0 ad=0.2197p pd=1.365u as=0.2197p ps=1.365u w=0.845u l=0.5u
X13 VSS A4 a_1458_68# VPW nfet_05v0 ad=0.3608p pd=2.52u as=0.1517p ps=1.19u w=0.82u l=0.6u
X14 VDD A3 ZN VNW pfet_05v0 ad=0.2197p pd=1.365u as=0.2197p ps=1.365u w=0.845u l=0.5u
X15 ZN A4 VDD VNW pfet_05v0 ad=0.3718p pd=2.57u as=0.2197p ps=1.365u w=0.845u l=0.5u
.ends

.subckt gf180mcu_fd_sc_mcu7t5v0__dlyc_1 Z VSS I VDD VNW VPW
X0 a_666_644# a_42_68# a_498_644# VNW pfet_05v0 ad=0.3852p pd=2.86u as=61.19999f ps=0.7u w=0.36u l=0.5u
X1 VSS I a_42_68# VPW nfet_05v0 ad=93.59999f pd=0.88u as=0.333p ps=2.57u w=0.36u l=0.6u
X2 a_1702_68# a_870_562# a_1554_644# VNW pfet_05v0 ad=0.3852p pd=2.86u as=61.19999f ps=0.7u w=0.36u l=0.5u
X3 Z a_1926_68# VDD VNW pfet_05v0 ad=0.5368p pd=3.32u as=0.379p ps=2.37u w=1.22u l=0.5u
X4 a_498_644# a_42_68# VDD VNW pfet_05v0 ad=61.19999f pd=0.7u as=0.1116p ps=0.98u w=0.36u l=0.5u
X5 a_1554_644# a_870_562# VDD VNW pfet_05v0 ad=61.19999f pd=0.7u as=0.1656p ps=1.28u w=0.36u l=0.5u
X6 a_1102_644# a_666_644# a_870_562# VNW pfet_05v0 ad=61.19999f pd=0.7u as=0.3852p ps=2.86u w=0.36u l=0.5u
X7 VDD I a_42_68# VNW pfet_05v0 ad=0.1116p pd=0.98u as=0.3852p ps=2.86u w=0.36u l=0.5u
X8 a_1534_68# a_870_562# VSS VPW nfet_05v0 ad=43.2f pd=0.6u as=93.59999f ps=0.88u w=0.36u l=0.6u
X9 a_1702_68# a_870_562# a_1534_68# VPW nfet_05v0 ad=0.369p pd=2.77u as=43.2f ps=0.6u w=0.36u l=0.6u
X10 Z a_1926_68# VSS VPW nfet_05v0 ad=0.3608p pd=2.52u as=0.28262p ps=1.87u w=0.82u l=0.6u
X11 VDD a_1702_68# a_2158_622# VNW pfet_05v0 ad=0.379p pd=2.37u as=61.19999f ps=0.7u w=0.36u l=0.5u
X12 a_518_68# a_42_68# VSS VPW nfet_05v0 ad=43.2f pd=0.6u as=93.59999f ps=0.88u w=0.36u l=0.6u
X13 a_666_644# a_42_68# a_518_68# VPW nfet_05v0 ad=0.369p pd=2.77u as=43.2f ps=0.6u w=0.36u l=0.6u
X14 a_1142_68# a_666_644# a_870_562# VPW nfet_05v0 ad=43.2f pd=0.6u as=0.369p ps=2.77u w=0.36u l=0.6u
X15 a_2158_622# a_1702_68# a_1926_68# VNW pfet_05v0 ad=61.19999f pd=0.7u as=0.3456p ps=2.64u w=0.36u l=0.5u
X16 a_2178_68# a_1702_68# a_1926_68# VPW nfet_05v0 ad=43.8f pd=0.605u as=0.3705p ps=2.77u w=0.365u l=0.6u
X17 VSS a_666_644# a_1142_68# VPW nfet_05v0 ad=93.59999f pd=0.88u as=43.2f ps=0.6u w=0.36u l=0.6u
X18 VSS a_1702_68# a_2178_68# VPW nfet_05v0 ad=0.28262p pd=1.87u as=43.8f ps=0.605u w=0.365u l=0.6u
X19 VDD a_666_644# a_1102_644# VNW pfet_05v0 ad=0.1656p pd=1.28u as=61.19999f ps=0.7u w=0.36u l=0.5u
.ends

.subckt gf180mcu_fd_sc_mcu7t5v0__nand2_2 VDD VSS ZN A1 A2 VNW VPW
X0 a_244_68# A2 VSS VPW nfet_05v0 ad=0.1312p pd=1.14u as=0.3608p ps=2.52u w=0.82u l=0.6u
X1 ZN A1 a_244_68# VPW nfet_05v0 ad=0.2132p pd=1.34u as=0.1312p ps=1.14u w=0.82u l=0.6u
X2 ZN A2 VDD VNW pfet_05v0 ad=0.2938p pd=1.65u as=0.4972p ps=3.14u w=1.13u l=0.5u
X3 VDD A1 ZN VNW pfet_05v0 ad=0.2938p pd=1.65u as=0.2938p ps=1.65u w=1.13u l=0.5u
X4 a_652_68# A1 ZN VPW nfet_05v0 ad=0.1312p pd=1.14u as=0.2132p ps=1.34u w=0.82u l=0.6u
X5 VSS A2 a_652_68# VPW nfet_05v0 ad=0.3608p pd=2.52u as=0.1312p ps=1.14u w=0.82u l=0.6u
X6 ZN A1 VDD VNW pfet_05v0 ad=0.2938p pd=1.65u as=0.2938p ps=1.65u w=1.13u l=0.5u
X7 VDD A2 ZN VNW pfet_05v0 ad=0.4972p pd=3.14u as=0.2938p ps=1.65u w=1.13u l=0.5u
.ends

.subckt gf180mcu_fd_sc_mcu7t5v0__or4_1 A3 A4 VDD VSS Z A1 A2 VNW VPW
X0 VSS A4 a_56_604# VPW nfet_05v0 ad=0.218p pd=1.52u as=93.59999f ps=0.88u w=0.36u l=0.6u
X1 Z a_56_604# VSS VPW nfet_05v0 ad=0.3608p pd=2.52u as=0.218p ps=1.52u w=0.82u l=0.6u
X2 Z a_56_604# VDD VNW pfet_05v0 ad=0.5368p pd=3.32u as=0.389p ps=2.02u w=1.22u l=0.5u
X3 VSS A2 a_56_604# VPW nfet_05v0 ad=93.59999f pd=0.88u as=0.126p ps=1.06u w=0.36u l=0.6u
X4 VDD A4 a_708_604# VNW pfet_05v0 ad=0.389p pd=2.02u as=0.1736p ps=1.18u w=0.56u l=0.5u
X5 a_244_604# A1 a_56_604# VNW pfet_05v0 ad=0.196p pd=1.26u as=0.2464p ps=2u w=0.56u l=0.5u
X6 a_56_604# A1 VSS VPW nfet_05v0 ad=0.126p pd=1.06u as=0.1584p ps=1.6u w=0.36u l=0.6u
X7 a_56_604# A3 VSS VPW nfet_05v0 ad=93.59999f pd=0.88u as=93.59999f ps=0.88u w=0.36u l=0.6u
X8 a_708_604# A3 a_484_604# VNW pfet_05v0 ad=0.1736p pd=1.18u as=0.1736p ps=1.18u w=0.56u l=0.5u
X9 a_484_604# A2 a_244_604# VNW pfet_05v0 ad=0.1736p pd=1.18u as=0.196p ps=1.26u w=0.56u l=0.5u
.ends

.subckt gf180mcu_fd_sc_mcu7t5v0__buf_12 Z I VDD VSS VNW VPW
X0 a_224_472# I VDD VNW pfet_05v0 ad=0.3782p pd=1.84u as=0.3782p ps=1.84u w=1.22u l=0.5u
X1 VDD a_224_472# Z VNW pfet_05v0 ad=0.3782p pd=1.84u as=0.3782p ps=1.84u w=1.22u l=0.5u
X2 Z a_224_472# VDD VNW pfet_05v0 ad=0.3782p pd=1.84u as=0.3782p ps=1.84u w=1.22u l=0.5u
X3 a_224_472# I VSS VPW nfet_05v0 ad=0.2132p pd=1.34u as=0.2132p ps=1.34u w=0.82u l=0.6u
X4 VSS a_224_472# Z VPW nfet_05v0 ad=0.2132p pd=1.34u as=0.2132p ps=1.34u w=0.82u l=0.6u
X5 VSS a_224_472# Z VPW nfet_05v0 ad=0.3608p pd=2.52u as=0.2132p ps=1.34u w=0.82u l=0.6u
X6 VDD I a_224_472# VNW pfet_05v0 ad=0.3782p pd=1.84u as=0.3782p ps=1.84u w=1.22u l=0.5u
X7 Z a_224_472# VDD VNW pfet_05v0 ad=0.3782p pd=1.84u as=0.3782p ps=1.84u w=1.22u l=0.5u
X8 a_224_472# I VSS VPW nfet_05v0 ad=0.2132p pd=1.34u as=0.3608p ps=2.52u w=0.82u l=0.6u
X9 Z a_224_472# VSS VPW nfet_05v0 ad=0.2132p pd=1.34u as=0.2132p ps=1.34u w=0.82u l=0.6u
X10 VSS a_224_472# Z VPW nfet_05v0 ad=0.2132p pd=1.34u as=0.2132p ps=1.34u w=0.82u l=0.6u
X11 VSS a_224_472# Z VPW nfet_05v0 ad=0.2132p pd=1.34u as=0.2132p ps=1.34u w=0.82u l=0.6u
X12 VDD a_224_472# Z VNW pfet_05v0 ad=0.3782p pd=1.84u as=0.3782p ps=1.84u w=1.22u l=0.5u
X13 Z a_224_472# VSS VPW nfet_05v0 ad=0.2132p pd=1.34u as=0.2132p ps=1.34u w=0.82u l=0.6u
X14 Z a_224_472# VSS VPW nfet_05v0 ad=0.2132p pd=1.34u as=0.2132p ps=1.34u w=0.82u l=0.6u
X15 Z a_224_472# VDD VNW pfet_05v0 ad=0.3782p pd=1.84u as=0.3782p ps=1.84u w=1.22u l=0.5u
X16 Z a_224_472# VSS VPW nfet_05v0 ad=0.2132p pd=1.34u as=0.2132p ps=1.34u w=0.82u l=0.6u
X17 VDD I a_224_472# VNW pfet_05v0 ad=0.3782p pd=1.84u as=0.3782p ps=1.84u w=1.22u l=0.5u
X18 VDD a_224_472# Z VNW pfet_05v0 ad=0.5368p pd=3.32u as=0.3782p ps=1.84u w=1.22u l=0.5u
X19 VDD a_224_472# Z VNW pfet_05v0 ad=0.3782p pd=1.84u as=0.3782p ps=1.84u w=1.22u l=0.5u
X20 Z a_224_472# VDD VNW pfet_05v0 ad=0.3782p pd=1.84u as=0.3782p ps=1.84u w=1.22u l=0.5u
X21 Z a_224_472# VSS VPW nfet_05v0 ad=0.2132p pd=1.34u as=0.2132p ps=1.34u w=0.82u l=0.6u
X22 a_224_472# I VDD VNW pfet_05v0 ad=0.3782p pd=1.84u as=0.3782p ps=1.84u w=1.22u l=0.5u
X23 VSS a_224_472# Z VPW nfet_05v0 ad=0.2132p pd=1.34u as=0.2132p ps=1.34u w=0.82u l=0.6u
X24 VDD I a_224_472# VNW pfet_05v0 ad=0.3782p pd=1.84u as=0.3782p ps=1.84u w=1.22u l=0.5u
X25 VSS I a_224_472# VPW nfet_05v0 ad=0.2132p pd=1.34u as=0.2132p ps=1.34u w=0.82u l=0.6u
X26 VDD a_224_472# Z VNW pfet_05v0 ad=0.3782p pd=1.84u as=0.3782p ps=1.84u w=1.22u l=0.5u
X27 VSS a_224_472# Z VPW nfet_05v0 ad=0.2132p pd=1.34u as=0.2132p ps=1.34u w=0.82u l=0.6u
X28 Z a_224_472# VDD VNW pfet_05v0 ad=0.3782p pd=1.84u as=0.3782p ps=1.84u w=1.22u l=0.5u
X29 VSS I a_224_472# VPW nfet_05v0 ad=0.2132p pd=1.34u as=0.2132p ps=1.34u w=0.82u l=0.6u
X30 a_224_472# I VDD VNW pfet_05v0 ad=0.3782p pd=1.84u as=0.5368p ps=3.32u w=1.22u l=0.5u
X31 VDD a_224_472# Z VNW pfet_05v0 ad=0.3782p pd=1.84u as=0.3782p ps=1.84u w=1.22u l=0.5u
X32 VSS I a_224_472# VPW nfet_05v0 ad=0.2132p pd=1.34u as=0.2132p ps=1.34u w=0.82u l=0.6u
X33 Z a_224_472# VSS VPW nfet_05v0 ad=0.2132p pd=1.34u as=0.2132p ps=1.34u w=0.82u l=0.6u
X34 Z a_224_472# VDD VNW pfet_05v0 ad=0.3782p pd=1.84u as=0.3782p ps=1.84u w=1.22u l=0.5u
X35 a_224_472# I VSS VPW nfet_05v0 ad=0.2132p pd=1.34u as=0.2132p ps=1.34u w=0.82u l=0.6u
.ends

.subckt spi_opentarget_i3c_top VDD VSS clk_i clk_i_PD clk_i_PU host_clk_i host_clk_i_PD
+ host_clk_i_PU irq_o_CS irq_o_IE irq_o_IN irq_o_OE irq_o_OUT irq_o_PD irq_o_PDRV0
+ irq_o_PDRV1 irq_o_PU irq_o_SL rst_ni rst_ni_PD rst_ni_PU scl_pad_i scl_pad_i_PD
+ scl_pad_i_PU sda_pad_CS sda_pad_IE sda_pad_IN sda_pad_OUT sda_pad_PD sda_pad_PDRV0
+ sda_pad_PDRV1 sda_pad_PU sda_pad_SL sda_pad_oe spi_cs_ni spi_cs_ni_PD spi_cs_ni_PU
+ spi_miso_o_CS spi_miso_o_IE spi_miso_o_IN spi_miso_o_OE spi_miso_o_OUT spi_miso_o_PD
+ spi_miso_o_PDRV0 spi_miso_o_PDRV1 spi_miso_o_PU spi_miso_o_SL spi_mosi_i spi_mosi_i_PD
+ spi_mosi_i_PU spi_sclk_i spi_sclk_i_PD spi_sclk_i_PU
XFILLER_255_632 VDD VSS VDD VSS gf180mcu_fd_sc_mcu7t5v0__fillcap_64
XFILLER_267_492 VDD VSS VDD VSS gf180mcu_fd_sc_mcu7t5v0__fillcap_64
X_3155_ _3155_/D _3155_/Q wire151/I VSS _3281_/CLK VDD VDD VSS gf180mcu_fd_sc_mcu7t5v0__dffrnq_1
XFILLER_94_361 VDD VSS VDD VSS gf180mcu_fd_sc_mcu7t5v0__fillcap_16
X_2106_ VDD VSS _2111_/A2 _3110_/Q _2106_/A2 VDD VSS gf180mcu_fd_sc_mcu7t5v0__nand2_1
X_3086_ _3086_/D _3086_/Q wire165/I VSS _3448_/CLK VDD VDD VSS gf180mcu_fd_sc_mcu7t5v0__dffrnq_1
X_2037_ _2040_/S VDD VSS _3070_/D _3286_/Q _3070_/Q VDD VSS gf180mcu_fd_sc_mcu7t5v0__mux2_2
XFILLER_54_247 VDD VSS VDD VSS gf180mcu_fd_sc_mcu7t5v0__fillcap_64
XFILLER_211_702 VDD VSS VDD VSS gf180mcu_fd_sc_mcu7t5v0__fillcap_64
XFILLER_223_562 VDD VSS VDD VSS gf180mcu_fd_sc_mcu7t5v0__fillcap_16
XFILLER_149_842 VDD VSS VDD VSS gf180mcu_fd_sc_mcu7t5v0__fillcap_32
XFILLER_210_223 VDD VSS VDD VSS gf180mcu_fd_sc_mcu7t5v0__fillcap_4
XFILLER_250_381 VDD VSS VDD VSS gf180mcu_fd_sc_mcu7t5v0__fillcap_4
XFILLER_10_317 VDD VSS VDD VSS gf180mcu_fd_sc_mcu7t5v0__fillcap_64
XFILLER_183_609 VDD VSS VDD VSS gf180mcu_fd_sc_mcu7t5v0__fillcap_16
XFILLER_164_801 VDD VSS VDD VSS gf180mcu_fd_sc_mcu7t5v0__fillcap_4
X_2939_ VDD _2939_/Q _2963_/CLK VSS _2939_/D VDD VSS gf180mcu_fd_sc_mcu7t5v0__dffq_1
XFILLER_148_341 VDD VSS VDD VSS gf180mcu_fd_sc_mcu7t5v0__fillcap_32
XFILLER_22_177 VDD VSS VDD VSS gf180mcu_fd_sc_mcu7t5v0__fillcap_64
XFILLER_163_311 VDD VSS VDD VSS gf180mcu_fd_sc_mcu7t5v0__fillcap_4
XFILLER_117_772 VDD VSS VDD VSS gf180mcu_fd_sc_mcu7t5v0__fillcap_64
XFILLER_2_527 VDD VSS VDD VSS gf180mcu_fd_sc_mcu7t5v0__fillcap_64
XFILLER_78_807 VDD VSS VDD VSS gf180mcu_fd_sc_mcu7t5v0__fillcap_64
XFILLER_132_764 VDD VSS VDD VSS gf180mcu_fd_sc_mcu7t5v0__fillcap_32
XFILLER_100_661 VDD VSS VDD VSS gf180mcu_fd_sc_mcu7t5v0__fillcap_4
XFILLER_245_142 VDD VSS VDD VSS gf180mcu_fd_sc_mcu7t5v0__fillcap_64
XFILLER_58_597 VDD VSS VDD VSS gf180mcu_fd_sc_mcu7t5v0__fillcap_64
XFILLER_46_737 VDD VSS VDD VSS gf180mcu_fd_sc_mcu7t5v0__fillcap_64
XFILLER_260_101 VDD VSS VDD VSS gf180mcu_fd_sc_mcu7t5v0__fillcap_4
XFILLER_73_556 VDD VSS VDD VSS gf180mcu_fd_sc_mcu7t5v0__fillcap_4
XFILLER_242_871 VDD VSS VDD VSS gf180mcu_fd_sc_mcu7t5v0__fillcap_4
XFILLER_201_212 VDD VSS VDD VSS gf180mcu_fd_sc_mcu7t5v0__fillcap_32
XFILLER_198_296 VDD VSS VDD VSS gf180mcu_fd_sc_mcu7t5v0__fillcap_16
XFILLER_14_667 VDD VSS VDD VSS gf180mcu_fd_sc_mcu7t5v0__fillcap_64
XFILLER_41_486 VDD VSS VDD VSS gf180mcu_fd_sc_mcu7t5v0__fillcap_4
XFILLER_154_344 VDD VSS VDD VSS gf180mcu_fd_sc_mcu7t5v0__fillcap_4
XFILLER_6_877 VDD VSS VDD VSS gf180mcu_fd_sc_mcu7t5v0__fillcap_8
XFILLER_107_282 VDD VSS VDD VSS gf180mcu_fd_sc_mcu7t5v0__fillcap_32
XFILLER_122_241 VDD VSS VDD VSS gf180mcu_fd_sc_mcu7t5v0__fillcap_4
XFILLER_68_317 VDD VSS VDD VSS gf180mcu_fd_sc_mcu7t5v0__fillcap_64
XFILLER_237_632 VDD VSS VDD VSS gf180mcu_fd_sc_mcu7t5v0__fillcap_64
XFILLER_249_492 VDD VSS VDD VSS gf180mcu_fd_sc_mcu7t5v0__fillcap_64
XFILLER_95_158 VDD VSS VDD VSS gf180mcu_fd_sc_mcu7t5v0__fillcap_8
XFILLER_264_451 VDD VSS VDD VSS gf180mcu_fd_sc_mcu7t5v0__fillcap_4
XFILLER_36_247 VDD VSS VDD VSS gf180mcu_fd_sc_mcu7t5v0__fillcap_64
XFILLER_205_551 VDD VSS VDD VSS gf180mcu_fd_sc_mcu7t5v0__fillcap_8
XFILLER_51_206 VDD VSS VDD VSS gf180mcu_fd_sc_mcu7t5v0__fillcap_4
XFILLER_205_562 VDD VSS VDD VSS gf180mcu_fd_sc_mcu7t5v0__fillcap_16
XFILLER_189_263 VDD VSS VDD VSS gf180mcu_fd_sc_mcu7t5v0__fillcap_16
XFILLER_220_543 VDD VSS VDD VSS gf180mcu_fd_sc_mcu7t5v0__fillcap_8
XFILLER_205_595 VDD VSS VDD VSS gf180mcu_fd_sc_mcu7t5v0__fillcap_4
XFILLER_232_381 VDD VSS VDD VSS gf180mcu_fd_sc_mcu7t5v0__fillcap_4
XFILLER_80_2 VDD VSS VDD VSS gf180mcu_fd_sc_mcu7t5v0__fillcap_32
XFILLER_158_661 VDD VSS VDD VSS gf180mcu_fd_sc_mcu7t5v0__fillcap_4
XFILLER_158_683 VDD VSS VDD VSS gf180mcu_fd_sc_mcu7t5v0__fillcap_4
XFILLER_146_801 VDD VSS VDD VSS gf180mcu_fd_sc_mcu7t5v0__fillcap_4
XFILLER_145_300 VDD VSS VDD VSS gf180mcu_fd_sc_mcu7t5v0__fillcap_16
X_2724_ _2724_/B _2724_/C VDD VSS _2727_/A1 _2732_/C _2723_/Z VDD VSS gf180mcu_fd_sc_mcu7t5v0__oai211_1
XFILLER_172_152 VDD VSS VDD VSS gf180mcu_fd_sc_mcu7t5v0__fillcap_4
X_2655_ _2758_/A3 _2655_/B2 VDD VSS _2656_/A2 _3094_/Q _2061_/Z VDD VSS gf180mcu_fd_sc_mcu7t5v0__aoi22_1
X_1606_ VDD VSS _1606_/Z _3389_/Q _3384_/D VDD VSS gf180mcu_fd_sc_mcu7t5v0__xor2_1
XFILLER_218_98 VDD VSS VDD VSS gf180mcu_fd_sc_mcu7t5v0__fillcap_4
XFILLER_114_731 VDD VSS VDD VSS gf180mcu_fd_sc_mcu7t5v0__fillcap_4
XFILLER_259_212 VDD VSS VDD VSS gf180mcu_fd_sc_mcu7t5v0__fillcap_64
X_2586_ wire12/I VDD VSS _3254_/D wire98/Z _3254_/Q VDD VSS gf180mcu_fd_sc_mcu7t5v0__mux2_2
X_1537_ _2243_/B VDD VSS output8/I _3172_/Q _2274_/A1 VDD VSS gf180mcu_fd_sc_mcu7t5v0__aoi21_1
XFILLER_87_626 VDD VSS VDD VSS gf180mcu_fd_sc_mcu7t5v0__fillcap_4
XFILLER_99_486 VDD VSS VDD VSS gf180mcu_fd_sc_mcu7t5v0__fillcap_4
X_1468_ VDD VSS _1470_/A2 _3407_/Q _1469_/A2 VDD VSS gf180mcu_fd_sc_mcu7t5v0__nor2_1
X_1399_ VDD VSS _3195_/Q _2363_/B2 VDD VSS gf180mcu_fd_sc_mcu7t5v0__clkinv_1
X_3207_ _3207_/D _3207_/Q wire153/I VSS _3349_/CLK VDD VDD VSS gf180mcu_fd_sc_mcu7t5v0__dffrnq_1
XFILLER_227_142 VDD VSS VDD VSS gf180mcu_fd_sc_mcu7t5v0__fillcap_64
X_3138_ _3138_/D _3138_/Q wire151/Z VSS _3182_/CLK VDD VDD VSS gf180mcu_fd_sc_mcu7t5v0__dffrnq_1
XFILLER_28_737 VDD VSS VDD VSS gf180mcu_fd_sc_mcu7t5v0__fillcap_64
XFILLER_242_101 VDD VSS VDD VSS gf180mcu_fd_sc_mcu7t5v0__fillcap_4
XFILLER_55_556 VDD VSS VDD VSS gf180mcu_fd_sc_mcu7t5v0__fillcap_4
X_3069_ _3069_/D _3069_/Q wire163/I VSS _3463_/CLK VDD VDD VSS gf180mcu_fd_sc_mcu7t5v0__dffrnq_1
XFILLER_224_871 VDD VSS VDD VSS gf180mcu_fd_sc_mcu7t5v0__fillcap_4
XFILLER_195_200 VDD VSS VDD VSS gf180mcu_fd_sc_mcu7t5v0__fillcap_8
XFILLER_259_72 VDD VSS VDD VSS gf180mcu_fd_sc_mcu7t5v0__fillcap_64
XFILLER_23_486 VDD VSS VDD VSS gf180mcu_fd_sc_mcu7t5v0__fillcap_4
XFILLER_11_626 VDD VSS VDD VSS gf180mcu_fd_sc_mcu7t5v0__fillcap_4
XFILLER_155_119 VDD VSS VDD VSS gf180mcu_fd_sc_mcu7t5v0__fillcap_16
Xmax_length115 VSS wire114/I _3181_/Q VDD VDD VSS gf180mcu_fd_sc_mcu7t5v0__buf_2
XFILLER_6_107 VDD VSS VDD VSS gf180mcu_fd_sc_mcu7t5v0__fillcap_64
XFILLER_148_171 VDD VSS VDD VSS gf180mcu_fd_sc_mcu7t5v0__fillcap_4
XFILLER_148_193 VDD VSS VDD VSS gf180mcu_fd_sc_mcu7t5v0__fillcap_8
XFILLER_136_311 VDD VSS VDD VSS gf180mcu_fd_sc_mcu7t5v0__fillcap_4
Xmax_length148 wire147/I wire145/I VDD VSS VDD VSS gf180mcu_fd_sc_mcu7t5v0__buf_8
Xmax_length159 _3458_/RN _3403_/RN VDD VSS VDD VSS gf180mcu_fd_sc_mcu7t5v0__buf_8
XFILLER_3_836 VDD VSS VDD VSS gf180mcu_fd_sc_mcu7t5v0__fillcap_4
Xclkbuf_4_8_0_host_clk_i _2914_/CLK VSS VDD clkbuf_0_host_clk_i/Z VDD VSS gf180mcu_fd_sc_mcu7t5v0__clkbuf_2
XFILLER_77_136 VDD VSS VDD VSS gf180mcu_fd_sc_mcu7t5v0__fillcap_4
XFILLER_246_451 VDD VSS VDD VSS gf180mcu_fd_sc_mcu7t5v0__fillcap_4
XFILLER_18_247 VDD VSS VDD VSS gf180mcu_fd_sc_mcu7t5v0__fillcap_64
XFILLER_33_206 VDD VSS VDD VSS gf180mcu_fd_sc_mcu7t5v0__fillcap_4
XFILLER_53_72 VDD VSS VDD VSS gf180mcu_fd_sc_mcu7t5v0__fillcap_64
XFILLER_230_885 VDD VSS VDD VSS gf180mcu_fd_sc_mcu7t5v0__fillcap_4
XFILLER_169_72 VDD VSS VDD VSS gf180mcu_fd_sc_mcu7t5v0__fillcap_64
XFILLER_186_255 VDD VSS VDD VSS gf180mcu_fd_sc_mcu7t5v0__fillcap_4
XFILLER_128_801 VDD VSS VDD VSS gf180mcu_fd_sc_mcu7t5v0__fillcap_4
XFILLER_182_450 VDD VSS VDD VSS gf180mcu_fd_sc_mcu7t5v0__fillcap_4
X_2440_ _2866_/Q VSS VDD _2850_/Q _2858_/Q wire78/Z _2842_/Q wire76/Z _2440_/Z VDD
+ VSS gf180mcu_fd_sc_mcu7t5v0__mux4_1
XFILLER_170_667 VDD VSS VDD VSS gf180mcu_fd_sc_mcu7t5v0__fillcap_64
X_2371_ _2442_/S VDD VSS _2371_/Z _2369_/Z _2370_/Z VDD VSS gf180mcu_fd_sc_mcu7t5v0__mux2_2
XFILLER_69_626 VDD VSS VDD VSS gf180mcu_fd_sc_mcu7t5v0__fillcap_4
XFILLER_37_556 VDD VSS VDD VSS gf180mcu_fd_sc_mcu7t5v0__fillcap_4
XFILLER_206_871 VDD VSS VDD VSS gf180mcu_fd_sc_mcu7t5v0__fillcap_4
XFILLER_221_874 VDD VSS VDD VSS gf180mcu_fd_sc_mcu7t5v0__fillcap_16
X_2707_ _3098_/Q _2707_/C VDD VSS _2715_/A2 _3066_/Q _2026_/Z _2061_/Z VDD VSS gf180mcu_fd_sc_mcu7t5v0__aoi221_1
XFILLER_161_623 VDD VSS VDD VSS gf180mcu_fd_sc_mcu7t5v0__fillcap_4
X_2638_ _2644_/S VDD VSS _3301_/D _3259_/Q _3301_/Q VDD VSS gf180mcu_fd_sc_mcu7t5v0__mux2_2
X_2569_ _2587_/S VDD VSS _3237_/D _3214_/Q _3237_/Q VDD VSS gf180mcu_fd_sc_mcu7t5v0__mux2_2
XFILLER_160_177 VDD VSS VDD VSS gf180mcu_fd_sc_mcu7t5v0__fillcap_8
XFILLER_59_136 VDD VSS VDD VSS gf180mcu_fd_sc_mcu7t5v0__fillcap_4
XFILLER_101_244 VDD VSS VDD VSS gf180mcu_fd_sc_mcu7t5v0__fillcap_4
XFILLER_228_451 VDD VSS VDD VSS gf180mcu_fd_sc_mcu7t5v0__fillcap_4
XFILLER_15_206 VDD VSS VDD VSS gf180mcu_fd_sc_mcu7t5v0__fillcap_4
XFILLER_168_211 VDD VSS VDD VSS gf180mcu_fd_sc_mcu7t5v0__fillcap_32
XFILLER_90_37 VDD VSS VDD VSS gf180mcu_fd_sc_mcu7t5v0__fillcap_8
XFILLER_212_885 VDD VSS VDD VSS gf180mcu_fd_sc_mcu7t5v0__fillcap_4
XFILLER_184_737 VDD VSS VDD VSS gf180mcu_fd_sc_mcu7t5v0__fillcap_64
XFILLER_168_255 VDD VSS VDD VSS gf180mcu_fd_sc_mcu7t5v0__fillcap_4
XFILLER_196_597 VDD VSS VDD VSS gf180mcu_fd_sc_mcu7t5v0__fillcap_4
XFILLER_7_416 VDD VSS VDD VSS gf180mcu_fd_sc_mcu7t5v0__fillcap_4
XFILLER_152_667 VDD VSS VDD VSS gf180mcu_fd_sc_mcu7t5v0__fillcap_4
XFILLER_140_807 VDD VSS VDD VSS gf180mcu_fd_sc_mcu7t5v0__fillcap_64
XFILLER_151_133 VDD VSS VDD VSS gf180mcu_fd_sc_mcu7t5v0__fillcap_4
XFILLER_151_199 VDD VSS VDD VSS gf180mcu_fd_sc_mcu7t5v0__fillcap_8
XFILLER_120_542 VDD VSS VDD VSS gf180mcu_fd_sc_mcu7t5v0__fillcap_4
XFILLER_120_597 VDD VSS VDD VSS gf180mcu_fd_sc_mcu7t5v0__fillcap_64
XFILLER_206_101 VDD VSS VDD VSS gf180mcu_fd_sc_mcu7t5v0__fillcap_4
XFILLER_19_556 VDD VSS VDD VSS gf180mcu_fd_sc_mcu7t5v0__fillcap_4
XFILLER_203_874 VDD VSS VDD VSS gf180mcu_fd_sc_mcu7t5v0__fillcap_16
X_1940_ _1942_/S VDD VSS _2992_/D wire119/Z _2992_/Q VDD VSS gf180mcu_fd_sc_mcu7t5v0__mux2_2
X_1871_ _1877_/S VDD VSS _2934_/D _2934_/Q wire123/I VDD VSS gf180mcu_fd_sc_mcu7t5v0__mux2_2
XFILLER_9_66 VDD VSS VDD VSS gf180mcu_fd_sc_mcu7t5v0__fillcap_4
XFILLER_174_236 VDD VSS VDD VSS gf180mcu_fd_sc_mcu7t5v0__fillcap_8
XFILLER_174_247 VDD VSS VDD VSS gf180mcu_fd_sc_mcu7t5v0__fillcap_32
XFILLER_155_483 VDD VSS VDD VSS gf180mcu_fd_sc_mcu7t5v0__fillcap_4
XFILLER_170_486 VDD VSS VDD VSS gf180mcu_fd_sc_mcu7t5v0__fillcap_32
XFILLER_142_177 VDD VSS VDD VSS gf180mcu_fd_sc_mcu7t5v0__fillcap_4
X_2423_ VDD _2423_/B _1654_/Z _2424_/A2 _3199_/Q VSS VDD VSS gf180mcu_fd_sc_mcu7t5v0__oai21_1
XFILLER_130_317 VDD VSS VDD VSS gf180mcu_fd_sc_mcu7t5v0__fillcap_32
XFILLER_43_2 VDD VSS VDD VSS gf180mcu_fd_sc_mcu7t5v0__fillcap_64
X_2354_ VDD _2354_/B _2354_/A2 _3192_/D _2361_/A3 VSS VDD VSS gf180mcu_fd_sc_mcu7t5v0__oai21_1
XFILLER_215_99 VDD VSS VDD VSS gf180mcu_fd_sc_mcu7t5v0__fillcap_32
X_2285_ _2289_/S VDD VSS _3178_/D _3178_/Q wire110/Z VDD VSS gf180mcu_fd_sc_mcu7t5v0__mux2_2
XFILLER_198_807 VDD VSS VDD VSS gf180mcu_fd_sc_mcu7t5v0__fillcap_64
XFILLER_240_457 VDD VSS VDD VSS gf180mcu_fd_sc_mcu7t5v0__fillcap_64
XFILLER_178_520 VDD VSS VDD VSS gf180mcu_fd_sc_mcu7t5v0__fillcap_4
XFILLER_178_597 VDD VSS VDD VSS gf180mcu_fd_sc_mcu7t5v0__fillcap_8
XFILLER_166_737 VDD VSS VDD VSS gf180mcu_fd_sc_mcu7t5v0__fillcap_64
XFILLER_176_18 VDD VSS VDD VSS gf180mcu_fd_sc_mcu7t5v0__fillcap_8
XFILLER_193_556 VDD VSS VDD VSS gf180mcu_fd_sc_mcu7t5v0__fillcap_4
XFILLER_146_450 VDD VSS VDD VSS gf180mcu_fd_sc_mcu7t5v0__fillcap_4
XFILLER_106_303 VDD VSS VDD VSS gf180mcu_fd_sc_mcu7t5v0__fillcap_8
XFILLER_122_807 VDD VSS VDD VSS gf180mcu_fd_sc_mcu7t5v0__fillcap_64
XFILLER_0_614 VDD VSS VDD VSS gf180mcu_fd_sc_mcu7t5v0__fillcap_32
XFILLER_87_242 VDD VSS VDD VSS gf180mcu_fd_sc_mcu7t5v0__fillcap_4
XFILLER_85_59 VDD VSS VDD VSS gf180mcu_fd_sc_mcu7t5v0__fillcap_8
XFILLER_141_65 VDD VSS VDD VSS gf180mcu_fd_sc_mcu7t5v0__fillcap_4
XFILLER_141_87 VDD VSS VDD VSS gf180mcu_fd_sc_mcu7t5v0__fillcap_4
XFILLER_83_492 VDD VSS VDD VSS gf180mcu_fd_sc_mcu7t5v0__fillcap_64
XFILLER_71_632 VDD VSS VDD VSS gf180mcu_fd_sc_mcu7t5v0__fillcap_64
XFILLER_245_2 VDD VSS VDD VSS gf180mcu_fd_sc_mcu7t5v0__fillcap_64
Xspi_opentarget_i3c_top_201 spi_mosi_i_PU VDD VSS VDD VSS gf180mcu_fd_sc_mcu7t5v0__tiel
Xwire111 _1424_/I VSS VDD _3196_/Q VDD VSS gf180mcu_fd_sc_mcu7t5v0__clkbuf_2
Xwire122 VSS wire122/Z _3177_/Q VDD VDD VSS gf180mcu_fd_sc_mcu7t5v0__buf_2
Xwire100 VSS wire100/Z _3218_/Q VDD VDD VSS gf180mcu_fd_sc_mcu7t5v0__clkbuf_1
Xwire133 VSS wire133/Z wire133/I VDD VDD VSS gf180mcu_fd_sc_mcu7t5v0__buf_2
XFILLER_200_877 VDD VSS VDD VSS gf180mcu_fd_sc_mcu7t5v0__fillcap_8
XFILLER_137_461 VDD VSS VDD VSS gf180mcu_fd_sc_mcu7t5v0__fillcap_4
XFILLER_171_206 VDD VSS VDD VSS gf180mcu_fd_sc_mcu7t5v0__fillcap_4
XFILLER_166_73 VDD VSS VDD VSS gf180mcu_fd_sc_mcu7t5v0__fillcap_4
XFILLER_93_212 VDD VSS VDD VSS gf180mcu_fd_sc_mcu7t5v0__fillcap_16
XFILLER_266_387 VDD VSS VDD VSS gf180mcu_fd_sc_mcu7t5v0__fillcap_64
XFILLER_254_527 VDD VSS VDD VSS gf180mcu_fd_sc_mcu7t5v0__fillcap_64
X_2070_ _2072_/S VDD VSS _3099_/D wire91/Z _3099_/Q VDD VSS gf180mcu_fd_sc_mcu7t5v0__mux2_2
Xload_slew41 _1917_/S _1914_/S VDD VSS VDD VSS gf180mcu_fd_sc_mcu7t5v0__buf_4
XFILLER_61_142 VDD VSS VDD VSS gf180mcu_fd_sc_mcu7t5v0__fillcap_64
XFILLER_222_457 VDD VSS VDD VSS gf180mcu_fd_sc_mcu7t5v0__fillcap_8
X_2972_ VDD _2972_/Q _3341_/CLK VSS _2972_/D VDD VSS gf180mcu_fd_sc_mcu7t5v0__dffq_1
X_1923_ _1926_/S VDD VSS _2977_/D _2015_/I0 _2977_/Q VDD VSS gf180mcu_fd_sc_mcu7t5v0__mux2_2
XFILLER_203_693 VDD VSS VDD VSS gf180mcu_fd_sc_mcu7t5v0__fillcap_4
XFILLER_148_737 VDD VSS VDD VSS gf180mcu_fd_sc_mcu7t5v0__fillcap_64
XFILLER_147_203 VDD VSS VDD VSS gf180mcu_fd_sc_mcu7t5v0__fillcap_4
XFILLER_187_394 VDD VSS VDD VSS gf180mcu_fd_sc_mcu7t5v0__fillcap_8
X_1854_ _1860_/S VDD VSS _2918_/D _1863_/I0 _2918_/Q VDD VSS gf180mcu_fd_sc_mcu7t5v0__mux2_2
X_1785_ _1786_/S VDD VSS _2859_/D _1794_/I1 _2859_/Q VDD VSS gf180mcu_fd_sc_mcu7t5v0__mux2_2
XFILLER_162_239 VDD VSS VDD VSS gf180mcu_fd_sc_mcu7t5v0__fillcap_4
X_3455_ _3455_/D _3455_/Q _3455_/RN VSS _3462_/CLK VDD VDD VSS gf180mcu_fd_sc_mcu7t5v0__dffrnq_1
XFILLER_104_807 VDD VSS VDD VSS gf180mcu_fd_sc_mcu7t5v0__fillcap_64
XFILLER_116_667 VDD VSS VDD VSS gf180mcu_fd_sc_mcu7t5v0__fillcap_4
X_2406_ _2406_/B _2448_/C VDD VSS _2408_/A2 _3382_/Q _2400_/Z VDD VSS gf180mcu_fd_sc_mcu7t5v0__oai211_1
X_3386_ _3386_/D _3386_/Q _3403_/RN VSS _3392_/CLK VDD VDD VSS gf180mcu_fd_sc_mcu7t5v0__dffrnq_1
XFILLER_85_702 VDD VSS VDD VSS gf180mcu_fd_sc_mcu7t5v0__fillcap_64
XFILLER_258_877 VDD VSS VDD VSS gf180mcu_fd_sc_mcu7t5v0__fillcap_8
X_2337_ _2337_/A3 VDD VSS _2338_/A2 _2337_/A1 _1664_/Z VDD VSS gf180mcu_fd_sc_mcu7t5v0__nand3_1
X_2268_ _2268_/B _2268_/C VDD VSS _2270_/S _2232_/B _2351_/A2 VDD VSS gf180mcu_fd_sc_mcu7t5v0__aoi211_1
XFILLER_111_394 VDD VSS VDD VSS gf180mcu_fd_sc_mcu7t5v0__fillcap_4
X_2199_ _2199_/B VDD VSS _3149_/D _2199_/A1 _2189_/S VDD VSS gf180mcu_fd_sc_mcu7t5v0__aoi21_1
XFILLER_65_492 VDD VSS VDD VSS gf180mcu_fd_sc_mcu7t5v0__fillcap_64
XFILLER_53_632 VDD VSS VDD VSS gf180mcu_fd_sc_mcu7t5v0__fillcap_64
XFILLER_80_451 VDD VSS VDD VSS gf180mcu_fd_sc_mcu7t5v0__fillcap_4
XFILLER_201_608 VDD VSS VDD VSS gf180mcu_fd_sc_mcu7t5v0__fillcap_8
XFILLER_241_766 VDD VSS VDD VSS gf180mcu_fd_sc_mcu7t5v0__fillcap_4
XFILLER_198_648 VDD VSS VDD VSS gf180mcu_fd_sc_mcu7t5v0__fillcap_16
XFILLER_200_107 VDD VSS VDD VSS gf180mcu_fd_sc_mcu7t5v0__fillcap_8
XFILLER_21_562 VDD VSS VDD VSS gf180mcu_fd_sc_mcu7t5v0__fillcap_64
XFILLER_181_515 VDD VSS VDD VSS gf180mcu_fd_sc_mcu7t5v0__fillcap_4
XFILLER_267_72 VDD VSS VDD VSS gf180mcu_fd_sc_mcu7t5v0__fillcap_64
XFILLER_106_100 VDD VSS VDD VSS gf180mcu_fd_sc_mcu7t5v0__fillcap_4
XFILLER_161_261 VDD VSS VDD VSS gf180mcu_fd_sc_mcu7t5v0__fillcap_4
XFILLER_0_444 VDD VSS VDD VSS gf180mcu_fd_sc_mcu7t5v0__fillcap_32
XFILLER_96_69 VDD VSS VDD VSS gf180mcu_fd_sc_mcu7t5v0__fillcap_16
XFILLER_102_372 VDD VSS VDD VSS gf180mcu_fd_sc_mcu7t5v0__fillcap_8
XFILLER_248_387 VDD VSS VDD VSS gf180mcu_fd_sc_mcu7t5v0__fillcap_64
XFILLER_236_527 VDD VSS VDD VSS gf180mcu_fd_sc_mcu7t5v0__fillcap_64
XFILLER_263_346 VDD VSS VDD VSS gf180mcu_fd_sc_mcu7t5v0__fillcap_4
XFILLER_43_142 VDD VSS VDD VSS gf180mcu_fd_sc_mcu7t5v0__fillcap_64
XFILLER_204_457 VDD VSS VDD VSS gf180mcu_fd_sc_mcu7t5v0__fillcap_8
XFILLER_231_276 VDD VSS VDD VSS gf180mcu_fd_sc_mcu7t5v0__fillcap_4
XFILLER_40_871 VDD VSS VDD VSS gf180mcu_fd_sc_mcu7t5v0__fillcap_4
XFILLER_157_556 VDD VSS VDD VSS gf180mcu_fd_sc_mcu7t5v0__fillcap_4
XFILLER_61_72 VDD VSS VDD VSS gf180mcu_fd_sc_mcu7t5v0__fillcap_64
XFILLER_172_515 VDD VSS VDD VSS gf180mcu_fd_sc_mcu7t5v0__fillcap_8
XFILLER_177_72 VDD VSS VDD VSS gf180mcu_fd_sc_mcu7t5v0__fillcap_16
X_1570_ _1589_/C VDD VSS _1573_/A1 _3186_/Q _1569_/Z VDD VSS gf180mcu_fd_sc_mcu7t5v0__aoi21_1
XFILLER_125_475 VDD VSS VDD VSS gf180mcu_fd_sc_mcu7t5v0__fillcap_8
XFILLER_258_107 VDD VSS VDD VSS gf180mcu_fd_sc_mcu7t5v0__fillcap_64
XFILLER_113_626 VDD VSS VDD VSS gf180mcu_fd_sc_mcu7t5v0__fillcap_4
XFILLER_3_282 VDD VSS VDD VSS gf180mcu_fd_sc_mcu7t5v0__fillcap_64
X_3240_ _3240_/D _3240_/Q _3452_/RN VSS _3451_/CLK VDD VDD VSS gf180mcu_fd_sc_mcu7t5v0__dffrnq_1
X_3171_ _3171_/D _3171_/Q wire153/I VSS _3360_/CLK VDD VDD VSS gf180mcu_fd_sc_mcu7t5v0__dffrnq_1
XFILLER_79_562 VDD VSS VDD VSS gf180mcu_fd_sc_mcu7t5v0__fillcap_64
XFILLER_67_702 VDD VSS VDD VSS gf180mcu_fd_sc_mcu7t5v0__fillcap_64
XFILLER_255_836 VDD VSS VDD VSS gf180mcu_fd_sc_mcu7t5v0__fillcap_4
XFILLER_267_696 VDD VSS VDD VSS gf180mcu_fd_sc_mcu7t5v0__fillcap_4
X_2122_ _3113_/Q VDD VSS _2123_/B1 _2123_/A1 _3114_/Q VDD VSS gf180mcu_fd_sc_mcu7t5v0__nand3_1
XFILLER_94_521 VDD VSS VDD VSS gf180mcu_fd_sc_mcu7t5v0__fillcap_4
XFILLER_47_492 VDD VSS VDD VSS gf180mcu_fd_sc_mcu7t5v0__fillcap_64
XFILLER_35_632 VDD VSS VDD VSS gf180mcu_fd_sc_mcu7t5v0__fillcap_64
X_2053_ _2059_/S VDD VSS _3086_/D _3302_/Q _3086_/Q VDD VSS gf180mcu_fd_sc_mcu7t5v0__mux2_2
XFILLER_212_89 VDD VSS VDD VSS gf180mcu_fd_sc_mcu7t5v0__fillcap_16
XFILLER_62_451 VDD VSS VDD VSS gf180mcu_fd_sc_mcu7t5v0__fillcap_4
XFILLER_223_766 VDD VSS VDD VSS gf180mcu_fd_sc_mcu7t5v0__fillcap_4
X_2955_ VDD _2955_/Q _2963_/CLK VSS _2955_/D VDD VSS gf180mcu_fd_sc_mcu7t5v0__dffq_1
X_1906_ _1907_/S VDD VSS _2963_/D _3181_/Q _2963_/Q VDD VSS gf180mcu_fd_sc_mcu7t5v0__mux2_2
X_2886_ VDD _2886_/Q _2900_/CLK VSS _2886_/D VDD VSS gf180mcu_fd_sc_mcu7t5v0__dffq_1
XFILLER_148_567 VDD VSS VDD VSS gf180mcu_fd_sc_mcu7t5v0__fillcap_16
XFILLER_30_381 VDD VSS VDD VSS gf180mcu_fd_sc_mcu7t5v0__fillcap_4
XFILLER_136_718 VDD VSS VDD VSS gf180mcu_fd_sc_mcu7t5v0__fillcap_16
X_1837_ _1842_/S VDD VSS _2903_/D _1864_/I0 _2903_/Q VDD VSS gf180mcu_fd_sc_mcu7t5v0__mux2_2
XFILLER_116_420 VDD VSS VDD VSS gf180mcu_fd_sc_mcu7t5v0__fillcap_32
XFILLER_128_280 VDD VSS VDD VSS gf180mcu_fd_sc_mcu7t5v0__fillcap_32
X_1768_ _1768_/S VDD VSS _2844_/D _3126_/Q _2844_/Q VDD VSS gf180mcu_fd_sc_mcu7t5v0__mux2_2
X_1699_ VDD VSS _1699_/Z _3204_/Q _1699_/A2 VDD VSS gf180mcu_fd_sc_mcu7t5v0__and2_1
X_3438_ _3438_/D _3438_/Q wire161/I VSS _3443_/CLK VDD VDD VSS gf180mcu_fd_sc_mcu7t5v0__dffrnq_1
XFILLER_103_125 VDD VSS VDD VSS gf180mcu_fd_sc_mcu7t5v0__fillcap_4
X_3369_ _3369_/D _3369_/Q _3458_/RN VSS _3369_/CLK VDD VDD VSS gf180mcu_fd_sc_mcu7t5v0__dffrnq_1
XFILLER_98_871 VDD VSS VDD VSS gf180mcu_fd_sc_mcu7t5v0__fillcap_4
XFILLER_106_68 VDD VSS VDD VSS gf180mcu_fd_sc_mcu7t5v0__fillcap_32
XFILLER_218_527 VDD VSS VDD VSS gf180mcu_fd_sc_mcu7t5v0__fillcap_16
XFILLER_57_212 VDD VSS VDD VSS gf180mcu_fd_sc_mcu7t5v0__fillcap_64
XFILLER_245_346 VDD VSS VDD VSS gf180mcu_fd_sc_mcu7t5v0__fillcap_4
XFILLER_25_142 VDD VSS VDD VSS gf180mcu_fd_sc_mcu7t5v0__fillcap_64
XFILLER_40_101 VDD VSS VDD VSS gf180mcu_fd_sc_mcu7t5v0__fillcap_4
XFILLER_198_489 VDD VSS VDD VSS gf180mcu_fd_sc_mcu7t5v0__fillcap_8
XFILLER_213_276 VDD VSS VDD VSS gf180mcu_fd_sc_mcu7t5v0__fillcap_4
XFILLER_213_298 VDD VSS VDD VSS gf180mcu_fd_sc_mcu7t5v0__fillcap_8
XFILLER_22_871 VDD VSS VDD VSS gf180mcu_fd_sc_mcu7t5v0__fillcap_4
XFILLER_110_2 VDD VSS VDD VSS gf180mcu_fd_sc_mcu7t5v0__fillcap_8
XFILLER_208_2 VDD VSS VDD VSS gf180mcu_fd_sc_mcu7t5v0__fillcap_16
XFILLER_162_581 VDD VSS VDD VSS gf180mcu_fd_sc_mcu7t5v0__fillcap_8
Xoutput7 VDD _1538_/Z VSS sda_pad_OUT VDD VSS gf180mcu_fd_sc_mcu7t5v0__dlyb_1
XFILLER_107_486 VDD VSS VDD VSS gf180mcu_fd_sc_mcu7t5v0__fillcap_4
XFILLER_95_329 VDD VSS VDD VSS gf180mcu_fd_sc_mcu7t5v0__fillcap_16
XFILLER_49_702 VDD VSS VDD VSS gf180mcu_fd_sc_mcu7t5v0__fillcap_64
XFILLER_237_836 VDD VSS VDD VSS gf180mcu_fd_sc_mcu7t5v0__fillcap_4
XFILLER_249_696 VDD VSS VDD VSS gf180mcu_fd_sc_mcu7t5v0__fillcap_4
XFILLER_209_516 VDD VSS VDD VSS gf180mcu_fd_sc_mcu7t5v0__fillcap_4
XFILLER_76_521 VDD VSS VDD VSS gf180mcu_fd_sc_mcu7t5v0__fillcap_4
XFILLER_0_274 VDD VSS VDD VSS gf180mcu_fd_sc_mcu7t5v0__fillcap_32
XFILLER_91_524 VDD VSS VDD VSS gf180mcu_fd_sc_mcu7t5v0__fillcap_4
XFILLER_17_632 VDD VSS VDD VSS gf180mcu_fd_sc_mcu7t5v0__fillcap_64
XFILLER_29_492 VDD VSS VDD VSS gf180mcu_fd_sc_mcu7t5v0__fillcap_64
XFILLER_44_451 VDD VSS VDD VSS gf180mcu_fd_sc_mcu7t5v0__fillcap_4
XFILLER_72_93 VDD VSS VDD VSS gf180mcu_fd_sc_mcu7t5v0__fillcap_8
X_2740_ _2996_/Q VSS VDD _2980_/Q _2988_/Q _2740_/S0 _2972_/Q _2740_/S1 _2740_/Z VDD
+ VSS gf180mcu_fd_sc_mcu7t5v0__mux4_1
XFILLER_9_842 VDD VSS VDD VSS gf180mcu_fd_sc_mcu7t5v0__fillcap_32
XFILLER_12_381 VDD VSS VDD VSS gf180mcu_fd_sc_mcu7t5v0__fillcap_4
XFILLER_117_217 VDD VSS VDD VSS gf180mcu_fd_sc_mcu7t5v0__fillcap_8
X_2671_ VDD VSS _2672_/B2 _2752_/A1 _2671_/A2 VDD VSS gf180mcu_fd_sc_mcu7t5v0__nand2_1
X_1622_ VDD VSS _1622_/Z _3440_/Q _3411_/D VDD VSS gf180mcu_fd_sc_mcu7t5v0__xor2_1
X_1553_ VDD VSS _2186_/A2 _3138_/Q _2175_/A1 VDD VSS gf180mcu_fd_sc_mcu7t5v0__nand2_1
XFILLER_98_112 VDD VSS VDD VSS gf180mcu_fd_sc_mcu7t5v0__fillcap_32
XFILLER_259_416 VDD VSS VDD VSS gf180mcu_fd_sc_mcu7t5v0__fillcap_4
XFILLER_4_591 VDD VSS VDD VSS gf180mcu_fd_sc_mcu7t5v0__fillcap_4
X_1484_ _1485_/A2 VDD VSS _1484_/Z _3421_/Q wire59/I VDD VSS gf180mcu_fd_sc_mcu7t5v0__and3_1
XFILLER_98_167 VDD VSS VDD VSS gf180mcu_fd_sc_mcu7t5v0__fillcap_8
X_3223_ _3223_/D _3223_/Q wire165/I VSS _3450_/CLK VDD VDD VSS gf180mcu_fd_sc_mcu7t5v0__dffrnq_1
XFILLER_39_212 VDD VSS VDD VSS gf180mcu_fd_sc_mcu7t5v0__fillcap_64
XFILLER_227_346 VDD VSS VDD VSS gf180mcu_fd_sc_mcu7t5v0__fillcap_4
X_3154_ _3154_/D _3154_/Q wire147/I VSS _3288_/CLK VDD VDD VSS gf180mcu_fd_sc_mcu7t5v0__dffrnq_1
XFILLER_95_874 VDD VSS VDD VSS gf180mcu_fd_sc_mcu7t5v0__fillcap_16
X_2105_ _2106_/A2 VDD VSS _2109_/A3 _3110_/Q _2074_/Z VDD VSS gf180mcu_fd_sc_mcu7t5v0__nand3_1
X_3085_ _3085_/D _3085_/Q wire165/Z VSS clkload9/I VDD VDD VSS gf180mcu_fd_sc_mcu7t5v0__dffrnq_1
X_2036_ _2060_/S VDD VSS _3069_/D wire89/Z _3069_/Q VDD VSS gf180mcu_fd_sc_mcu7t5v0__mux2_2
XFILLER_223_552 VDD VSS VDD VSS gf180mcu_fd_sc_mcu7t5v0__fillcap_8
XFILLER_22_101 VDD VSS VDD VSS gf180mcu_fd_sc_mcu7t5v0__fillcap_4
X_2938_ VDD _2938_/Q _3415_/CLK VSS _2938_/D VDD VSS gf180mcu_fd_sc_mcu7t5v0__dffq_1
XFILLER_176_651 VDD VSS VDD VSS gf180mcu_fd_sc_mcu7t5v0__fillcap_8
XFILLER_191_610 VDD VSS VDD VSS gf180mcu_fd_sc_mcu7t5v0__fillcap_4
X_2869_ VDD _2869_/Q _2932_/CLK VSS _2869_/D VDD VSS gf180mcu_fd_sc_mcu7t5v0__dffq_1
XFILLER_191_632 VDD VSS VDD VSS gf180mcu_fd_sc_mcu7t5v0__fillcap_8
XFILLER_77_38 VDD VSS VDD VSS gf180mcu_fd_sc_mcu7t5v0__fillcap_16
XFILLER_219_836 VDD VSS VDD VSS gf180mcu_fd_sc_mcu7t5v0__fillcap_4
XFILLER_58_521 VDD VSS VDD VSS gf180mcu_fd_sc_mcu7t5v0__fillcap_4
XFILLER_100_640 VDD VSS VDD VSS gf180mcu_fd_sc_mcu7t5v0__fillcap_4
XFILLER_86_885 VDD VSS VDD VSS gf180mcu_fd_sc_mcu7t5v0__fillcap_4
XFILLER_26_451 VDD VSS VDD VSS gf180mcu_fd_sc_mcu7t5v0__fillcap_4
XFILLER_214_563 VDD VSS VDD VSS gf180mcu_fd_sc_mcu7t5v0__fillcap_8
XFILLER_199_765 VDD VSS VDD VSS gf180mcu_fd_sc_mcu7t5v0__fillcap_4
XFILLER_158_2 VDD VSS VDD VSS gf180mcu_fd_sc_mcu7t5v0__fillcap_32
XFILLER_6_801 VDD VSS VDD VSS gf180mcu_fd_sc_mcu7t5v0__fillcap_4
XFILLER_182_643 VDD VSS VDD VSS gf180mcu_fd_sc_mcu7t5v0__fillcap_16
XFILLER_181_120 VDD VSS VDD VSS gf180mcu_fd_sc_mcu7t5v0__fillcap_8
XFILLER_10_885 VDD VSS VDD VSS gf180mcu_fd_sc_mcu7t5v0__fillcap_4
XFILLER_181_142 VDD VSS VDD VSS gf180mcu_fd_sc_mcu7t5v0__fillcap_8
XFILLER_114_209 VDD VSS VDD VSS gf180mcu_fd_sc_mcu7t5v0__fillcap_8
XFILLER_122_286 VDD VSS VDD VSS gf180mcu_fd_sc_mcu7t5v0__fillcap_16
XFILLER_77_874 VDD VSS VDD VSS gf180mcu_fd_sc_mcu7t5v0__fillcap_16
Xwire19 VSS wire19/Z wire20/I VDD VDD VSS gf180mcu_fd_sc_mcu7t5v0__buf_2
XFILLER_92_877 VDD VSS VDD VSS gf180mcu_fd_sc_mcu7t5v0__fillcap_8
XFILLER_189_231 VDD VSS VDD VSS gf180mcu_fd_sc_mcu7t5v0__fillcap_32
X_2723_ wire59/Z VDD VSS _2723_/Z _2721_/Z _2722_/Z VDD VSS gf180mcu_fd_sc_mcu7t5v0__mux2_2
XFILLER_73_2 VDD VSS VDD VSS gf180mcu_fd_sc_mcu7t5v0__fillcap_16
XFILLER_173_632 VDD VSS VDD VSS gf180mcu_fd_sc_mcu7t5v0__fillcap_64
XFILLER_185_492 VDD VSS VDD VSS gf180mcu_fd_sc_mcu7t5v0__fillcap_4
XFILLER_8_171 VDD VSS VDD VSS gf180mcu_fd_sc_mcu7t5v0__fillcap_4
X_2654_ _2654_/A3 VDD VSS _2758_/A3 _3272_/Q _1540_/Z VDD VSS gf180mcu_fd_sc_mcu7t5v0__nor3_1
X_1605_ VDD VSS _1605_/Z _3388_/Q _3379_/D VDD VSS gf180mcu_fd_sc_mcu7t5v0__xor2_1
XFILLER_218_77 VDD VSS VDD VSS gf180mcu_fd_sc_mcu7t5v0__fillcap_4
XFILLER_172_164 VDD VSS VDD VSS gf180mcu_fd_sc_mcu7t5v0__fillcap_4
X_2585_ _2587_/S VDD VSS _3253_/D _3245_/Q _3253_/Q VDD VSS gf180mcu_fd_sc_mcu7t5v0__mux2_2
X_1536_ VDD VSS _2184_/S _3348_/D VDD VSS gf180mcu_fd_sc_mcu7t5v0__clkinv_1
XFILLER_141_562 VDD VSS VDD VSS gf180mcu_fd_sc_mcu7t5v0__fillcap_32
X_1467_ VDD VSS _3408_/D _1465_/Z _1473_/A2 VDD VSS gf180mcu_fd_sc_mcu7t5v0__nor2_1
X_3206_ _3206_/D _3206_/Q _3344_/RN VSS _3211_/CLK VDD VDD VSS gf180mcu_fd_sc_mcu7t5v0__dffrnq_1
X_1398_ VDD VSS _3192_/Q _1677_/A2 VDD VSS gf180mcu_fd_sc_mcu7t5v0__clkinv_1
XFILLER_68_885 VDD VSS VDD VSS gf180mcu_fd_sc_mcu7t5v0__fillcap_4
X_3137_ _3137_/D _3137_/Q wire151/Z VSS _3185_/CLK VDD VDD VSS gf180mcu_fd_sc_mcu7t5v0__dffrnq_1
XFILLER_94_170 VDD VSS VDD VSS gf180mcu_fd_sc_mcu7t5v0__fillcap_4
XFILLER_82_387 VDD VSS VDD VSS gf180mcu_fd_sc_mcu7t5v0__fillcap_64
X_3068_ _3068_/D _3068_/Q wire145/Z VSS _3277_/CLK VDD VDD VSS gf180mcu_fd_sc_mcu7t5v0__dffrnq_1
XFILLER_70_527 VDD VSS VDD VSS gf180mcu_fd_sc_mcu7t5v0__fillcap_64
X_2019_ VDD VSS _2020_/B _3276_/Q _2652_/A2 VDD VSS gf180mcu_fd_sc_mcu7t5v0__nand2_1
XFILLER_196_713 VDD VSS VDD VSS gf180mcu_fd_sc_mcu7t5v0__fillcap_16
XFILLER_211_577 VDD VSS VDD VSS gf180mcu_fd_sc_mcu7t5v0__fillcap_4
XFILLER_149_640 VDD VSS VDD VSS gf180mcu_fd_sc_mcu7t5v0__fillcap_4
XFILLER_149_695 VDD VSS VDD VSS gf180mcu_fd_sc_mcu7t5v0__fillcap_4
XFILLER_195_39 VDD VSS VDD VSS gf180mcu_fd_sc_mcu7t5v0__fillcap_16
Xmax_length127 _1869_/I0 VSS VDD _3126_/Q VDD VSS gf180mcu_fd_sc_mcu7t5v0__clkbuf_3
Xmax_length138 VSS _1788_/I1 _3119_/Q VDD VDD VSS gf180mcu_fd_sc_mcu7t5v0__buf_2
Xmax_length149 _3455_/RN wire145/I VDD VSS VDD VSS gf180mcu_fd_sc_mcu7t5v0__buf_8
XFILLER_12_22 VDD VSS VDD VSS gf180mcu_fd_sc_mcu7t5v0__fillcap_8
XFILLER_88_48 VDD VSS VDD VSS gf180mcu_fd_sc_mcu7t5v0__fillcap_16
XFILLER_160_871 VDD VSS VDD VSS gf180mcu_fd_sc_mcu7t5v0__fillcap_4
XFILLER_77_104 VDD VSS VDD VSS gf180mcu_fd_sc_mcu7t5v0__fillcap_8
XFILLER_59_874 VDD VSS VDD VSS gf180mcu_fd_sc_mcu7t5v0__fillcap_16
XFILLER_92_107 VDD VSS VDD VSS gf180mcu_fd_sc_mcu7t5v0__fillcap_16
Xclkbuf_leaf_42_clk_i _3044_/CLK VSS VDD clkload2/I VDD VSS gf180mcu_fd_sc_mcu7t5v0__clkbuf_2
XFILLER_261_422 VDD VSS VDD VSS gf180mcu_fd_sc_mcu7t5v0__fillcap_64
XFILLER_74_877 VDD VSS VDD VSS gf180mcu_fd_sc_mcu7t5v0__fillcap_8
XFILLER_199_562 VDD VSS VDD VSS gf180mcu_fd_sc_mcu7t5v0__fillcap_16
Xclkbuf_leaf_57_clk_i _3012_/CLK VSS VDD clkload2/I VDD VSS gf180mcu_fd_sc_mcu7t5v0__clkbuf_2
XFILLER_167_481 VDD VSS VDD VSS gf180mcu_fd_sc_mcu7t5v0__fillcap_8
XFILLER_155_632 VDD VSS VDD VSS gf180mcu_fd_sc_mcu7t5v0__fillcap_16
XFILLER_182_473 VDD VSS VDD VSS gf180mcu_fd_sc_mcu7t5v0__fillcap_4
XFILLER_185_72 VDD VSS VDD VSS gf180mcu_fd_sc_mcu7t5v0__fillcap_4
X_2370_ _2925_/Q VSS VDD _2909_/Q _2917_/Q _2427_/S0 _2901_/Q _2460_/S1 _2370_/Z VDD
+ VSS gf180mcu_fd_sc_mcu7t5v0__mux4_1
XFILLER_123_562 VDD VSS VDD VSS gf180mcu_fd_sc_mcu7t5v0__fillcap_4
XFILLER_111_702 VDD VSS VDD VSS gf180mcu_fd_sc_mcu7t5v0__fillcap_64
XFILLER_150_381 VDD VSS VDD VSS gf180mcu_fd_sc_mcu7t5v0__fillcap_4
XFILLER_123_595 VDD VSS VDD VSS gf180mcu_fd_sc_mcu7t5v0__fillcap_32
XFILLER_96_457 VDD VSS VDD VSS gf180mcu_fd_sc_mcu7t5v0__fillcap_8
XFILLER_265_772 VDD VSS VDD VSS gf180mcu_fd_sc_mcu7t5v0__fillcap_64
XFILLER_209_176 VDD VSS VDD VSS gf180mcu_fd_sc_mcu7t5v0__fillcap_32
XFILLER_76_192 VDD VSS VDD VSS gf180mcu_fd_sc_mcu7t5v0__fillcap_32
XFILLER_52_527 VDD VSS VDD VSS gf180mcu_fd_sc_mcu7t5v0__fillcap_64
XFILLER_64_387 VDD VSS VDD VSS gf180mcu_fd_sc_mcu7t5v0__fillcap_64
XFILLER_221_842 VDD VSS VDD VSS gf180mcu_fd_sc_mcu7t5v0__fillcap_32
XFILLER_177_212 VDD VSS VDD VSS gf180mcu_fd_sc_mcu7t5v0__fillcap_4
XFILLER_20_457 VDD VSS VDD VSS gf180mcu_fd_sc_mcu7t5v0__fillcap_64
XFILLER_145_142 VDD VSS VDD VSS gf180mcu_fd_sc_mcu7t5v0__fillcap_16
X_2706_ _3271_/Q _2706_/A4 VDD VSS _2707_/C _3269_/Q _3268_/Q VDD VSS gf180mcu_fd_sc_mcu7t5v0__nor4_1
X_2637_ wire46/Z VDD VSS _3300_/D _3258_/Q _3300_/Q VDD VSS gf180mcu_fd_sc_mcu7t5v0__mux2_2
XFILLER_142_871 VDD VSS VDD VSS gf180mcu_fd_sc_mcu7t5v0__fillcap_4
XFILLER_0_818 VDD VSS VDD VSS gf180mcu_fd_sc_mcu7t5v0__fillcap_32
X_2568_ _2587_/S VDD VSS _3236_/D _3452_/Q _3236_/Q VDD VSS gf180mcu_fd_sc_mcu7t5v0__mux2_2
X_1519_ _1519_/B VDD VSS _1521_/A2 _1519_/A1 _3174_/Q VDD VSS gf180mcu_fd_sc_mcu7t5v0__aoi21_1
XFILLER_101_212 VDD VSS VDD VSS gf180mcu_fd_sc_mcu7t5v0__fillcap_32
X_2499_ VDD VSS _2554_/A2 _3226_/Q _2552_/A2 VDD VSS gf180mcu_fd_sc_mcu7t5v0__nor2_1
XFILLER_74_107 VDD VSS VDD VSS gf180mcu_fd_sc_mcu7t5v0__fillcap_16
XFILLER_243_422 VDD VSS VDD VSS gf180mcu_fd_sc_mcu7t5v0__fillcap_64
XFILLER_255_282 VDD VSS VDD VSS gf180mcu_fd_sc_mcu7t5v0__fillcap_64
XFILLER_56_877 VDD VSS VDD VSS gf180mcu_fd_sc_mcu7t5v0__fillcap_8
XFILLER_71_836 VDD VSS VDD VSS gf180mcu_fd_sc_mcu7t5v0__fillcap_4
XFILLER_83_696 VDD VSS VDD VSS gf180mcu_fd_sc_mcu7t5v0__fillcap_4
XFILLER_196_510 VDD VSS VDD VSS gf180mcu_fd_sc_mcu7t5v0__fillcap_8
XFILLER_169_702 VDD VSS VDD VSS gf180mcu_fd_sc_mcu7t5v0__fillcap_64
XFILLER_196_543 VDD VSS VDD VSS gf180mcu_fd_sc_mcu7t5v0__fillcap_4
XFILLER_211_385 VDD VSS VDD VSS gf180mcu_fd_sc_mcu7t5v0__fillcap_4
XFILLER_149_492 VDD VSS VDD VSS gf180mcu_fd_sc_mcu7t5v0__fillcap_32
XFILLER_137_632 VDD VSS VDD VSS gf180mcu_fd_sc_mcu7t5v0__fillcap_16
XFILLER_164_451 VDD VSS VDD VSS gf180mcu_fd_sc_mcu7t5v0__fillcap_4
XFILLER_105_562 VDD VSS VDD VSS gf180mcu_fd_sc_mcu7t5v0__fillcap_16
XFILLER_3_2 VDD VSS VDD VSS gf180mcu_fd_sc_mcu7t5v0__fillcap_64
XFILLER_2_177 VDD VSS VDD VSS gf180mcu_fd_sc_mcu7t5v0__fillcap_64
XFILLER_78_457 VDD VSS VDD VSS gf180mcu_fd_sc_mcu7t5v0__fillcap_64
XFILLER_93_438 VDD VSS VDD VSS gf180mcu_fd_sc_mcu7t5v0__fillcap_8
XFILLER_247_772 VDD VSS VDD VSS gf180mcu_fd_sc_mcu7t5v0__fillcap_64
XFILLER_262_731 VDD VSS VDD VSS gf180mcu_fd_sc_mcu7t5v0__fillcap_4
XFILLER_0_36 VDD VSS VDD VSS gf180mcu_fd_sc_mcu7t5v0__fillcap_32
XFILLER_46_387 VDD VSS VDD VSS gf180mcu_fd_sc_mcu7t5v0__fillcap_64
XFILLER_206_157 VDD VSS VDD VSS gf180mcu_fd_sc_mcu7t5v0__fillcap_4
XFILLER_34_527 VDD VSS VDD VSS gf180mcu_fd_sc_mcu7t5v0__fillcap_64
XFILLER_73_195 VDD VSS VDD VSS gf180mcu_fd_sc_mcu7t5v0__fillcap_8
XFILLER_203_842 VDD VSS VDD VSS gf180mcu_fd_sc_mcu7t5v0__fillcap_32
XFILLER_61_346 VDD VSS VDD VSS gf180mcu_fd_sc_mcu7t5v0__fillcap_4
XFILLER_230_661 VDD VSS VDD VSS gf180mcu_fd_sc_mcu7t5v0__fillcap_4
X_1870_ _1877_/S VDD VSS _2933_/D _2933_/Q wire126/Z VDD VSS gf180mcu_fd_sc_mcu7t5v0__mux2_2
XFILLER_202_374 VDD VSS VDD VSS gf180mcu_fd_sc_mcu7t5v0__fillcap_8
XFILLER_128_621 VDD VSS VDD VSS gf180mcu_fd_sc_mcu7t5v0__fillcap_8
XFILLER_127_142 VDD VSS VDD VSS gf180mcu_fd_sc_mcu7t5v0__fillcap_8
X_2422_ _2422_/A3 VDD VSS _2423_/B _1654_/Z _2422_/A2 VDD VSS gf180mcu_fd_sc_mcu7t5v0__nand3_1
XFILLER_124_871 VDD VSS VDD VSS gf180mcu_fd_sc_mcu7t5v0__fillcap_4
X_2353_ _2353_/B VDD VSS _2354_/B _3192_/Q _2362_/B VDD VSS gf180mcu_fd_sc_mcu7t5v0__aoi21_1
XFILLER_111_554 VDD VSS VDD VSS gf180mcu_fd_sc_mcu7t5v0__fillcap_4
XFILLER_97_766 VDD VSS VDD VSS gf180mcu_fd_sc_mcu7t5v0__fillcap_4
X_2284_ _2284_/B VDD VSS _3177_/D _2305_/B2 wire24/Z VDD VSS gf180mcu_fd_sc_mcu7t5v0__aoi21_1
XFILLER_56_107 VDD VSS VDD VSS gf180mcu_fd_sc_mcu7t5v0__fillcap_64
XFILLER_225_422 VDD VSS VDD VSS gf180mcu_fd_sc_mcu7t5v0__fillcap_64
XFILLER_237_282 VDD VSS VDD VSS gf180mcu_fd_sc_mcu7t5v0__fillcap_64
XFILLER_38_877 VDD VSS VDD VSS gf180mcu_fd_sc_mcu7t5v0__fillcap_8
XFILLER_252_241 VDD VSS VDD VSS gf180mcu_fd_sc_mcu7t5v0__fillcap_4
XFILLER_231_66 VDD VSS VDD VSS gf180mcu_fd_sc_mcu7t5v0__fillcap_4
XFILLER_53_836 VDD VSS VDD VSS gf180mcu_fd_sc_mcu7t5v0__fillcap_4
XFILLER_65_696 VDD VSS VDD VSS gf180mcu_fd_sc_mcu7t5v0__fillcap_4
XFILLER_100_37 VDD VSS VDD VSS gf180mcu_fd_sc_mcu7t5v0__fillcap_32
XFILLER_21_766 VDD VSS VDD VSS gf180mcu_fd_sc_mcu7t5v0__fillcap_4
XFILLER_119_621 VDD VSS VDD VSS gf180mcu_fd_sc_mcu7t5v0__fillcap_8
X_1999_ _2000_/S VDD VSS _3043_/D wire114/Z _3043_/Q VDD VSS gf180mcu_fd_sc_mcu7t5v0__mux2_2
XFILLER_119_632 VDD VSS VDD VSS gf180mcu_fd_sc_mcu7t5v0__fillcap_16
XFILLER_134_613 VDD VSS VDD VSS gf180mcu_fd_sc_mcu7t5v0__fillcap_4
Xclkload80 VDD VSS clkload80/ZN _3427_/CLK VDD VSS gf180mcu_fd_sc_mcu7t5v0__clkinv_8
XFILLER_0_648 VDD VSS VDD VSS gf180mcu_fd_sc_mcu7t5v0__fillcap_32
XFILLER_75_416 VDD VSS VDD VSS gf180mcu_fd_sc_mcu7t5v0__fillcap_4
XFILLER_130_885 VDD VSS VDD VSS gf180mcu_fd_sc_mcu7t5v0__fillcap_4
XFILLER_229_772 VDD VSS VDD VSS gf180mcu_fd_sc_mcu7t5v0__fillcap_64
XFILLER_244_731 VDD VSS VDD VSS gf180mcu_fd_sc_mcu7t5v0__fillcap_4
XFILLER_256_591 VDD VSS VDD VSS gf180mcu_fd_sc_mcu7t5v0__fillcap_4
XFILLER_141_33 VDD VSS VDD VSS gf180mcu_fd_sc_mcu7t5v0__fillcap_32
XFILLER_28_387 VDD VSS VDD VSS gf180mcu_fd_sc_mcu7t5v0__fillcap_64
XFILLER_16_527 VDD VSS VDD VSS gf180mcu_fd_sc_mcu7t5v0__fillcap_64
XFILLER_43_346 VDD VSS VDD VSS gf180mcu_fd_sc_mcu7t5v0__fillcap_4
Xspi_opentarget_i3c_top_202 spi_sclk_i_PD VDD VSS VDD VSS gf180mcu_fd_sc_mcu7t5v0__tiel
XFILLER_197_874 VDD VSS VDD VSS gf180mcu_fd_sc_mcu7t5v0__fillcap_16
XFILLER_200_801 VDD VSS VDD VSS gf180mcu_fd_sc_mcu7t5v0__fillcap_4
XFILLER_238_2 VDD VSS VDD VSS gf180mcu_fd_sc_mcu7t5v0__fillcap_32
XFILLER_140_2 VDD VSS VDD VSS gf180mcu_fd_sc_mcu7t5v0__fillcap_4
Xwire123 wire123/Z VSS VDD wire123/I VDD VSS gf180mcu_fd_sc_mcu7t5v0__clkbuf_3
Xwire112 VSS _1454_/I _3183_/Q VDD VDD VSS gf180mcu_fd_sc_mcu7t5v0__clkbuf_1
XFILLER_8_737 VDD VSS VDD VSS gf180mcu_fd_sc_mcu7t5v0__fillcap_64
Xwire101 VSS wire101/Z _3213_/Q VDD VDD VSS gf180mcu_fd_sc_mcu7t5v0__clkbuf_1
XFILLER_11_276 VDD VSS VDD VSS gf180mcu_fd_sc_mcu7t5v0__fillcap_4
Xwire145 wire145/Z wire145/I VDD VSS VDD VSS gf180mcu_fd_sc_mcu7t5v0__buf_8
XFILLER_166_30 VDD VSS VDD VSS gf180mcu_fd_sc_mcu7t5v0__fillcap_4
XFILLER_109_142 VDD VSS VDD VSS gf180mcu_fd_sc_mcu7t5v0__fillcap_8
XFILLER_106_871 VDD VSS VDD VSS gf180mcu_fd_sc_mcu7t5v0__fillcap_4
XFILLER_3_486 VDD VSS VDD VSS gf180mcu_fd_sc_mcu7t5v0__fillcap_4
XFILLER_266_311 VDD VSS VDD VSS gf180mcu_fd_sc_mcu7t5v0__fillcap_4
XFILLER_79_766 VDD VSS VDD VSS gf180mcu_fd_sc_mcu7t5v0__fillcap_4
XFILLER_59_72 VDD VSS VDD VSS gf180mcu_fd_sc_mcu7t5v0__fillcap_64
XFILLER_94_714 VDD VSS VDD VSS gf180mcu_fd_sc_mcu7t5v0__fillcap_16
XFILLER_121_874 VDD VSS VDD VSS gf180mcu_fd_sc_mcu7t5v0__fillcap_16
XFILLER_38_107 VDD VSS VDD VSS gf180mcu_fd_sc_mcu7t5v0__fillcap_64
XFILLER_207_422 VDD VSS VDD VSS gf180mcu_fd_sc_mcu7t5v0__fillcap_64
XFILLER_219_282 VDD VSS VDD VSS gf180mcu_fd_sc_mcu7t5v0__fillcap_16
XFILLER_234_241 VDD VSS VDD VSS gf180mcu_fd_sc_mcu7t5v0__fillcap_4
XFILLER_35_836 VDD VSS VDD VSS gf180mcu_fd_sc_mcu7t5v0__fillcap_4
XFILLER_47_696 VDD VSS VDD VSS gf180mcu_fd_sc_mcu7t5v0__fillcap_4
X_2971_ VDD _2971_/Q _3181_/CLK VSS _2971_/D VDD VSS gf180mcu_fd_sc_mcu7t5v0__dffq_1
XFILLER_188_885 VDD VSS VDD VSS gf180mcu_fd_sc_mcu7t5v0__fillcap_4
X_1922_ _1924_/S VDD VSS _2976_/D wire119/I _2976_/Q VDD VSS gf180mcu_fd_sc_mcu7t5v0__mux2_2
X_1853_ _1860_/S VDD VSS _2917_/D wire137/Z _2917_/Q VDD VSS gf180mcu_fd_sc_mcu7t5v0__mux2_2
X_1784_ _1786_/S VDD VSS _2858_/D _3124_/Q _2858_/Q VDD VSS gf180mcu_fd_sc_mcu7t5v0__mux2_2
XFILLER_190_527 VDD VSS VDD VSS gf180mcu_fd_sc_mcu7t5v0__fillcap_64
XFILLER_226_22 VDD VSS VDD VSS gf180mcu_fd_sc_mcu7t5v0__fillcap_8
XFILLER_170_240 VDD VSS VDD VSS gf180mcu_fd_sc_mcu7t5v0__fillcap_4
X_3454_ VSS _3454_/CLK VDD _3454_/D _3454_/Q wire145/I VDD VSS gf180mcu_fd_sc_mcu7t5v0__dffsnq_1
XFILLER_258_801 VDD VSS VDD VSS gf180mcu_fd_sc_mcu7t5v0__fillcap_4
X_2405_ _2405_/A3 VDD VSS _2406_/B _3382_/Q _2405_/A2 VDD VSS gf180mcu_fd_sc_mcu7t5v0__nand3_1
X_3385_ _3385_/D _3385_/Q _3403_/RN VSS _3394_/CLK VDD VDD VSS gf180mcu_fd_sc_mcu7t5v0__dffrnq_1
XFILLER_242_10 VDD VSS VDD VSS gf180mcu_fd_sc_mcu7t5v0__fillcap_16
X_2336_ _2336_/B VDD VSS _2337_/A3 _2262_/B _2484_/B1 VDD VSS gf180mcu_fd_sc_mcu7t5v0__aoi21_1
XFILLER_69_276 VDD VSS VDD VSS gf180mcu_fd_sc_mcu7t5v0__fillcap_4
XFILLER_112_885 VDD VSS VDD VSS gf180mcu_fd_sc_mcu7t5v0__fillcap_4
XFILLER_57_416 VDD VSS VDD VSS gf180mcu_fd_sc_mcu7t5v0__fillcap_4
X_2267_ VDD VSS _2351_/A2 _2316_/C _1673_/B VDD VSS gf180mcu_fd_sc_mcu7t5v0__nand2_1
XFILLER_226_731 VDD VSS VDD VSS gf180mcu_fd_sc_mcu7t5v0__fillcap_4
XFILLER_238_591 VDD VSS VDD VSS gf180mcu_fd_sc_mcu7t5v0__fillcap_4
X_2198_ VDD VSS _2199_/B _3149_/Q _2198_/A2 VDD VSS gf180mcu_fd_sc_mcu7t5v0__xor2_1
XFILLER_198_616 VDD VSS VDD VSS gf180mcu_fd_sc_mcu7t5v0__fillcap_32
XFILLER_25_346 VDD VSS VDD VSS gf180mcu_fd_sc_mcu7t5v0__fillcap_4
XFILLER_179_874 VDD VSS VDD VSS gf180mcu_fd_sc_mcu7t5v0__fillcap_16
XFILLER_139_749 VDD VSS VDD VSS gf180mcu_fd_sc_mcu7t5v0__fillcap_16
XFILLER_194_877 VDD VSS VDD VSS gf180mcu_fd_sc_mcu7t5v0__fillcap_8
XFILLER_138_237 VDD VSS VDD VSS gf180mcu_fd_sc_mcu7t5v0__fillcap_8
XFILLER_121_104 VDD VSS VDD VSS gf180mcu_fd_sc_mcu7t5v0__fillcap_4
XFILLER_248_311 VDD VSS VDD VSS gf180mcu_fd_sc_mcu7t5v0__fillcap_4
XFILLER_96_37 VDD VSS VDD VSS gf180mcu_fd_sc_mcu7t5v0__fillcap_32
XFILLER_0_478 VDD VSS VDD VSS gf180mcu_fd_sc_mcu7t5v0__fillcap_32
XFILLER_103_874 VDD VSS VDD VSS gf180mcu_fd_sc_mcu7t5v0__fillcap_16
XFILLER_152_87 VDD VSS VDD VSS gf180mcu_fd_sc_mcu7t5v0__fillcap_16
XFILLER_216_241 VDD VSS VDD VSS gf180mcu_fd_sc_mcu7t5v0__fillcap_4
XFILLER_17_836 VDD VSS VDD VSS gf180mcu_fd_sc_mcu7t5v0__fillcap_4
XFILLER_29_696 VDD VSS VDD VSS gf180mcu_fd_sc_mcu7t5v0__fillcap_4
XFILLER_144_218 VDD VSS VDD VSS gf180mcu_fd_sc_mcu7t5v0__fillcap_16
XFILLER_184_387 VDD VSS VDD VSS gf180mcu_fd_sc_mcu7t5v0__fillcap_16
XFILLER_193_72 VDD VSS VDD VSS gf180mcu_fd_sc_mcu7t5v0__fillcap_8
XFILLER_140_457 VDD VSS VDD VSS gf180mcu_fd_sc_mcu7t5v0__fillcap_64
XFILLER_98_349 VDD VSS VDD VSS gf180mcu_fd_sc_mcu7t5v0__fillcap_4
X_3170_ VSS _3360_/CLK VDD _3170_/D _3360_/D wire153/Z VDD VSS gf180mcu_fd_sc_mcu7t5v0__dffsnq_1
XFILLER_39_416 VDD VSS VDD VSS gf180mcu_fd_sc_mcu7t5v0__fillcap_4
X_2121_ _2121_/B VDD VSS _3114_/D _2121_/A1 _2121_/A2 VDD VSS gf180mcu_fd_sc_mcu7t5v0__aoi21_1
X_2052_ wire28/I VDD VSS _3085_/D _3301_/Q _3085_/Q VDD VSS gf180mcu_fd_sc_mcu7t5v0__mux2_2
XFILLER_179_104 VDD VSS VDD VSS gf180mcu_fd_sc_mcu7t5v0__fillcap_4
XFILLER_250_597 VDD VSS VDD VSS gf180mcu_fd_sc_mcu7t5v0__fillcap_64
XFILLER_179_148 VDD VSS VDD VSS gf180mcu_fd_sc_mcu7t5v0__fillcap_16
X_2954_ VDD _2954_/Q _3415_/CLK VSS _2954_/D VDD VSS gf180mcu_fd_sc_mcu7t5v0__dffq_1
X_2885_ VDD _2885_/Q _2900_/CLK VSS _2885_/D VDD VSS gf180mcu_fd_sc_mcu7t5v0__dffq_1
X_1905_ _1907_/S VDD VSS _2962_/D _2287_/I0 _2962_/Q VDD VSS gf180mcu_fd_sc_mcu7t5v0__mux2_2
XFILLER_176_877 VDD VSS VDD VSS gf180mcu_fd_sc_mcu7t5v0__fillcap_8
XFILLER_187_192 VDD VSS VDD VSS gf180mcu_fd_sc_mcu7t5v0__fillcap_8
XFILLER_175_343 VDD VSS VDD VSS gf180mcu_fd_sc_mcu7t5v0__fillcap_4
XFILLER_191_836 VDD VSS VDD VSS gf180mcu_fd_sc_mcu7t5v0__fillcap_4
X_1836_ _1842_/S VDD VSS _2902_/D _1863_/I0 _2902_/Q VDD VSS gf180mcu_fd_sc_mcu7t5v0__mux2_2
XFILLER_190_346 VDD VSS VDD VSS gf180mcu_fd_sc_mcu7t5v0__fillcap_16
X_1767_ _1768_/S VDD VSS _2843_/D _1794_/I1 _2843_/Q VDD VSS gf180mcu_fd_sc_mcu7t5v0__mux2_2
X_1698_ _1695_/Z _1696_/Z VDD VSS _1699_/A2 _2305_/B2 _3203_/Q VDD VSS gf180mcu_fd_sc_mcu7t5v0__nand4_1
XFILLER_116_487 VDD VSS VDD VSS gf180mcu_fd_sc_mcu7t5v0__fillcap_32
X_3437_ _3437_/D _3437_/Q wire161/I VSS _3443_/CLK VDD VDD VSS gf180mcu_fd_sc_mcu7t5v0__dffrnq_1
X_3368_ _3368_/D _3368_/Q _3458_/RN VSS _3370_/CLK VDD VDD VSS gf180mcu_fd_sc_mcu7t5v0__dffrnq_1
X_2319_ VDD _2319_/B _2320_/A3 _2320_/B _2324_/A2 VSS VDD VSS gf180mcu_fd_sc_mcu7t5v0__oai21_1
X_3299_ _3299_/D _3299_/Q _3339_/RN VSS _3307_/CLK VDD VDD VSS gf180mcu_fd_sc_mcu7t5v0__dffrnq_1
XFILLER_100_877 VDD VSS VDD VSS gf180mcu_fd_sc_mcu7t5v0__fillcap_8
XFILLER_260_317 VDD VSS VDD VSS gf180mcu_fd_sc_mcu7t5v0__fillcap_64
XFILLER_81_772 VDD VSS VDD VSS gf180mcu_fd_sc_mcu7t5v0__fillcap_64
XFILLER_198_457 VDD VSS VDD VSS gf180mcu_fd_sc_mcu7t5v0__fillcap_32
XFILLER_15_66 VDD VSS VDD VSS gf180mcu_fd_sc_mcu7t5v0__fillcap_4
XFILLER_139_524 VDD VSS VDD VSS gf180mcu_fd_sc_mcu7t5v0__fillcap_16
XFILLER_194_685 VDD VSS VDD VSS gf180mcu_fd_sc_mcu7t5v0__fillcap_4
XFILLER_166_387 VDD VSS VDD VSS gf180mcu_fd_sc_mcu7t5v0__fillcap_64
XFILLER_154_527 VDD VSS VDD VSS gf180mcu_fd_sc_mcu7t5v0__fillcap_32
XFILLER_134_240 VDD VSS VDD VSS gf180mcu_fd_sc_mcu7t5v0__fillcap_4
Xoutput8 VDD output8/I VSS sda_pad_oe VDD VSS gf180mcu_fd_sc_mcu7t5v0__dlyb_1
XFILLER_122_457 VDD VSS VDD VSS gf180mcu_fd_sc_mcu7t5v0__fillcap_16
XFILLER_88_371 VDD VSS VDD VSS gf180mcu_fd_sc_mcu7t5v0__fillcap_8
XFILLER_264_667 VDD VSS VDD VSS gf180mcu_fd_sc_mcu7t5v0__fillcap_64
XFILLER_252_807 VDD VSS VDD VSS gf180mcu_fd_sc_mcu7t5v0__fillcap_64
XFILLER_189_468 VDD VSS VDD VSS gf180mcu_fd_sc_mcu7t5v0__fillcap_16
XFILLER_71_282 VDD VSS VDD VSS gf180mcu_fd_sc_mcu7t5v0__fillcap_64
XFILLER_112_90 VDD VSS VDD VSS gf180mcu_fd_sc_mcu7t5v0__fillcap_8
XFILLER_220_737 VDD VSS VDD VSS gf180mcu_fd_sc_mcu7t5v0__fillcap_64
XFILLER_232_597 VDD VSS VDD VSS gf180mcu_fd_sc_mcu7t5v0__fillcap_64
XFILLER_176_118 VDD VSS VDD VSS gf180mcu_fd_sc_mcu7t5v0__fillcap_16
XFILLER_158_877 VDD VSS VDD VSS gf180mcu_fd_sc_mcu7t5v0__fillcap_8
X_2670_ VSS VDD _2758_/A3 wire140/Z _3095_/Q _2061_/Z _2026_/Z _3063_/Q _2671_/A2
+ VDD VSS gf180mcu_fd_sc_mcu7t5v0__aoi222_1
XFILLER_184_140 VDD VSS VDD VSS gf180mcu_fd_sc_mcu7t5v0__fillcap_4
X_1621_ _1620_/Z VDD VSS _3435_/D _1615_/Z _1621_/A2 VDD VSS gf180mcu_fd_sc_mcu7t5v0__nor3_1
XFILLER_173_836 VDD VSS VDD VSS gf180mcu_fd_sc_mcu7t5v0__fillcap_4
X_1552_ _3140_/Q _2179_/A1 VDD VSS _1587_/A1 _3138_/Q _2175_/A1 VDD VSS gf180mcu_fd_sc_mcu7t5v0__nor4_1
X_1483_ VDD VSS _3416_/D _3421_/Q _1483_/A2 VDD VSS gf180mcu_fd_sc_mcu7t5v0__xnor2_1
XFILLER_141_755 VDD VSS VDD VSS gf180mcu_fd_sc_mcu7t5v0__fillcap_8
XFILLER_113_468 VDD VSS VDD VSS gf180mcu_fd_sc_mcu7t5v0__fillcap_16
X_3222_ _3222_/D _3222_/Q wire165/I VSS _3332_/CLK VDD VDD VSS gf180mcu_fd_sc_mcu7t5v0__dffrnq_1
X_3153_ _3153_/D _3153_/Q wire151/I VSS _3279_/CLK VDD VDD VSS gf180mcu_fd_sc_mcu7t5v0__dffrnq_1
XFILLER_95_842 VDD VSS VDD VSS gf180mcu_fd_sc_mcu7t5v0__fillcap_32
X_2104_ _3110_/Q VDD VSS _2108_/B _2074_/Z _2106_/A2 VDD VSS gf180mcu_fd_sc_mcu7t5v0__aoi21_1
X_3084_ _3084_/D _3084_/Q wire165/I VSS _3332_/CLK VDD VDD VSS gf180mcu_fd_sc_mcu7t5v0__dffrnq_1
XFILLER_254_177 VDD VSS VDD VSS gf180mcu_fd_sc_mcu7t5v0__fillcap_64
XFILLER_242_317 VDD VSS VDD VSS gf180mcu_fd_sc_mcu7t5v0__fillcap_64
X_2035_ _2040_/S VDD VSS _3068_/D wire90/Z _3068_/Q VDD VSS gf180mcu_fd_sc_mcu7t5v0__mux2_2
XFILLER_63_772 VDD VSS VDD VSS gf180mcu_fd_sc_mcu7t5v0__fillcap_64
X_2937_ VDD _2937_/Q _2958_/CLK VSS _2937_/D VDD VSS gf180mcu_fd_sc_mcu7t5v0__dffq_1
XFILLER_210_247 VDD VSS VDD VSS gf180mcu_fd_sc_mcu7t5v0__fillcap_4
XFILLER_148_387 VDD VSS VDD VSS gf180mcu_fd_sc_mcu7t5v0__fillcap_64
XFILLER_191_622 VDD VSS VDD VSS gf180mcu_fd_sc_mcu7t5v0__fillcap_8
XFILLER_136_527 VDD VSS VDD VSS gf180mcu_fd_sc_mcu7t5v0__fillcap_4
X_2868_ VDD _2868_/Q _2914_/CLK VSS _2868_/D VDD VSS gf180mcu_fd_sc_mcu7t5v0__dffq_1
X_1819_ _1823_/S VDD VSS _2888_/D wire133/Z _2888_/Q VDD VSS gf180mcu_fd_sc_mcu7t5v0__mux2_2
X_2799_ VDD VSS _2801_/A1 _3093_/Q _2799_/A2 VDD VSS gf180mcu_fd_sc_mcu7t5v0__nand2_1
XFILLER_131_232 VDD VSS VDD VSS gf180mcu_fd_sc_mcu7t5v0__fillcap_8
XFILLER_104_457 VDD VSS VDD VSS gf180mcu_fd_sc_mcu7t5v0__fillcap_4
XFILLER_85_352 VDD VSS VDD VSS gf180mcu_fd_sc_mcu7t5v0__fillcap_64
XFILLER_246_667 VDD VSS VDD VSS gf180mcu_fd_sc_mcu7t5v0__fillcap_64
XFILLER_234_807 VDD VSS VDD VSS gf180mcu_fd_sc_mcu7t5v0__fillcap_64
XFILLER_261_626 VDD VSS VDD VSS gf180mcu_fd_sc_mcu7t5v0__fillcap_4
XFILLER_198_210 VDD VSS VDD VSS gf180mcu_fd_sc_mcu7t5v0__fillcap_4
XFILLER_41_422 VDD VSS VDD VSS gf180mcu_fd_sc_mcu7t5v0__fillcap_64
XFILLER_53_282 VDD VSS VDD VSS gf180mcu_fd_sc_mcu7t5v0__fillcap_64
XFILLER_202_737 VDD VSS VDD VSS gf180mcu_fd_sc_mcu7t5v0__fillcap_64
XFILLER_214_597 VDD VSS VDD VSS gf180mcu_fd_sc_mcu7t5v0__fillcap_4
XFILLER_158_107 VDD VSS VDD VSS gf180mcu_fd_sc_mcu7t5v0__fillcap_4
XFILLER_220_2 VDD VSS VDD VSS gf180mcu_fd_sc_mcu7t5v0__fillcap_16
XFILLER_182_611 VDD VSS VDD VSS gf180mcu_fd_sc_mcu7t5v0__fillcap_32
Xmax_length82 _1519_/B _3380_/Q VDD VSS VDD VSS gf180mcu_fd_sc_mcu7t5v0__buf_4
XFILLER_167_696 VDD VSS VDD VSS gf180mcu_fd_sc_mcu7t5v0__fillcap_4
XFILLER_155_836 VDD VSS VDD VSS gf180mcu_fd_sc_mcu7t5v0__fillcap_4
Xmax_length93 VSS wire92/I _3282_/Q VDD VDD VSS gf180mcu_fd_sc_mcu7t5v0__clkbuf_1
XFILLER_174_85 VDD VSS VDD VSS gf180mcu_fd_sc_mcu7t5v0__fillcap_8
XFILLER_122_254 VDD VSS VDD VSS gf180mcu_fd_sc_mcu7t5v0__fillcap_32
XFILLER_1_562 VDD VSS VDD VSS gf180mcu_fd_sc_mcu7t5v0__fillcap_64
XFILLER_123_766 VDD VSS VDD VSS gf180mcu_fd_sc_mcu7t5v0__fillcap_4
XFILLER_110_438 VDD VSS VDD VSS gf180mcu_fd_sc_mcu7t5v0__fillcap_16
XFILLER_77_842 VDD VSS VDD VSS gf180mcu_fd_sc_mcu7t5v0__fillcap_32
XFILLER_67_72 VDD VSS VDD VSS gf180mcu_fd_sc_mcu7t5v0__fillcap_64
XFILLER_92_801 VDD VSS VDD VSS gf180mcu_fd_sc_mcu7t5v0__fillcap_4
XFILLER_236_177 VDD VSS VDD VSS gf180mcu_fd_sc_mcu7t5v0__fillcap_64
XFILLER_224_317 VDD VSS VDD VSS gf180mcu_fd_sc_mcu7t5v0__fillcap_16
XFILLER_251_136 VDD VSS VDD VSS gf180mcu_fd_sc_mcu7t5v0__fillcap_4
XFILLER_45_772 VDD VSS VDD VSS gf180mcu_fd_sc_mcu7t5v0__fillcap_64
XFILLER_72_591 VDD VSS VDD VSS gf180mcu_fd_sc_mcu7t5v0__fillcap_4
XFILLER_60_731 VDD VSS VDD VSS gf180mcu_fd_sc_mcu7t5v0__fillcap_4
XFILLER_189_298 VDD VSS VDD VSS gf180mcu_fd_sc_mcu7t5v0__fillcap_32
X_2722_ _3026_/Q VSS VDD _3010_/Q _3018_/Q _2722_/S0 _3002_/Q wire60/Z _2722_/Z VDD
+ VSS gf180mcu_fd_sc_mcu7t5v0__mux4_1
X_2653_ _2653_/B _2737_/C VDD VSS _2656_/A1 _3062_/Q _2026_/Z VDD VSS gf180mcu_fd_sc_mcu7t5v0__aoi211_1
XFILLER_66_2 VDD VSS VDD VSS gf180mcu_fd_sc_mcu7t5v0__fillcap_32
X_1604_ _1604_/A3 VDD VSS _1607_/A1 _1604_/A1 _1604_/A2 VDD VSS gf180mcu_fd_sc_mcu7t5v0__nand3_1
X_2584_ _2596_/S VDD VSS _3252_/D wire99/Z _3252_/Q VDD VSS gf180mcu_fd_sc_mcu7t5v0__mux2_2
XFILLER_99_422 VDD VSS VDD VSS gf180mcu_fd_sc_mcu7t5v0__fillcap_64
X_1535_ _3346_/Q _2470_/B VDD VSS _2184_/S _3184_/Q _3185_/Q VDD VSS gf180mcu_fd_sc_mcu7t5v0__nand4_1
XFILLER_126_582 VDD VSS VDD VSS gf180mcu_fd_sc_mcu7t5v0__fillcap_8
X_1466_ _3408_/Q VDD VSS _1473_/A2 _3407_/Q _1469_/A2 VDD VSS gf180mcu_fd_sc_mcu7t5v0__aoi21_1
XFILLER_101_416 VDD VSS VDD VSS gf180mcu_fd_sc_mcu7t5v0__fillcap_4
XFILLER_113_287 VDD VSS VDD VSS gf180mcu_fd_sc_mcu7t5v0__fillcap_32
X_1397_ VDD VSS _3193_/Q _2357_/B2 VDD VSS gf180mcu_fd_sc_mcu7t5v0__clkinv_1
X_3205_ _3205_/D _3205_/Q wire153/I VSS _3358_/CLK VDD VDD VSS gf180mcu_fd_sc_mcu7t5v0__dffrnq_1
XFILLER_67_352 VDD VSS VDD VSS gf180mcu_fd_sc_mcu7t5v0__fillcap_64
XFILLER_228_667 VDD VSS VDD VSS gf180mcu_fd_sc_mcu7t5v0__fillcap_64
XFILLER_216_807 VDD VSS VDD VSS gf180mcu_fd_sc_mcu7t5v0__fillcap_64
X_3136_ _3136_/D _3136_/Q wire151/Z VSS _3185_/CLK VDD VDD VSS gf180mcu_fd_sc_mcu7t5v0__dffrnq_1
XFILLER_243_626 VDD VSS VDD VSS gf180mcu_fd_sc_mcu7t5v0__fillcap_4
XFILLER_255_486 VDD VSS VDD VSS gf180mcu_fd_sc_mcu7t5v0__fillcap_4
X_3067_ _3067_/D _3067_/Q _3336_/RN VSS _3316_/CLK VDD VDD VSS gf180mcu_fd_sc_mcu7t5v0__dffrnq_1
X_2018_ _2018_/S VDD VSS _3060_/D wire113/Z _3060_/Q VDD VSS gf180mcu_fd_sc_mcu7t5v0__mux2_2
XFILLER_23_422 VDD VSS VDD VSS gf180mcu_fd_sc_mcu7t5v0__fillcap_64
XFILLER_35_282 VDD VSS VDD VSS gf180mcu_fd_sc_mcu7t5v0__fillcap_64
XFILLER_50_241 VDD VSS VDD VSS gf180mcu_fd_sc_mcu7t5v0__fillcap_4
XFILLER_195_268 VDD VSS VDD VSS gf180mcu_fd_sc_mcu7t5v0__fillcap_8
XFILLER_137_836 VDD VSS VDD VSS gf180mcu_fd_sc_mcu7t5v0__fillcap_4
Xmax_length139 VSS _2688_/C1 _2804_/Q VDD VDD VSS gf180mcu_fd_sc_mcu7t5v0__buf_2
Xmax_length117 VSS _2287_/I0 _3180_/Q VDD VDD VSS gf180mcu_fd_sc_mcu7t5v0__buf_2
XFILLER_105_766 VDD VSS VDD VSS gf180mcu_fd_sc_mcu7t5v0__fillcap_4
XFILLER_265_206 VDD VSS VDD VSS gf180mcu_fd_sc_mcu7t5v0__fillcap_4
XFILLER_59_842 VDD VSS VDD VSS gf180mcu_fd_sc_mcu7t5v0__fillcap_32
XFILLER_74_801 VDD VSS VDD VSS gf180mcu_fd_sc_mcu7t5v0__fillcap_4
XFILLER_86_661 VDD VSS VDD VSS gf180mcu_fd_sc_mcu7t5v0__fillcap_4
XFILLER_218_177 VDD VSS VDD VSS gf180mcu_fd_sc_mcu7t5v0__fillcap_64
XFILLER_206_317 VDD VSS VDD VSS gf180mcu_fd_sc_mcu7t5v0__fillcap_64
XFILLER_170_2 VDD VSS VDD VSS gf180mcu_fd_sc_mcu7t5v0__fillcap_32
XFILLER_73_333 VDD VSS VDD VSS gf180mcu_fd_sc_mcu7t5v0__fillcap_16
XFILLER_268_2 VDD VSS VDD VSS gf180mcu_fd_sc_mcu7t5v0__fillcap_32
XFILLER_233_136 VDD VSS VDD VSS gf180mcu_fd_sc_mcu7t5v0__fillcap_4
XFILLER_27_772 VDD VSS VDD VSS gf180mcu_fd_sc_mcu7t5v0__fillcap_64
XFILLER_202_501 VDD VSS VDD VSS gf180mcu_fd_sc_mcu7t5v0__fillcap_8
XFILLER_54_591 VDD VSS VDD VSS gf180mcu_fd_sc_mcu7t5v0__fillcap_4
XFILLER_42_731 VDD VSS VDD VSS gf180mcu_fd_sc_mcu7t5v0__fillcap_4
XFILLER_187_736 VDD VSS VDD VSS gf180mcu_fd_sc_mcu7t5v0__fillcap_32
XFILLER_10_661 VDD VSS VDD VSS gf180mcu_fd_sc_mcu7t5v0__fillcap_4
XFILLER_5_142 VDD VSS VDD VSS gf180mcu_fd_sc_mcu7t5v0__fillcap_64
XFILLER_96_403 VDD VSS VDD VSS gf180mcu_fd_sc_mcu7t5v0__fillcap_8
Xspi_opentarget_i3c_top clk_i_PD VDD VSS VDD VSS gf180mcu_fd_sc_mcu7t5v0__tiel
XFILLER_2_871 VDD VSS VDD VSS gf180mcu_fd_sc_mcu7t5v0__fillcap_4
XFILLER_49_352 VDD VSS VDD VSS gf180mcu_fd_sc_mcu7t5v0__fillcap_64
XFILLER_237_486 VDD VSS VDD VSS gf180mcu_fd_sc_mcu7t5v0__fillcap_4
XFILLER_225_626 VDD VSS VDD VSS gf180mcu_fd_sc_mcu7t5v0__fillcap_4
XFILLER_64_311 VDD VSS VDD VSS gf180mcu_fd_sc_mcu7t5v0__fillcap_4
XFILLER_17_282 VDD VSS VDD VSS gf180mcu_fd_sc_mcu7t5v0__fillcap_64
XFILLER_91_174 VDD VSS VDD VSS gf180mcu_fd_sc_mcu7t5v0__fillcap_32
XFILLER_32_241 VDD VSS VDD VSS gf180mcu_fd_sc_mcu7t5v0__fillcap_4
XFILLER_119_836 VDD VSS VDD VSS gf180mcu_fd_sc_mcu7t5v0__fillcap_4
XFILLER_229_66 VDD VSS VDD VSS gf180mcu_fd_sc_mcu7t5v0__fillcap_4
X_2705_ VDD VSS _3313_/D _2705_/A1 _2705_/A2 VDD VSS gf180mcu_fd_sc_mcu7t5v0__nand2_1
XFILLER_9_492 VDD VSS VDD VSS gf180mcu_fd_sc_mcu7t5v0__fillcap_64
XFILLER_173_485 VDD VSS VDD VSS gf180mcu_fd_sc_mcu7t5v0__fillcap_4
X_2636_ _2644_/S VDD VSS _3299_/D _3257_/Q _3299_/Q VDD VSS gf180mcu_fd_sc_mcu7t5v0__mux2_2
XFILLER_133_305 VDD VSS VDD VSS gf180mcu_fd_sc_mcu7t5v0__fillcap_4
XFILLER_106_519 VDD VSS VDD VSS gf180mcu_fd_sc_mcu7t5v0__fillcap_4
XFILLER_102_703 VDD VSS VDD VSS gf180mcu_fd_sc_mcu7t5v0__fillcap_32
X_2567_ _3226_/Q _2567_/ZN _3225_/Q VSS _2567_/B VDD VDD VSS gf180mcu_fd_sc_mcu7t5v0__oai21_2
X_1518_ VDD VSS _3381_/D _3381_/Q _1516_/Z VDD VSS gf180mcu_fd_sc_mcu7t5v0__xor2_1
XFILLER_247_206 VDD VSS VDD VSS gf180mcu_fd_sc_mcu7t5v0__fillcap_4
X_2498_ VDD VSS _2552_/A2 _3224_/Q _3225_/Q VDD VSS gf180mcu_fd_sc_mcu7t5v0__nand2_1
X_1449_ VDD VSS _3318_/Q _2750_/A1 VDD VSS gf180mcu_fd_sc_mcu7t5v0__clkinv_1
XFILLER_68_661 VDD VSS VDD VSS gf180mcu_fd_sc_mcu7t5v0__fillcap_4
XFILLER_56_801 VDD VSS VDD VSS gf180mcu_fd_sc_mcu7t5v0__fillcap_4
X_3119_ _3119_/D _3119_/Q wire147/Z VSS _3202_/CLK VDD VDD VSS gf180mcu_fd_sc_mcu7t5v0__dffrnq_1
XFILLER_82_141 VDD VSS VDD VSS gf180mcu_fd_sc_mcu7t5v0__fillcap_8
XFILLER_24_731 VDD VSS VDD VSS gf180mcu_fd_sc_mcu7t5v0__fillcap_4
XFILLER_36_591 VDD VSS VDD VSS gf180mcu_fd_sc_mcu7t5v0__fillcap_4
XFILLER_109_313 VDD VSS VDD VSS gf180mcu_fd_sc_mcu7t5v0__fillcap_8
XFILLER_23_66 VDD VSS VDD VSS gf180mcu_fd_sc_mcu7t5v0__fillcap_4
XFILLER_124_305 VDD VSS VDD VSS gf180mcu_fd_sc_mcu7t5v0__fillcap_8
XFILLER_191_282 VDD VSS VDD VSS gf180mcu_fd_sc_mcu7t5v0__fillcap_16
XFILLER_124_338 VDD VSS VDD VSS gf180mcu_fd_sc_mcu7t5v0__fillcap_8
XFILLER_2_101 VDD VSS VDD VSS gf180mcu_fd_sc_mcu7t5v0__fillcap_4
XFILLER_155_87 VDD VSS VDD VSS gf180mcu_fd_sc_mcu7t5v0__fillcap_32
XFILLER_132_360 VDD VSS VDD VSS gf180mcu_fd_sc_mcu7t5v0__fillcap_8
XFILLER_120_577 VDD VSS VDD VSS gf180mcu_fd_sc_mcu7t5v0__fillcap_16
XFILLER_219_475 VDD VSS VDD VSS gf180mcu_fd_sc_mcu7t5v0__fillcap_8
XFILLER_207_626 VDD VSS VDD VSS gf180mcu_fd_sc_mcu7t5v0__fillcap_4
XFILLER_46_311 VDD VSS VDD VSS gf180mcu_fd_sc_mcu7t5v0__fillcap_4
XFILLER_58_171 VDD VSS VDD VSS gf180mcu_fd_sc_mcu7t5v0__fillcap_4
XFILLER_206_125 VDD VSS VDD VSS gf180mcu_fd_sc_mcu7t5v0__fillcap_32
XFILLER_187_500 VDD VSS VDD VSS gf180mcu_fd_sc_mcu7t5v0__fillcap_4
XFILLER_14_241 VDD VSS VDD VSS gf180mcu_fd_sc_mcu7t5v0__fillcap_4
XFILLER_187_555 VDD VSS VDD VSS gf180mcu_fd_sc_mcu7t5v0__fillcap_4
XFILLER_183_772 VDD VSS VDD VSS gf180mcu_fd_sc_mcu7t5v0__fillcap_64
XFILLER_182_260 VDD VSS VDD VSS gf180mcu_fd_sc_mcu7t5v0__fillcap_16
XFILLER_6_451 VDD VSS VDD VSS gf180mcu_fd_sc_mcu7t5v0__fillcap_4
XFILLER_115_338 VDD VSS VDD VSS gf180mcu_fd_sc_mcu7t5v0__fillcap_4
X_2421_ VDD VSS _2422_/A3 _2449_/A1 _3132_/Q VDD VSS gf180mcu_fd_sc_mcu7t5v0__nand2_1
XFILLER_130_308 VDD VSS VDD VSS gf180mcu_fd_sc_mcu7t5v0__fillcap_4
X_2352_ _2490_/A2 _2352_/C VDD VSS _2354_/A2 _3192_/Q _2230_/Z _2349_/Z VDD VSS gf180mcu_fd_sc_mcu7t5v0__oai221_1
XFILLER_215_46 VDD VSS VDD VSS gf180mcu_fd_sc_mcu7t5v0__fillcap_16
XFILLER_229_206 VDD VSS VDD VSS gf180mcu_fd_sc_mcu7t5v0__fillcap_4
X_2283_ VDD VSS _2284_/B _3177_/Q wire24/Z VDD VSS gf180mcu_fd_sc_mcu7t5v0__nor2_1
XFILLER_29_2 VDD VSS VDD VSS gf180mcu_fd_sc_mcu7t5v0__fillcap_64
XFILLER_38_801 VDD VSS VDD VSS gf180mcu_fd_sc_mcu7t5v0__fillcap_4
XFILLER_18_591 VDD VSS VDD VSS gf180mcu_fd_sc_mcu7t5v0__fillcap_4
XFILLER_80_667 VDD VSS VDD VSS gf180mcu_fd_sc_mcu7t5v0__fillcap_64
XFILLER_221_695 VDD VSS VDD VSS gf180mcu_fd_sc_mcu7t5v0__fillcap_4
X_1998_ _2000_/S VDD VSS _3042_/D wire116/Z _3042_/Q VDD VSS gf180mcu_fd_sc_mcu7t5v0__mux2_2
Xclkbuf_leaf_41_clk_i _3409_/CLK VSS VDD clkload2/I VDD VSS gf180mcu_fd_sc_mcu7t5v0__clkbuf_2
Xclkload70 VSS clkload70/ZN _3380_/CLK VDD VDD VSS gf180mcu_fd_sc_mcu7t5v0__inv_2
XFILLER_173_282 VDD VSS VDD VSS gf180mcu_fd_sc_mcu7t5v0__fillcap_16
XFILLER_161_422 VDD VSS VDD VSS gf180mcu_fd_sc_mcu7t5v0__fillcap_8
XFILLER_106_349 VDD VSS VDD VSS gf180mcu_fd_sc_mcu7t5v0__fillcap_16
Xclkload81 VDD VSS clkload81/ZN _3434_/CLK VDD VSS gf180mcu_fd_sc_mcu7t5v0__clkinv_8
XFILLER_133_157 VDD VSS VDD VSS gf180mcu_fd_sc_mcu7t5v0__fillcap_16
X_2619_ _2619_/S VDD VSS _3282_/D _3240_/Q _3282_/Q VDD VSS gf180mcu_fd_sc_mcu7t5v0__mux2_2
XFILLER_133_135 VDD VSS VDD VSS gf180mcu_fd_sc_mcu7t5v0__fillcap_4
Xclkbuf_leaf_56_clk_i _3005_/CLK VSS VDD clkload1/I VDD VSS gf180mcu_fd_sc_mcu7t5v0__clkbuf_2
XFILLER_28_311 VDD VSS VDD VSS gf180mcu_fd_sc_mcu7t5v0__fillcap_4
XFILLER_216_489 VDD VSS VDD VSS gf180mcu_fd_sc_mcu7t5v0__fillcap_16
XFILLER_197_842 VDD VSS VDD VSS gf180mcu_fd_sc_mcu7t5v0__fillcap_32
XFILLER_70_177 VDD VSS VDD VSS gf180mcu_fd_sc_mcu7t5v0__fillcap_64
Xspi_opentarget_i3c_top_203 spi_sclk_i_PU VDD VSS VDD VSS gf180mcu_fd_sc_mcu7t5v0__tiel
Xwire102 VSS wire102/Z _1400_/I VDD VDD VSS gf180mcu_fd_sc_mcu7t5v0__clkbuf_1
Xwire113 wire113/Z VSS VDD _3182_/Q VDD VSS gf180mcu_fd_sc_mcu7t5v0__clkbuf_3
XFILLER_133_2 VDD VSS VDD VSS gf180mcu_fd_sc_mcu7t5v0__fillcap_16
XFILLER_165_772 VDD VSS VDD VSS gf180mcu_fd_sc_mcu7t5v0__fillcap_64
XFILLER_125_614 VDD VSS VDD VSS gf180mcu_fd_sc_mcu7t5v0__fillcap_16
XFILLER_164_293 VDD VSS VDD VSS gf180mcu_fd_sc_mcu7t5v0__fillcap_4
XFILLER_109_187 VDD VSS VDD VSS gf180mcu_fd_sc_mcu7t5v0__fillcap_16
XFILLER_121_842 VDD VSS VDD VSS gf180mcu_fd_sc_mcu7t5v0__fillcap_32
XFILLER_120_341 VDD VSS VDD VSS gf180mcu_fd_sc_mcu7t5v0__fillcap_4
XFILLER_94_737 VDD VSS VDD VSS gf180mcu_fd_sc_mcu7t5v0__fillcap_64
XFILLER_78_299 VDD VSS VDD VSS gf180mcu_fd_sc_mcu7t5v0__fillcap_16
XFILLER_75_72 VDD VSS VDD VSS gf180mcu_fd_sc_mcu7t5v0__fillcap_8
XFILLER_75_50 VDD VSS VDD VSS gf180mcu_fd_sc_mcu7t5v0__fillcap_16
Xload_slew54 _2442_/S _2461_/A1 VDD VSS VDD VSS gf180mcu_fd_sc_mcu7t5v0__buf_4
XFILLER_50_807 VDD VSS VDD VSS gf180mcu_fd_sc_mcu7t5v0__fillcap_64
XFILLER_62_667 VDD VSS VDD VSS gf180mcu_fd_sc_mcu7t5v0__fillcap_64
X_2970_ VDD _2970_/Q clkload9/I VSS _2970_/D VDD VSS gf180mcu_fd_sc_mcu7t5v0__dffq_1
X_1921_ _1924_/S VDD VSS _2975_/D wire121/Z _2975_/Q VDD VSS gf180mcu_fd_sc_mcu7t5v0__mux2_2
XFILLER_187_352 VDD VSS VDD VSS gf180mcu_fd_sc_mcu7t5v0__fillcap_8
X_1852_ VDD VSS _1860_/S _1852_/A1 _1861_/A2 VDD VSS gf180mcu_fd_sc_mcu7t5v0__nand2_1
XFILLER_30_597 VDD VSS VDD VSS gf180mcu_fd_sc_mcu7t5v0__fillcap_64
X_1783_ _1786_/S VDD VSS _2857_/D wire132/Z _2857_/Q VDD VSS gf180mcu_fd_sc_mcu7t5v0__mux2_2
XFILLER_155_282 VDD VSS VDD VSS gf180mcu_fd_sc_mcu7t5v0__fillcap_16
XFILLER_143_422 VDD VSS VDD VSS gf180mcu_fd_sc_mcu7t5v0__fillcap_8
X_3453_ VSS _3453_/CLK VDD input4/Z _3454_/D _3335_/RN VDD VSS gf180mcu_fd_sc_mcu7t5v0__dffsnq_1
XFILLER_115_135 VDD VSS VDD VSS gf180mcu_fd_sc_mcu7t5v0__fillcap_4
X_2404_ VDD VSS _2405_/A3 _2461_/A1 _2403_/Z VDD VSS gf180mcu_fd_sc_mcu7t5v0__nand2_1
XFILLER_131_617 VDD VSS VDD VSS gf180mcu_fd_sc_mcu7t5v0__fillcap_8
X_3384_ _3384_/D _3405_/D wire161/Z VSS _3445_/CLK VDD VDD VSS gf180mcu_fd_sc_mcu7t5v0__dffrnq_1
XFILLER_97_553 VDD VSS VDD VSS gf180mcu_fd_sc_mcu7t5v0__fillcap_4
X_2335_ VDD _2481_/B _2339_/B _3188_/D _2335_/A1 VSS VDD VSS gf180mcu_fd_sc_mcu7t5v0__oai21_1
XFILLER_111_352 VDD VSS VDD VSS gf180mcu_fd_sc_mcu7t5v0__fillcap_16
X_2266_ VDD VSS _2268_/B _2494_/C _2365_/A3 VDD VSS gf180mcu_fd_sc_mcu7t5v0__nand2_1
X_2197_ _2197_/B VDD VSS _3148_/D _2197_/A1 _2189_/S VDD VSS gf180mcu_fd_sc_mcu7t5v0__aoi21_1
XFILLER_84_247 VDD VSS VDD VSS gf180mcu_fd_sc_mcu7t5v0__fillcap_64
XFILLER_241_702 VDD VSS VDD VSS gf180mcu_fd_sc_mcu7t5v0__fillcap_64
XFILLER_253_562 VDD VSS VDD VSS gf180mcu_fd_sc_mcu7t5v0__fillcap_64
XFILLER_197_105 VDD VSS VDD VSS gf180mcu_fd_sc_mcu7t5v0__fillcap_16
XFILLER_179_842 VDD VSS VDD VSS gf180mcu_fd_sc_mcu7t5v0__fillcap_32
XFILLER_52_177 VDD VSS VDD VSS gf180mcu_fd_sc_mcu7t5v0__fillcap_64
XFILLER_40_317 VDD VSS VDD VSS gf180mcu_fd_sc_mcu7t5v0__fillcap_64
XFILLER_194_801 VDD VSS VDD VSS gf180mcu_fd_sc_mcu7t5v0__fillcap_4
XFILLER_147_772 VDD VSS VDD VSS gf180mcu_fd_sc_mcu7t5v0__fillcap_64
XFILLER_162_731 VDD VSS VDD VSS gf180mcu_fd_sc_mcu7t5v0__fillcap_4
XFILLER_146_271 VDD VSS VDD VSS gf180mcu_fd_sc_mcu7t5v0__fillcap_4
XFILLER_103_842 VDD VSS VDD VSS gf180mcu_fd_sc_mcu7t5v0__fillcap_32
XFILLER_96_27 VDD VSS VDD VSS gf180mcu_fd_sc_mcu7t5v0__fillcap_8
XFILLER_88_597 VDD VSS VDD VSS gf180mcu_fd_sc_mcu7t5v0__fillcap_64
XFILLER_76_737 VDD VSS VDD VSS gf180mcu_fd_sc_mcu7t5v0__fillcap_64
XFILLER_231_212 VDD VSS VDD VSS gf180mcu_fd_sc_mcu7t5v0__fillcap_64
XFILLER_32_807 VDD VSS VDD VSS gf180mcu_fd_sc_mcu7t5v0__fillcap_64
XFILLER_44_667 VDD VSS VDD VSS gf180mcu_fd_sc_mcu7t5v0__fillcap_64
XFILLER_250_2 VDD VSS VDD VSS gf180mcu_fd_sc_mcu7t5v0__fillcap_32
XFILLER_71_486 VDD VSS VDD VSS gf180mcu_fd_sc_mcu7t5v0__fillcap_4
XFILLER_169_352 VDD VSS VDD VSS gf180mcu_fd_sc_mcu7t5v0__fillcap_16
XFILLER_200_621 VDD VSS VDD VSS gf180mcu_fd_sc_mcu7t5v0__fillcap_4
XFILLER_196_160 VDD VSS VDD VSS gf180mcu_fd_sc_mcu7t5v0__fillcap_8
XFILLER_129_205 VDD VSS VDD VSS gf180mcu_fd_sc_mcu7t5v0__fillcap_4
XFILLER_12_597 VDD VSS VDD VSS gf180mcu_fd_sc_mcu7t5v0__fillcap_64
XFILLER_137_282 VDD VSS VDD VSS gf180mcu_fd_sc_mcu7t5v0__fillcap_64
XFILLER_125_422 VDD VSS VDD VSS gf180mcu_fd_sc_mcu7t5v0__fillcap_4
XFILLER_152_230 VDD VSS VDD VSS gf180mcu_fd_sc_mcu7t5v0__fillcap_4
XFILLER_98_317 VDD VSS VDD VSS gf180mcu_fd_sc_mcu7t5v0__fillcap_32
XFILLER_267_632 VDD VSS VDD VSS gf180mcu_fd_sc_mcu7t5v0__fillcap_64
X_2120_ VDD _2120_/B _2121_/A2 _2121_/B _2121_/A1 VSS VDD VSS gf180mcu_fd_sc_mcu7t5v0__oai21_1
XFILLER_120_171 VDD VSS VDD VSS gf180mcu_fd_sc_mcu7t5v0__fillcap_4
XFILLER_120_193 VDD VSS VDD VSS gf180mcu_fd_sc_mcu7t5v0__fillcap_8
XFILLER_66_247 VDD VSS VDD VSS gf180mcu_fd_sc_mcu7t5v0__fillcap_64
X_2051_ _2059_/S VDD VSS _3084_/D _3300_/Q _3084_/Q VDD VSS gf180mcu_fd_sc_mcu7t5v0__mux2_2
XFILLER_86_93 VDD VSS VDD VSS gf180mcu_fd_sc_mcu7t5v0__fillcap_8
XFILLER_212_47 VDD VSS VDD VSS gf180mcu_fd_sc_mcu7t5v0__fillcap_4
XFILLER_223_702 VDD VSS VDD VSS gf180mcu_fd_sc_mcu7t5v0__fillcap_64
XFILLER_235_562 VDD VSS VDD VSS gf180mcu_fd_sc_mcu7t5v0__fillcap_64
XFILLER_250_521 VDD VSS VDD VSS gf180mcu_fd_sc_mcu7t5v0__fillcap_4
XFILLER_262_381 VDD VSS VDD VSS gf180mcu_fd_sc_mcu7t5v0__fillcap_4
XFILLER_179_127 VDD VSS VDD VSS gf180mcu_fd_sc_mcu7t5v0__fillcap_4
X_2953_ VDD _2953_/Q _3409_/CLK VSS _2953_/D VDD VSS gf180mcu_fd_sc_mcu7t5v0__dffq_1
XFILLER_34_177 VDD VSS VDD VSS gf180mcu_fd_sc_mcu7t5v0__fillcap_64
XFILLER_22_317 VDD VSS VDD VSS gf180mcu_fd_sc_mcu7t5v0__fillcap_64
XFILLER_96_2 VDD VSS VDD VSS gf180mcu_fd_sc_mcu7t5v0__fillcap_16
X_1904_ _1907_/S VDD VSS _2961_/D _3179_/Q _2961_/Q VDD VSS gf180mcu_fd_sc_mcu7t5v0__mux2_2
XFILLER_188_661 VDD VSS VDD VSS gf180mcu_fd_sc_mcu7t5v0__fillcap_4
XFILLER_176_801 VDD VSS VDD VSS gf180mcu_fd_sc_mcu7t5v0__fillcap_4
XFILLER_194_119 VDD VSS VDD VSS gf180mcu_fd_sc_mcu7t5v0__fillcap_8
X_2884_ VDD _2884_/Q _2932_/CLK VSS _2884_/D VDD VSS gf180mcu_fd_sc_mcu7t5v0__dffq_1
X_1835_ _1842_/S VDD VSS _2901_/D wire137/Z _2901_/Q VDD VSS gf180mcu_fd_sc_mcu7t5v0__mux2_2
XFILLER_129_772 VDD VSS VDD VSS gf180mcu_fd_sc_mcu7t5v0__fillcap_64
XFILLER_156_591 VDD VSS VDD VSS gf180mcu_fd_sc_mcu7t5v0__fillcap_4
XFILLER_144_731 VDD VSS VDD VSS gf180mcu_fd_sc_mcu7t5v0__fillcap_4
X_1766_ _1768_/S VDD VSS _2842_/D _3124_/Q _2842_/Q VDD VSS gf180mcu_fd_sc_mcu7t5v0__mux2_2
XFILLER_237_66 VDD VSS VDD VSS gf180mcu_fd_sc_mcu7t5v0__fillcap_4
X_1697_ VDD VSS _2295_/A4 _1695_/Z _1696_/Z VDD VSS gf180mcu_fd_sc_mcu7t5v0__nand2_1
XFILLER_89_306 VDD VSS VDD VSS gf180mcu_fd_sc_mcu7t5v0__fillcap_4
X_3436_ _3436_/D _3436_/Q wire161/I VSS _3443_/CLK VDD VDD VSS gf180mcu_fd_sc_mcu7t5v0__dffrnq_1
X_3367_ _3367_/D _3367_/Q _3458_/RN VSS _3370_/CLK VDD VDD VSS gf180mcu_fd_sc_mcu7t5v0__dffrnq_1
XFILLER_100_801 VDD VSS VDD VSS gf180mcu_fd_sc_mcu7t5v0__fillcap_4
XFILLER_257_142 VDD VSS VDD VSS gf180mcu_fd_sc_mcu7t5v0__fillcap_64
X_2318_ _2318_/A3 VDD VSS _2474_/A1 _2314_/Z _2318_/A2 VDD VSS gf180mcu_fd_sc_mcu7t5v0__nand3_1
XFILLER_58_737 VDD VSS VDD VSS gf180mcu_fd_sc_mcu7t5v0__fillcap_64
XFILLER_85_556 VDD VSS VDD VSS gf180mcu_fd_sc_mcu7t5v0__fillcap_4
X_3298_ _3298_/D _3298_/Q wire169/Z VSS _3446_/CLK VDD VDD VSS gf180mcu_fd_sc_mcu7t5v0__dffrnq_1
X_2249_ VDD VSS _2257_/A1 _2459_/A1 _2248_/Z VDD VSS gf180mcu_fd_sc_mcu7t5v0__nand2_1
XFILLER_254_871 VDD VSS VDD VSS gf180mcu_fd_sc_mcu7t5v0__fillcap_4
XFILLER_72_239 VDD VSS VDD VSS gf180mcu_fd_sc_mcu7t5v0__fillcap_4
XFILLER_213_212 VDD VSS VDD VSS gf180mcu_fd_sc_mcu7t5v0__fillcap_64
XFILLER_14_807 VDD VSS VDD VSS gf180mcu_fd_sc_mcu7t5v0__fillcap_64
XFILLER_26_667 VDD VSS VDD VSS gf180mcu_fd_sc_mcu7t5v0__fillcap_64
XFILLER_41_626 VDD VSS VDD VSS gf180mcu_fd_sc_mcu7t5v0__fillcap_4
XFILLER_53_486 VDD VSS VDD VSS gf180mcu_fd_sc_mcu7t5v0__fillcap_4
XFILLER_166_311 VDD VSS VDD VSS gf180mcu_fd_sc_mcu7t5v0__fillcap_4
XFILLER_107_422 VDD VSS VDD VSS gf180mcu_fd_sc_mcu7t5v0__fillcap_64
XFILLER_193_174 VDD VSS VDD VSS gf180mcu_fd_sc_mcu7t5v0__fillcap_4
XFILLER_181_336 VDD VSS VDD VSS gf180mcu_fd_sc_mcu7t5v0__fillcap_8
XFILLER_119_282 VDD VSS VDD VSS gf180mcu_fd_sc_mcu7t5v0__fillcap_16
XFILLER_31_66 VDD VSS VDD VSS gf180mcu_fd_sc_mcu7t5v0__fillcap_4
XFILLER_147_66 VDD VSS VDD VSS gf180mcu_fd_sc_mcu7t5v0__fillcap_4
XFILLER_134_263 VDD VSS VDD VSS gf180mcu_fd_sc_mcu7t5v0__fillcap_8
Xoutput9 VDD wire101/Z VSS spi_miso_o_OUT VDD VSS gf180mcu_fd_sc_mcu7t5v0__dlyb_1
XFILLER_122_425 VDD VSS VDD VSS gf180mcu_fd_sc_mcu7t5v0__fillcap_16
XFILLER_249_632 VDD VSS VDD VSS gf180mcu_fd_sc_mcu7t5v0__fillcap_64
XFILLER_1_766 VDD VSS VDD VSS gf180mcu_fd_sc_mcu7t5v0__fillcap_4
XFILLER_103_672 VDD VSS VDD VSS gf180mcu_fd_sc_mcu7t5v0__fillcap_8
XFILLER_48_247 VDD VSS VDD VSS gf180mcu_fd_sc_mcu7t5v0__fillcap_64
XFILLER_217_540 VDD VSS VDD VSS gf180mcu_fd_sc_mcu7t5v0__fillcap_4
XFILLER_63_206 VDD VSS VDD VSS gf180mcu_fd_sc_mcu7t5v0__fillcap_4
XFILLER_232_521 VDD VSS VDD VSS gf180mcu_fd_sc_mcu7t5v0__fillcap_4
XFILLER_244_381 VDD VSS VDD VSS gf180mcu_fd_sc_mcu7t5v0__fillcap_4
XFILLER_260_885 VDD VSS VDD VSS gf180mcu_fd_sc_mcu7t5v0__fillcap_4
XFILLER_16_177 VDD VSS VDD VSS gf180mcu_fd_sc_mcu7t5v0__fillcap_64
XFILLER_158_801 VDD VSS VDD VSS gf180mcu_fd_sc_mcu7t5v0__fillcap_4
XFILLER_31_136 VDD VSS VDD VSS gf180mcu_fd_sc_mcu7t5v0__fillcap_4
XFILLER_197_480 VDD VSS VDD VSS gf180mcu_fd_sc_mcu7t5v0__fillcap_4
XFILLER_200_451 VDD VSS VDD VSS gf180mcu_fd_sc_mcu7t5v0__fillcap_4
XFILLER_8_387 VDD VSS VDD VSS gf180mcu_fd_sc_mcu7t5v0__fillcap_64
XFILLER_145_539 VDD VSS VDD VSS gf180mcu_fd_sc_mcu7t5v0__fillcap_4
XFILLER_138_580 VDD VSS VDD VSS gf180mcu_fd_sc_mcu7t5v0__fillcap_8
X_1620_ VDD VSS _1620_/Z _3428_/Q _3419_/D VDD VSS gf180mcu_fd_sc_mcu7t5v0__xor2_1
X_1551_ VDD _1551_/B _1551_/A2 _3342_/D _1551_/A1 VSS VDD VSS gf180mcu_fd_sc_mcu7t5v0__oai21_1
XFILLER_99_626 VDD VSS VDD VSS gf180mcu_fd_sc_mcu7t5v0__fillcap_4
XFILLER_180_380 VDD VSS VDD VSS gf180mcu_fd_sc_mcu7t5v0__fillcap_4
X_1482_ VDD VSS _3421_/D _3421_/Q _1485_/A2 VDD VSS gf180mcu_fd_sc_mcu7t5v0__xor2_1
X_3221_ _3221_/D _3221_/Q wire165/I VSS _3332_/CLK VDD VDD VSS gf180mcu_fd_sc_mcu7t5v0__dffrnq_1
XFILLER_239_142 VDD VSS VDD VSS gf180mcu_fd_sc_mcu7t5v0__fillcap_64
X_3152_ _3152_/D _3152_/Q wire151/I VSS _3165_/CLK VDD VDD VSS gf180mcu_fd_sc_mcu7t5v0__dffrnq_1
XFILLER_254_101 VDD VSS VDD VSS gf180mcu_fd_sc_mcu7t5v0__fillcap_4
X_2103_ VDD VSS _2106_/A2 _2113_/A1 _2113_/A3 VDD VSS gf180mcu_fd_sc_mcu7t5v0__nor2_1
XFILLER_67_556 VDD VSS VDD VSS gf180mcu_fd_sc_mcu7t5v0__fillcap_4
X_3083_ _3083_/D _3083_/Q _3339_/RN VSS _3307_/CLK VDD VDD VSS gf180mcu_fd_sc_mcu7t5v0__dffrnq_1
XFILLER_236_871 VDD VSS VDD VSS gf180mcu_fd_sc_mcu7t5v0__fillcap_4
X_2034_ wire28/I VDD VSS _3067_/D wire91/I _3067_/Q VDD VSS gf180mcu_fd_sc_mcu7t5v0__mux2_2
XFILLER_251_874 VDD VSS VDD VSS gf180mcu_fd_sc_mcu7t5v0__fillcap_16
XFILLER_35_486 VDD VSS VDD VSS gf180mcu_fd_sc_mcu7t5v0__fillcap_4
XFILLER_23_626 VDD VSS VDD VSS gf180mcu_fd_sc_mcu7t5v0__fillcap_4
XFILLER_210_215 VDD VSS VDD VSS gf180mcu_fd_sc_mcu7t5v0__fillcap_8
XFILLER_188_480 VDD VSS VDD VSS gf180mcu_fd_sc_mcu7t5v0__fillcap_8
X_2936_ VDD _2936_/Q _3150_/CLK VSS _2936_/D VDD VSS gf180mcu_fd_sc_mcu7t5v0__dffq_1
XFILLER_148_311 VDD VSS VDD VSS gf180mcu_fd_sc_mcu7t5v0__fillcap_4
X_2867_ VDD _2867_/Q _2867_/CLK VSS _2867_/D VDD VSS gf180mcu_fd_sc_mcu7t5v0__dffq_1
X_1818_ _1823_/S VDD VSS _2887_/D _1864_/I0 _2887_/Q VDD VSS gf180mcu_fd_sc_mcu7t5v0__mux2_2
XFILLER_163_303 VDD VSS VDD VSS gf180mcu_fd_sc_mcu7t5v0__fillcap_8
X_2798_ VDD VSS _2798_/I _3340_/D VDD VSS gf180mcu_fd_sc_mcu7t5v0__clkinv_1
X_1749_ _1749_/A3 VDD VSS _1861_/A1 _3368_/Q _3367_/Q VDD VSS gf180mcu_fd_sc_mcu7t5v0__nor3_1
XFILLER_190_177 VDD VSS VDD VSS gf180mcu_fd_sc_mcu7t5v0__fillcap_8
XFILLER_116_263 VDD VSS VDD VSS gf180mcu_fd_sc_mcu7t5v0__fillcap_8
XFILLER_132_712 VDD VSS VDD VSS gf180mcu_fd_sc_mcu7t5v0__fillcap_16
X_3419_ _3419_/D _3444_/D wire161/I VSS _3435_/CLK VDD VDD VSS gf180mcu_fd_sc_mcu7t5v0__dffrnq_1
XFILLER_89_158 VDD VSS VDD VSS gf180mcu_fd_sc_mcu7t5v0__fillcap_8
XFILLER_258_451 VDD VSS VDD VSS gf180mcu_fd_sc_mcu7t5v0__fillcap_4
XFILLER_45_206 VDD VSS VDD VSS gf180mcu_fd_sc_mcu7t5v0__fillcap_4
XFILLER_93_39 VDD VSS VDD VSS gf180mcu_fd_sc_mcu7t5v0__fillcap_16
XFILLER_226_381 VDD VSS VDD VSS gf180mcu_fd_sc_mcu7t5v0__fillcap_4
XFILLER_242_885 VDD VSS VDD VSS gf180mcu_fd_sc_mcu7t5v0__fillcap_4
XFILLER_13_136 VDD VSS VDD VSS gf180mcu_fd_sc_mcu7t5v0__fillcap_4
Xclkbuf_3_3__f_clk_i VDD VSS clkload2/I clkbuf_0_clk_i/Z VDD VSS gf180mcu_fd_sc_mcu7t5v0__clkbuf_16
Xmax_length61 VSS _2740_/S1 _2741_/S1 VDD VDD VSS gf180mcu_fd_sc_mcu7t5v0__buf_2
Xmax_length50 _2642_/S _2619_/S VDD VSS VDD VSS gf180mcu_fd_sc_mcu7t5v0__buf_4
Xmax_length83 _2460_/S0 _3380_/Q VDD VSS VDD VSS gf180mcu_fd_sc_mcu7t5v0__buf_4
XFILLER_213_2 VDD VSS VDD VSS gf180mcu_fd_sc_mcu7t5v0__fillcap_64
XFILLER_170_807 VDD VSS VDD VSS gf180mcu_fd_sc_mcu7t5v0__fillcap_64
XFILLER_166_196 VDD VSS VDD VSS gf180mcu_fd_sc_mcu7t5v0__fillcap_4
XFILLER_154_336 VDD VSS VDD VSS gf180mcu_fd_sc_mcu7t5v0__fillcap_8
XFILLER_5_346 VDD VSS VDD VSS gf180mcu_fd_sc_mcu7t5v0__fillcap_4
XFILLER_107_274 VDD VSS VDD VSS gf180mcu_fd_sc_mcu7t5v0__fillcap_4
XFILLER_122_233 VDD VSS VDD VSS gf180mcu_fd_sc_mcu7t5v0__fillcap_8
XFILLER_150_597 VDD VSS VDD VSS gf180mcu_fd_sc_mcu7t5v0__fillcap_16
XFILLER_95_106 VDD VSS VDD VSS gf180mcu_fd_sc_mcu7t5v0__fillcap_16
XFILLER_107_80 VDD VSS VDD VSS gf180mcu_fd_sc_mcu7t5v0__fillcap_4
XFILLER_236_101 VDD VSS VDD VSS gf180mcu_fd_sc_mcu7t5v0__fillcap_4
XFILLER_190_30 VDD VSS VDD VSS gf180mcu_fd_sc_mcu7t5v0__fillcap_4
XFILLER_49_556 VDD VSS VDD VSS gf180mcu_fd_sc_mcu7t5v0__fillcap_4
XFILLER_190_74 VDD VSS VDD VSS gf180mcu_fd_sc_mcu7t5v0__fillcap_4
XFILLER_218_871 VDD VSS VDD VSS gf180mcu_fd_sc_mcu7t5v0__fillcap_4
XFILLER_233_874 VDD VSS VDD VSS gf180mcu_fd_sc_mcu7t5v0__fillcap_16
XFILLER_199_72 VDD VSS VDD VSS gf180mcu_fd_sc_mcu7t5v0__fillcap_32
XFILLER_17_486 VDD VSS VDD VSS gf180mcu_fd_sc_mcu7t5v0__fillcap_4
XFILLER_83_72 VDD VSS VDD VSS gf180mcu_fd_sc_mcu7t5v0__fillcap_8
XFILLER_118_506 VDD VSS VDD VSS gf180mcu_fd_sc_mcu7t5v0__fillcap_4
X_2721_ _3058_/Q VSS VDD _3042_/Q _3050_/Q _2722_/S0 _3034_/Q wire60/Z _2721_/Z VDD
+ VSS gf180mcu_fd_sc_mcu7t5v0__mux4_1
XFILLER_173_623 VDD VSS VDD VSS gf180mcu_fd_sc_mcu7t5v0__fillcap_4
XFILLER_9_696 VDD VSS VDD VSS gf180mcu_fd_sc_mcu7t5v0__fillcap_4
X_2652_ _2652_/A3 VDD VSS _2737_/C _3272_/Q _2652_/A2 VDD VSS gf180mcu_fd_sc_mcu7t5v0__and3_1
X_1603_ VDD VSS _1604_/A3 _3387_/Q _3378_/D VDD VSS gf180mcu_fd_sc_mcu7t5v0__xnor2_1
XFILLER_160_317 VDD VSS VDD VSS gf180mcu_fd_sc_mcu7t5v0__fillcap_32
X_2583_ wire12/Z VDD VSS _3251_/D _3243_/Q _3251_/Q VDD VSS gf180mcu_fd_sc_mcu7t5v0__mux2_2
XFILLER_59_2 VDD VSS VDD VSS gf180mcu_fd_sc_mcu7t5v0__fillcap_64
X_1534_ VDD VSS _2470_/B _2324_/A1 _1532_/Z VDD VSS gf180mcu_fd_sc_mcu7t5v0__nand2_1
XFILLER_141_542 VDD VSS VDD VSS gf180mcu_fd_sc_mcu7t5v0__fillcap_16
X_1465_ _1454_/I _1465_/A4 VDD VSS _1465_/Z _3408_/Q _3407_/Q VDD VSS gf180mcu_fd_sc_mcu7t5v0__and4_1
X_3204_ _3204_/D _3204_/Q wire153/I VSS _3358_/CLK VDD VDD VSS gf180mcu_fd_sc_mcu7t5v0__dffrnq_1
X_1396_ VDD VSS _3363_/Q _2341_/A2 VDD VSS gf180mcu_fd_sc_mcu7t5v0__clkinv_1
X_3135_ _3135_/D _3135_/Q wire151/Z VSS _3185_/CLK VDD VDD VSS gf180mcu_fd_sc_mcu7t5v0__dffrnq_1
XFILLER_27_206 VDD VSS VDD VSS gf180mcu_fd_sc_mcu7t5v0__fillcap_4
X_3066_ _3066_/D _3066_/Q wire163/I VSS _3277_/CLK VDD VDD VSS gf180mcu_fd_sc_mcu7t5v0__dffrnq_1
XFILLER_103_38 VDD VSS VDD VSS gf180mcu_fd_sc_mcu7t5v0__fillcap_16
X_2017_ _2018_/S VDD VSS _3059_/D wire114/Z _3059_/Q VDD VSS gf180mcu_fd_sc_mcu7t5v0__mux2_2
XFILLER_224_885 VDD VSS VDD VSS gf180mcu_fd_sc_mcu7t5v0__fillcap_4
XFILLER_211_524 VDD VSS VDD VSS gf180mcu_fd_sc_mcu7t5v0__fillcap_4
XFILLER_196_737 VDD VSS VDD VSS gf180mcu_fd_sc_mcu7t5v0__fillcap_64
X_2919_ VDD _2919_/Q _2932_/CLK VSS _2919_/D VDD VSS gf180mcu_fd_sc_mcu7t5v0__dffq_1
Xmax_length118 _2015_/I0 VSS VDD _3179_/Q VDD VSS gf180mcu_fd_sc_mcu7t5v0__clkbuf_3
XFILLER_164_634 VDD VSS VDD VSS gf180mcu_fd_sc_mcu7t5v0__fillcap_16
XFILLER_148_163 VDD VSS VDD VSS gf180mcu_fd_sc_mcu7t5v0__fillcap_8
Xmax_length129 VSS _1794_/I1 _3125_/Q VDD VDD VSS gf180mcu_fd_sc_mcu7t5v0__buf_2
Xmax_length107 VSS _2474_/B _2449_/A1 VDD VDD VSS gf180mcu_fd_sc_mcu7t5v0__buf_2
XFILLER_164_667 VDD VSS VDD VSS gf180mcu_fd_sc_mcu7t5v0__fillcap_64
XFILLER_152_807 VDD VSS VDD VSS gf180mcu_fd_sc_mcu7t5v0__fillcap_64
XFILLER_191_486 VDD VSS VDD VSS gf180mcu_fd_sc_mcu7t5v0__fillcap_4
XFILLER_104_255 VDD VSS VDD VSS gf180mcu_fd_sc_mcu7t5v0__fillcap_8
XFILLER_120_737 VDD VSS VDD VSS gf180mcu_fd_sc_mcu7t5v0__fillcap_64
XFILLER_77_128 VDD VSS VDD VSS gf180mcu_fd_sc_mcu7t5v0__fillcap_8
XFILLER_219_679 VDD VSS VDD VSS gf180mcu_fd_sc_mcu7t5v0__fillcap_16
XFILLER_85_194 VDD VSS VDD VSS gf180mcu_fd_sc_mcu7t5v0__fillcap_16
XFILLER_215_874 VDD VSS VDD VSS gf180mcu_fd_sc_mcu7t5v0__fillcap_16
XFILLER_199_586 VDD VSS VDD VSS gf180mcu_fd_sc_mcu7t5v0__fillcap_4
XFILLER_230_877 VDD VSS VDD VSS gf180mcu_fd_sc_mcu7t5v0__fillcap_8
XFILLER_169_53 VDD VSS VDD VSS gf180mcu_fd_sc_mcu7t5v0__fillcap_16
XFILLER_186_247 VDD VSS VDD VSS gf180mcu_fd_sc_mcu7t5v0__fillcap_8
XFILLER_155_689 VDD VSS VDD VSS gf180mcu_fd_sc_mcu7t5v0__fillcap_8
XFILLER_154_177 VDD VSS VDD VSS gf180mcu_fd_sc_mcu7t5v0__fillcap_64
XFILLER_142_317 VDD VSS VDD VSS gf180mcu_fd_sc_mcu7t5v0__fillcap_64
XFILLER_110_247 VDD VSS VDD VSS gf180mcu_fd_sc_mcu7t5v0__fillcap_32
XFILLER_204_37 VDD VSS VDD VSS gf180mcu_fd_sc_mcu7t5v0__fillcap_8
XFILLER_91_142 VDD VSS VDD VSS gf180mcu_fd_sc_mcu7t5v0__fillcap_16
XFILLER_252_457 VDD VSS VDD VSS gf180mcu_fd_sc_mcu7t5v0__fillcap_64
XFILLER_206_885 VDD VSS VDD VSS gf180mcu_fd_sc_mcu7t5v0__fillcap_4
XFILLER_178_737 VDD VSS VDD VSS gf180mcu_fd_sc_mcu7t5v0__fillcap_64
XFILLER_220_365 VDD VSS VDD VSS gf180mcu_fd_sc_mcu7t5v0__fillcap_4
XFILLER_220_387 VDD VSS VDD VSS gf180mcu_fd_sc_mcu7t5v0__fillcap_4
XFILLER_134_807 VDD VSS VDD VSS gf180mcu_fd_sc_mcu7t5v0__fillcap_64
X_2704_ _3065_/Q _2704_/C VDD VSS _2705_/A2 _3097_/Q _2668_/Z _2799_/A2 VDD VSS gf180mcu_fd_sc_mcu7t5v0__aoi221_1
XFILLER_146_667 VDD VSS VDD VSS gf180mcu_fd_sc_mcu7t5v0__fillcap_4
XFILLER_161_615 VDD VSS VDD VSS gf180mcu_fd_sc_mcu7t5v0__fillcap_8
XFILLER_118_369 VDD VSS VDD VSS gf180mcu_fd_sc_mcu7t5v0__fillcap_16
X_2635_ wire46/Z VDD VSS _3298_/D _3256_/Q _3298_/Q VDD VSS gf180mcu_fd_sc_mcu7t5v0__mux2_2
XFILLER_245_66 VDD VSS VDD VSS gf180mcu_fd_sc_mcu7t5v0__fillcap_4
X_2566_ _2566_/S VDD VSS _3235_/D _3220_/Q _3235_/Q VDD VSS gf180mcu_fd_sc_mcu7t5v0__mux2_2
X_1517_ VDD VSS _1525_/A2 _3381_/Q _1516_/Z VDD VSS gf180mcu_fd_sc_mcu7t5v0__nor2_1
XFILLER_114_597 VDD VSS VDD VSS gf180mcu_fd_sc_mcu7t5v0__fillcap_8
XFILLER_102_737 VDD VSS VDD VSS gf180mcu_fd_sc_mcu7t5v0__fillcap_64
X_2497_ VDD _3213_/Q _2530_/A3 _2532_/B _3448_/D VSS VDD VSS gf180mcu_fd_sc_mcu7t5v0__oai21_1
XFILLER_101_203 VDD VSS VDD VSS gf180mcu_fd_sc_mcu7t5v0__fillcap_4
X_1448_ VDD VSS _3463_/Q _2748_/B2 VDD VSS gf180mcu_fd_sc_mcu7t5v0__clkinv_1
XFILLER_114_37 VDD VSS VDD VSS gf180mcu_fd_sc_mcu7t5v0__fillcap_16
X_3118_ VSS _3359_/CLK VDD _3118_/D _3118_/Q _3359_/RN VDD VSS gf180mcu_fd_sc_mcu7t5v0__dffsnq_1
XFILLER_95_470 VDD VSS VDD VSS gf180mcu_fd_sc_mcu7t5v0__fillcap_4
XFILLER_83_632 VDD VSS VDD VSS gf180mcu_fd_sc_mcu7t5v0__fillcap_64
X_3049_ VDD _3049_/Q _3059_/CLK VSS _3049_/D VDD VSS gf180mcu_fd_sc_mcu7t5v0__dffq_1
XFILLER_82_186 VDD VSS VDD VSS gf180mcu_fd_sc_mcu7t5v0__fillcap_4
XFILLER_230_107 VDD VSS VDD VSS gf180mcu_fd_sc_mcu7t5v0__fillcap_64
XFILLER_51_562 VDD VSS VDD VSS gf180mcu_fd_sc_mcu7t5v0__fillcap_64
XFILLER_90_29 VDD VSS VDD VSS gf180mcu_fd_sc_mcu7t5v0__fillcap_4
XFILLER_212_877 VDD VSS VDD VSS gf180mcu_fd_sc_mcu7t5v0__fillcap_8
XFILLER_196_567 VDD VSS VDD VSS gf180mcu_fd_sc_mcu7t5v0__fillcap_16
XFILLER_168_247 VDD VSS VDD VSS gf180mcu_fd_sc_mcu7t5v0__fillcap_8
XFILLER_137_623 VDD VSS VDD VSS gf180mcu_fd_sc_mcu7t5v0__fillcap_4
XFILLER_184_729 VDD VSS VDD VSS gf180mcu_fd_sc_mcu7t5v0__fillcap_4
XFILLER_183_206 VDD VSS VDD VSS gf180mcu_fd_sc_mcu7t5v0__fillcap_4
XFILLER_99_38 VDD VSS VDD VSS gf180mcu_fd_sc_mcu7t5v0__fillcap_16
XFILLER_136_166 VDD VSS VDD VSS gf180mcu_fd_sc_mcu7t5v0__fillcap_8
XFILLER_266_527 VDD VSS VDD VSS gf180mcu_fd_sc_mcu7t5v0__fillcap_64
XFILLER_219_410 VDD VSS VDD VSS gf180mcu_fd_sc_mcu7t5v0__fillcap_8
XFILLER_234_457 VDD VSS VDD VSS gf180mcu_fd_sc_mcu7t5v0__fillcap_64
XFILLER_261_276 VDD VSS VDD VSS gf180mcu_fd_sc_mcu7t5v0__fillcap_4
XFILLER_187_512 VDD VSS VDD VSS gf180mcu_fd_sc_mcu7t5v0__fillcap_16
XFILLER_70_871 VDD VSS VDD VSS gf180mcu_fd_sc_mcu7t5v0__fillcap_4
XFILLER_147_409 VDD VSS VDD VSS gf180mcu_fd_sc_mcu7t5v0__fillcap_8
XFILLER_202_387 VDD VSS VDD VSS gf180mcu_fd_sc_mcu7t5v0__fillcap_4
XFILLER_116_807 VDD VSS VDD VSS gf180mcu_fd_sc_mcu7t5v0__fillcap_64
XFILLER_128_667 VDD VSS VDD VSS gf180mcu_fd_sc_mcu7t5v0__fillcap_8
XFILLER_143_626 VDD VSS VDD VSS gf180mcu_fd_sc_mcu7t5v0__fillcap_4
X_2420_ _2420_/B _2448_/C VDD VSS _2422_/A2 _3382_/Q _2414_/Z VDD VSS gf180mcu_fd_sc_mcu7t5v0__oai211_1
XFILLER_97_702 VDD VSS VDD VSS gf180mcu_fd_sc_mcu7t5v0__fillcap_64
X_2351_ VDD _2351_/B _2351_/A2 _2352_/C _2365_/A2 VSS VDD VSS gf180mcu_fd_sc_mcu7t5v0__oai21_1
X_2282_ _2282_/B VDD VSS _3176_/D _2304_/A1 _2288_/S VDD VSS gf180mcu_fd_sc_mcu7t5v0__aoi21_1
XFILLER_77_492 VDD VSS VDD VSS gf180mcu_fd_sc_mcu7t5v0__fillcap_64
XFILLER_65_632 VDD VSS VDD VSS gf180mcu_fd_sc_mcu7t5v0__fillcap_64
XFILLER_92_451 VDD VSS VDD VSS gf180mcu_fd_sc_mcu7t5v0__fillcap_4
XFILLER_253_766 VDD VSS VDD VSS gf180mcu_fd_sc_mcu7t5v0__fillcap_4
XFILLER_212_107 VDD VSS VDD VSS gf180mcu_fd_sc_mcu7t5v0__fillcap_16
XFILLER_205_170 VDD VSS VDD VSS gf180mcu_fd_sc_mcu7t5v0__fillcap_32
XFILLER_33_562 VDD VSS VDD VSS gf180mcu_fd_sc_mcu7t5v0__fillcap_64
XFILLER_21_702 VDD VSS VDD VSS gf180mcu_fd_sc_mcu7t5v0__fillcap_64
XFILLER_60_381 VDD VSS VDD VSS gf180mcu_fd_sc_mcu7t5v0__fillcap_4
X_1997_ _2000_/S VDD VSS _3041_/D _2015_/I0 _3041_/Q VDD VSS gf180mcu_fd_sc_mcu7t5v0__mux2_2
XFILLER_109_26 VDD VSS VDD VSS gf180mcu_fd_sc_mcu7t5v0__fillcap_4
Xclkload71 VSS clkload71/Z _3392_/CLK VDD VDD VSS gf180mcu_fd_sc_mcu7t5v0__clkbuf_1
Xclkload60 VSS clkload60/Z _3363_/CLK VDD VDD VSS gf180mcu_fd_sc_mcu7t5v0__clkbuf_1
XFILLER_161_412 VDD VSS VDD VSS gf180mcu_fd_sc_mcu7t5v0__fillcap_8
XFILLER_106_317 VDD VSS VDD VSS gf180mcu_fd_sc_mcu7t5v0__fillcap_32
X_2618_ _2626_/S VDD VSS _3281_/D _3239_/Q wire94/I VDD VSS gf180mcu_fd_sc_mcu7t5v0__mux2_2
Xclkload82 VDD VSS clkload82/ZN _3435_/CLK VDD VSS gf180mcu_fd_sc_mcu7t5v0__clkinv_8
X_2549_ VDD VSS _2550_/A2 _2549_/A1 _2549_/A2 VDD VSS gf180mcu_fd_sc_mcu7t5v0__nand2_1
XFILLER_248_527 VDD VSS VDD VSS gf180mcu_fd_sc_mcu7t5v0__fillcap_64
XFILLER_85_18 VDD VSS VDD VSS gf180mcu_fd_sc_mcu7t5v0__fillcap_4
XFILLER_55_142 VDD VSS VDD VSS gf180mcu_fd_sc_mcu7t5v0__fillcap_64
XFILLER_216_457 VDD VSS VDD VSS gf180mcu_fd_sc_mcu7t5v0__fillcap_32
XFILLER_70_101 VDD VSS VDD VSS gf180mcu_fd_sc_mcu7t5v0__fillcap_4
XFILLER_243_276 VDD VSS VDD VSS gf180mcu_fd_sc_mcu7t5v0__fillcap_4
XFILLER_231_416 VDD VSS VDD VSS gf180mcu_fd_sc_mcu7t5v0__fillcap_4
XFILLER_203_107 VDD VSS VDD VSS gf180mcu_fd_sc_mcu7t5v0__fillcap_32
XFILLER_188_309 VDD VSS VDD VSS gf180mcu_fd_sc_mcu7t5v0__fillcap_4
XFILLER_70_123 VDD VSS VDD VSS gf180mcu_fd_sc_mcu7t5v0__fillcap_4
XFILLER_212_641 VDD VSS VDD VSS gf180mcu_fd_sc_mcu7t5v0__fillcap_16
Xspi_opentarget_i3c_top_204 irq_o_OE VDD VSS VDD VSS gf180mcu_fd_sc_mcu7t5v0__tieh
XFILLER_52_871 VDD VSS VDD VSS gf180mcu_fd_sc_mcu7t5v0__fillcap_4
XFILLER_11_212 VDD VSS VDD VSS gf180mcu_fd_sc_mcu7t5v0__fillcap_64
Xwire114 VSS wire114/Z wire114/I VDD VDD VSS gf180mcu_fd_sc_mcu7t5v0__buf_2
Xwire147 wire147/Z VSS VDD wire147/I VDD VSS gf180mcu_fd_sc_mcu7t5v0__clkbuf_8
XFILLER_126_2 VDD VSS VDD VSS gf180mcu_fd_sc_mcu7t5v0__fillcap_32
XFILLER_137_453 VDD VSS VDD VSS gf180mcu_fd_sc_mcu7t5v0__fillcap_8
Xwire169 wire169/Z VSS VDD wire170/Z VDD VSS gf180mcu_fd_sc_mcu7t5v0__clkbuf_8
XFILLER_180_710 VDD VSS VDD VSS gf180mcu_fd_sc_mcu7t5v0__fillcap_16
XFILLER_3_422 VDD VSS VDD VSS gf180mcu_fd_sc_mcu7t5v0__fillcap_64
XFILLER_112_309 VDD VSS VDD VSS gf180mcu_fd_sc_mcu7t5v0__fillcap_4
XFILLER_79_702 VDD VSS VDD VSS gf180mcu_fd_sc_mcu7t5v0__fillcap_64
XFILLER_78_201 VDD VSS VDD VSS gf180mcu_fd_sc_mcu7t5v0__fillcap_4
XFILLER_267_836 VDD VSS VDD VSS gf180mcu_fd_sc_mcu7t5v0__fillcap_4
XFILLER_182_53 VDD VSS VDD VSS gf180mcu_fd_sc_mcu7t5v0__fillcap_4
XFILLER_59_492 VDD VSS VDD VSS gf180mcu_fd_sc_mcu7t5v0__fillcap_64
XFILLER_47_632 VDD VSS VDD VSS gf180mcu_fd_sc_mcu7t5v0__fillcap_64
XFILLER_74_451 VDD VSS VDD VSS gf180mcu_fd_sc_mcu7t5v0__fillcap_4
XFILLER_235_766 VDD VSS VDD VSS gf180mcu_fd_sc_mcu7t5v0__fillcap_4
XFILLER_15_562 VDD VSS VDD VSS gf180mcu_fd_sc_mcu7t5v0__fillcap_64
XFILLER_199_191 VDD VSS VDD VSS gf180mcu_fd_sc_mcu7t5v0__fillcap_16
X_1920_ _1924_/S VDD VSS _2974_/D wire123/Z _2974_/Q VDD VSS gf180mcu_fd_sc_mcu7t5v0__mux2_2
XFILLER_30_521 VDD VSS VDD VSS gf180mcu_fd_sc_mcu7t5v0__fillcap_4
XFILLER_42_381 VDD VSS VDD VSS gf180mcu_fd_sc_mcu7t5v0__fillcap_4
XFILLER_91_72 VDD VSS VDD VSS gf180mcu_fd_sc_mcu7t5v0__fillcap_16
X_1851_ _1851_/S VDD VSS _2916_/D _1869_/I0 _2916_/Q VDD VSS gf180mcu_fd_sc_mcu7t5v0__mux2_2
XFILLER_190_518 VDD VSS VDD VSS gf180mcu_fd_sc_mcu7t5v0__fillcap_4
X_1782_ _1786_/S VDD VSS _2856_/D wire133/I _2856_/Q VDD VSS gf180mcu_fd_sc_mcu7t5v0__mux2_2
XFILLER_7_772 VDD VSS VDD VSS gf180mcu_fd_sc_mcu7t5v0__fillcap_64
X_3452_ _3452_/D _3452_/Q _3452_/RN VSS _3452_/CLK VDD VDD VSS gf180mcu_fd_sc_mcu7t5v0__dffrnq_1
X_3383_ _3383_/D _3383_/Q wire161/Z VSS _3394_/CLK VDD VDD VSS gf180mcu_fd_sc_mcu7t5v0__dffrnq_1
X_2403_ _2895_/Q VSS VDD _2879_/Q _2887_/Q _2460_/S0 _2871_/Q _3381_/Q _2403_/Z VDD
+ VSS gf180mcu_fd_sc_mcu7t5v0__mux4_1
XFILLER_41_2 VDD VSS VDD VSS gf180mcu_fd_sc_mcu7t5v0__fillcap_64
X_2334_ VDD VSS _2339_/B _1689_/B _2339_/A2 VDD VSS gf180mcu_fd_sc_mcu7t5v0__nor2_1
XFILLER_170_297 VDD VSS VDD VSS gf180mcu_fd_sc_mcu7t5v0__fillcap_8
XFILLER_69_212 VDD VSS VDD VSS gf180mcu_fd_sc_mcu7t5v0__fillcap_64
XFILLER_97_521 VDD VSS VDD VSS gf180mcu_fd_sc_mcu7t5v0__fillcap_32
XFILLER_257_346 VDD VSS VDD VSS gf180mcu_fd_sc_mcu7t5v0__fillcap_4
XFILLER_123_191 VDD VSS VDD VSS gf180mcu_fd_sc_mcu7t5v0__fillcap_16
X_2265_ _2448_/C VDD VSS _2365_/A3 wire72/Z _1654_/Z VDD VSS gf180mcu_fd_sc_mcu7t5v0__nand3_1
XFILLER_111_386 VDD VSS VDD VSS gf180mcu_fd_sc_mcu7t5v0__fillcap_8
XFILLER_84_226 VDD VSS VDD VSS gf180mcu_fd_sc_mcu7t5v0__fillcap_16
X_2196_ VDD VSS _2197_/B _3148_/Q _2196_/A2 VDD VSS gf180mcu_fd_sc_mcu7t5v0__xor2_1
XFILLER_37_142 VDD VSS VDD VSS gf180mcu_fd_sc_mcu7t5v0__fillcap_64
XFILLER_52_101 VDD VSS VDD VSS gf180mcu_fd_sc_mcu7t5v0__fillcap_4
XFILLER_225_276 VDD VSS VDD VSS gf180mcu_fd_sc_mcu7t5v0__fillcap_4
XFILLER_111_38 VDD VSS VDD VSS gf180mcu_fd_sc_mcu7t5v0__fillcap_4
XFILLER_34_871 VDD VSS VDD VSS gf180mcu_fd_sc_mcu7t5v0__fillcap_4
XFILLER_138_217 VDD VSS VDD VSS gf180mcu_fd_sc_mcu7t5v0__fillcap_4
XFILLER_107_604 VDD VSS VDD VSS gf180mcu_fd_sc_mcu7t5v0__fillcap_16
XFILLER_161_253 VDD VSS VDD VSS gf180mcu_fd_sc_mcu7t5v0__fillcap_8
XFILLER_249_836 VDD VSS VDD VSS gf180mcu_fd_sc_mcu7t5v0__fillcap_4
XFILLER_115_681 VDD VSS VDD VSS gf180mcu_fd_sc_mcu7t5v0__fillcap_16
XFILLER_29_66 VDD VSS VDD VSS gf180mcu_fd_sc_mcu7t5v0__fillcap_4
XFILLER_29_632 VDD VSS VDD VSS gf180mcu_fd_sc_mcu7t5v0__fillcap_64
XFILLER_217_766 VDD VSS VDD VSS gf180mcu_fd_sc_mcu7t5v0__fillcap_4
XFILLER_56_451 VDD VSS VDD VSS gf180mcu_fd_sc_mcu7t5v0__fillcap_4
XFILLER_243_2 VDD VSS VDD VSS gf180mcu_fd_sc_mcu7t5v0__fillcap_64
XFILLER_12_521 VDD VSS VDD VSS gf180mcu_fd_sc_mcu7t5v0__fillcap_4
XFILLER_24_381 VDD VSS VDD VSS gf180mcu_fd_sc_mcu7t5v0__fillcap_4
XFILLER_200_633 VDD VSS VDD VSS gf180mcu_fd_sc_mcu7t5v0__fillcap_32
XFILLER_40_885 VDD VSS VDD VSS gf180mcu_fd_sc_mcu7t5v0__fillcap_4
XFILLER_125_412 VDD VSS VDD VSS gf180mcu_fd_sc_mcu7t5v0__fillcap_8
XFILLER_6_37 VDD VSS VDD VSS gf180mcu_fd_sc_mcu7t5v0__fillcap_64
XFILLER_4_731 VDD VSS VDD VSS gf180mcu_fd_sc_mcu7t5v0__fillcap_4
XFILLER_193_63 VDD VSS VDD VSS gf180mcu_fd_sc_mcu7t5v0__fillcap_4
XFILLER_112_139 VDD VSS VDD VSS gf180mcu_fd_sc_mcu7t5v0__fillcap_8
XFILLER_239_346 VDD VSS VDD VSS gf180mcu_fd_sc_mcu7t5v0__fillcap_4
XFILLER_94_513 VDD VSS VDD VSS gf180mcu_fd_sc_mcu7t5v0__fillcap_8
X_2050_ _2058_/S VDD VSS _3083_/D _3299_/Q _3083_/Q VDD VSS gf180mcu_fd_sc_mcu7t5v0__mux2_2
Xclkbuf_leaf_40_clk_i _2958_/CLK VSS VDD clkload2/I VDD VSS gf180mcu_fd_sc_mcu7t5v0__clkbuf_2
XFILLER_19_142 VDD VSS VDD VSS gf180mcu_fd_sc_mcu7t5v0__fillcap_64
XFILLER_34_101 VDD VSS VDD VSS gf180mcu_fd_sc_mcu7t5v0__fillcap_4
XFILLER_16_871 VDD VSS VDD VSS gf180mcu_fd_sc_mcu7t5v0__fillcap_4
X_2952_ VDD _2952_/Q _3150_/CLK VSS _2952_/D VDD VSS gf180mcu_fd_sc_mcu7t5v0__dffq_1
XFILLER_222_279 VDD VSS VDD VSS gf180mcu_fd_sc_mcu7t5v0__fillcap_4
Xclkbuf_leaf_55_clk_i _3021_/CLK VSS VDD clkload2/I VDD VSS gf180mcu_fd_sc_mcu7t5v0__clkbuf_2
X_1903_ _1907_/S VDD VSS _2960_/D _3178_/Q _2960_/Q VDD VSS gf180mcu_fd_sc_mcu7t5v0__mux2_2
X_2883_ VDD _2883_/Q _2900_/CLK VSS _2883_/D VDD VSS gf180mcu_fd_sc_mcu7t5v0__dffq_1
XFILLER_31_874 VDD VSS VDD VSS gf180mcu_fd_sc_mcu7t5v0__fillcap_16
XFILLER_89_2 VDD VSS VDD VSS gf180mcu_fd_sc_mcu7t5v0__fillcap_8
X_1834_ VDD VSS _1842_/S _1500_/Z _1861_/A2 VDD VSS gf180mcu_fd_sc_mcu7t5v0__nand2_1
X_1765_ _1768_/S VDD VSS _2841_/D wire132/Z _2841_/Q VDD VSS gf180mcu_fd_sc_mcu7t5v0__mux2_2
XFILLER_190_304 VDD VSS VDD VSS gf180mcu_fd_sc_mcu7t5v0__fillcap_8
X_3435_ VSS _3435_/CLK VDD _3435_/D wire55/I wire161/I VDD VSS gf180mcu_fd_sc_mcu7t5v0__dffsnq_1
XFILLER_171_562 VDD VSS VDD VSS gf180mcu_fd_sc_mcu7t5v0__fillcap_4
X_1696_ _3201_/Q VDD VSS _1696_/Z _3200_/Q _3202_/Q VDD VSS gf180mcu_fd_sc_mcu7t5v0__and3_1
XFILLER_104_629 VDD VSS VDD VSS gf180mcu_fd_sc_mcu7t5v0__fillcap_4
XFILLER_171_595 VDD VSS VDD VSS gf180mcu_fd_sc_mcu7t5v0__fillcap_16
X_3366_ _3366_/D _3366_/Q _3403_/RN VSS _3403_/CLK VDD VDD VSS gf180mcu_fd_sc_mcu7t5v0__dffrnq_1
XFILLER_98_885 VDD VSS VDD VSS gf180mcu_fd_sc_mcu7t5v0__fillcap_4
XFILLER_253_66 VDD VSS VDD VSS gf180mcu_fd_sc_mcu7t5v0__fillcap_4
X_2317_ _2318_/A3 VDD VSS _2319_/B _2314_/Z _2318_/A2 VDD VSS gf180mcu_fd_sc_mcu7t5v0__and3_1
XFILLER_112_695 VDD VSS VDD VSS gf180mcu_fd_sc_mcu7t5v0__fillcap_32
X_3297_ _3297_/D _3297_/Q _3335_/RN VSS _3329_/CLK VDD VDD VSS gf180mcu_fd_sc_mcu7t5v0__dffrnq_1
X_2248_ _2868_/Q VSS VDD _2852_/Q _2860_/Q wire78/Z _2844_/Q wire76/Z _2248_/Z VDD
+ VSS gf180mcu_fd_sc_mcu7t5v0__mux4_1
XFILLER_38_451 VDD VSS VDD VSS gf180mcu_fd_sc_mcu7t5v0__fillcap_4
X_2179_ VDD _2179_/B _3348_/D _3141_/D _2179_/A1 VSS VDD VSS gf180mcu_fd_sc_mcu7t5v0__oai21_1
XFILLER_179_673 VDD VSS VDD VSS gf180mcu_fd_sc_mcu7t5v0__fillcap_16
XFILLER_22_885 VDD VSS VDD VSS gf180mcu_fd_sc_mcu7t5v0__fillcap_4
XFILLER_193_142 VDD VSS VDD VSS gf180mcu_fd_sc_mcu7t5v0__fillcap_32
XFILLER_190_871 VDD VSS VDD VSS gf180mcu_fd_sc_mcu7t5v0__fillcap_4
XFILLER_89_874 VDD VSS VDD VSS gf180mcu_fd_sc_mcu7t5v0__fillcap_16
XFILLER_209_508 VDD VSS VDD VSS gf180mcu_fd_sc_mcu7t5v0__fillcap_8
XFILLER_103_695 VDD VSS VDD VSS gf180mcu_fd_sc_mcu7t5v0__fillcap_4
XFILLER_16_101 VDD VSS VDD VSS gf180mcu_fd_sc_mcu7t5v0__fillcap_4
XFILLER_205_736 VDD VSS VDD VSS gf180mcu_fd_sc_mcu7t5v0__fillcap_32
XFILLER_204_224 VDD VSS VDD VSS gf180mcu_fd_sc_mcu7t5v0__fillcap_16
XFILLER_72_52 VDD VSS VDD VSS gf180mcu_fd_sc_mcu7t5v0__fillcap_4
XFILLER_188_30 VDD VSS VDD VSS gf180mcu_fd_sc_mcu7t5v0__fillcap_4
XFILLER_197_492 VDD VSS VDD VSS gf180mcu_fd_sc_mcu7t5v0__fillcap_16
XFILLER_13_874 VDD VSS VDD VSS gf180mcu_fd_sc_mcu7t5v0__fillcap_16
XFILLER_8_311 VDD VSS VDD VSS gf180mcu_fd_sc_mcu7t5v0__fillcap_4
X_1550_ _1550_/B1 _3342_/Q VDD VSS _1551_/B _3343_/Q _3191_/Q VDD VSS gf180mcu_fd_sc_mcu7t5v0__aoi22_1
X_1481_ VDD VSS _1487_/A2 _3421_/Q _1485_/A2 VDD VSS gf180mcu_fd_sc_mcu7t5v0__nor2_1
X_3220_ _3220_/D _3220_/Q _3455_/RN VSS _3450_/CLK VDD VDD VSS gf180mcu_fd_sc_mcu7t5v0__dffrnq_1
X_3151_ _3151_/D _3459_/D wire163/I VSS _3463_/CLK VDD VDD VSS gf180mcu_fd_sc_mcu7t5v0__dffrnq_1
X_2102_ _2100_/B _2101_/Z _2110_/A2 VDD VSS _3109_/D _2113_/A1 _2115_/C VDD VSS gf180mcu_fd_sc_mcu7t5v0__oai32_1
XFILLER_121_481 VDD VSS VDD VSS gf180mcu_fd_sc_mcu7t5v0__fillcap_8
XFILLER_121_492 VDD VSS VDD VSS gf180mcu_fd_sc_mcu7t5v0__fillcap_16
XFILLER_94_387 VDD VSS VDD VSS gf180mcu_fd_sc_mcu7t5v0__fillcap_32
XFILLER_82_527 VDD VSS VDD VSS gf180mcu_fd_sc_mcu7t5v0__fillcap_64
X_3082_ _3082_/D _3082_/Q wire169/Z VSS _3448_/CLK VDD VDD VSS gf180mcu_fd_sc_mcu7t5v0__dffrnq_1
XFILLER_223_500 VDD VSS VDD VSS gf180mcu_fd_sc_mcu7t5v0__fillcap_4
X_2033_ _2060_/S VDD VSS _3066_/D wire92/I _3066_/Q VDD VSS gf180mcu_fd_sc_mcu7t5v0__mux2_2
XFILLER_251_842 VDD VSS VDD VSS gf180mcu_fd_sc_mcu7t5v0__fillcap_32
XFILLER_90_560 VDD VSS VDD VSS gf180mcu_fd_sc_mcu7t5v0__fillcap_32
XFILLER_50_457 VDD VSS VDD VSS gf180mcu_fd_sc_mcu7t5v0__fillcap_64
X_2935_ VDD _2935_/Q _2963_/CLK VSS _2935_/D VDD VSS gf180mcu_fd_sc_mcu7t5v0__dffq_1
X_2866_ VDD _2866_/Q _2867_/CLK VSS _2866_/D VDD VSS gf180mcu_fd_sc_mcu7t5v0__dffq_1
XFILLER_175_142 VDD VSS VDD VSS gf180mcu_fd_sc_mcu7t5v0__fillcap_64
XFILLER_175_120 VDD VSS VDD VSS gf180mcu_fd_sc_mcu7t5v0__fillcap_16
X_1817_ _1823_/S VDD VSS _2886_/D _1863_/I0 _2886_/Q VDD VSS gf180mcu_fd_sc_mcu7t5v0__mux2_2
X_2797_ wire20/Z _3092_/Q VDD VSS _2798_/I _3340_/Q _2739_/S VDD VSS gf180mcu_fd_sc_mcu7t5v0__aoi22_1
X_1748_ _1748_/S VDD VSS _2828_/D _2828_/Q _3126_/Q VDD VSS gf180mcu_fd_sc_mcu7t5v0__mux2_2
XFILLER_172_871 VDD VSS VDD VSS gf180mcu_fd_sc_mcu7t5v0__fillcap_4
XFILLER_89_104 VDD VSS VDD VSS gf180mcu_fd_sc_mcu7t5v0__fillcap_16
X_1679_ _2363_/B2 VDD VSS _2269_/A1 _3192_/Q _3194_/Q VDD VSS gf180mcu_fd_sc_mcu7t5v0__nand3_1
XFILLER_131_212 VDD VSS VDD VSS gf180mcu_fd_sc_mcu7t5v0__fillcap_4
X_3418_ _3418_/D _3443_/D wire161/I VSS _3427_/CLK VDD VDD VSS gf180mcu_fd_sc_mcu7t5v0__dffrnq_1
X_3349_ _3349_/D _3349_/Q wire151/Z VSS _3349_/CLK VDD VDD VSS gf180mcu_fd_sc_mcu7t5v0__dffrnq_1
XFILLER_86_877 VDD VSS VDD VSS gf180mcu_fd_sc_mcu7t5v0__fillcap_8
XFILLER_241_352 VDD VSS VDD VSS gf180mcu_fd_sc_mcu7t5v0__fillcap_64
XFILLER_198_234 VDD VSS VDD VSS gf180mcu_fd_sc_mcu7t5v0__fillcap_4
XFILLER_201_205 VDD VSS VDD VSS gf180mcu_fd_sc_mcu7t5v0__fillcap_4
XFILLER_167_632 VDD VSS VDD VSS gf180mcu_fd_sc_mcu7t5v0__fillcap_64
XFILLER_179_492 VDD VSS VDD VSS gf180mcu_fd_sc_mcu7t5v0__fillcap_8
Xmax_length40 _1942_/S VSS VDD _1944_/S VDD VSS gf180mcu_fd_sc_mcu7t5v0__clkbuf_3
Xmax_length51 _2619_/S wire46/I VDD VSS VDD VSS gf180mcu_fd_sc_mcu7t5v0__buf_4
Xmax_length73 VSS _2459_/A1 _3383_/Q VDD VDD VSS gf180mcu_fd_sc_mcu7t5v0__buf_2
XFILLER_194_462 VDD VSS VDD VSS gf180mcu_fd_sc_mcu7t5v0__fillcap_16
XFILLER_10_877 VDD VSS VDD VSS gf180mcu_fd_sc_mcu7t5v0__fillcap_8
Xmax_length62 VSS _2741_/S1 _2742_/S1 VDD VDD VSS gf180mcu_fd_sc_mcu7t5v0__buf_2
Xclkbuf_4_13_0_host_clk_i _3403_/CLK VSS VDD clkbuf_0_host_clk_i/Z VDD VSS gf180mcu_fd_sc_mcu7t5v0__clkbuf_2
XFILLER_206_2 VDD VSS VDD VSS gf180mcu_fd_sc_mcu7t5v0__fillcap_8
XFILLER_107_253 VDD VSS VDD VSS gf180mcu_fd_sc_mcu7t5v0__fillcap_8
XFILLER_123_702 VDD VSS VDD VSS gf180mcu_fd_sc_mcu7t5v0__fillcap_64
XFILLER_150_521 VDD VSS VDD VSS gf180mcu_fd_sc_mcu7t5v0__fillcap_4
XFILLER_76_387 VDD VSS VDD VSS gf180mcu_fd_sc_mcu7t5v0__fillcap_64
XFILLER_205_500 VDD VSS VDD VSS gf180mcu_fd_sc_mcu7t5v0__fillcap_4
XFILLER_64_527 VDD VSS VDD VSS gf180mcu_fd_sc_mcu7t5v0__fillcap_64
XFILLER_233_842 VDD VSS VDD VSS gf180mcu_fd_sc_mcu7t5v0__fillcap_32
XFILLER_91_368 VDD VSS VDD VSS gf180mcu_fd_sc_mcu7t5v0__fillcap_4
XFILLER_260_661 VDD VSS VDD VSS gf180mcu_fd_sc_mcu7t5v0__fillcap_4
XFILLER_199_62 VDD VSS VDD VSS gf180mcu_fd_sc_mcu7t5v0__fillcap_8
XFILLER_220_503 VDD VSS VDD VSS gf180mcu_fd_sc_mcu7t5v0__fillcap_4
XFILLER_32_457 VDD VSS VDD VSS gf180mcu_fd_sc_mcu7t5v0__fillcap_64
X_2720_ _2720_/B _2732_/C VDD VSS _2724_/B wire59/Z _2720_/A2 VDD VSS gf180mcu_fd_sc_mcu7t5v0__oai211_1
XFILLER_201_772 VDD VSS VDD VSS gf180mcu_fd_sc_mcu7t5v0__fillcap_64
XFILLER_157_142 VDD VSS VDD VSS gf180mcu_fd_sc_mcu7t5v0__fillcap_4
XFILLER_172_101 VDD VSS VDD VSS gf180mcu_fd_sc_mcu7t5v0__fillcap_4
X_2651_ VDD VSS _2653_/B _2654_/A3 _2706_/A4 VDD VSS gf180mcu_fd_sc_mcu7t5v0__nor2_1
X_1602_ VDD VSS _1604_/A2 _3386_/Q _3377_/D VDD VSS gf180mcu_fd_sc_mcu7t5v0__xnor2_1
XFILLER_154_871 VDD VSS VDD VSS gf180mcu_fd_sc_mcu7t5v0__fillcap_4
XFILLER_218_69 VDD VSS VDD VSS gf180mcu_fd_sc_mcu7t5v0__fillcap_8
X_2582_ wire12/I VDD VSS _3250_/D _3242_/Q _3250_/Q VDD VSS gf180mcu_fd_sc_mcu7t5v0__mux2_2
X_1533_ _1704_/A3 VDD VSS _2488_/B _3362_/Q _2469_/A1 VDD VSS gf180mcu_fd_sc_mcu7t5v0__nor3_1
XFILLER_113_212 VDD VSS VDD VSS gf180mcu_fd_sc_mcu7t5v0__fillcap_4
X_1464_ VDD VSS _1879_/A2 _3408_/Q _1469_/A2 VDD VSS gf180mcu_fd_sc_mcu7t5v0__nand2_1
XFILLER_268_750 VDD VSS VDD VSS gf180mcu_fd_sc_mcu7t5v0__fillcap_32
X_3203_ _3203_/D _3203_/Q _3344_/RN VSS _3211_/CLK VDD VDD VSS gf180mcu_fd_sc_mcu7t5v0__dffrnq_1
X_1395_ VDD VSS _2804_/Q _1689_/C VDD VSS gf180mcu_fd_sc_mcu7t5v0__clkinv_1
XFILLER_255_422 VDD VSS VDD VSS gf180mcu_fd_sc_mcu7t5v0__fillcap_64
XFILLER_267_282 VDD VSS VDD VSS gf180mcu_fd_sc_mcu7t5v0__fillcap_64
X_3134_ _3134_/D _3134_/Q wire151/Z VSS _3166_/CLK VDD VDD VSS gf180mcu_fd_sc_mcu7t5v0__dffrnq_1
XFILLER_68_877 VDD VSS VDD VSS gf180mcu_fd_sc_mcu7t5v0__fillcap_8
XFILLER_95_674 VDD VSS VDD VSS gf180mcu_fd_sc_mcu7t5v0__fillcap_16
X_3065_ _3065_/D _3065_/Q wire145/Z VSS _3181_/CLK VDD VDD VSS gf180mcu_fd_sc_mcu7t5v0__dffrnq_1
XFILLER_83_836 VDD VSS VDD VSS gf180mcu_fd_sc_mcu7t5v0__fillcap_4
X_2016_ _2018_/S VDD VSS _3058_/D wire116/Z _3058_/Q VDD VSS gf180mcu_fd_sc_mcu7t5v0__mux2_2
XFILLER_250_171 VDD VSS VDD VSS gf180mcu_fd_sc_mcu7t5v0__fillcap_4
XFILLER_51_766 VDD VSS VDD VSS gf180mcu_fd_sc_mcu7t5v0__fillcap_4
XFILLER_149_632 VDD VSS VDD VSS gf180mcu_fd_sc_mcu7t5v0__fillcap_8
XFILLER_10_107 VDD VSS VDD VSS gf180mcu_fd_sc_mcu7t5v0__fillcap_64
X_2918_ VDD _2918_/Q _2931_/CLK VSS _2918_/D VDD VSS gf180mcu_fd_sc_mcu7t5v0__dffq_1
XFILLER_149_687 VDD VSS VDD VSS gf180mcu_fd_sc_mcu7t5v0__fillcap_8
Xmax_length108 VSS _2484_/A1 _3206_/Q VDD VDD VSS gf180mcu_fd_sc_mcu7t5v0__buf_2
X_2849_ VDD _2849_/Q _2914_/CLK VSS _2849_/D VDD VSS gf180mcu_fd_sc_mcu7t5v0__dffq_1
XFILLER_117_562 VDD VSS VDD VSS gf180mcu_fd_sc_mcu7t5v0__fillcap_16
XFILLER_105_702 VDD VSS VDD VSS gf180mcu_fd_sc_mcu7t5v0__fillcap_64
XFILLER_2_317 VDD VSS VDD VSS gf180mcu_fd_sc_mcu7t5v0__fillcap_64
XFILLER_160_885 VDD VSS VDD VSS gf180mcu_fd_sc_mcu7t5v0__fillcap_4
XFILLER_259_772 VDD VSS VDD VSS gf180mcu_fd_sc_mcu7t5v0__fillcap_64
XFILLER_219_647 VDD VSS VDD VSS gf180mcu_fd_sc_mcu7t5v0__fillcap_32
XFILLER_100_451 VDD VSS VDD VSS gf180mcu_fd_sc_mcu7t5v0__fillcap_4
XFILLER_58_387 VDD VSS VDD VSS gf180mcu_fd_sc_mcu7t5v0__fillcap_64
XFILLER_46_527 VDD VSS VDD VSS gf180mcu_fd_sc_mcu7t5v0__fillcap_64
XFILLER_85_162 VDD VSS VDD VSS gf180mcu_fd_sc_mcu7t5v0__fillcap_32
XFILLER_160_78 VDD VSS VDD VSS gf180mcu_fd_sc_mcu7t5v0__fillcap_16
XFILLER_230_801 VDD VSS VDD VSS gf180mcu_fd_sc_mcu7t5v0__fillcap_4
XFILLER_215_842 VDD VSS VDD VSS gf180mcu_fd_sc_mcu7t5v0__fillcap_32
XFILLER_242_661 VDD VSS VDD VSS gf180mcu_fd_sc_mcu7t5v0__fillcap_4
XFILLER_156_2 VDD VSS VDD VSS gf180mcu_fd_sc_mcu7t5v0__fillcap_32
XFILLER_14_457 VDD VSS VDD VSS gf180mcu_fd_sc_mcu7t5v0__fillcap_64
XFILLER_41_276 VDD VSS VDD VSS gf180mcu_fd_sc_mcu7t5v0__fillcap_4
XFILLER_139_142 VDD VSS VDD VSS gf180mcu_fd_sc_mcu7t5v0__fillcap_64
XFILLER_170_605 VDD VSS VDD VSS gf180mcu_fd_sc_mcu7t5v0__fillcap_4
XFILLER_136_871 VDD VSS VDD VSS gf180mcu_fd_sc_mcu7t5v0__fillcap_4
XFILLER_6_667 VDD VSS VDD VSS gf180mcu_fd_sc_mcu7t5v0__fillcap_64
XFILLER_170_638 VDD VSS VDD VSS gf180mcu_fd_sc_mcu7t5v0__fillcap_16
XFILLER_123_543 VDD VSS VDD VSS gf180mcu_fd_sc_mcu7t5v0__fillcap_16
XFILLER_151_874 VDD VSS VDD VSS gf180mcu_fd_sc_mcu7t5v0__fillcap_16
XFILLER_68_107 VDD VSS VDD VSS gf180mcu_fd_sc_mcu7t5v0__fillcap_64
XFILLER_78_95 VDD VSS VDD VSS gf180mcu_fd_sc_mcu7t5v0__fillcap_8
XFILLER_237_422 VDD VSS VDD VSS gf180mcu_fd_sc_mcu7t5v0__fillcap_64
XFILLER_249_282 VDD VSS VDD VSS gf180mcu_fd_sc_mcu7t5v0__fillcap_64
XFILLER_209_135 VDD VSS VDD VSS gf180mcu_fd_sc_mcu7t5v0__fillcap_4
XFILLER_264_241 VDD VSS VDD VSS gf180mcu_fd_sc_mcu7t5v0__fillcap_4
XFILLER_65_836 VDD VSS VDD VSS gf180mcu_fd_sc_mcu7t5v0__fillcap_4
XFILLER_77_696 VDD VSS VDD VSS gf180mcu_fd_sc_mcu7t5v0__fillcap_4
XFILLER_205_330 VDD VSS VDD VSS gf180mcu_fd_sc_mcu7t5v0__fillcap_16
XFILLER_205_352 VDD VSS VDD VSS gf180mcu_fd_sc_mcu7t5v0__fillcap_64
XFILLER_220_48 VDD VSS VDD VSS gf180mcu_fd_sc_mcu7t5v0__fillcap_16
XFILLER_220_311 VDD VSS VDD VSS gf180mcu_fd_sc_mcu7t5v0__fillcap_4
XFILLER_232_171 VDD VSS VDD VSS gf180mcu_fd_sc_mcu7t5v0__fillcap_4
XFILLER_33_766 VDD VSS VDD VSS gf180mcu_fd_sc_mcu7t5v0__fillcap_4
XFILLER_192_218 VDD VSS VDD VSS gf180mcu_fd_sc_mcu7t5v0__fillcap_16
X_2703_ _2703_/A3 _2703_/A4 VDD VSS wire20/I _3277_/Q _2020_/B VDD VSS gf180mcu_fd_sc_mcu7t5v0__nor4_2
X_2634_ _2642_/S VDD VSS _3297_/D _3255_/Q _3297_/Q VDD VSS gf180mcu_fd_sc_mcu7t5v0__mux2_2
X_2565_ _2565_/S VDD VSS _3234_/D _3219_/Q _3234_/Q VDD VSS gf180mcu_fd_sc_mcu7t5v0__mux2_2
X_1516_ _3174_/Q VDD VSS _1516_/Z _1519_/A1 _1519_/B VDD VSS gf180mcu_fd_sc_mcu7t5v0__and3_1
XFILLER_142_885 VDD VSS VDD VSS gf180mcu_fd_sc_mcu7t5v0__fillcap_4
XFILLER_87_416 VDD VSS VDD VSS gf180mcu_fd_sc_mcu7t5v0__fillcap_4
X_2496_ VDD VSS _2530_/A3 _3448_/Q _2549_/A2 VDD VSS gf180mcu_fd_sc_mcu7t5v0__nand2_1
XFILLER_99_298 VDD VSS VDD VSS gf180mcu_fd_sc_mcu7t5v0__fillcap_4
X_1447_ VDD VSS _3420_/Q _1459_/A1 VDD VSS gf180mcu_fd_sc_mcu7t5v0__clkinv_1
XFILLER_256_731 VDD VSS VDD VSS gf180mcu_fd_sc_mcu7t5v0__fillcap_4
XFILLER_268_580 VDD VSS VDD VSS gf180mcu_fd_sc_mcu7t5v0__fillcap_32
XFILLER_261_66 VDD VSS VDD VSS gf180mcu_fd_sc_mcu7t5v0__fillcap_4
X_3117_ _3117_/D _3117_/Q _3359_/RN VSS _3192_/CLK VDD VDD VSS gf180mcu_fd_sc_mcu7t5v0__dffrnq_1
XFILLER_28_527 VDD VSS VDD VSS gf180mcu_fd_sc_mcu7t5v0__fillcap_64
XFILLER_55_346 VDD VSS VDD VSS gf180mcu_fd_sc_mcu7t5v0__fillcap_4
X_3048_ VDD _3048_/Q _3058_/CLK VSS _3048_/D VDD VSS gf180mcu_fd_sc_mcu7t5v0__dffq_1
XFILLER_212_801 VDD VSS VDD VSS gf180mcu_fd_sc_mcu7t5v0__fillcap_4
XFILLER_224_661 VDD VSS VDD VSS gf180mcu_fd_sc_mcu7t5v0__fillcap_4
XFILLER_130_37 VDD VSS VDD VSS gf180mcu_fd_sc_mcu7t5v0__fillcap_64
XFILLER_11_416 VDD VSS VDD VSS gf180mcu_fd_sc_mcu7t5v0__fillcap_4
XFILLER_23_276 VDD VSS VDD VSS gf180mcu_fd_sc_mcu7t5v0__fillcap_4
XFILLER_136_101 VDD VSS VDD VSS gf180mcu_fd_sc_mcu7t5v0__fillcap_4
XFILLER_136_123 VDD VSS VDD VSS gf180mcu_fd_sc_mcu7t5v0__fillcap_8
XFILLER_164_443 VDD VSS VDD VSS gf180mcu_fd_sc_mcu7t5v0__fillcap_8
XFILLER_3_626 VDD VSS VDD VSS gf180mcu_fd_sc_mcu7t5v0__fillcap_4
XFILLER_118_871 VDD VSS VDD VSS gf180mcu_fd_sc_mcu7t5v0__fillcap_4
XFILLER_133_874 VDD VSS VDD VSS gf180mcu_fd_sc_mcu7t5v0__fillcap_16
XFILLER_219_422 VDD VSS VDD VSS gf180mcu_fd_sc_mcu7t5v0__fillcap_4
XFILLER_246_241 VDD VSS VDD VSS gf180mcu_fd_sc_mcu7t5v0__fillcap_4
XFILLER_171_66 VDD VSS VDD VSS gf180mcu_fd_sc_mcu7t5v0__fillcap_4
XFILLER_47_836 VDD VSS VDD VSS gf180mcu_fd_sc_mcu7t5v0__fillcap_4
XFILLER_59_696 VDD VSS VDD VSS gf180mcu_fd_sc_mcu7t5v0__fillcap_4
XFILLER_0_28 VDD VSS VDD VSS gf180mcu_fd_sc_mcu7t5v0__fillcap_4
XFILLER_15_766 VDD VSS VDD VSS gf180mcu_fd_sc_mcu7t5v0__fillcap_4
XFILLER_120_92 VDD VSS VDD VSS gf180mcu_fd_sc_mcu7t5v0__fillcap_8
XFILLER_196_85 VDD VSS VDD VSS gf180mcu_fd_sc_mcu7t5v0__fillcap_16
XFILLER_127_189 VDD VSS VDD VSS gf180mcu_fd_sc_mcu7t5v0__fillcap_4
XFILLER_89_72 VDD VSS VDD VSS gf180mcu_fd_sc_mcu7t5v0__fillcap_32
X_2350_ _2490_/B VDD VSS _2351_/B _2480_/A3 _2351_/A2 VDD VSS gf180mcu_fd_sc_mcu7t5v0__aoi21_1
XFILLER_69_416 VDD VSS VDD VSS gf180mcu_fd_sc_mcu7t5v0__fillcap_4
XFILLER_124_885 VDD VSS VDD VSS gf180mcu_fd_sc_mcu7t5v0__fillcap_4
X_2281_ VDD VSS _2282_/B _3176_/Q _2288_/S VDD VSS gf180mcu_fd_sc_mcu7t5v0__nor2_1
XFILLER_238_731 VDD VSS VDD VSS gf180mcu_fd_sc_mcu7t5v0__fillcap_4
XFILLER_37_346 VDD VSS VDD VSS gf180mcu_fd_sc_mcu7t5v0__fillcap_4
XFILLER_206_661 VDD VSS VDD VSS gf180mcu_fd_sc_mcu7t5v0__fillcap_4
X_1996_ _2000_/S VDD VSS _3040_/D wire119/Z _3040_/Q VDD VSS gf180mcu_fd_sc_mcu7t5v0__mux2_2
Xclkload61 VSS clkload61/Z _3344_/CLK VDD VDD VSS gf180mcu_fd_sc_mcu7t5v0__clkbuf_1
Xclkload50 VSS clkload50/Z _3348_/CLK VDD VDD VSS gf180mcu_fd_sc_mcu7t5v0__clkbuf_1
XFILLER_118_189 VDD VSS VDD VSS gf180mcu_fd_sc_mcu7t5v0__fillcap_16
Xclkload72 VSS clkload72/Z _3394_/CLK VDD VDD VSS gf180mcu_fd_sc_mcu7t5v0__clkbuf_1
X_2617_ _2625_/S VDD VSS _3280_/D _3238_/Q wire95/I VDD VSS gf180mcu_fd_sc_mcu7t5v0__mux2_2
Xclkload83 VSS clkload83/ZN _2914_/CLK VDD VDD VSS gf180mcu_fd_sc_mcu7t5v0__inv_2
XFILLER_114_351 VDD VSS VDD VSS gf180mcu_fd_sc_mcu7t5v0__fillcap_16
XFILLER_115_874 VDD VSS VDD VSS gf180mcu_fd_sc_mcu7t5v0__fillcap_16
X_2548_ VDD _2548_/B _2550_/A1 _3223_/D _2546_/B VSS VDD VSS gf180mcu_fd_sc_mcu7t5v0__oai21_1
X_2479_ VDD VSS _3207_/D _2320_/B _2479_/A2 VDD VSS gf180mcu_fd_sc_mcu7t5v0__nand2_1
XFILLER_130_877 VDD VSS VDD VSS gf180mcu_fd_sc_mcu7t5v0__fillcap_8
XFILLER_228_241 VDD VSS VDD VSS gf180mcu_fd_sc_mcu7t5v0__fillcap_4
XFILLER_29_836 VDD VSS VDD VSS gf180mcu_fd_sc_mcu7t5v0__fillcap_4
XFILLER_216_403 VDD VSS VDD VSS gf180mcu_fd_sc_mcu7t5v0__fillcap_4
Xspi_opentarget_i3c_top_205 sda_pad_IE VDD VSS VDD VSS gf180mcu_fd_sc_mcu7t5v0__tieh
XFILLER_184_527 VDD VSS VDD VSS gf180mcu_fd_sc_mcu7t5v0__fillcap_64
Xwire104 VSS wire104/Z wire105/Z VDD VDD VSS gf180mcu_fd_sc_mcu7t5v0__clkbuf_1
XFILLER_196_387 VDD VSS VDD VSS gf180mcu_fd_sc_mcu7t5v0__fillcap_4
Xwire137 VSS wire137/Z _3119_/Q VDD VDD VSS gf180mcu_fd_sc_mcu7t5v0__buf_2
Xwire126 wire126/Z VSS VDD _3175_/Q VDD VSS gf180mcu_fd_sc_mcu7t5v0__clkbuf_2
XFILLER_137_410 VDD VSS VDD VSS gf180mcu_fd_sc_mcu7t5v0__fillcap_8
Xclkload0 VDD clkload0/ZN clkload0/I VSS VDD VSS gf180mcu_fd_sc_mcu7t5v0__clkinv_3
XFILLER_7_206 VDD VSS VDD VSS gf180mcu_fd_sc_mcu7t5v0__fillcap_4
XFILLER_109_123 VDD VSS VDD VSS gf180mcu_fd_sc_mcu7t5v0__fillcap_16
XFILLER_166_22 VDD VSS VDD VSS gf180mcu_fd_sc_mcu7t5v0__fillcap_8
XFILLER_119_2 VDD VSS VDD VSS gf180mcu_fd_sc_mcu7t5v0__fillcap_8
XFILLER_106_885 VDD VSS VDD VSS gf180mcu_fd_sc_mcu7t5v0__fillcap_4
XFILLER_120_387 VDD VSS VDD VSS gf180mcu_fd_sc_mcu7t5v0__fillcap_8
XFILLER_19_346 VDD VSS VDD VSS gf180mcu_fd_sc_mcu7t5v0__fillcap_4
XFILLER_250_737 VDD VSS VDD VSS gf180mcu_fd_sc_mcu7t5v0__fillcap_64
XFILLER_262_597 VDD VSS VDD VSS gf180mcu_fd_sc_mcu7t5v0__fillcap_64
XFILLER_148_708 VDD VSS VDD VSS gf180mcu_fd_sc_mcu7t5v0__fillcap_16
XFILLER_188_877 VDD VSS VDD VSS gf180mcu_fd_sc_mcu7t5v0__fillcap_8
X_1850_ _1851_/S VDD VSS _2915_/D wire128/Z _2915_/Q VDD VSS gf180mcu_fd_sc_mcu7t5v0__mux2_2
XFILLER_168_590 VDD VSS VDD VSS gf180mcu_fd_sc_mcu7t5v0__fillcap_4
X_1781_ _1786_/S VDD VSS _2855_/D _1864_/I0 _2855_/Q VDD VSS gf180mcu_fd_sc_mcu7t5v0__mux2_2
XFILLER_171_766 VDD VSS VDD VSS gf180mcu_fd_sc_mcu7t5v0__fillcap_4
XFILLER_115_148 VDD VSS VDD VSS gf180mcu_fd_sc_mcu7t5v0__fillcap_32
X_3451_ input5/Z _3451_/Q _3452_/RN VSS _3451_/CLK VDD VDD VSS gf180mcu_fd_sc_mcu7t5v0__dffrnq_1
X_3382_ _3382_/D _3382_/Q _3458_/RN VSS _3394_/CLK VDD VDD VSS gf180mcu_fd_sc_mcu7t5v0__dffrnq_1
X_2402_ VDD VSS _2405_/A2 _2459_/A1 _2401_/Z VDD VSS gf180mcu_fd_sc_mcu7t5v0__nand2_1
XFILLER_124_660 VDD VSS VDD VSS gf180mcu_fd_sc_mcu7t5v0__fillcap_4
X_2333_ _2333_/A3 _2333_/A4 VDD VSS _2339_/A2 _2485_/A1 _2333_/A2 VDD VSS gf180mcu_fd_sc_mcu7t5v0__nand4_1
XFILLER_34_2 VDD VSS VDD VSS gf180mcu_fd_sc_mcu7t5v0__fillcap_32
XFILLER_111_332 VDD VSS VDD VSS gf180mcu_fd_sc_mcu7t5v0__fillcap_16
XFILLER_112_877 VDD VSS VDD VSS gf180mcu_fd_sc_mcu7t5v0__fillcap_8
X_2264_ _2264_/A3 VDD VSS _2268_/C _2264_/A1 _2264_/A2 VDD VSS gf180mcu_fd_sc_mcu7t5v0__nand3_1
X_2195_ _3148_/Q _2189_/S VDD VSS _2198_/A2 _3146_/Q _3147_/Q VDD VSS gf180mcu_fd_sc_mcu7t5v0__nand4_1
XFILLER_93_772 VDD VSS VDD VSS gf180mcu_fd_sc_mcu7t5v0__fillcap_64
XFILLER_240_247 VDD VSS VDD VSS gf180mcu_fd_sc_mcu7t5v0__fillcap_64
XFILLER_166_527 VDD VSS VDD VSS gf180mcu_fd_sc_mcu7t5v0__fillcap_4
XFILLER_193_379 VDD VSS VDD VSS gf180mcu_fd_sc_mcu7t5v0__fillcap_16
X_1979_ _1981_/S VDD VSS _3026_/D wire116/Z _3026_/Q VDD VSS gf180mcu_fd_sc_mcu7t5v0__mux2_2
XFILLER_134_457 VDD VSS VDD VSS gf180mcu_fd_sc_mcu7t5v0__fillcap_4
XFILLER_161_221 VDD VSS VDD VSS gf180mcu_fd_sc_mcu7t5v0__fillcap_32
XFILLER_161_298 VDD VSS VDD VSS gf180mcu_fd_sc_mcu7t5v0__fillcap_4
XFILLER_264_807 VDD VSS VDD VSS gf180mcu_fd_sc_mcu7t5v0__fillcap_64
XFILLER_102_387 VDD VSS VDD VSS gf180mcu_fd_sc_mcu7t5v0__fillcap_32
XFILLER_88_588 VDD VSS VDD VSS gf180mcu_fd_sc_mcu7t5v0__fillcap_4
XFILLER_71_422 VDD VSS VDD VSS gf180mcu_fd_sc_mcu7t5v0__fillcap_64
XFILLER_189_619 VDD VSS VDD VSS gf180mcu_fd_sc_mcu7t5v0__fillcap_8
XFILLER_83_271 VDD VSS VDD VSS gf180mcu_fd_sc_mcu7t5v0__fillcap_8
XFILLER_83_282 VDD VSS VDD VSS gf180mcu_fd_sc_mcu7t5v0__fillcap_32
XFILLER_232_737 VDD VSS VDD VSS gf180mcu_fd_sc_mcu7t5v0__fillcap_64
XFILLER_244_597 VDD VSS VDD VSS gf180mcu_fd_sc_mcu7t5v0__fillcap_64
XFILLER_188_107 VDD VSS VDD VSS gf180mcu_fd_sc_mcu7t5v0__fillcap_4
XFILLER_45_66 VDD VSS VDD VSS gf180mcu_fd_sc_mcu7t5v0__fillcap_4
XFILLER_212_450 VDD VSS VDD VSS gf180mcu_fd_sc_mcu7t5v0__fillcap_4
XFILLER_236_2 VDD VSS VDD VSS gf180mcu_fd_sc_mcu7t5v0__fillcap_32
XFILLER_101_72 VDD VSS VDD VSS gf180mcu_fd_sc_mcu7t5v0__fillcap_8
XFILLER_200_667 VDD VSS VDD VSS gf180mcu_fd_sc_mcu7t5v0__fillcap_16
XFILLER_185_836 VDD VSS VDD VSS gf180mcu_fd_sc_mcu7t5v0__fillcap_4
XFILLER_169_398 VDD VSS VDD VSS gf180mcu_fd_sc_mcu7t5v0__fillcap_16
XFILLER_177_54 VDD VSS VDD VSS gf180mcu_fd_sc_mcu7t5v0__fillcap_16
XFILLER_153_766 VDD VSS VDD VSS gf180mcu_fd_sc_mcu7t5v0__fillcap_4
XFILLER_180_574 VDD VSS VDD VSS gf180mcu_fd_sc_mcu7t5v0__fillcap_4
XFILLER_112_107 VDD VSS VDD VSS gf180mcu_fd_sc_mcu7t5v0__fillcap_32
XFILLER_140_449 VDD VSS VDD VSS gf180mcu_fd_sc_mcu7t5v0__fillcap_4
XFILLER_126_91 VDD VSS VDD VSS gf180mcu_fd_sc_mcu7t5v0__fillcap_8
XFILLER_121_696 VDD VSS VDD VSS gf180mcu_fd_sc_mcu7t5v0__fillcap_4
XFILLER_266_177 VDD VSS VDD VSS gf180mcu_fd_sc_mcu7t5v0__fillcap_64
XFILLER_254_317 VDD VSS VDD VSS gf180mcu_fd_sc_mcu7t5v0__fillcap_64
XFILLER_75_772 VDD VSS VDD VSS gf180mcu_fd_sc_mcu7t5v0__fillcap_64
XFILLER_90_731 VDD VSS VDD VSS gf180mcu_fd_sc_mcu7t5v0__fillcap_4
X_2951_ VDD _2951_/Q _2963_/CLK VSS _2951_/D VDD VSS gf180mcu_fd_sc_mcu7t5v0__dffq_1
XFILLER_222_247 VDD VSS VDD VSS gf180mcu_fd_sc_mcu7t5v0__fillcap_32
X_1902_ _1907_/S VDD VSS _2959_/D wire122/Z _2959_/Q VDD VSS gf180mcu_fd_sc_mcu7t5v0__mux2_2
XFILLER_31_842 VDD VSS VDD VSS gf180mcu_fd_sc_mcu7t5v0__fillcap_32
X_2882_ VDD _2882_/Q _3370_/CLK VSS _2882_/D VDD VSS gf180mcu_fd_sc_mcu7t5v0__dffq_1
XFILLER_148_527 VDD VSS VDD VSS gf180mcu_fd_sc_mcu7t5v0__fillcap_16
XFILLER_175_335 VDD VSS VDD VSS gf180mcu_fd_sc_mcu7t5v0__fillcap_8
X_1833_ VDD VSS _1861_/A2 _3369_/Q _3370_/Q VDD VSS gf180mcu_fd_sc_mcu7t5v0__nor2_1
X_1764_ _1768_/S VDD VSS _2840_/D wire133/I _2840_/Q VDD VSS gf180mcu_fd_sc_mcu7t5v0__mux2_2
X_3434_ _3434_/D _3434_/Q wire161/I VSS _3434_/CLK VDD VDD VSS gf180mcu_fd_sc_mcu7t5v0__dffrnq_1
X_1695_ VDD VSS _1695_/Z wire110/Z _3199_/Q VDD VSS gf180mcu_fd_sc_mcu7t5v0__and2_1
XFILLER_116_457 VDD VSS VDD VSS gf180mcu_fd_sc_mcu7t5v0__fillcap_16
XFILLER_143_276 VDD VSS VDD VSS gf180mcu_fd_sc_mcu7t5v0__fillcap_4
X_3365_ _3365_/D _3365_/Q _3457_/RN VSS _3365_/CLK VDD VDD VSS gf180mcu_fd_sc_mcu7t5v0__dffrnq_1
XFILLER_97_352 VDD VSS VDD VSS gf180mcu_fd_sc_mcu7t5v0__fillcap_16
XFILLER_258_667 VDD VSS VDD VSS gf180mcu_fd_sc_mcu7t5v0__fillcap_64
XFILLER_246_807 VDD VSS VDD VSS gf180mcu_fd_sc_mcu7t5v0__fillcap_64
X_2316_ _2347_/B _2316_/C VDD VSS _2318_/A3 _1683_/Z _2482_/A2 VDD VSS gf180mcu_fd_sc_mcu7t5v0__oai211_1
X_3296_ _3296_/D _3296_/Q _3336_/RN VSS _3328_/CLK VDD VDD VSS gf180mcu_fd_sc_mcu7t5v0__dffrnq_1
X_2247_ _2274_/C VDD VSS _3171_/D _2247_/A1 _2247_/A2 VDD VSS gf180mcu_fd_sc_mcu7t5v0__aoi21_1
XFILLER_53_422 VDD VSS VDD VSS gf180mcu_fd_sc_mcu7t5v0__fillcap_64
X_2178_ VDD VSS _2179_/B _3178_/Q _3348_/D VDD VSS gf180mcu_fd_sc_mcu7t5v0__nand2_1
XFILLER_65_282 VDD VSS VDD VSS gf180mcu_fd_sc_mcu7t5v0__fillcap_64
XFILLER_214_737 VDD VSS VDD VSS gf180mcu_fd_sc_mcu7t5v0__fillcap_64
XFILLER_226_597 VDD VSS VDD VSS gf180mcu_fd_sc_mcu7t5v0__fillcap_64
XFILLER_241_556 VDD VSS VDD VSS gf180mcu_fd_sc_mcu7t5v0__fillcap_4
XFILLER_194_633 VDD VSS VDD VSS gf180mcu_fd_sc_mcu7t5v0__fillcap_16
XFILLER_167_836 VDD VSS VDD VSS gf180mcu_fd_sc_mcu7t5v0__fillcap_4
XFILLER_21_352 VDD VSS VDD VSS gf180mcu_fd_sc_mcu7t5v0__fillcap_64
XFILLER_194_677 VDD VSS VDD VSS gf180mcu_fd_sc_mcu7t5v0__fillcap_8
XFILLER_193_187 VDD VSS VDD VSS gf180mcu_fd_sc_mcu7t5v0__fillcap_8
XFILLER_119_251 VDD VSS VDD VSS gf180mcu_fd_sc_mcu7t5v0__fillcap_4
XFILLER_135_766 VDD VSS VDD VSS gf180mcu_fd_sc_mcu7t5v0__fillcap_4
XFILLER_1_702 VDD VSS VDD VSS gf180mcu_fd_sc_mcu7t5v0__fillcap_64
XFILLER_89_842 VDD VSS VDD VSS gf180mcu_fd_sc_mcu7t5v0__fillcap_32
XFILLER_248_177 VDD VSS VDD VSS gf180mcu_fd_sc_mcu7t5v0__fillcap_64
XFILLER_236_317 VDD VSS VDD VSS gf180mcu_fd_sc_mcu7t5v0__fillcap_64
XFILLER_263_136 VDD VSS VDD VSS gf180mcu_fd_sc_mcu7t5v0__fillcap_4
XFILLER_186_2 VDD VSS VDD VSS gf180mcu_fd_sc_mcu7t5v0__fillcap_32
XFILLER_57_772 VDD VSS VDD VSS gf180mcu_fd_sc_mcu7t5v0__fillcap_64
XFILLER_84_591 VDD VSS VDD VSS gf180mcu_fd_sc_mcu7t5v0__fillcap_4
XFILLER_72_731 VDD VSS VDD VSS gf180mcu_fd_sc_mcu7t5v0__fillcap_4
XFILLER_204_247 VDD VSS VDD VSS gf180mcu_fd_sc_mcu7t5v0__fillcap_8
XFILLER_71_274 VDD VSS VDD VSS gf180mcu_fd_sc_mcu7t5v0__fillcap_4
XFILLER_185_600 VDD VSS VDD VSS gf180mcu_fd_sc_mcu7t5v0__fillcap_16
XFILLER_13_842 VDD VSS VDD VSS gf180mcu_fd_sc_mcu7t5v0__fillcap_32
XFILLER_157_324 VDD VSS VDD VSS gf180mcu_fd_sc_mcu7t5v0__fillcap_16
XFILLER_40_661 VDD VSS VDD VSS gf180mcu_fd_sc_mcu7t5v0__fillcap_4
XFILLER_200_497 VDD VSS VDD VSS gf180mcu_fd_sc_mcu7t5v0__fillcap_4
XFILLER_125_254 VDD VSS VDD VSS gf180mcu_fd_sc_mcu7t5v0__fillcap_16
X_1480_ VDD VSS _3415_/D _3434_/D _1480_/A2 VDD VSS gf180mcu_fd_sc_mcu7t5v0__xnor2_1
XFILLER_137_90 VDD VSS VDD VSS gf180mcu_fd_sc_mcu7t5v0__fillcap_32
XFILLER_125_298 VDD VSS VDD VSS gf180mcu_fd_sc_mcu7t5v0__fillcap_4
XFILLER_79_352 VDD VSS VDD VSS gf180mcu_fd_sc_mcu7t5v0__fillcap_64
XFILLER_97_72 VDD VSS VDD VSS gf180mcu_fd_sc_mcu7t5v0__fillcap_64
XFILLER_228_807 VDD VSS VDD VSS gf180mcu_fd_sc_mcu7t5v0__fillcap_64
X_3150_ _3150_/D _3456_/D _3457_/RN VSS _3150_/CLK VDD VDD VSS gf180mcu_fd_sc_mcu7t5v0__dffrnq_1
XFILLER_94_311 VDD VSS VDD VSS gf180mcu_fd_sc_mcu7t5v0__fillcap_4
XFILLER_255_626 VDD VSS VDD VSS gf180mcu_fd_sc_mcu7t5v0__fillcap_4
XFILLER_267_486 VDD VSS VDD VSS gf180mcu_fd_sc_mcu7t5v0__fillcap_4
X_2101_ VDD VSS _2101_/Z _3109_/Q _2113_/A3 VDD VSS gf180mcu_fd_sc_mcu7t5v0__or2_1
X_3081_ _3081_/D _3081_/Q _3335_/RN VSS _3329_/CLK VDD VDD VSS gf180mcu_fd_sc_mcu7t5v0__dffrnq_1
X_2032_ _2060_/S VDD VSS _3065_/D wire94/Z _3065_/Q VDD VSS gf180mcu_fd_sc_mcu7t5v0__mux2_2
XFILLER_94_377 VDD VSS VDD VSS gf180mcu_fd_sc_mcu7t5v0__fillcap_8
XFILLER_35_422 VDD VSS VDD VSS gf180mcu_fd_sc_mcu7t5v0__fillcap_64
XFILLER_47_282 VDD VSS VDD VSS gf180mcu_fd_sc_mcu7t5v0__fillcap_64
XFILLER_208_597 VDD VSS VDD VSS gf180mcu_fd_sc_mcu7t5v0__fillcap_64
XFILLER_62_241 VDD VSS VDD VSS gf180mcu_fd_sc_mcu7t5v0__fillcap_4
XFILLER_223_578 VDD VSS VDD VSS gf180mcu_fd_sc_mcu7t5v0__fillcap_4
XFILLER_188_493 VDD VSS VDD VSS gf180mcu_fd_sc_mcu7t5v0__fillcap_4
XFILLER_149_836 VDD VSS VDD VSS gf180mcu_fd_sc_mcu7t5v0__fillcap_4
X_2934_ VDD _2934_/Q _3012_/CLK VSS _2934_/D VDD VSS gf180mcu_fd_sc_mcu7t5v0__dffq_1
X_2865_ VDD _2865_/Q _3369_/CLK VSS _2865_/D VDD VSS gf180mcu_fd_sc_mcu7t5v0__dffq_1
XFILLER_30_171 VDD VSS VDD VSS gf180mcu_fd_sc_mcu7t5v0__fillcap_4
X_1816_ _1823_/S VDD VSS _2885_/D wire137/Z _2885_/Q VDD VSS gf180mcu_fd_sc_mcu7t5v0__mux2_2
X_2796_ VDD VSS _3339_/D _2796_/A1 _2796_/A2 VDD VSS gf180mcu_fd_sc_mcu7t5v0__nand2_1
X_1747_ _1748_/S VDD VSS _2827_/D _2827_/Q _1794_/I1 VDD VSS gf180mcu_fd_sc_mcu7t5v0__mux2_2
XFILLER_190_146 VDD VSS VDD VSS gf180mcu_fd_sc_mcu7t5v0__fillcap_16
XFILLER_117_766 VDD VSS VDD VSS gf180mcu_fd_sc_mcu7t5v0__fillcap_4
X_1678_ _3194_/Q VDD VSS _2362_/A1 _3193_/Q _3192_/Q VDD VSS gf180mcu_fd_sc_mcu7t5v0__nand3_1
XFILLER_117_38 VDD VSS VDD VSS gf180mcu_fd_sc_mcu7t5v0__fillcap_32
X_3417_ _3417_/D _3442_/D wire161/I VSS _3427_/CLK VDD VDD VSS gf180mcu_fd_sc_mcu7t5v0__dffrnq_1
X_3348_ _3348_/D _3348_/Q wire151/Z VSS _3348_/CLK VDD VDD VSS gf180mcu_fd_sc_mcu7t5v0__dffrnq_1
XFILLER_98_661 VDD VSS VDD VSS gf180mcu_fd_sc_mcu7t5v0__fillcap_4
XFILLER_86_801 VDD VSS VDD VSS gf180mcu_fd_sc_mcu7t5v0__fillcap_4
XFILLER_218_317 VDD VSS VDD VSS gf180mcu_fd_sc_mcu7t5v0__fillcap_64
XFILLER_245_136 VDD VSS VDD VSS gf180mcu_fd_sc_mcu7t5v0__fillcap_4
X_3279_ _3279_/D wire96/I wire147/I VSS _3279_/CLK VDD VDD VSS gf180mcu_fd_sc_mcu7t5v0__dffrnq_1
XFILLER_39_772 VDD VSS VDD VSS gf180mcu_fd_sc_mcu7t5v0__fillcap_64
XFILLER_66_591 VDD VSS VDD VSS gf180mcu_fd_sc_mcu7t5v0__fillcap_4
XFILLER_54_731 VDD VSS VDD VSS gf180mcu_fd_sc_mcu7t5v0__fillcap_4
XFILLER_22_661 VDD VSS VDD VSS gf180mcu_fd_sc_mcu7t5v0__fillcap_4
XFILLER_10_801 VDD VSS VDD VSS gf180mcu_fd_sc_mcu7t5v0__fillcap_4
Xmax_length52 VSS _2347_/B _2470_/B VDD VDD VSS gf180mcu_fd_sc_mcu7t5v0__buf_2
Xmax_length30 _2058_/S wire28/I VDD VSS VDD VSS gf180mcu_fd_sc_mcu7t5v0__buf_4
Xmax_length74 VSS _2454_/S1 _2460_/S1 VDD VDD VSS gf180mcu_fd_sc_mcu7t5v0__buf_2
Xmax_length63 VSS _2742_/S1 _2743_/S1 VDD VDD VSS gf180mcu_fd_sc_mcu7t5v0__buf_2
XFILLER_107_221 VDD VSS VDD VSS gf180mcu_fd_sc_mcu7t5v0__fillcap_32
XFILLER_101_2 VDD VSS VDD VSS gf180mcu_fd_sc_mcu7t5v0__fillcap_8
XFILLER_190_691 VDD VSS VDD VSS gf180mcu_fd_sc_mcu7t5v0__fillcap_4
XFILLER_268_206 VDD VSS VDD VSS gf180mcu_fd_sc_mcu7t5v0__fillcap_32
XFILLER_150_588 VDD VSS VDD VSS gf180mcu_fd_sc_mcu7t5v0__fillcap_4
XFILLER_110_419 VDD VSS VDD VSS gf180mcu_fd_sc_mcu7t5v0__fillcap_8
Xclkbuf_leaf_54_clk_i _3022_/CLK VSS VDD clkload1/I VDD VSS gf180mcu_fd_sc_mcu7t5v0__clkbuf_2
XFILLER_237_626 VDD VSS VDD VSS gf180mcu_fd_sc_mcu7t5v0__fillcap_4
XFILLER_249_486 VDD VSS VDD VSS gf180mcu_fd_sc_mcu7t5v0__fillcap_4
XFILLER_76_311 VDD VSS VDD VSS gf180mcu_fd_sc_mcu7t5v0__fillcap_4
XFILLER_88_193 VDD VSS VDD VSS gf180mcu_fd_sc_mcu7t5v0__fillcap_8
XFILLER_88_171 VDD VSS VDD VSS gf180mcu_fd_sc_mcu7t5v0__fillcap_4
XFILLER_17_422 VDD VSS VDD VSS gf180mcu_fd_sc_mcu7t5v0__fillcap_64
XFILLER_190_98 VDD VSS VDD VSS gf180mcu_fd_sc_mcu7t5v0__fillcap_4
XFILLER_91_314 VDD VSS VDD VSS gf180mcu_fd_sc_mcu7t5v0__fillcap_16
Xclkbuf_leaf_69_clk_i _3336_/CLK VSS VDD clkbuf_3_0__f_clk_i/Z VDD VSS gf180mcu_fd_sc_mcu7t5v0__clkbuf_2
XFILLER_29_282 VDD VSS VDD VSS gf180mcu_fd_sc_mcu7t5v0__fillcap_64
XFILLER_44_241 VDD VSS VDD VSS gf180mcu_fd_sc_mcu7t5v0__fillcap_4
XFILLER_9_632 VDD VSS VDD VSS gf180mcu_fd_sc_mcu7t5v0__fillcap_64
XFILLER_12_171 VDD VSS VDD VSS gf180mcu_fd_sc_mcu7t5v0__fillcap_4
XFILLER_185_463 VDD VSS VDD VSS gf180mcu_fd_sc_mcu7t5v0__fillcap_16
XFILLER_145_316 VDD VSS VDD VSS gf180mcu_fd_sc_mcu7t5v0__fillcap_4
X_2650_ VDD VSS _2706_/A4 _3272_/Q _2652_/A2 VDD VSS gf180mcu_fd_sc_mcu7t5v0__nand2_1
X_1601_ VDD VSS _1604_/A1 _3385_/Q _3376_/D VDD VSS gf180mcu_fd_sc_mcu7t5v0__xnor2_1
XFILLER_218_37 VDD VSS VDD VSS gf180mcu_fd_sc_mcu7t5v0__fillcap_32
X_2581_ wire12/Z VDD VSS _3249_/D _3241_/Q _3249_/Q VDD VSS gf180mcu_fd_sc_mcu7t5v0__mux2_2
X_1532_ VDD VSS _1532_/Z _3362_/D _3363_/D VDD VSS gf180mcu_fd_sc_mcu7t5v0__and2_1
X_1463_ VDD VSS _1889_/A2 _3407_/Q _1469_/A2 VDD VSS gf180mcu_fd_sc_mcu7t5v0__nand2_1
XFILLER_259_206 VDD VSS VDD VSS gf180mcu_fd_sc_mcu7t5v0__fillcap_4
XFILLER_4_381 VDD VSS VDD VSS gf180mcu_fd_sc_mcu7t5v0__fillcap_4
X_3202_ _3202_/D _3202_/Q wire147/Z VSS _3202_/CLK VDD VDD VSS gf180mcu_fd_sc_mcu7t5v0__dffrnq_1
XFILLER_68_801 VDD VSS VDD VSS gf180mcu_fd_sc_mcu7t5v0__fillcap_4
XFILLER_86_119 VDD VSS VDD VSS gf180mcu_fd_sc_mcu7t5v0__fillcap_16
XFILLER_268_784 VDD VSS VDD VSS gf180mcu_fd_sc_mcu7t5v0__fillcap_32
X_1394_ VDD VSS _2803_/Q _1712_/A1 VDD VSS gf180mcu_fd_sc_mcu7t5v0__clkinv_1
XFILLER_227_136 VDD VSS VDD VSS gf180mcu_fd_sc_mcu7t5v0__fillcap_4
X_3133_ _3133_/D _3133_/Q wire151/I VSS _3165_/CLK VDD VDD VSS gf180mcu_fd_sc_mcu7t5v0__dffrnq_1
X_3064_ _3064_/D _3064_/Q wire145/Z VSS _3277_/CLK VDD VDD VSS gf180mcu_fd_sc_mcu7t5v0__dffrnq_1
XFILLER_48_591 VDD VSS VDD VSS gf180mcu_fd_sc_mcu7t5v0__fillcap_4
XFILLER_36_731 VDD VSS VDD VSS gf180mcu_fd_sc_mcu7t5v0__fillcap_4
X_2015_ _2018_/S VDD VSS _3057_/D _2015_/I0 _3057_/Q VDD VSS gf180mcu_fd_sc_mcu7t5v0__mux2_2
X_2917_ VDD _2917_/Q _2931_/CLK VSS _2917_/D VDD VSS gf180mcu_fd_sc_mcu7t5v0__dffq_1
XFILLER_259_66 VDD VSS VDD VSS gf180mcu_fd_sc_mcu7t5v0__fillcap_4
Xmax_length109 VSS _2449_/A1 _3206_/Q VDD VDD VSS gf180mcu_fd_sc_mcu7t5v0__buf_2
XFILLER_191_422 VDD VSS VDD VSS gf180mcu_fd_sc_mcu7t5v0__fillcap_64
XFILLER_164_658 VDD VSS VDD VSS gf180mcu_fd_sc_mcu7t5v0__fillcap_4
X_2848_ VDD _2848_/Q _3369_/CLK VSS _2848_/D VDD VSS gf180mcu_fd_sc_mcu7t5v0__dffq_1
XFILLER_136_349 VDD VSS VDD VSS gf180mcu_fd_sc_mcu7t5v0__fillcap_16
XFILLER_12_37 VDD VSS VDD VSS gf180mcu_fd_sc_mcu7t5v0__fillcap_64
XFILLER_128_37 VDD VSS VDD VSS gf180mcu_fd_sc_mcu7t5v0__fillcap_16
X_2779_ wire20/Z _3083_/Q VDD VSS _2780_/A2 _3331_/Q _2739_/S VDD VSS gf180mcu_fd_sc_mcu7t5v0__aoi22_1
XFILLER_117_541 VDD VSS VDD VSS gf180mcu_fd_sc_mcu7t5v0__fillcap_4
XFILLER_58_311 VDD VSS VDD VSS gf180mcu_fd_sc_mcu7t5v0__fillcap_4
XFILLER_26_241 VDD VSS VDD VSS gf180mcu_fd_sc_mcu7t5v0__fillcap_4
XFILLER_202_515 VDD VSS VDD VSS gf180mcu_fd_sc_mcu7t5v0__fillcap_8
XFILLER_199_555 VDD VSS VDD VSS gf180mcu_fd_sc_mcu7t5v0__fillcap_4
XFILLER_53_66 VDD VSS VDD VSS gf180mcu_fd_sc_mcu7t5v0__fillcap_4
XFILLER_195_772 VDD VSS VDD VSS gf180mcu_fd_sc_mcu7t5v0__fillcap_64
XFILLER_123_511 VDD VSS VDD VSS gf180mcu_fd_sc_mcu7t5v0__fillcap_32
XFILLER_123_500 VDD VSS VDD VSS gf180mcu_fd_sc_mcu7t5v0__fillcap_4
XFILLER_151_842 VDD VSS VDD VSS gf180mcu_fd_sc_mcu7t5v0__fillcap_32
XFILLER_2_885 VDD VSS VDD VSS gf180mcu_fd_sc_mcu7t5v0__fillcap_4
XFILLER_110_238 VDD VSS VDD VSS gf180mcu_fd_sc_mcu7t5v0__fillcap_4
XFILLER_18_731 VDD VSS VDD VSS gf180mcu_fd_sc_mcu7t5v0__fillcap_4
XFILLER_80_807 VDD VSS VDD VSS gf180mcu_fd_sc_mcu7t5v0__fillcap_64
XFILLER_92_667 VDD VSS VDD VSS gf180mcu_fd_sc_mcu7t5v0__fillcap_64
XFILLER_72_380 VDD VSS VDD VSS gf180mcu_fd_sc_mcu7t5v0__fillcap_4
XFILLER_60_597 VDD VSS VDD VSS gf180mcu_fd_sc_mcu7t5v0__fillcap_64
XFILLER_185_260 VDD VSS VDD VSS gf180mcu_fd_sc_mcu7t5v0__fillcap_4
X_2702_ _2703_/A3 VDD VSS _2749_/A2 _3277_/Q _2020_/B VDD VSS gf180mcu_fd_sc_mcu7t5v0__nor3_1
XFILLER_146_625 VDD VSS VDD VSS gf180mcu_fd_sc_mcu7t5v0__fillcap_16
XFILLER_185_282 VDD VSS VDD VSS gf180mcu_fd_sc_mcu7t5v0__fillcap_4
XFILLER_145_135 VDD VSS VDD VSS gf180mcu_fd_sc_mcu7t5v0__fillcap_4
X_2633_ wire46/Z VDD VSS _3296_/D _3254_/Q _3296_/Q VDD VSS gf180mcu_fd_sc_mcu7t5v0__mux2_2
XFILLER_64_2 VDD VSS VDD VSS gf180mcu_fd_sc_mcu7t5v0__fillcap_32
X_2564_ _2566_/S VDD VSS _3233_/D _3218_/Q _3233_/Q VDD VSS gf180mcu_fd_sc_mcu7t5v0__mux2_2
X_1515_ VDD VSS _1515_/I _3375_/D VDD VSS gf180mcu_fd_sc_mcu7t5v0__clkinv_1
X_2495_ VDD VSS _3212_/D _2495_/A1 _2495_/A2 VDD VSS gf180mcu_fd_sc_mcu7t5v0__nand2_1
XFILLER_141_352 VDD VSS VDD VSS gf180mcu_fd_sc_mcu7t5v0__fillcap_64
X_1446_ VDD VSS _3135_/Q _2167_/A1 VDD VSS gf180mcu_fd_sc_mcu7t5v0__clkinv_1
X_3116_ _3116_/D _3116_/Q _3359_/RN VSS _3192_/CLK VDD VDD VSS gf180mcu_fd_sc_mcu7t5v0__dffrnq_1
XFILLER_70_317 VDD VSS VDD VSS gf180mcu_fd_sc_mcu7t5v0__fillcap_64
X_3047_ VDD _3047_/Q _3055_/CLK VSS _3047_/D VDD VSS gf180mcu_fd_sc_mcu7t5v0__dffq_1
XFILLER_82_166 VDD VSS VDD VSS gf180mcu_fd_sc_mcu7t5v0__fillcap_4
XFILLER_251_492 VDD VSS VDD VSS gf180mcu_fd_sc_mcu7t5v0__fillcap_64
XFILLER_211_345 VDD VSS VDD VSS gf180mcu_fd_sc_mcu7t5v0__fillcap_4
XFILLER_177_772 VDD VSS VDD VSS gf180mcu_fd_sc_mcu7t5v0__fillcap_64
XFILLER_192_731 VDD VSS VDD VSS gf180mcu_fd_sc_mcu7t5v0__fillcap_4
XFILLER_219_80 VDD VSS VDD VSS gf180mcu_fd_sc_mcu7t5v0__fillcap_4
XFILLER_105_500 VDD VSS VDD VSS gf180mcu_fd_sc_mcu7t5v0__fillcap_4
XFILLER_133_842 VDD VSS VDD VSS gf180mcu_fd_sc_mcu7t5v0__fillcap_32
XFILLER_160_661 VDD VSS VDD VSS gf180mcu_fd_sc_mcu7t5v0__fillcap_4
XFILLER_101_772 VDD VSS VDD VSS gf180mcu_fd_sc_mcu7t5v0__fillcap_64
XFILLER_261_212 VDD VSS VDD VSS gf180mcu_fd_sc_mcu7t5v0__fillcap_64
XFILLER_62_807 VDD VSS VDD VSS gf180mcu_fd_sc_mcu7t5v0__fillcap_64
XFILLER_74_667 VDD VSS VDD VSS gf180mcu_fd_sc_mcu7t5v0__fillcap_64
XFILLER_266_2 VDD VSS VDD VSS gf180mcu_fd_sc_mcu7t5v0__fillcap_32
XFILLER_199_352 VDD VSS VDD VSS gf180mcu_fd_sc_mcu7t5v0__fillcap_64
XFILLER_187_536 VDD VSS VDD VSS gf180mcu_fd_sc_mcu7t5v0__fillcap_4
XFILLER_42_597 VDD VSS VDD VSS gf180mcu_fd_sc_mcu7t5v0__fillcap_64
XFILLER_30_737 VDD VSS VDD VSS gf180mcu_fd_sc_mcu7t5v0__fillcap_64
XFILLER_155_422 VDD VSS VDD VSS gf180mcu_fd_sc_mcu7t5v0__fillcap_32
XFILLER_167_282 VDD VSS VDD VSS gf180mcu_fd_sc_mcu7t5v0__fillcap_64
XFILLER_80_86 VDD VSS VDD VSS gf180mcu_fd_sc_mcu7t5v0__fillcap_8
XFILLER_108_371 VDD VSS VDD VSS gf180mcu_fd_sc_mcu7t5v0__fillcap_8
XFILLER_170_447 VDD VSS VDD VSS gf180mcu_fd_sc_mcu7t5v0__fillcap_8
XFILLER_123_352 VDD VSS VDD VSS gf180mcu_fd_sc_mcu7t5v0__fillcap_4
X_2280_ _2280_/B VDD VSS _3175_/D _2469_/A1 wire24/Z VDD VSS gf180mcu_fd_sc_mcu7t5v0__aoi21_1
XFILLER_36_6 VDD VSS VDD VSS gf180mcu_fd_sc_mcu7t5v0__fillcap_16
XFILLER_150_193 VDD VSS VDD VSS gf180mcu_fd_sc_mcu7t5v0__fillcap_4
XFILLER_96_247 VDD VSS VDD VSS gf180mcu_fd_sc_mcu7t5v0__fillcap_16
XFILLER_253_702 VDD VSS VDD VSS gf180mcu_fd_sc_mcu7t5v0__fillcap_64
XFILLER_265_562 VDD VSS VDD VSS gf180mcu_fd_sc_mcu7t5v0__fillcap_64
XFILLER_64_177 VDD VSS VDD VSS gf180mcu_fd_sc_mcu7t5v0__fillcap_64
XFILLER_52_317 VDD VSS VDD VSS gf180mcu_fd_sc_mcu7t5v0__fillcap_64
XFILLER_233_492 VDD VSS VDD VSS gf180mcu_fd_sc_mcu7t5v0__fillcap_64
XFILLER_159_772 VDD VSS VDD VSS gf180mcu_fd_sc_mcu7t5v0__fillcap_64
XFILLER_165_219 VDD VSS VDD VSS gf180mcu_fd_sc_mcu7t5v0__fillcap_16
X_1995_ _2000_/S VDD VSS _3039_/D wire121/Z _3039_/Q VDD VSS gf180mcu_fd_sc_mcu7t5v0__mux2_2
XFILLER_20_247 VDD VSS VDD VSS gf180mcu_fd_sc_mcu7t5v0__fillcap_64
XFILLER_174_731 VDD VSS VDD VSS gf180mcu_fd_sc_mcu7t5v0__fillcap_4
X_2616_ _2625_/S VDD VSS _3279_/D _3237_/Q wire96/I VDD VSS gf180mcu_fd_sc_mcu7t5v0__mux2_2
Xclkload62 VSS clkload62/Z _3212_/CLK VDD VDD VSS gf180mcu_fd_sc_mcu7t5v0__clkbuf_1
Xclkload51 VSS clkload51/Z _3185_/CLK VDD VDD VSS gf180mcu_fd_sc_mcu7t5v0__clkbuf_1
Xclkload40 VSS clkload40/Z _3409_/CLK VDD VDD VSS gf180mcu_fd_sc_mcu7t5v0__clkbuf_1
Xclkload73 VDD VSS _3445_/CLK clkload73/ZN VDD VSS gf180mcu_fd_sc_mcu7t5v0__clkinv_2
Xclkload84 VSS clkload84/ZN _3369_/CLK VDD VDD VSS gf180mcu_fd_sc_mcu7t5v0__inv_1
XFILLER_115_842 VDD VSS VDD VSS gf180mcu_fd_sc_mcu7t5v0__fillcap_32
XFILLER_142_650 VDD VSS VDD VSS gf180mcu_fd_sc_mcu7t5v0__fillcap_8
XFILLER_114_341 VDD VSS VDD VSS gf180mcu_fd_sc_mcu7t5v0__fillcap_4
XFILLER_130_801 VDD VSS VDD VSS gf180mcu_fd_sc_mcu7t5v0__fillcap_4
X_2547_ _2547_/A3 _2547_/A4 VDD VSS _2548_/B _2549_/A1 _2549_/A2 VDD VSS gf180mcu_fd_sc_mcu7t5v0__nand4_1
XFILLER_142_683 VDD VSS VDD VSS gf180mcu_fd_sc_mcu7t5v0__fillcap_4
X_2478_ VDD _2479_/A2 _3207_/Q _2478_/A1 _2478_/A2 VSS _2478_/A3 VDD VSS gf180mcu_fd_sc_mcu7t5v0__oai31_1
XFILLER_88_737 VDD VSS VDD VSS gf180mcu_fd_sc_mcu7t5v0__fillcap_64
XFILLER_102_558 VDD VSS VDD VSS gf180mcu_fd_sc_mcu7t5v0__fillcap_8
X_1429_ VDD VSS _3221_/Q _2546_/A1 VDD VSS gf180mcu_fd_sc_mcu7t5v0__clkinv_1
XFILLER_243_212 VDD VSS VDD VSS gf180mcu_fd_sc_mcu7t5v0__fillcap_64
XFILLER_44_807 VDD VSS VDD VSS gf180mcu_fd_sc_mcu7t5v0__fillcap_64
XFILLER_216_437 VDD VSS VDD VSS gf180mcu_fd_sc_mcu7t5v0__fillcap_16
XFILLER_71_626 VDD VSS VDD VSS gf180mcu_fd_sc_mcu7t5v0__fillcap_4
XFILLER_56_667 VDD VSS VDD VSS gf180mcu_fd_sc_mcu7t5v0__fillcap_64
XFILLER_83_486 VDD VSS VDD VSS gf180mcu_fd_sc_mcu7t5v0__fillcap_4
XFILLER_211_142 VDD VSS VDD VSS gf180mcu_fd_sc_mcu7t5v0__fillcap_16
Xspi_opentarget_i3c_top_206 spi_miso_o_OE VDD VSS VDD VSS gf180mcu_fd_sc_mcu7t5v0__tieh
XFILLER_24_597 VDD VSS VDD VSS gf180mcu_fd_sc_mcu7t5v0__fillcap_64
XFILLER_12_737 VDD VSS VDD VSS gf180mcu_fd_sc_mcu7t5v0__fillcap_64
Xwire105 VSS wire105/Z _3208_/Q VDD VDD VSS gf180mcu_fd_sc_mcu7t5v0__buf_1
Xwire116 wire116/Z VSS VDD _3180_/Q VDD VSS gf180mcu_fd_sc_mcu7t5v0__clkbuf_3
Xclkload1 VSS clkload1/ZN clkload1/I VDD VDD VSS gf180mcu_fd_sc_mcu7t5v0__inv_3
XFILLER_192_561 VDD VSS VDD VSS gf180mcu_fd_sc_mcu7t5v0__fillcap_32
XFILLER_152_403 VDD VSS VDD VSS gf180mcu_fd_sc_mcu7t5v0__fillcap_4
XFILLER_166_89 VDD VSS VDD VSS gf180mcu_fd_sc_mcu7t5v0__fillcap_4
XFILLER_164_285 VDD VSS VDD VSS gf180mcu_fd_sc_mcu7t5v0__fillcap_8
XFILLER_105_352 VDD VSS VDD VSS gf180mcu_fd_sc_mcu7t5v0__fillcap_4
XFILLER_120_333 VDD VSS VDD VSS gf180mcu_fd_sc_mcu7t5v0__fillcap_8
XFILLER_78_247 VDD VSS VDD VSS gf180mcu_fd_sc_mcu7t5v0__fillcap_16
XFILLER_132_193 VDD VSS VDD VSS gf180mcu_fd_sc_mcu7t5v0__fillcap_8
XFILLER_235_702 VDD VSS VDD VSS gf180mcu_fd_sc_mcu7t5v0__fillcap_64
XFILLER_247_562 VDD VSS VDD VSS gf180mcu_fd_sc_mcu7t5v0__fillcap_64
XFILLER_262_521 VDD VSS VDD VSS gf180mcu_fd_sc_mcu7t5v0__fillcap_4
XFILLER_46_177 VDD VSS VDD VSS gf180mcu_fd_sc_mcu7t5v0__fillcap_64
XFILLER_34_317 VDD VSS VDD VSS gf180mcu_fd_sc_mcu7t5v0__fillcap_64
XFILLER_215_492 VDD VSS VDD VSS gf180mcu_fd_sc_mcu7t5v0__fillcap_8
XFILLER_188_801 VDD VSS VDD VSS gf180mcu_fd_sc_mcu7t5v0__fillcap_4
XFILLER_222_429 VDD VSS VDD VSS gf180mcu_fd_sc_mcu7t5v0__fillcap_16
XFILLER_61_136 VDD VSS VDD VSS gf180mcu_fd_sc_mcu7t5v0__fillcap_4
XFILLER_230_451 VDD VSS VDD VSS gf180mcu_fd_sc_mcu7t5v0__fillcap_4
XFILLER_187_344 VDD VSS VDD VSS gf180mcu_fd_sc_mcu7t5v0__fillcap_4
XFILLER_202_164 VDD VSS VDD VSS gf180mcu_fd_sc_mcu7t5v0__fillcap_4
XFILLER_156_731 VDD VSS VDD VSS gf180mcu_fd_sc_mcu7t5v0__fillcap_4
XFILLER_202_186 VDD VSS VDD VSS gf180mcu_fd_sc_mcu7t5v0__fillcap_32
X_1780_ _1786_/S VDD VSS _2854_/D _3120_/Q _2854_/Q VDD VSS gf180mcu_fd_sc_mcu7t5v0__mux2_2
XFILLER_143_414 VDD VSS VDD VSS gf180mcu_fd_sc_mcu7t5v0__fillcap_4
XFILLER_128_477 VDD VSS VDD VSS gf180mcu_fd_sc_mcu7t5v0__fillcap_4
XFILLER_183_594 VDD VSS VDD VSS gf180mcu_fd_sc_mcu7t5v0__fillcap_4
X_3450_ _3450_/D _3450_/Q _3455_/RN VSS _3450_/CLK VDD VDD VSS gf180mcu_fd_sc_mcu7t5v0__dffrnq_1
XFILLER_115_116 VDD VSS VDD VSS gf180mcu_fd_sc_mcu7t5v0__fillcap_4
X_2401_ _2831_/Q VSS VDD _2815_/Q _2823_/Q _1519_/B _2807_/Q wire76/I _2401_/Z VDD
+ VSS gf180mcu_fd_sc_mcu7t5v0__mux4_1
X_3381_ _3381_/D _3381_/Q _3458_/RN VSS _3392_/CLK VDD VDD VSS gf180mcu_fd_sc_mcu7t5v0__dffrnq_1
XFILLER_226_37 VDD VSS VDD VSS gf180mcu_fd_sc_mcu7t5v0__fillcap_64
XFILLER_112_801 VDD VSS VDD VSS gf180mcu_fd_sc_mcu7t5v0__fillcap_4
X_2332_ _2332_/A3 VDD VSS _2333_/A4 _2804_/Q _2274_/C VDD VSS gf180mcu_fd_sc_mcu7t5v0__nor3_1
XFILLER_111_322 VDD VSS VDD VSS gf180mcu_fd_sc_mcu7t5v0__fillcap_4
XFILLER_27_2 VDD VSS VDD VSS gf180mcu_fd_sc_mcu7t5v0__fillcap_64
X_2263_ VDD _2264_/A3 _2263_/B _2364_/A1 _2482_/A2 VSS _1716_/B VDD VSS gf180mcu_fd_sc_mcu7t5v0__oai31_1
XFILLER_266_871 VDD VSS VDD VSS gf180mcu_fd_sc_mcu7t5v0__fillcap_4
X_2194_ _2189_/S VDD VSS _2196_/A2 _3146_/Q _3147_/Q VDD VSS gf180mcu_fd_sc_mcu7t5v0__nand3_1
XFILLER_225_212 VDD VSS VDD VSS gf180mcu_fd_sc_mcu7t5v0__fillcap_64
XFILLER_26_807 VDD VSS VDD VSS gf180mcu_fd_sc_mcu7t5v0__fillcap_64
XFILLER_38_667 VDD VSS VDD VSS gf180mcu_fd_sc_mcu7t5v0__fillcap_64
XFILLER_1_72 VDD VSS VDD VSS gf180mcu_fd_sc_mcu7t5v0__fillcap_64
XFILLER_53_626 VDD VSS VDD VSS gf180mcu_fd_sc_mcu7t5v0__fillcap_4
XFILLER_65_486 VDD VSS VDD VSS gf180mcu_fd_sc_mcu7t5v0__fillcap_4
XFILLER_21_556 VDD VSS VDD VSS gf180mcu_fd_sc_mcu7t5v0__fillcap_4
XFILLER_193_314 VDD VSS VDD VSS gf180mcu_fd_sc_mcu7t5v0__fillcap_16
XFILLER_119_422 VDD VSS VDD VSS gf180mcu_fd_sc_mcu7t5v0__fillcap_4
XFILLER_267_66 VDD VSS VDD VSS gf180mcu_fd_sc_mcu7t5v0__fillcap_4
X_1978_ _1981_/S VDD VSS _3025_/D _2015_/I0 _3025_/Q VDD VSS gf180mcu_fd_sc_mcu7t5v0__mux2_2
XFILLER_146_263 VDD VSS VDD VSS gf180mcu_fd_sc_mcu7t5v0__fillcap_8
XFILLER_20_37 VDD VSS VDD VSS gf180mcu_fd_sc_mcu7t5v0__fillcap_64
XFILLER_136_37 VDD VSS VDD VSS gf180mcu_fd_sc_mcu7t5v0__fillcap_16
XFILLER_75_206 VDD VSS VDD VSS gf180mcu_fd_sc_mcu7t5v0__fillcap_4
XFILLER_217_702 VDD VSS VDD VSS gf180mcu_fd_sc_mcu7t5v0__fillcap_64
XFILLER_229_562 VDD VSS VDD VSS gf180mcu_fd_sc_mcu7t5v0__fillcap_64
XFILLER_188_6 VDD VSS VDD VSS gf180mcu_fd_sc_mcu7t5v0__fillcap_16
XFILLER_244_521 VDD VSS VDD VSS gf180mcu_fd_sc_mcu7t5v0__fillcap_4
XFILLER_256_381 VDD VSS VDD VSS gf180mcu_fd_sc_mcu7t5v0__fillcap_4
XFILLER_28_177 VDD VSS VDD VSS gf180mcu_fd_sc_mcu7t5v0__fillcap_64
XFILLER_16_317 VDD VSS VDD VSS gf180mcu_fd_sc_mcu7t5v0__fillcap_64
XFILLER_43_136 VDD VSS VDD VSS gf180mcu_fd_sc_mcu7t5v0__fillcap_4
XFILLER_200_613 VDD VSS VDD VSS gf180mcu_fd_sc_mcu7t5v0__fillcap_8
XFILLER_138_720 VDD VSS VDD VSS gf180mcu_fd_sc_mcu7t5v0__fillcap_4
XFILLER_8_527 VDD VSS VDD VSS gf180mcu_fd_sc_mcu7t5v0__fillcap_64
XFILLER_61_66 VDD VSS VDD VSS gf180mcu_fd_sc_mcu7t5v0__fillcap_4
XFILLER_131_2 VDD VSS VDD VSS gf180mcu_fd_sc_mcu7t5v0__fillcap_8
XFILLER_229_2 VDD VSS VDD VSS gf180mcu_fd_sc_mcu7t5v0__fillcap_64
XFILLER_138_797 VDD VSS VDD VSS gf180mcu_fd_sc_mcu7t5v0__fillcap_8
XFILLER_177_88 VDD VSS VDD VSS gf180mcu_fd_sc_mcu7t5v0__fillcap_8
XFILLER_180_542 VDD VSS VDD VSS gf180mcu_fd_sc_mcu7t5v0__fillcap_32
XFILLER_165_594 VDD VSS VDD VSS gf180mcu_fd_sc_mcu7t5v0__fillcap_4
XFILLER_152_222 VDD VSS VDD VSS gf180mcu_fd_sc_mcu7t5v0__fillcap_8
XFILLER_106_661 VDD VSS VDD VSS gf180mcu_fd_sc_mcu7t5v0__fillcap_4
XFILLER_193_98 VDD VSS VDD VSS gf180mcu_fd_sc_mcu7t5v0__fillcap_8
XFILLER_3_276 VDD VSS VDD VSS gf180mcu_fd_sc_mcu7t5v0__fillcap_4
XFILLER_266_101 VDD VSS VDD VSS gf180mcu_fd_sc_mcu7t5v0__fillcap_4
XFILLER_79_556 VDD VSS VDD VSS gf180mcu_fd_sc_mcu7t5v0__fillcap_4
XFILLER_86_30 VDD VSS VDD VSS gf180mcu_fd_sc_mcu7t5v0__fillcap_4
XFILLER_248_871 VDD VSS VDD VSS gf180mcu_fd_sc_mcu7t5v0__fillcap_4
XFILLER_263_874 VDD VSS VDD VSS gf180mcu_fd_sc_mcu7t5v0__fillcap_16
XFILLER_74_272 VDD VSS VDD VSS gf180mcu_fd_sc_mcu7t5v0__fillcap_4
XFILLER_35_626 VDD VSS VDD VSS gf180mcu_fd_sc_mcu7t5v0__fillcap_4
XFILLER_47_486 VDD VSS VDD VSS gf180mcu_fd_sc_mcu7t5v0__fillcap_4
XFILLER_179_119 VDD VSS VDD VSS gf180mcu_fd_sc_mcu7t5v0__fillcap_8
X_2950_ VDD _2950_/Q _3012_/CLK VSS _2950_/D VDD VSS gf180mcu_fd_sc_mcu7t5v0__dffq_1
X_1901_ _1907_/S VDD VSS _2958_/D wire123/I _2958_/Q VDD VSS gf180mcu_fd_sc_mcu7t5v0__mux2_2
X_2881_ VDD _2881_/Q _2900_/CLK VSS _2881_/D VDD VSS gf180mcu_fd_sc_mcu7t5v0__dffq_1
XFILLER_188_653 VDD VSS VDD VSS gf180mcu_fd_sc_mcu7t5v0__fillcap_8
X_1832_ _1832_/S VDD VSS _2900_/D _2900_/Q _1869_/I0 VDD VSS gf180mcu_fd_sc_mcu7t5v0__mux2_2
XFILLER_175_303 VDD VSS VDD VSS gf180mcu_fd_sc_mcu7t5v0__fillcap_4
XFILLER_128_230 VDD VSS VDD VSS gf180mcu_fd_sc_mcu7t5v0__fillcap_8
X_1763_ _1768_/S VDD VSS _2839_/D _3121_/Q _2839_/Q VDD VSS gf180mcu_fd_sc_mcu7t5v0__mux2_2
XFILLER_190_317 VDD VSS VDD VSS gf180mcu_fd_sc_mcu7t5v0__fillcap_4
XFILLER_128_263 VDD VSS VDD VSS gf180mcu_fd_sc_mcu7t5v0__fillcap_4
X_1694_ _1694_/A3 VDD VSS _1720_/A2 _1694_/A1 _1694_/A2 VDD VSS gf180mcu_fd_sc_mcu7t5v0__nand3_1
X_3433_ _3433_/D _3433_/Q wire161/I VSS _3434_/CLK VDD VDD VSS gf180mcu_fd_sc_mcu7t5v0__dffrnq_1
X_3364_ _3364_/D _3364_/Q _3457_/RN VSS _3364_/CLK VDD VDD VSS gf180mcu_fd_sc_mcu7t5v0__dffrnq_1
XFILLER_97_331 VDD VSS VDD VSS gf180mcu_fd_sc_mcu7t5v0__fillcap_16
X_2315_ VDD VSS _2318_/A2 _2486_/C _2486_/B VDD VSS gf180mcu_fd_sc_mcu7t5v0__nor2_1
XFILLER_112_675 VDD VSS VDD VSS gf180mcu_fd_sc_mcu7t5v0__fillcap_4
XFILLER_57_206 VDD VSS VDD VSS gf180mcu_fd_sc_mcu7t5v0__fillcap_4
X_3295_ _3295_/D _3295_/Q _3452_/RN VSS _3453_/CLK VDD VDD VSS gf180mcu_fd_sc_mcu7t5v0__dffrnq_1
X_2246_ _2246_/A3 _2246_/A4 VDD VSS _2247_/A2 _2233_/Z _2235_/B VDD VSS gf180mcu_fd_sc_mcu7t5v0__nand4_1
XFILLER_226_521 VDD VSS VDD VSS gf180mcu_fd_sc_mcu7t5v0__fillcap_4
XFILLER_238_381 VDD VSS VDD VSS gf180mcu_fd_sc_mcu7t5v0__fillcap_4
XFILLER_254_885 VDD VSS VDD VSS gf180mcu_fd_sc_mcu7t5v0__fillcap_4
X_2177_ VDD _2177_/B _3348_/D _3140_/D _2177_/A1 VSS VDD VSS gf180mcu_fd_sc_mcu7t5v0__oai21_1
XFILLER_202_61 VDD VSS VDD VSS gf180mcu_fd_sc_mcu7t5v0__fillcap_4
XFILLER_25_136 VDD VSS VDD VSS gf180mcu_fd_sc_mcu7t5v0__fillcap_4
XFILLER_166_303 VDD VSS VDD VSS gf180mcu_fd_sc_mcu7t5v0__fillcap_8
XFILLER_182_807 VDD VSS VDD VSS gf180mcu_fd_sc_mcu7t5v0__fillcap_64
XFILLER_162_597 VDD VSS VDD VSS gf180mcu_fd_sc_mcu7t5v0__fillcap_8
XFILLER_150_737 VDD VSS VDD VSS gf180mcu_fd_sc_mcu7t5v0__fillcap_64
XFILLER_150_726 VDD VSS VDD VSS gf180mcu_fd_sc_mcu7t5v0__fillcap_8
XFILLER_248_101 VDD VSS VDD VSS gf180mcu_fd_sc_mcu7t5v0__fillcap_4
XFILLER_245_874 VDD VSS VDD VSS gf180mcu_fd_sc_mcu7t5v0__fillcap_16
XFILLER_29_486 VDD VSS VDD VSS gf180mcu_fd_sc_mcu7t5v0__fillcap_4
XFILLER_17_626 VDD VSS VDD VSS gf180mcu_fd_sc_mcu7t5v0__fillcap_4
XFILLER_71_220 VDD VSS VDD VSS gf180mcu_fd_sc_mcu7t5v0__fillcap_4
XFILLER_260_877 VDD VSS VDD VSS gf180mcu_fd_sc_mcu7t5v0__fillcap_8
XFILLER_169_174 VDD VSS VDD VSS gf180mcu_fd_sc_mcu7t5v0__fillcap_16
XFILLER_184_100 VDD VSS VDD VSS gf180mcu_fd_sc_mcu7t5v0__fillcap_4
XFILLER_9_836 VDD VSS VDD VSS gf180mcu_fd_sc_mcu7t5v0__fillcap_4
XFILLER_184_177 VDD VSS VDD VSS gf180mcu_fd_sc_mcu7t5v0__fillcap_32
XFILLER_180_372 VDD VSS VDD VSS gf180mcu_fd_sc_mcu7t5v0__fillcap_8
XFILLER_39_206 VDD VSS VDD VSS gf180mcu_fd_sc_mcu7t5v0__fillcap_4
X_2100_ _2100_/B _2115_/C VDD VSS _3108_/D _2100_/A1 _2100_/A2 VDD VSS gf180mcu_fd_sc_mcu7t5v0__aoi211_1
X_3080_ _3080_/D _3080_/Q _3336_/RN VSS _3328_/CLK VDD VDD VSS gf180mcu_fd_sc_mcu7t5v0__dffrnq_1
XFILLER_208_521 VDD VSS VDD VSS gf180mcu_fd_sc_mcu7t5v0__fillcap_4
X_2031_ _2040_/S VDD VSS _3064_/D wire95/I _3064_/Q VDD VSS gf180mcu_fd_sc_mcu7t5v0__mux2_2
XFILLER_208_554 VDD VSS VDD VSS gf180mcu_fd_sc_mcu7t5v0__fillcap_8
XFILLER_236_885 VDD VSS VDD VSS gf180mcu_fd_sc_mcu7t5v0__fillcap_4
XFILLER_250_387 VDD VSS VDD VSS gf180mcu_fd_sc_mcu7t5v0__fillcap_64
X_2933_ VDD _2933_/Q _2958_/CLK VSS _2933_/D VDD VSS gf180mcu_fd_sc_mcu7t5v0__dffq_1
XFILLER_94_2 VDD VSS VDD VSS gf180mcu_fd_sc_mcu7t5v0__fillcap_32
XFILLER_176_667 VDD VSS VDD VSS gf180mcu_fd_sc_mcu7t5v0__fillcap_64
X_2864_ VDD _2864_/Q _2867_/CLK VSS _2864_/D VDD VSS gf180mcu_fd_sc_mcu7t5v0__dffq_1
XFILLER_164_807 VDD VSS VDD VSS gf180mcu_fd_sc_mcu7t5v0__fillcap_64
X_1815_ VDD VSS _1823_/S _1852_/A1 _1796_/Z VDD VSS gf180mcu_fd_sc_mcu7t5v0__nand2_1
X_2795_ wire20/Z _3091_/Q VDD VSS _2796_/A2 _3339_/Q _2739_/S VDD VSS gf180mcu_fd_sc_mcu7t5v0__aoi22_1
XFILLER_191_648 VDD VSS VDD VSS gf180mcu_fd_sc_mcu7t5v0__fillcap_32
X_1746_ _1748_/S VDD VSS _2826_/D _2826_/Q _3124_/Q VDD VSS gf180mcu_fd_sc_mcu7t5v0__mux2_2
XFILLER_129_594 VDD VSS VDD VSS gf180mcu_fd_sc_mcu7t5v0__fillcap_16
XFILLER_144_597 VDD VSS VDD VSS gf180mcu_fd_sc_mcu7t5v0__fillcap_16
X_1677_ VDD VSS _2359_/A1 _2357_/B2 _1677_/A2 VDD VSS gf180mcu_fd_sc_mcu7t5v0__nor2_1
XFILLER_104_417 VDD VSS VDD VSS gf180mcu_fd_sc_mcu7t5v0__fillcap_8
X_3416_ _3416_/D _3441_/D wire161/I VSS _3435_/CLK VDD VDD VSS gf180mcu_fd_sc_mcu7t5v0__dffrnq_1
X_3347_ _3347_/D _3347_/Q wire151/Z VSS _3348_/CLK VDD VDD VSS gf180mcu_fd_sc_mcu7t5v0__dffrnq_1
XFILLER_85_345 VDD VSS VDD VSS gf180mcu_fd_sc_mcu7t5v0__fillcap_4
XFILLER_100_667 VDD VSS VDD VSS gf180mcu_fd_sc_mcu7t5v0__fillcap_64
X_3278_ _3278_/D wire97/I _3452_/RN VSS _3452_/CLK VDD VDD VSS gf180mcu_fd_sc_mcu7t5v0__dffrnq_1
XFILLER_227_874 VDD VSS VDD VSS gf180mcu_fd_sc_mcu7t5v0__fillcap_16
X_2229_ VDD VSS _2357_/A2 _3193_/Q _3192_/Q VDD VSS gf180mcu_fd_sc_mcu7t5v0__nor2_1
XFILLER_260_107 VDD VSS VDD VSS gf180mcu_fd_sc_mcu7t5v0__fillcap_64
XFILLER_242_877 VDD VSS VDD VSS gf180mcu_fd_sc_mcu7t5v0__fillcap_8
XFILLER_81_562 VDD VSS VDD VSS gf180mcu_fd_sc_mcu7t5v0__fillcap_64
XFILLER_198_247 VDD VSS VDD VSS gf180mcu_fd_sc_mcu7t5v0__fillcap_4
Xmax_length42 _2274_/C VSS VDD _2336_/B VDD VSS gf180mcu_fd_sc_mcu7t5v0__clkbuf_3
Xmax_length31 _2040_/S _2060_/S VDD VSS VDD VSS gf180mcu_fd_sc_mcu7t5v0__buf_4
Xmax_length75 _2460_/S1 VSS VDD _3381_/Q VDD VSS gf180mcu_fd_sc_mcu7t5v0__clkbuf_3
Xmax_length64 VSS _2743_/S1 _3421_/Q VDD VDD VSS gf180mcu_fd_sc_mcu7t5v0__buf_2
XFILLER_194_486 VDD VSS VDD VSS gf180mcu_fd_sc_mcu7t5v0__fillcap_4
XFILLER_166_177 VDD VSS VDD VSS gf180mcu_fd_sc_mcu7t5v0__fillcap_8
XFILLER_107_266 VDD VSS VDD VSS gf180mcu_fd_sc_mcu7t5v0__fillcap_8
XFILLER_107_72 VDD VSS VDD VSS gf180mcu_fd_sc_mcu7t5v0__fillcap_8
XFILLER_190_22 VDD VSS VDD VSS gf180mcu_fd_sc_mcu7t5v0__fillcap_8
XFILLER_264_457 VDD VSS VDD VSS gf180mcu_fd_sc_mcu7t5v0__fillcap_64
XFILLER_218_885 VDD VSS VDD VSS gf180mcu_fd_sc_mcu7t5v0__fillcap_4
XFILLER_205_535 VDD VSS VDD VSS gf180mcu_fd_sc_mcu7t5v0__fillcap_16
XFILLER_232_387 VDD VSS VDD VSS gf180mcu_fd_sc_mcu7t5v0__fillcap_64
XFILLER_220_527 VDD VSS VDD VSS gf180mcu_fd_sc_mcu7t5v0__fillcap_16
XFILLER_198_792 VDD VSS VDD VSS gf180mcu_fd_sc_mcu7t5v0__fillcap_8
XFILLER_158_667 VDD VSS VDD VSS gf180mcu_fd_sc_mcu7t5v0__fillcap_16
XFILLER_146_807 VDD VSS VDD VSS gf180mcu_fd_sc_mcu7t5v0__fillcap_64
XFILLER_157_166 VDD VSS VDD VSS gf180mcu_fd_sc_mcu7t5v0__fillcap_8
XFILLER_200_273 VDD VSS VDD VSS gf180mcu_fd_sc_mcu7t5v0__fillcap_32
X_1600_ VDD VSS _3449_/D _1543_/I wire46/I VDD VSS gf180mcu_fd_sc_mcu7t5v0__nand2_1
X_2580_ _2587_/S VDD VSS _3248_/D _3240_/Q _3248_/Q VDD VSS gf180mcu_fd_sc_mcu7t5v0__mux2_2
X_1531_ VDD VSS _3379_/D _3405_/D _1531_/A2 VDD VSS gf180mcu_fd_sc_mcu7t5v0__xnor2_1
XFILLER_114_737 VDD VSS VDD VSS gf180mcu_fd_sc_mcu7t5v0__fillcap_64
X_1462_ VDD VSS _1469_/A2 _1898_/A3 _3406_/Q VDD VSS gf180mcu_fd_sc_mcu7t5v0__nor2_1
XFILLER_181_692 VDD VSS VDD VSS gf180mcu_fd_sc_mcu7t5v0__fillcap_8
XFILLER_234_37 VDD VSS VDD VSS gf180mcu_fd_sc_mcu7t5v0__fillcap_64
X_3201_ _3201_/D _3201_/Q wire147/Z VSS _3202_/CLK VDD VDD VSS gf180mcu_fd_sc_mcu7t5v0__dffrnq_1
X_1393_ VDD VSS _2331_/B _2341_/C VDD VSS gf180mcu_fd_sc_mcu7t5v0__clkinv_1
X_3132_ _3132_/D _3132_/Q wire151/Z VSS _3185_/CLK VDD VDD VSS gf180mcu_fd_sc_mcu7t5v0__dffrnq_1
XFILLER_95_632 VDD VSS VDD VSS gf180mcu_fd_sc_mcu7t5v0__fillcap_8
XFILLER_209_874 VDD VSS VDD VSS gf180mcu_fd_sc_mcu7t5v0__fillcap_16
X_3063_ _3063_/D _3063_/Q wire145/Z VSS _3159_/CLK VDD VDD VSS gf180mcu_fd_sc_mcu7t5v0__dffrnq_1
XFILLER_82_304 VDD VSS VDD VSS gf180mcu_fd_sc_mcu7t5v0__fillcap_8
XFILLER_242_107 VDD VSS VDD VSS gf180mcu_fd_sc_mcu7t5v0__fillcap_64
X_2014_ _2018_/S VDD VSS _3056_/D wire119/Z _3056_/Q VDD VSS gf180mcu_fd_sc_mcu7t5v0__mux2_2
XFILLER_63_562 VDD VSS VDD VSS gf180mcu_fd_sc_mcu7t5v0__fillcap_64
XFILLER_51_702 VDD VSS VDD VSS gf180mcu_fd_sc_mcu7t5v0__fillcap_64
XFILLER_224_877 VDD VSS VDD VSS gf180mcu_fd_sc_mcu7t5v0__fillcap_8
XFILLER_251_696 VDD VSS VDD VSS gf180mcu_fd_sc_mcu7t5v0__fillcap_4
XFILLER_196_729 VDD VSS VDD VSS gf180mcu_fd_sc_mcu7t5v0__fillcap_4
X_2916_ VDD _2916_/Q _2931_/CLK VSS _2916_/D VDD VSS gf180mcu_fd_sc_mcu7t5v0__dffq_1
X_2847_ VDD _2847_/Q _3369_/CLK VSS _2847_/D VDD VSS gf180mcu_fd_sc_mcu7t5v0__dffq_1
XFILLER_31_492 VDD VSS VDD VSS gf180mcu_fd_sc_mcu7t5v0__fillcap_64
XFILLER_163_114 VDD VSS VDD VSS gf180mcu_fd_sc_mcu7t5v0__fillcap_8
XFILLER_148_177 VDD VSS VDD VSS gf180mcu_fd_sc_mcu7t5v0__fillcap_16
XFILLER_136_317 VDD VSS VDD VSS gf180mcu_fd_sc_mcu7t5v0__fillcap_32
X_2778_ VDD VSS _3330_/D wire10/Z _2778_/A2 VDD VSS gf180mcu_fd_sc_mcu7t5v0__nand2_1
X_1729_ VDD VSS _1843_/A1 _3367_/Q _1729_/A2 VDD VSS gf180mcu_fd_sc_mcu7t5v0__nor2_1
XFILLER_85_142 VDD VSS VDD VSS gf180mcu_fd_sc_mcu7t5v0__fillcap_4
XFILLER_246_457 VDD VSS VDD VSS gf180mcu_fd_sc_mcu7t5v0__fillcap_64
XFILLER_218_159 VDD VSS VDD VSS gf180mcu_fd_sc_mcu7t5v0__fillcap_16
XFILLER_261_416 VDD VSS VDD VSS gf180mcu_fd_sc_mcu7t5v0__fillcap_4
XFILLER_82_871 VDD VSS VDD VSS gf180mcu_fd_sc_mcu7t5v0__fillcap_4
XFILLER_41_212 VDD VSS VDD VSS gf180mcu_fd_sc_mcu7t5v0__fillcap_64
XFILLER_214_387 VDD VSS VDD VSS gf180mcu_fd_sc_mcu7t5v0__fillcap_64
XFILLER_202_527 VDD VSS VDD VSS gf180mcu_fd_sc_mcu7t5v0__fillcap_64
XFILLER_199_578 VDD VSS VDD VSS gf180mcu_fd_sc_mcu7t5v0__fillcap_8
XFILLER_169_34 VDD VSS VDD VSS gf180mcu_fd_sc_mcu7t5v0__fillcap_4
XFILLER_128_807 VDD VSS VDD VSS gf180mcu_fd_sc_mcu7t5v0__fillcap_64
XFILLER_155_626 VDD VSS VDD VSS gf180mcu_fd_sc_mcu7t5v0__fillcap_4
XFILLER_211_2 VDD VSS VDD VSS gf180mcu_fd_sc_mcu7t5v0__fillcap_4
XFILLER_185_66 VDD VSS VDD VSS gf180mcu_fd_sc_mcu7t5v0__fillcap_4
XFILLER_142_309 VDD VSS VDD VSS gf180mcu_fd_sc_mcu7t5v0__fillcap_4
XFILLER_108_597 VDD VSS VDD VSS gf180mcu_fd_sc_mcu7t5v0__fillcap_8
XFILLER_1_352 VDD VSS VDD VSS gf180mcu_fd_sc_mcu7t5v0__fillcap_64
XFILLER_89_492 VDD VSS VDD VSS gf180mcu_fd_sc_mcu7t5v0__fillcap_4
XFILLER_77_632 VDD VSS VDD VSS gf180mcu_fd_sc_mcu7t5v0__fillcap_64
XFILLER_204_18 VDD VSS VDD VSS gf180mcu_fd_sc_mcu7t5v0__fillcap_4
XFILLER_204_29 VDD VSS VDD VSS gf180mcu_fd_sc_mcu7t5v0__fillcap_4
XFILLER_265_766 VDD VSS VDD VSS gf180mcu_fd_sc_mcu7t5v0__fillcap_4
XFILLER_224_107 VDD VSS VDD VSS gf180mcu_fd_sc_mcu7t5v0__fillcap_64
XFILLER_45_562 VDD VSS VDD VSS gf180mcu_fd_sc_mcu7t5v0__fillcap_64
XFILLER_33_702 VDD VSS VDD VSS gf180mcu_fd_sc_mcu7t5v0__fillcap_64
XFILLER_206_877 VDD VSS VDD VSS gf180mcu_fd_sc_mcu7t5v0__fillcap_8
XFILLER_60_521 VDD VSS VDD VSS gf180mcu_fd_sc_mcu7t5v0__fillcap_4
XFILLER_233_696 VDD VSS VDD VSS gf180mcu_fd_sc_mcu7t5v0__fillcap_4
XFILLER_221_836 VDD VSS VDD VSS gf180mcu_fd_sc_mcu7t5v0__fillcap_4
X_2701_ VDD _2701_/B _2752_/A1 _2704_/C _2752_/B VSS VDD VSS gf180mcu_fd_sc_mcu7t5v0__oai21_1
XFILLER_13_492 VDD VSS VDD VSS gf180mcu_fd_sc_mcu7t5v0__fillcap_64
XFILLER_145_158 VDD VSS VDD VSS gf180mcu_fd_sc_mcu7t5v0__fillcap_8
X_2632_ _2642_/S VDD VSS _3295_/D _3253_/Q _3295_/Q VDD VSS gf180mcu_fd_sc_mcu7t5v0__mux2_2
XFILLER_57_2 VDD VSS VDD VSS gf180mcu_fd_sc_mcu7t5v0__fillcap_16
X_2563_ _2566_/S VDD VSS _3232_/D _3217_/Q _3232_/Q VDD VSS gf180mcu_fd_sc_mcu7t5v0__mux2_2
X_1514_ VDD VSS _1515_/I _3394_/D _1514_/A2 VDD VSS gf180mcu_fd_sc_mcu7t5v0__xor2_1
XFILLER_160_139 VDD VSS VDD VSS gf180mcu_fd_sc_mcu7t5v0__fillcap_16
XFILLER_99_212 VDD VSS VDD VSS gf180mcu_fd_sc_mcu7t5v0__fillcap_16
X_2494_ _2494_/B _2494_/C VDD VSS _2495_/A2 _3212_/Q _3211_/Q VDD VSS gf180mcu_fd_sc_mcu7t5v0__oai211_1
X_1445_ VDD VSS _3133_/Q _2161_/A1 VDD VSS gf180mcu_fd_sc_mcu7t5v0__clkinv_1
XFILLER_67_142 VDD VSS VDD VSS gf180mcu_fd_sc_mcu7t5v0__fillcap_64
XFILLER_228_457 VDD VSS VDD VSS gf180mcu_fd_sc_mcu7t5v0__fillcap_64
X_3115_ _3115_/D _3115_/Q _3359_/RN VSS _3363_/CLK VDD VDD VSS gf180mcu_fd_sc_mcu7t5v0__dffrnq_1
XFILLER_95_462 VDD VSS VDD VSS gf180mcu_fd_sc_mcu7t5v0__fillcap_8
XFILLER_243_416 VDD VSS VDD VSS gf180mcu_fd_sc_mcu7t5v0__fillcap_4
XFILLER_255_276 VDD VSS VDD VSS gf180mcu_fd_sc_mcu7t5v0__fillcap_4
X_3046_ VDD _3046_/Q _3046_/CLK VSS _3046_/D VDD VSS gf180mcu_fd_sc_mcu7t5v0__dffq_1
XFILLER_82_123 VDD VSS VDD VSS gf180mcu_fd_sc_mcu7t5v0__fillcap_8
XFILLER_64_871 VDD VSS VDD VSS gf180mcu_fd_sc_mcu7t5v0__fillcap_4
XFILLER_23_212 VDD VSS VDD VSS gf180mcu_fd_sc_mcu7t5v0__fillcap_64
Xclkbuf_leaf_53_clk_i _3006_/CLK VSS VDD clkload1/I VDD VSS gf180mcu_fd_sc_mcu7t5v0__clkbuf_2
XFILLER_149_486 VDD VSS VDD VSS gf180mcu_fd_sc_mcu7t5v0__fillcap_4
XFILLER_137_615 VDD VSS VDD VSS gf180mcu_fd_sc_mcu7t5v0__fillcap_8
XFILLER_137_648 VDD VSS VDD VSS gf180mcu_fd_sc_mcu7t5v0__fillcap_8
XFILLER_219_92 VDD VSS VDD VSS gf180mcu_fd_sc_mcu7t5v0__fillcap_8
Xclkbuf_leaf_68_clk_i _3328_/CLK VSS VDD clkbuf_3_0__f_clk_i/Z VDD VSS gf180mcu_fd_sc_mcu7t5v0__clkbuf_2
XFILLER_105_578 VDD VSS VDD VSS gf180mcu_fd_sc_mcu7t5v0__fillcap_8
XFILLER_59_632 VDD VSS VDD VSS gf180mcu_fd_sc_mcu7t5v0__fillcap_64
XFILLER_86_451 VDD VSS VDD VSS gf180mcu_fd_sc_mcu7t5v0__fillcap_4
XFILLER_247_766 VDD VSS VDD VSS gf180mcu_fd_sc_mcu7t5v0__fillcap_4
XFILLER_206_107 VDD VSS VDD VSS gf180mcu_fd_sc_mcu7t5v0__fillcap_8
XFILLER_27_562 VDD VSS VDD VSS gf180mcu_fd_sc_mcu7t5v0__fillcap_64
XFILLER_15_702 VDD VSS VDD VSS gf180mcu_fd_sc_mcu7t5v0__fillcap_64
XFILLER_259_2 VDD VSS VDD VSS gf180mcu_fd_sc_mcu7t5v0__fillcap_64
XFILLER_161_2 VDD VSS VDD VSS gf180mcu_fd_sc_mcu7t5v0__fillcap_64
XFILLER_42_521 VDD VSS VDD VSS gf180mcu_fd_sc_mcu7t5v0__fillcap_4
XFILLER_54_381 VDD VSS VDD VSS gf180mcu_fd_sc_mcu7t5v0__fillcap_4
XFILLER_215_696 VDD VSS VDD VSS gf180mcu_fd_sc_mcu7t5v0__fillcap_4
XFILLER_203_836 VDD VSS VDD VSS gf180mcu_fd_sc_mcu7t5v0__fillcap_4
XFILLER_159_228 VDD VSS VDD VSS gf180mcu_fd_sc_mcu7t5v0__fillcap_32
XFILLER_70_885 VDD VSS VDD VSS gf180mcu_fd_sc_mcu7t5v0__fillcap_4
XFILLER_195_570 VDD VSS VDD VSS gf180mcu_fd_sc_mcu7t5v0__fillcap_16
XFILLER_155_412 VDD VSS VDD VSS gf180mcu_fd_sc_mcu7t5v0__fillcap_8
XFILLER_10_451 VDD VSS VDD VSS gf180mcu_fd_sc_mcu7t5v0__fillcap_4
XFILLER_155_467 VDD VSS VDD VSS gf180mcu_fd_sc_mcu7t5v0__fillcap_16
XFILLER_89_63 VDD VSS VDD VSS gf180mcu_fd_sc_mcu7t5v0__fillcap_4
XFILLER_2_661 VDD VSS VDD VSS gf180mcu_fd_sc_mcu7t5v0__fillcap_4
XFILLER_64_101 VDD VSS VDD VSS gf180mcu_fd_sc_mcu7t5v0__fillcap_4
XFILLER_49_142 VDD VSS VDD VSS gf180mcu_fd_sc_mcu7t5v0__fillcap_64
XFILLER_92_443 VDD VSS VDD VSS gf180mcu_fd_sc_mcu7t5v0__fillcap_8
XFILLER_237_276 VDD VSS VDD VSS gf180mcu_fd_sc_mcu7t5v0__fillcap_4
XFILLER_225_416 VDD VSS VDD VSS gf180mcu_fd_sc_mcu7t5v0__fillcap_4
XFILLER_46_871 VDD VSS VDD VSS gf180mcu_fd_sc_mcu7t5v0__fillcap_4
XFILLER_61_874 VDD VSS VDD VSS gf180mcu_fd_sc_mcu7t5v0__fillcap_16
X_1994_ _2000_/S VDD VSS _3038_/D wire123/Z _3038_/Q VDD VSS gf180mcu_fd_sc_mcu7t5v0__mux2_2
XFILLER_9_282 VDD VSS VDD VSS gf180mcu_fd_sc_mcu7t5v0__fillcap_64
XFILLER_109_18 VDD VSS VDD VSS gf180mcu_fd_sc_mcu7t5v0__fillcap_8
Xclkload52 VDD VSS _3349_/CLK clkload52/ZN VDD VSS gf180mcu_fd_sc_mcu7t5v0__clkinv_2
Xclkload30 VSS clkload30/Z _3046_/CLK VDD VDD VSS gf180mcu_fd_sc_mcu7t5v0__clkbuf_1
Xclkload41 VDD VSS _3044_/CLK clkload41/ZN VDD VSS gf180mcu_fd_sc_mcu7t5v0__clkinv_1
X_2615_ _2619_/S VDD VSS _3278_/D _3236_/Q wire97/I VDD VSS gf180mcu_fd_sc_mcu7t5v0__mux2_2
Xclkload74 VSS clkload74/Z _3415_/CLK VDD VDD VSS gf180mcu_fd_sc_mcu7t5v0__clkbuf_1
Xclkload85 VSS clkload85/Z _2931_/CLK VDD VDD VSS gf180mcu_fd_sc_mcu7t5v0__clkbuf_1
Xclkload63 VDD VSS _3211_/CLK clkload63/ZN VDD VSS gf180mcu_fd_sc_mcu7t5v0__clkinv_2
X_2546_ VDD _2546_/B _2529_/C _2547_/A4 _2546_/A1 VSS VDD VSS gf180mcu_fd_sc_mcu7t5v0__oai21_1
X_2477_ VDD _2478_/A3 _2477_/B _2804_/Q _2477_/A2 VSS _2274_/C VDD VSS gf180mcu_fd_sc_mcu7t5v0__oai31_1
XFILLER_87_226 VDD VSS VDD VSS gf180mcu_fd_sc_mcu7t5v0__fillcap_16
X_1428_ VDD VSS _3223_/Q _2546_/B VDD VSS gf180mcu_fd_sc_mcu7t5v0__clkinv_1
XFILLER_229_766 VDD VSS VDD VSS gf180mcu_fd_sc_mcu7t5v0__fillcap_4
XFILLER_68_451 VDD VSS VDD VSS gf180mcu_fd_sc_mcu7t5v0__fillcap_4
XFILLER_18_37 VDD VSS VDD VSS gf180mcu_fd_sc_mcu7t5v0__fillcap_64
XFILLER_24_521 VDD VSS VDD VSS gf180mcu_fd_sc_mcu7t5v0__fillcap_4
X_3029_ VDD _3029_/Q _3044_/CLK VSS _3029_/D VDD VSS gf180mcu_fd_sc_mcu7t5v0__dffq_1
XFILLER_36_381 VDD VSS VDD VSS gf180mcu_fd_sc_mcu7t5v0__fillcap_4
XFILLER_196_334 VDD VSS VDD VSS gf180mcu_fd_sc_mcu7t5v0__fillcap_4
XFILLER_52_885 VDD VSS VDD VSS gf180mcu_fd_sc_mcu7t5v0__fillcap_4
Xclkload2 VSS clkload2/ZN clkload2/I VDD VDD VSS gf180mcu_fd_sc_mcu7t5v0__inv_4
Xwire106 VSS wire106/Z _2474_/B VDD VDD VSS gf180mcu_fd_sc_mcu7t5v0__clkbuf_1
Xwire128 VSS wire128/Z _3125_/Q VDD VDD VSS gf180mcu_fd_sc_mcu7t5v0__buf_2
XFILLER_192_551 VDD VSS VDD VSS gf180mcu_fd_sc_mcu7t5v0__fillcap_4
XFILLER_59_66 VDD VSS VDD VSS gf180mcu_fd_sc_mcu7t5v0__fillcap_4
XFILLER_75_10 VDD VSS VDD VSS gf180mcu_fd_sc_mcu7t5v0__fillcap_4
XFILLER_115_72 VDD VSS VDD VSS gf180mcu_fd_sc_mcu7t5v0__fillcap_8
XFILLER_219_276 VDD VSS VDD VSS gf180mcu_fd_sc_mcu7t5v0__fillcap_4
XFILLER_207_416 VDD VSS VDD VSS gf180mcu_fd_sc_mcu7t5v0__fillcap_4
XFILLER_46_101 VDD VSS VDD VSS gf180mcu_fd_sc_mcu7t5v0__fillcap_4
XFILLER_219_298 VDD VSS VDD VSS gf180mcu_fd_sc_mcu7t5v0__fillcap_8
XFILLER_28_871 VDD VSS VDD VSS gf180mcu_fd_sc_mcu7t5v0__fillcap_4
Xload_slew69 _2722_/S0 _2730_/S0 VDD VSS VDD VSS gf180mcu_fd_sc_mcu7t5v0__buf_4
XFILLER_131_60 VDD VSS VDD VSS gf180mcu_fd_sc_mcu7t5v0__fillcap_8
XFILLER_43_874 VDD VSS VDD VSS gf180mcu_fd_sc_mcu7t5v0__fillcap_16
XFILLER_203_677 VDD VSS VDD VSS gf180mcu_fd_sc_mcu7t5v0__fillcap_16
XFILLER_183_540 VDD VSS VDD VSS gf180mcu_fd_sc_mcu7t5v0__fillcap_8
XFILLER_183_562 VDD VSS VDD VSS gf180mcu_fd_sc_mcu7t5v0__fillcap_32
XFILLER_171_702 VDD VSS VDD VSS gf180mcu_fd_sc_mcu7t5v0__fillcap_64
XFILLER_6_241 VDD VSS VDD VSS gf180mcu_fd_sc_mcu7t5v0__fillcap_4
X_2400_ _2442_/S VDD VSS _2400_/Z _2398_/Z _2399_/Z VDD VSS gf180mcu_fd_sc_mcu7t5v0__mux2_2
X_3380_ _3380_/D _3380_/Q _3458_/RN VSS _3380_/CLK VDD VDD VSS gf180mcu_fd_sc_mcu7t5v0__dffrnq_1
X_2331_ VDD _2331_/B _2482_/A3 _2333_/A3 _2803_/Q VSS VDD VSS gf180mcu_fd_sc_mcu7t5v0__oai21_1
X_2262_ VDD _2262_/B _2232_/B _2264_/A2 _2262_/A1 VSS VDD VSS gf180mcu_fd_sc_mcu7t5v0__oai21_1
XFILLER_242_37 VDD VSS VDD VSS gf180mcu_fd_sc_mcu7t5v0__fillcap_64
XFILLER_242_26 VDD VSS VDD VSS gf180mcu_fd_sc_mcu7t5v0__fillcap_8
X_2193_ _2193_/B VDD VSS _3147_/D _2189_/S _2193_/A2 VDD VSS gf180mcu_fd_sc_mcu7t5v0__aoi21_1
XFILLER_80_457 VDD VSS VDD VSS gf180mcu_fd_sc_mcu7t5v0__fillcap_64
XFILLER_18_381 VDD VSS VDD VSS gf180mcu_fd_sc_mcu7t5v0__fillcap_4
XFILLER_34_885 VDD VSS VDD VSS gf180mcu_fd_sc_mcu7t5v0__fillcap_4
XFILLER_138_209 VDD VSS VDD VSS gf180mcu_fd_sc_mcu7t5v0__fillcap_8
X_1977_ _1981_/S VDD VSS _3024_/D wire119/Z _3024_/Q VDD VSS gf180mcu_fd_sc_mcu7t5v0__mux2_2
XFILLER_119_456 VDD VSS VDD VSS gf180mcu_fd_sc_mcu7t5v0__fillcap_4
X_2529_ _2546_/B _2529_/C VDD VSS _2532_/A1 _2529_/A1 _2529_/A2 _2528_/Z VDD VSS gf180mcu_fd_sc_mcu7t5v0__aoi221_1
XFILLER_152_37 VDD VSS VDD VSS gf180mcu_fd_sc_mcu7t5v0__fillcap_16
XFILLER_102_356 VDD VSS VDD VSS gf180mcu_fd_sc_mcu7t5v0__fillcap_16
XFILLER_130_698 VDD VSS VDD VSS gf180mcu_fd_sc_mcu7t5v0__fillcap_32
XFILLER_28_101 VDD VSS VDD VSS gf180mcu_fd_sc_mcu7t5v0__fillcap_4
XFILLER_25_874 VDD VSS VDD VSS gf180mcu_fd_sc_mcu7t5v0__fillcap_16
XFILLER_40_877 VDD VSS VDD VSS gf180mcu_fd_sc_mcu7t5v0__fillcap_8
Xclkbuf_3_6__f_clk_i VDD VSS clkload5/I clkbuf_0_clk_i/Z VDD VSS gf180mcu_fd_sc_mcu7t5v0__clkbuf_16
XFILLER_124_2 VDD VSS VDD VSS gf180mcu_fd_sc_mcu7t5v0__fillcap_32
XFILLER_165_562 VDD VSS VDD VSS gf180mcu_fd_sc_mcu7t5v0__fillcap_32
XFILLER_138_765 VDD VSS VDD VSS gf180mcu_fd_sc_mcu7t5v0__fillcap_32
XFILLER_153_702 VDD VSS VDD VSS gf180mcu_fd_sc_mcu7t5v0__fillcap_64
XFILLER_192_381 VDD VSS VDD VSS gf180mcu_fd_sc_mcu7t5v0__fillcap_4
XFILLER_193_55 VDD VSS VDD VSS gf180mcu_fd_sc_mcu7t5v0__fillcap_8
XFILLER_121_632 VDD VSS VDD VSS gf180mcu_fd_sc_mcu7t5v0__fillcap_64
XFILLER_94_527 VDD VSS VDD VSS gf180mcu_fd_sc_mcu7t5v0__fillcap_4
XFILLER_86_53 VDD VSS VDD VSS gf180mcu_fd_sc_mcu7t5v0__fillcap_4
XFILLER_94_549 VDD VSS VDD VSS gf180mcu_fd_sc_mcu7t5v0__fillcap_8
XFILLER_263_842 VDD VSS VDD VSS gf180mcu_fd_sc_mcu7t5v0__fillcap_32
XFILLER_212_18 VDD VSS VDD VSS gf180mcu_fd_sc_mcu7t5v0__fillcap_4
XFILLER_62_457 VDD VSS VDD VSS gf180mcu_fd_sc_mcu7t5v0__fillcap_64
XFILLER_16_885 VDD VSS VDD VSS gf180mcu_fd_sc_mcu7t5v0__fillcap_4
XFILLER_231_772 VDD VSS VDD VSS gf180mcu_fd_sc_mcu7t5v0__fillcap_64
X_2880_ VDD _2880_/Q _2899_/CLK VSS _2880_/D VDD VSS gf180mcu_fd_sc_mcu7t5v0__dffq_1
X_1900_ _1907_/S VDD VSS _2957_/D wire126/Z _2957_/Q VDD VSS gf180mcu_fd_sc_mcu7t5v0__mux2_2
XFILLER_187_142 VDD VSS VDD VSS gf180mcu_fd_sc_mcu7t5v0__fillcap_32
XFILLER_203_485 VDD VSS VDD VSS gf180mcu_fd_sc_mcu7t5v0__fillcap_4
X_1831_ _1832_/S VDD VSS _2899_/D _2899_/Q wire128/Z VDD VSS gf180mcu_fd_sc_mcu7t5v0__mux2_2
XFILLER_30_387 VDD VSS VDD VSS gf180mcu_fd_sc_mcu7t5v0__fillcap_64
XFILLER_184_871 VDD VSS VDD VSS gf180mcu_fd_sc_mcu7t5v0__fillcap_4
X_1762_ _1768_/S VDD VSS _2838_/D _3120_/Q _2838_/Q VDD VSS gf180mcu_fd_sc_mcu7t5v0__mux2_2
XFILLER_143_212 VDD VSS VDD VSS gf180mcu_fd_sc_mcu7t5v0__fillcap_64
X_1693_ _2239_/B _1693_/C VDD VSS _1694_/A3 _2262_/B _2480_/A3 _1683_/Z VDD VSS gf180mcu_fd_sc_mcu7t5v0__aoi221_1
X_3432_ _3432_/D _3432_/Q wire163/Z VSS _3461_/CLK VDD VDD VSS gf180mcu_fd_sc_mcu7t5v0__dffrnq_1
X_3363_ VSS _3363_/CLK VDD _3363_/D _3363_/Q _3359_/RN VDD VSS gf180mcu_fd_sc_mcu7t5v0__dffsnq_1
X_2314_ _2314_/A3 VDD VSS _2314_/Z _2482_/A2 _2274_/C VDD VSS gf180mcu_fd_sc_mcu7t5v0__or3_1
XFILLER_98_877 VDD VSS VDD VSS gf180mcu_fd_sc_mcu7t5v0__fillcap_8
X_3294_ _3294_/D _3294_/Q wire169/Z VSS _3446_/CLK VDD VDD VSS gf180mcu_fd_sc_mcu7t5v0__dffrnq_1
XFILLER_111_142 VDD VSS VDD VSS gf180mcu_fd_sc_mcu7t5v0__fillcap_16
X_2245_ VDD VSS _2246_/A4 _2239_/B _2245_/A2 VDD VSS gf180mcu_fd_sc_mcu7t5v0__nand2_1
X_2176_ VDD VSS _2177_/B _3177_/Q _3348_/D VDD VSS gf180mcu_fd_sc_mcu7t5v0__nand2_1
XFILLER_122_18 VDD VSS VDD VSS gf180mcu_fd_sc_mcu7t5v0__fillcap_16
XFILLER_253_352 VDD VSS VDD VSS gf180mcu_fd_sc_mcu7t5v0__fillcap_64
XFILLER_81_766 VDD VSS VDD VSS gf180mcu_fd_sc_mcu7t5v0__fillcap_4
XFILLER_179_632 VDD VSS VDD VSS gf180mcu_fd_sc_mcu7t5v0__fillcap_4
XFILLER_40_107 VDD VSS VDD VSS gf180mcu_fd_sc_mcu7t5v0__fillcap_64
XFILLER_178_131 VDD VSS VDD VSS gf180mcu_fd_sc_mcu7t5v0__fillcap_4
XFILLER_221_282 VDD VSS VDD VSS gf180mcu_fd_sc_mcu7t5v0__fillcap_16
XFILLER_22_877 VDD VSS VDD VSS gf180mcu_fd_sc_mcu7t5v0__fillcap_8
XFILLER_147_562 VDD VSS VDD VSS gf180mcu_fd_sc_mcu7t5v0__fillcap_16
XFILLER_135_702 VDD VSS VDD VSS gf180mcu_fd_sc_mcu7t5v0__fillcap_64
XFILLER_162_521 VDD VSS VDD VSS gf180mcu_fd_sc_mcu7t5v0__fillcap_4
XFILLER_174_381 VDD VSS VDD VSS gf180mcu_fd_sc_mcu7t5v0__fillcap_4
XFILLER_162_543 VDD VSS VDD VSS gf180mcu_fd_sc_mcu7t5v0__fillcap_8
XFILLER_190_885 VDD VSS VDD VSS gf180mcu_fd_sc_mcu7t5v0__fillcap_4
XFILLER_115_492 VDD VSS VDD VSS gf180mcu_fd_sc_mcu7t5v0__fillcap_64
XFILLER_103_632 VDD VSS VDD VSS gf180mcu_fd_sc_mcu7t5v0__fillcap_8
XFILLER_102_153 VDD VSS VDD VSS gf180mcu_fd_sc_mcu7t5v0__fillcap_16
XFILLER_130_451 VDD VSS VDD VSS gf180mcu_fd_sc_mcu7t5v0__fillcap_4
XFILLER_88_387 VDD VSS VDD VSS gf180mcu_fd_sc_mcu7t5v0__fillcap_32
XFILLER_76_527 VDD VSS VDD VSS gf180mcu_fd_sc_mcu7t5v0__fillcap_64
XFILLER_245_842 VDD VSS VDD VSS gf180mcu_fd_sc_mcu7t5v0__fillcap_32
XFILLER_260_801 VDD VSS VDD VSS gf180mcu_fd_sc_mcu7t5v0__fillcap_4
Xclkbuf_4_4_0_host_clk_i _3461_/CLK VSS VDD clkbuf_0_host_clk_i/Z VDD VSS gf180mcu_fd_sc_mcu7t5v0__clkbuf_2
XFILLER_44_457 VDD VSS VDD VSS gf180mcu_fd_sc_mcu7t5v0__fillcap_64
XFILLER_213_772 VDD VSS VDD VSS gf180mcu_fd_sc_mcu7t5v0__fillcap_64
XFILLER_169_142 VDD VSS VDD VSS gf180mcu_fd_sc_mcu7t5v0__fillcap_32
XFILLER_188_22 VDD VSS VDD VSS gf180mcu_fd_sc_mcu7t5v0__fillcap_8
XFILLER_240_591 VDD VSS VDD VSS gf180mcu_fd_sc_mcu7t5v0__fillcap_4
XFILLER_185_624 VDD VSS VDD VSS gf180mcu_fd_sc_mcu7t5v0__fillcap_4
XFILLER_12_387 VDD VSS VDD VSS gf180mcu_fd_sc_mcu7t5v0__fillcap_64
XFILLER_169_197 VDD VSS VDD VSS gf180mcu_fd_sc_mcu7t5v0__fillcap_4
XFILLER_166_871 VDD VSS VDD VSS gf180mcu_fd_sc_mcu7t5v0__fillcap_4
XFILLER_125_212 VDD VSS VDD VSS gf180mcu_fd_sc_mcu7t5v0__fillcap_4
XFILLER_126_724 VDD VSS VDD VSS gf180mcu_fd_sc_mcu7t5v0__fillcap_8
XFILLER_153_532 VDD VSS VDD VSS gf180mcu_fd_sc_mcu7t5v0__fillcap_16
XFILLER_181_874 VDD VSS VDD VSS gf180mcu_fd_sc_mcu7t5v0__fillcap_16
XFILLER_4_597 VDD VSS VDD VSS gf180mcu_fd_sc_mcu7t5v0__fillcap_64
XFILLER_267_422 VDD VSS VDD VSS gf180mcu_fd_sc_mcu7t5v0__fillcap_64
XFILLER_95_836 VDD VSS VDD VSS gf180mcu_fd_sc_mcu7t5v0__fillcap_4
X_2030_ _2040_/S VDD VSS _3063_/D wire96/Z _3063_/Q VDD VSS gf180mcu_fd_sc_mcu7t5v0__mux2_2
XFILLER_11_6 VDD VSS VDD VSS gf180mcu_fd_sc_mcu7t5v0__fillcap_64
XFILLER_235_352 VDD VSS VDD VSS gf180mcu_fd_sc_mcu7t5v0__fillcap_64
XFILLER_250_311 VDD VSS VDD VSS gf180mcu_fd_sc_mcu7t5v0__fillcap_4
XFILLER_223_536 VDD VSS VDD VSS gf180mcu_fd_sc_mcu7t5v0__fillcap_16
XFILLER_262_171 VDD VSS VDD VSS gf180mcu_fd_sc_mcu7t5v0__fillcap_4
XFILLER_63_766 VDD VSS VDD VSS gf180mcu_fd_sc_mcu7t5v0__fillcap_4
XFILLER_22_107 VDD VSS VDD VSS gf180mcu_fd_sc_mcu7t5v0__fillcap_64
X_2932_ VDD _2932_/Q _2932_/CLK VSS _2932_/D VDD VSS gf180mcu_fd_sc_mcu7t5v0__dffq_1
XFILLER_176_613 VDD VSS VDD VSS gf180mcu_fd_sc_mcu7t5v0__fillcap_8
XFILLER_203_282 VDD VSS VDD VSS gf180mcu_fd_sc_mcu7t5v0__fillcap_16
X_2863_ VDD _2863_/Q _3369_/CLK VSS _2863_/D VDD VSS gf180mcu_fd_sc_mcu7t5v0__dffq_1
XFILLER_31_696 VDD VSS VDD VSS gf180mcu_fd_sc_mcu7t5v0__fillcap_4
X_1814_ _1814_/S VDD VSS _2884_/D _1869_/I0 _2884_/Q VDD VSS gf180mcu_fd_sc_mcu7t5v0__mux2_2
XFILLER_129_562 VDD VSS VDD VSS gf180mcu_fd_sc_mcu7t5v0__fillcap_32
XFILLER_117_702 VDD VSS VDD VSS gf180mcu_fd_sc_mcu7t5v0__fillcap_64
X_2794_ VDD VSS _2794_/I _3338_/D VDD VSS gf180mcu_fd_sc_mcu7t5v0__clkinv_1
X_1745_ _1748_/S VDD VSS _2825_/D _2825_/Q wire132/Z VDD VSS gf180mcu_fd_sc_mcu7t5v0__mux2_2
XFILLER_7_72 VDD VSS VDD VSS gf180mcu_fd_sc_mcu7t5v0__fillcap_64
XFILLER_172_885 VDD VSS VDD VSS gf180mcu_fd_sc_mcu7t5v0__fillcap_4
X_1676_ VDD _1676_/B _1689_/B _1693_/C _2804_/Q VSS VDD VSS gf180mcu_fd_sc_mcu7t5v0__oai21_1
X_3415_ _3415_/D _3433_/D wire161/I VSS _3415_/CLK VDD VDD VSS gf180mcu_fd_sc_mcu7t5v0__dffrnq_1
X_3346_ VSS _3348_/CLK VDD _3346_/D _3346_/Q wire151/Z VDD VSS gf180mcu_fd_sc_mcu7t5v0__dffsnq_1
XFILLER_58_527 VDD VSS VDD VSS gf180mcu_fd_sc_mcu7t5v0__fillcap_64
X_3277_ _3277_/D _3277_/Q wire145/Z VSS _3277_/CLK VDD VDD VSS gf180mcu_fd_sc_mcu7t5v0__dffrnq_1
XFILLER_227_842 VDD VSS VDD VSS gf180mcu_fd_sc_mcu7t5v0__fillcap_32
X_2228_ _2228_/B VDD VSS _3170_/D _2228_/A1 _2228_/A2 VDD VSS gf180mcu_fd_sc_mcu7t5v0__aoi21_1
XFILLER_242_801 VDD VSS VDD VSS gf180mcu_fd_sc_mcu7t5v0__fillcap_4
XFILLER_254_661 VDD VSS VDD VSS gf180mcu_fd_sc_mcu7t5v0__fillcap_4
X_2159_ _2157_/Z _2159_/B2 VDD VSS _3132_/D _2159_/A1 _2168_/C VDD VSS gf180mcu_fd_sc_mcu7t5v0__aoi22_1
XFILLER_26_37 VDD VSS VDD VSS gf180mcu_fd_sc_mcu7t5v0__fillcap_64
XFILLER_214_547 VDD VSS VDD VSS gf180mcu_fd_sc_mcu7t5v0__fillcap_16
XFILLER_199_749 VDD VSS VDD VSS gf180mcu_fd_sc_mcu7t5v0__fillcap_16
XFILLER_26_457 VDD VSS VDD VSS gf180mcu_fd_sc_mcu7t5v0__fillcap_64
XFILLER_53_276 VDD VSS VDD VSS gf180mcu_fd_sc_mcu7t5v0__fillcap_4
XFILLER_41_416 VDD VSS VDD VSS gf180mcu_fd_sc_mcu7t5v0__fillcap_4
XFILLER_210_731 VDD VSS VDD VSS gf180mcu_fd_sc_mcu7t5v0__fillcap_4
Xmax_length32 wire28/I _2060_/S VDD VSS VDD VSS gf180mcu_fd_sc_mcu7t5v0__buf_4
Xmax_length43 _2537_/S VSS VDD _2539_/S VDD VSS gf180mcu_fd_sc_mcu7t5v0__clkbuf_3
XFILLER_148_871 VDD VSS VDD VSS gf180mcu_fd_sc_mcu7t5v0__fillcap_4
XFILLER_158_69 VDD VSS VDD VSS gf180mcu_fd_sc_mcu7t5v0__fillcap_16
XFILLER_6_807 VDD VSS VDD VSS gf180mcu_fd_sc_mcu7t5v0__fillcap_64
Xmax_length65 VSS wire60/I _3421_/Q VDD VDD VSS gf180mcu_fd_sc_mcu7t5v0__buf_2
XFILLER_181_104 VDD VSS VDD VSS gf180mcu_fd_sc_mcu7t5v0__fillcap_16
XFILLER_108_724 VDD VSS VDD VSS gf180mcu_fd_sc_mcu7t5v0__fillcap_8
XFILLER_107_201 VDD VSS VDD VSS gf180mcu_fd_sc_mcu7t5v0__fillcap_8
XFILLER_150_513 VDD VSS VDD VSS gf180mcu_fd_sc_mcu7t5v0__fillcap_8
XFILLER_163_874 VDD VSS VDD VSS gf180mcu_fd_sc_mcu7t5v0__fillcap_16
XFILLER_249_422 VDD VSS VDD VSS gf180mcu_fd_sc_mcu7t5v0__fillcap_64
XFILLER_1_556 VDD VSS VDD VSS gf180mcu_fd_sc_mcu7t5v0__fillcap_4
XFILLER_191_2 VDD VSS VDD VSS gf180mcu_fd_sc_mcu7t5v0__fillcap_16
XFILLER_67_66 VDD VSS VDD VSS gf180mcu_fd_sc_mcu7t5v0__fillcap_4
XFILLER_77_836 VDD VSS VDD VSS gf180mcu_fd_sc_mcu7t5v0__fillcap_4
XFILLER_89_696 VDD VSS VDD VSS gf180mcu_fd_sc_mcu7t5v0__fillcap_4
XFILLER_217_352 VDD VSS VDD VSS gf180mcu_fd_sc_mcu7t5v0__fillcap_64
XFILLER_123_72 VDD VSS VDD VSS gf180mcu_fd_sc_mcu7t5v0__fillcap_32
XFILLER_232_311 VDD VSS VDD VSS gf180mcu_fd_sc_mcu7t5v0__fillcap_4
XFILLER_244_171 VDD VSS VDD VSS gf180mcu_fd_sc_mcu7t5v0__fillcap_4
XFILLER_45_766 VDD VSS VDD VSS gf180mcu_fd_sc_mcu7t5v0__fillcap_4
XFILLER_213_580 VDD VSS VDD VSS gf180mcu_fd_sc_mcu7t5v0__fillcap_8
XFILLER_13_696 VDD VSS VDD VSS gf180mcu_fd_sc_mcu7t5v0__fillcap_4
XFILLER_138_370 VDD VSS VDD VSS gf180mcu_fd_sc_mcu7t5v0__fillcap_8
XFILLER_8_177 VDD VSS VDD VSS gf180mcu_fd_sc_mcu7t5v0__fillcap_64
XFILLER_153_340 VDD VSS VDD VSS gf180mcu_fd_sc_mcu7t5v0__fillcap_8
XFILLER_126_554 VDD VSS VDD VSS gf180mcu_fd_sc_mcu7t5v0__fillcap_8
X_1530_ VDD VSS _3384_/D _3405_/D _1530_/A2 VDD VSS gf180mcu_fd_sc_mcu7t5v0__xnor2_1
XFILLER_154_885 VDD VSS VDD VSS gf180mcu_fd_sc_mcu7t5v0__fillcap_4
X_1461_ VDD VSS _3420_/D _1485_/A2 _1483_/A2 VDD VSS gf180mcu_fd_sc_mcu7t5v0__nor2_1
X_1392_ VDD VSS _3171_/Q _2243_/B VDD VSS gf180mcu_fd_sc_mcu7t5v0__clkinv_1
X_3200_ _3200_/D _3200_/Q wire147/Z VSS _3202_/CLK VDD VDD VSS gf180mcu_fd_sc_mcu7t5v0__dffrnq_1
X_3131_ _3131_/D _3131_/Q wire151/Z VSS _3185_/CLK VDD VDD VSS gf180mcu_fd_sc_mcu7t5v0__dffrnq_1
XFILLER_67_346 VDD VSS VDD VSS gf180mcu_fd_sc_mcu7t5v0__fillcap_4
XFILLER_94_132 VDD VSS VDD VSS gf180mcu_fd_sc_mcu7t5v0__fillcap_8
XFILLER_209_842 VDD VSS VDD VSS gf180mcu_fd_sc_mcu7t5v0__fillcap_32
X_3062_ _3062_/D _3062_/Q wire145/Z VSS _3277_/CLK VDD VDD VSS gf180mcu_fd_sc_mcu7t5v0__dffrnq_1
XFILLER_224_801 VDD VSS VDD VSS gf180mcu_fd_sc_mcu7t5v0__fillcap_4
XFILLER_236_661 VDD VSS VDD VSS gf180mcu_fd_sc_mcu7t5v0__fillcap_4
XFILLER_208_363 VDD VSS VDD VSS gf180mcu_fd_sc_mcu7t5v0__fillcap_16
XFILLER_250_37 VDD VSS VDD VSS gf180mcu_fd_sc_mcu7t5v0__fillcap_64
X_2013_ _2018_/S VDD VSS _3055_/D wire121/Z _3055_/Q VDD VSS gf180mcu_fd_sc_mcu7t5v0__mux2_2
XFILLER_90_371 VDD VSS VDD VSS gf180mcu_fd_sc_mcu7t5v0__fillcap_8
XFILLER_23_416 VDD VSS VDD VSS gf180mcu_fd_sc_mcu7t5v0__fillcap_4
XFILLER_35_276 VDD VSS VDD VSS gf180mcu_fd_sc_mcu7t5v0__fillcap_4
X_2915_ VDD _2915_/Q _2931_/CLK VSS _2915_/D VDD VSS gf180mcu_fd_sc_mcu7t5v0__dffq_1
XFILLER_148_123 VDD VSS VDD VSS gf180mcu_fd_sc_mcu7t5v0__fillcap_4
XFILLER_176_410 VDD VSS VDD VSS gf180mcu_fd_sc_mcu7t5v0__fillcap_4
X_2846_ VDD _2846_/Q _2914_/CLK VSS _2846_/D VDD VSS gf180mcu_fd_sc_mcu7t5v0__dffq_1
X_2777_ wire20/Z _3082_/Q VDD VSS _2778_/A2 _3330_/Q _2739_/S VDD VSS gf180mcu_fd_sc_mcu7t5v0__aoi22_1
X_1728_ _1728_/S VDD VSS _2812_/D _2812_/Q _3126_/Q VDD VSS gf180mcu_fd_sc_mcu7t5v0__mux2_2
XFILLER_145_874 VDD VSS VDD VSS gf180mcu_fd_sc_mcu7t5v0__fillcap_16
XFILLER_144_362 VDD VSS VDD VSS gf180mcu_fd_sc_mcu7t5v0__fillcap_4
X_1659_ VDD VSS _2262_/B _2803_/Q _2337_/A1 VDD VSS gf180mcu_fd_sc_mcu7t5v0__and2_1
XFILLER_160_877 VDD VSS VDD VSS gf180mcu_fd_sc_mcu7t5v0__fillcap_8
XFILLER_258_241 VDD VSS VDD VSS gf180mcu_fd_sc_mcu7t5v0__fillcap_4
XFILLER_59_836 VDD VSS VDD VSS gf180mcu_fd_sc_mcu7t5v0__fillcap_4
XFILLER_224_60 VDD VSS VDD VSS gf180mcu_fd_sc_mcu7t5v0__fillcap_8
X_3329_ _3329_/D _3329_/Q wire145/I VSS _3329_/CLK VDD VDD VSS gf180mcu_fd_sc_mcu7t5v0__dffrnq_1
XFILLER_160_37 VDD VSS VDD VSS gf180mcu_fd_sc_mcu7t5v0__fillcap_4
XFILLER_214_311 VDD VSS VDD VSS gf180mcu_fd_sc_mcu7t5v0__fillcap_4
XFILLER_226_171 VDD VSS VDD VSS gf180mcu_fd_sc_mcu7t5v0__fillcap_4
XFILLER_163_6 VDD VSS VDD VSS gf180mcu_fd_sc_mcu7t5v0__fillcap_64
XFILLER_27_766 VDD VSS VDD VSS gf180mcu_fd_sc_mcu7t5v0__fillcap_4
XFILLER_186_229 VDD VSS VDD VSS gf180mcu_fd_sc_mcu7t5v0__fillcap_16
XFILLER_167_454 VDD VSS VDD VSS gf180mcu_fd_sc_mcu7t5v0__fillcap_16
XFILLER_194_284 VDD VSS VDD VSS gf180mcu_fd_sc_mcu7t5v0__fillcap_16
XFILLER_182_457 VDD VSS VDD VSS gf180mcu_fd_sc_mcu7t5v0__fillcap_16
XFILLER_108_521 VDD VSS VDD VSS gf180mcu_fd_sc_mcu7t5v0__fillcap_4
XFILLER_5_136 VDD VSS VDD VSS gf180mcu_fd_sc_mcu7t5v0__fillcap_4
XFILLER_136_885 VDD VSS VDD VSS gf180mcu_fd_sc_mcu7t5v0__fillcap_4
XFILLER_204_2 VDD VSS VDD VSS gf180mcu_fd_sc_mcu7t5v0__fillcap_16
XFILLER_78_21 VDD VSS VDD VSS gf180mcu_fd_sc_mcu7t5v0__fillcap_8
XFILLER_150_387 VDD VSS VDD VSS gf180mcu_fd_sc_mcu7t5v0__fillcap_64
XFILLER_49_346 VDD VSS VDD VSS gf180mcu_fd_sc_mcu7t5v0__fillcap_4
XFILLER_134_93 VDD VSS VDD VSS gf180mcu_fd_sc_mcu7t5v0__fillcap_8
XFILLER_209_127 VDD VSS VDD VSS gf180mcu_fd_sc_mcu7t5v0__fillcap_8
XFILLER_206_801 VDD VSS VDD VSS gf180mcu_fd_sc_mcu7t5v0__fillcap_4
XFILLER_220_29 VDD VSS VDD VSS gf180mcu_fd_sc_mcu7t5v0__fillcap_4
XFILLER_17_276 VDD VSS VDD VSS gf180mcu_fd_sc_mcu7t5v0__fillcap_4
X_2700_ VDD VSS _2701_/B _3313_/Q _2749_/C VDD VSS gf180mcu_fd_sc_mcu7t5v0__nand2_1
XFILLER_9_486 VDD VSS VDD VSS gf180mcu_fd_sc_mcu7t5v0__fillcap_4
X_2631_ wire46/Z VDD VSS _3294_/D _3252_/Q _3294_/Q VDD VSS gf180mcu_fd_sc_mcu7t5v0__mux2_2
XFILLER_160_107 VDD VSS VDD VSS gf180mcu_fd_sc_mcu7t5v0__fillcap_32
X_2562_ _2566_/S VDD VSS _3231_/D _3216_/Q _3231_/Q VDD VSS gf180mcu_fd_sc_mcu7t5v0__mux2_2
XFILLER_127_874 VDD VSS VDD VSS gf180mcu_fd_sc_mcu7t5v0__fillcap_16
X_1513_ VDD VSS _3371_/D _3394_/D _1728_/S VDD VSS gf180mcu_fd_sc_mcu7t5v0__xor2_1
XFILLER_141_310 VDD VSS VDD VSS gf180mcu_fd_sc_mcu7t5v0__fillcap_16
XFILLER_142_877 VDD VSS VDD VSS gf180mcu_fd_sc_mcu7t5v0__fillcap_8
X_2493_ VDD VSS _2495_/A1 _3212_/Q _2486_/B VDD VSS gf180mcu_fd_sc_mcu7t5v0__nand2_1
X_1444_ VDD VSS _3132_/Q _2159_/A1 VDD VSS gf180mcu_fd_sc_mcu7t5v0__clkinv_1
X_3114_ _3114_/D _3114_/Q _3359_/RN VSS _3192_/CLK VDD VDD VSS gf180mcu_fd_sc_mcu7t5v0__dffrnq_1
X_3045_ VDD _3045_/Q _3046_/CLK VSS _3045_/D VDD VSS gf180mcu_fd_sc_mcu7t5v0__dffq_1
XFILLER_209_694 VDD VSS VDD VSS gf180mcu_fd_sc_mcu7t5v0__fillcap_4
XFILLER_223_130 VDD VSS VDD VSS gf180mcu_fd_sc_mcu7t5v0__fillcap_8
XFILLER_196_527 VDD VSS VDD VSS gf180mcu_fd_sc_mcu7t5v0__fillcap_16
XFILLER_211_369 VDD VSS VDD VSS gf180mcu_fd_sc_mcu7t5v0__fillcap_16
XFILLER_139_38 VDD VSS VDD VSS gf180mcu_fd_sc_mcu7t5v0__fillcap_32
X_2829_ VDD _2829_/Q _3458_/CLK VSS _2829_/D VDD VSS gf180mcu_fd_sc_mcu7t5v0__dffq_1
XFILLER_164_457 VDD VSS VDD VSS gf180mcu_fd_sc_mcu7t5v0__fillcap_4
XFILLER_117_340 VDD VSS VDD VSS gf180mcu_fd_sc_mcu7t5v0__fillcap_8
XFILLER_118_885 VDD VSS VDD VSS gf180mcu_fd_sc_mcu7t5v0__fillcap_4
XFILLER_191_298 VDD VSS VDD VSS gf180mcu_fd_sc_mcu7t5v0__fillcap_4
XFILLER_132_387 VDD VSS VDD VSS gf180mcu_fd_sc_mcu7t5v0__fillcap_16
XFILLER_262_737 VDD VSS VDD VSS gf180mcu_fd_sc_mcu7t5v0__fillcap_64
XFILLER_73_157 VDD VSS VDD VSS gf180mcu_fd_sc_mcu7t5v0__fillcap_4
XFILLER_214_141 VDD VSS VDD VSS gf180mcu_fd_sc_mcu7t5v0__fillcap_32
XFILLER_154_2 VDD VSS VDD VSS gf180mcu_fd_sc_mcu7t5v0__fillcap_32
XFILLER_230_667 VDD VSS VDD VSS gf180mcu_fd_sc_mcu7t5v0__fillcap_64
XFILLER_167_273 VDD VSS VDD VSS gf180mcu_fd_sc_mcu7t5v0__fillcap_4
XFILLER_183_766 VDD VSS VDD VSS gf180mcu_fd_sc_mcu7t5v0__fillcap_4
XFILLER_142_107 VDD VSS VDD VSS gf180mcu_fd_sc_mcu7t5v0__fillcap_8
XFILLER_182_276 VDD VSS VDD VSS gf180mcu_fd_sc_mcu7t5v0__fillcap_4
XFILLER_109_874 VDD VSS VDD VSS gf180mcu_fd_sc_mcu7t5v0__fillcap_16
XFILLER_182_287 VDD VSS VDD VSS gf180mcu_fd_sc_mcu7t5v0__fillcap_16
XFILLER_124_877 VDD VSS VDD VSS gf180mcu_fd_sc_mcu7t5v0__fillcap_8
XFILLER_96_238 VDD VSS VDD VSS gf180mcu_fd_sc_mcu7t5v0__fillcap_4
XFILLER_252_247 VDD VSS VDD VSS gf180mcu_fd_sc_mcu7t5v0__fillcap_64
XFILLER_61_842 VDD VSS VDD VSS gf180mcu_fd_sc_mcu7t5v0__fillcap_32
XFILLER_178_527 VDD VSS VDD VSS gf180mcu_fd_sc_mcu7t5v0__fillcap_32
XFILLER_220_177 VDD VSS VDD VSS gf180mcu_fd_sc_mcu7t5v0__fillcap_64
X_1993_ _2000_/S VDD VSS _3037_/D _2011_/I0 _3037_/Q VDD VSS gf180mcu_fd_sc_mcu7t5v0__mux2_2
XFILLER_119_605 VDD VSS VDD VSS gf180mcu_fd_sc_mcu7t5v0__fillcap_16
XFILLER_146_457 VDD VSS VDD VSS gf180mcu_fd_sc_mcu7t5v0__fillcap_64
Xclkload20 VSS clkload20/Z _3454_/CLK VDD VDD VSS gf180mcu_fd_sc_mcu7t5v0__clkbuf_1
Xclkload53 VSS clkload53/Z _3166_/CLK VDD VDD VSS gf180mcu_fd_sc_mcu7t5v0__clkbuf_1
XFILLER_173_276 VDD VSS VDD VSS gf180mcu_fd_sc_mcu7t5v0__fillcap_4
X_2614_ _2614_/B VDD VSS _3277_/D _2614_/A1 wire46/I VDD VSS gf180mcu_fd_sc_mcu7t5v0__aoi21_1
Xclkload42 VDD VSS _3414_/CLK clkload42/ZN VDD VSS gf180mcu_fd_sc_mcu7t5v0__clkinv_2
Xclkload31 VSS clkload31/Z _3058_/CLK VDD VDD VSS gf180mcu_fd_sc_mcu7t5v0__clkbuf_1
Xclkload86 VDD VSS clkload86/ZN _3370_/CLK VDD VSS gf180mcu_fd_sc_mcu7t5v0__clkinv_8
Xclkload75 VDD VSS clkload75/ZN _2867_/CLK VDD VSS gf180mcu_fd_sc_mcu7t5v0__clkinv_4
Xclkload64 VDD VSS _3179_/CLK clkload64/ZN VDD VSS gf180mcu_fd_sc_mcu7t5v0__clkinv_2
X_2545_ _2550_/A1 _2544_/Z _2539_/S VDD VSS _3222_/D _2529_/C VDD VSS gf180mcu_fd_sc_mcu7t5v0__oai22_1
X_2476_ _2494_/C _2476_/B2 VDD VSS _2477_/B _2474_/B _2483_/B VDD VSS gf180mcu_fd_sc_mcu7t5v0__aoi22_1
XFILLER_125_18 VDD VSS VDD VSS gf180mcu_fd_sc_mcu7t5v0__fillcap_4
X_1427_ VDD VSS _3448_/D _1643_/A1 VDD VSS gf180mcu_fd_sc_mcu7t5v0__clkinv_1
XFILLER_83_422 VDD VSS VDD VSS gf180mcu_fd_sc_mcu7t5v0__fillcap_64
XFILLER_95_282 VDD VSS VDD VSS gf180mcu_fd_sc_mcu7t5v0__fillcap_32
XFILLER_244_737 VDD VSS VDD VSS gf180mcu_fd_sc_mcu7t5v0__fillcap_64
XFILLER_256_597 VDD VSS VDD VSS gf180mcu_fd_sc_mcu7t5v0__fillcap_64
XFILLER_224_450 VDD VSS VDD VSS gf180mcu_fd_sc_mcu7t5v0__fillcap_4
Xclkbuf_4_9_0_host_clk_i _3369_/CLK VSS VDD clkbuf_0_host_clk_i/Z VDD VSS gf180mcu_fd_sc_mcu7t5v0__clkbuf_2
X_3028_ VDD _3028_/Q _3409_/CLK VSS _3028_/D VDD VSS gf180mcu_fd_sc_mcu7t5v0__dffq_1
XFILLER_34_37 VDD VSS VDD VSS gf180mcu_fd_sc_mcu7t5v0__fillcap_64
XFILLER_169_549 VDD VSS VDD VSS gf180mcu_fd_sc_mcu7t5v0__fillcap_8
XFILLER_197_836 VDD VSS VDD VSS gf180mcu_fd_sc_mcu7t5v0__fillcap_4
XFILLER_200_807 VDD VSS VDD VSS gf180mcu_fd_sc_mcu7t5v0__fillcap_64
XFILLER_51_352 VDD VSS VDD VSS gf180mcu_fd_sc_mcu7t5v0__fillcap_64
XFILLER_212_667 VDD VSS VDD VSS gf180mcu_fd_sc_mcu7t5v0__fillcap_64
XFILLER_184_519 VDD VSS VDD VSS gf180mcu_fd_sc_mcu7t5v0__fillcap_4
Xclkload3 VSS clkload3/ZN clkload3/I VDD VDD VSS gf180mcu_fd_sc_mcu7t5v0__inv_4
XFILLER_196_379 VDD VSS VDD VSS gf180mcu_fd_sc_mcu7t5v0__fillcap_4
XFILLER_165_766 VDD VSS VDD VSS gf180mcu_fd_sc_mcu7t5v0__fillcap_4
XFILLER_106_877 VDD VSS VDD VSS gf180mcu_fd_sc_mcu7t5v0__fillcap_8
XFILLER_133_696 VDD VSS VDD VSS gf180mcu_fd_sc_mcu7t5v0__fillcap_4
XFILLER_121_836 VDD VSS VDD VSS gf180mcu_fd_sc_mcu7t5v0__fillcap_4
XFILLER_266_317 VDD VSS VDD VSS gf180mcu_fd_sc_mcu7t5v0__fillcap_64
XFILLER_87_772 VDD VSS VDD VSS gf180mcu_fd_sc_mcu7t5v0__fillcap_64
XFILLER_75_66 VDD VSS VDD VSS gf180mcu_fd_sc_mcu7t5v0__fillcap_4
XFILLER_234_247 VDD VSS VDD VSS gf180mcu_fd_sc_mcu7t5v0__fillcap_64
XFILLER_202_100 VDD VSS VDD VSS gf180mcu_fd_sc_mcu7t5v0__fillcap_4
XFILLER_131_72 VDD VSS VDD VSS gf180mcu_fd_sc_mcu7t5v0__fillcap_64
XFILLER_43_842 VDD VSS VDD VSS gf180mcu_fd_sc_mcu7t5v0__fillcap_32
XFILLER_70_661 VDD VSS VDD VSS gf180mcu_fd_sc_mcu7t5v0__fillcap_4
XFILLER_91_65 VDD VSS VDD VSS gf180mcu_fd_sc_mcu7t5v0__fillcap_4
XFILLER_11_772 VDD VSS VDD VSS gf180mcu_fd_sc_mcu7t5v0__fillcap_64
XFILLER_128_457 VDD VSS VDD VSS gf180mcu_fd_sc_mcu7t5v0__fillcap_4
XFILLER_143_438 VDD VSS VDD VSS gf180mcu_fd_sc_mcu7t5v0__fillcap_32
XFILLER_170_224 VDD VSS VDD VSS gf180mcu_fd_sc_mcu7t5v0__fillcap_16
XFILLER_258_807 VDD VSS VDD VSS gf180mcu_fd_sc_mcu7t5v0__fillcap_64
X_2330_ _2482_/A1 VDD VSS _2333_/A2 _1689_/C _2330_/A2 VDD VSS gf180mcu_fd_sc_mcu7t5v0__nand3_1
X_2261_ _2490_/B _2263_/B VDD VSS _2269_/B1 _3203_/Q _2239_/C VDD VSS gf180mcu_fd_sc_mcu7t5v0__aoi211_1
Xclkbuf_leaf_52_clk_i _2994_/CLK VSS VDD clkload1/I VDD VSS gf180mcu_fd_sc_mcu7t5v0__clkbuf_2
XFILLER_65_422 VDD VSS VDD VSS gf180mcu_fd_sc_mcu7t5v0__fillcap_64
X_2192_ VDD VSS _2193_/B _3147_/Q _2189_/S VDD VSS gf180mcu_fd_sc_mcu7t5v0__nor2_1
XFILLER_77_282 VDD VSS VDD VSS gf180mcu_fd_sc_mcu7t5v0__fillcap_32
XFILLER_226_737 VDD VSS VDD VSS gf180mcu_fd_sc_mcu7t5v0__fillcap_64
XFILLER_238_597 VDD VSS VDD VSS gf180mcu_fd_sc_mcu7t5v0__fillcap_64
XFILLER_92_241 VDD VSS VDD VSS gf180mcu_fd_sc_mcu7t5v0__fillcap_4
XFILLER_253_556 VDD VSS VDD VSS gf180mcu_fd_sc_mcu7t5v0__fillcap_4
Xclkbuf_leaf_67_clk_i _3339_/CLK VSS VDD clkbuf_3_0__f_clk_i/Z VDD VSS gf180mcu_fd_sc_mcu7t5v0__clkbuf_2
XFILLER_179_836 VDD VSS VDD VSS gf180mcu_fd_sc_mcu7t5v0__fillcap_4
XFILLER_33_352 VDD VSS VDD VSS gf180mcu_fd_sc_mcu7t5v0__fillcap_64
XFILLER_60_171 VDD VSS VDD VSS gf180mcu_fd_sc_mcu7t5v0__fillcap_4
XFILLER_166_519 VDD VSS VDD VSS gf180mcu_fd_sc_mcu7t5v0__fillcap_4
X_1976_ _1981_/S VDD VSS _3023_/D wire121/Z _3023_/Q VDD VSS gf180mcu_fd_sc_mcu7t5v0__mux2_2
XFILLER_106_107 VDD VSS VDD VSS gf180mcu_fd_sc_mcu7t5v0__fillcap_64
XFILLER_136_28 VDD VSS VDD VSS gf180mcu_fd_sc_mcu7t5v0__fillcap_4
XFILLER_103_836 VDD VSS VDD VSS gf180mcu_fd_sc_mcu7t5v0__fillcap_4
X_2528_ VDD VSS _2528_/Z _2528_/A1 _2528_/A2 VDD VSS gf180mcu_fd_sc_mcu7t5v0__and2_1
XFILLER_248_317 VDD VSS VDD VSS gf180mcu_fd_sc_mcu7t5v0__fillcap_64
X_2459_ VDD VSS _2462_/A2 _2459_/A1 _2458_/Z VDD VSS gf180mcu_fd_sc_mcu7t5v0__nand2_1
XFILLER_69_772 VDD VSS VDD VSS gf180mcu_fd_sc_mcu7t5v0__fillcap_64
XFILLER_84_731 VDD VSS VDD VSS gf180mcu_fd_sc_mcu7t5v0__fillcap_4
XFILLER_216_247 VDD VSS VDD VSS gf180mcu_fd_sc_mcu7t5v0__fillcap_64
XFILLER_231_206 VDD VSS VDD VSS gf180mcu_fd_sc_mcu7t5v0__fillcap_4
XFILLER_25_842 VDD VSS VDD VSS gf180mcu_fd_sc_mcu7t5v0__fillcap_32
XFILLER_52_661 VDD VSS VDD VSS gf180mcu_fd_sc_mcu7t5v0__fillcap_4
XFILLER_40_801 VDD VSS VDD VSS gf180mcu_fd_sc_mcu7t5v0__fillcap_4
XFILLER_212_442 VDD VSS VDD VSS gf180mcu_fd_sc_mcu7t5v0__fillcap_8
XFILLER_169_346 VDD VSS VDD VSS gf180mcu_fd_sc_mcu7t5v0__fillcap_4
XFILLER_20_591 VDD VSS VDD VSS gf180mcu_fd_sc_mcu7t5v0__fillcap_4
XFILLER_3_212 VDD VSS VDD VSS gf180mcu_fd_sc_mcu7t5v0__fillcap_64
XFILLER_267_626 VDD VSS VDD VSS gf180mcu_fd_sc_mcu7t5v0__fillcap_4
XFILLER_47_422 VDD VSS VDD VSS gf180mcu_fd_sc_mcu7t5v0__fillcap_64
XFILLER_59_282 VDD VSS VDD VSS gf180mcu_fd_sc_mcu7t5v0__fillcap_64
XFILLER_208_737 VDD VSS VDD VSS gf180mcu_fd_sc_mcu7t5v0__fillcap_64
XFILLER_74_241 VDD VSS VDD VSS gf180mcu_fd_sc_mcu7t5v0__fillcap_4
XFILLER_235_556 VDD VSS VDD VSS gf180mcu_fd_sc_mcu7t5v0__fillcap_4
XFILLER_188_611 VDD VSS VDD VSS gf180mcu_fd_sc_mcu7t5v0__fillcap_8
XFILLER_15_352 VDD VSS VDD VSS gf180mcu_fd_sc_mcu7t5v0__fillcap_64
XFILLER_187_121 VDD VSS VDD VSS gf180mcu_fd_sc_mcu7t5v0__fillcap_16
XFILLER_30_311 VDD VSS VDD VSS gf180mcu_fd_sc_mcu7t5v0__fillcap_4
XFILLER_42_171 VDD VSS VDD VSS gf180mcu_fd_sc_mcu7t5v0__fillcap_4
X_1830_ _1832_/S VDD VSS _2898_/D _2898_/Q wire130/Z VDD VSS gf180mcu_fd_sc_mcu7t5v0__mux2_2
X_1761_ _1768_/S VDD VSS _2837_/D _1788_/I1 _2837_/Q VDD VSS gf180mcu_fd_sc_mcu7t5v0__mux2_2
XFILLER_129_766 VDD VSS VDD VSS gf180mcu_fd_sc_mcu7t5v0__fillcap_4
X_1692_ _2239_/C _2486_/C VDD VSS _1694_/A2 _1654_/Z _2239_/A2 _2363_/A1 VDD VSS gf180mcu_fd_sc_mcu7t5v0__aoi221_1
XFILLER_7_562 VDD VSS VDD VSS gf180mcu_fd_sc_mcu7t5v0__fillcap_64
X_3431_ _3431_/D _3431_/Q wire163/Z VSS _3461_/CLK VDD VDD VSS gf180mcu_fd_sc_mcu7t5v0__dffrnq_1
X_3362_ VSS _3362_/CLK VDD _3362_/D _3362_/Q wire153/I VDD VSS gf180mcu_fd_sc_mcu7t5v0__dffsnq_1
XFILLER_98_801 VDD VSS VDD VSS gf180mcu_fd_sc_mcu7t5v0__fillcap_4
X_2313_ _2314_/A3 VDD VSS _2478_/A2 _2482_/A2 _2274_/C VDD VSS gf180mcu_fd_sc_mcu7t5v0__nor3_1
XFILLER_32_2 VDD VSS VDD VSS gf180mcu_fd_sc_mcu7t5v0__fillcap_32
XFILLER_257_136 VDD VSS VDD VSS gf180mcu_fd_sc_mcu7t5v0__fillcap_4
X_3293_ _3293_/D _3293_/Q wire165/Z VSS clkload8/I VDD VDD VSS gf180mcu_fd_sc_mcu7t5v0__dffrnq_1
XFILLER_112_655 VDD VSS VDD VSS gf180mcu_fd_sc_mcu7t5v0__fillcap_8
X_2244_ VDD _2244_/B _2482_/A3 _2245_/A2 _2482_/A1 VSS VDD VSS gf180mcu_fd_sc_mcu7t5v0__oai21_1
XFILLER_78_591 VDD VSS VDD VSS gf180mcu_fd_sc_mcu7t5v0__fillcap_4
XFILLER_66_731 VDD VSS VDD VSS gf180mcu_fd_sc_mcu7t5v0__fillcap_4
X_2175_ VDD _2175_/B _3348_/D _3139_/D _2175_/A1 VSS VDD VSS gf180mcu_fd_sc_mcu7t5v0__oai21_1
XFILLER_213_206 VDD VSS VDD VSS gf180mcu_fd_sc_mcu7t5v0__fillcap_4
XFILLER_80_233 VDD VSS VDD VSS gf180mcu_fd_sc_mcu7t5v0__fillcap_8
XFILLER_34_661 VDD VSS VDD VSS gf180mcu_fd_sc_mcu7t5v0__fillcap_4
XFILLER_22_801 VDD VSS VDD VSS gf180mcu_fd_sc_mcu7t5v0__fillcap_4
XFILLER_193_124 VDD VSS VDD VSS gf180mcu_fd_sc_mcu7t5v0__fillcap_8
X_1959_ _1963_/S VDD VSS _3008_/D wire119/Z _3008_/Q VDD VSS gf180mcu_fd_sc_mcu7t5v0__mux2_2
XFILLER_107_416 VDD VSS VDD VSS gf180mcu_fd_sc_mcu7t5v0__fillcap_4
XFILLER_134_224 VDD VSS VDD VSS gf180mcu_fd_sc_mcu7t5v0__fillcap_16
XFILLER_119_298 VDD VSS VDD VSS gf180mcu_fd_sc_mcu7t5v0__fillcap_8
XFILLER_249_626 VDD VSS VDD VSS gf180mcu_fd_sc_mcu7t5v0__fillcap_4
XFILLER_88_355 VDD VSS VDD VSS gf180mcu_fd_sc_mcu7t5v0__fillcap_16
XFILLER_29_422 VDD VSS VDD VSS gf180mcu_fd_sc_mcu7t5v0__fillcap_64
XFILLER_56_241 VDD VSS VDD VSS gf180mcu_fd_sc_mcu7t5v0__fillcap_4
XFILLER_112_74 VDD VSS VDD VSS gf180mcu_fd_sc_mcu7t5v0__fillcap_16
XFILLER_12_311 VDD VSS VDD VSS gf180mcu_fd_sc_mcu7t5v0__fillcap_4
XFILLER_24_171 VDD VSS VDD VSS gf180mcu_fd_sc_mcu7t5v0__fillcap_4
XFILLER_234_2 VDD VSS VDD VSS gf180mcu_fd_sc_mcu7t5v0__fillcap_32
XFILLER_200_489 VDD VSS VDD VSS gf180mcu_fd_sc_mcu7t5v0__fillcap_8
XFILLER_181_842 VDD VSS VDD VSS gf180mcu_fd_sc_mcu7t5v0__fillcap_32
XFILLER_4_521 VDD VSS VDD VSS gf180mcu_fd_sc_mcu7t5v0__fillcap_4
XFILLER_141_739 VDD VSS VDD VSS gf180mcu_fd_sc_mcu7t5v0__fillcap_16
XFILLER_239_136 VDD VSS VDD VSS gf180mcu_fd_sc_mcu7t5v0__fillcap_4
XFILLER_48_731 VDD VSS VDD VSS gf180mcu_fd_sc_mcu7t5v0__fillcap_4
XFILLER_208_578 VDD VSS VDD VSS gf180mcu_fd_sc_mcu7t5v0__fillcap_16
XFILLER_90_520 VDD VSS VDD VSS gf180mcu_fd_sc_mcu7t5v0__fillcap_4
XFILLER_16_661 VDD VSS VDD VSS gf180mcu_fd_sc_mcu7t5v0__fillcap_4
X_2931_ VDD _2931_/Q _2931_/CLK VSS _2931_/D VDD VSS gf180mcu_fd_sc_mcu7t5v0__dffq_1
XFILLER_90_597 VDD VSS VDD VSS gf180mcu_fd_sc_mcu7t5v0__fillcap_64
X_2862_ VDD _2862_/Q _3369_/CLK VSS _2862_/D VDD VSS gf180mcu_fd_sc_mcu7t5v0__dffq_1
X_1813_ _1814_/S VDD VSS _2883_/D wire128/Z _2883_/Q VDD VSS gf180mcu_fd_sc_mcu7t5v0__mux2_2
XFILLER_248_37 VDD VSS VDD VSS gf180mcu_fd_sc_mcu7t5v0__fillcap_64
X_2793_ wire20/Z _3090_/Q VDD VSS _2794_/I _3338_/Q _2739_/S VDD VSS gf180mcu_fd_sc_mcu7t5v0__aoi22_1
X_1744_ _1748_/S VDD VSS _2824_/D _2824_/Q _3122_/Q VDD VSS gf180mcu_fd_sc_mcu7t5v0__mux2_2
XFILLER_8_871 VDD VSS VDD VSS gf180mcu_fd_sc_mcu7t5v0__fillcap_4
X_1675_ _2804_/Q VDD VSS _1676_/B _2331_/B _2803_/Q VDD VSS gf180mcu_fd_sc_mcu7t5v0__nand3_1
XFILLER_131_205 VDD VSS VDD VSS gf180mcu_fd_sc_mcu7t5v0__fillcap_4
X_3414_ _3414_/D _3432_/D wire163/Z VSS _3414_/CLK VDD VDD VSS gf180mcu_fd_sc_mcu7t5v0__dffrnq_1
XFILLER_132_728 VDD VSS VDD VSS gf180mcu_fd_sc_mcu7t5v0__fillcap_4
X_3345_ VSS _3348_/CLK VDD _3345_/D _3345_/Q wire151/Z VDD VSS gf180mcu_fd_sc_mcu7t5v0__dffsnq_1
X_3276_ _3276_/D _3276_/Q _3455_/RN VSS _3277_/CLK VDD VDD VSS gf180mcu_fd_sc_mcu7t5v0__dffrnq_1
XFILLER_97_174 VDD VSS VDD VSS gf180mcu_fd_sc_mcu7t5v0__fillcap_8
X_2227_ _3353_/Q VDD VSS _2228_/B _3353_/D _3352_/D VDD VSS gf180mcu_fd_sc_mcu7t5v0__nor3_1
XFILLER_38_241 VDD VSS VDD VSS gf180mcu_fd_sc_mcu7t5v0__fillcap_4
X_2158_ _3164_/Q _2168_/C VDD VSS _2159_/B2 _3155_/Q _2168_/A2 _2168_/B1 VDD VSS gf180mcu_fd_sc_mcu7t5v0__aoi221_1
X_2089_ VDD _3105_/D _2089_/B _3105_/Q _2110_/A2 VSS _2089_/A3 VDD VSS gf180mcu_fd_sc_mcu7t5v0__oai31_1
XFILLER_179_485 VDD VSS VDD VSS gf180mcu_fd_sc_mcu7t5v0__fillcap_4
XFILLER_167_625 VDD VSS VDD VSS gf180mcu_fd_sc_mcu7t5v0__fillcap_4
XFILLER_166_124 VDD VSS VDD VSS gf180mcu_fd_sc_mcu7t5v0__fillcap_8
Xmax_length11 VSS _2796_/A1 wire10/I VDD VDD VSS gf180mcu_fd_sc_mcu7t5v0__buf_2
XFILLER_42_37 VDD VSS VDD VSS gf180mcu_fd_sc_mcu7t5v0__fillcap_64
Xmax_length77 wire76/I _3381_/Q VDD VSS VDD VSS gf180mcu_fd_sc_mcu7t5v0__buf_4
XFILLER_158_37 VDD VSS VDD VSS gf180mcu_fd_sc_mcu7t5v0__fillcap_32
Xmax_length66 _2740_/S0 _2741_/S0 VDD VSS VDD VSS gf180mcu_fd_sc_mcu7t5v0__buf_4
Xmax_length44 VSS _2524_/B1 _2517_/C1 VDD VDD VSS gf180mcu_fd_sc_mcu7t5v0__buf_2
XFILLER_147_360 VDD VSS VDD VSS gf180mcu_fd_sc_mcu7t5v0__fillcap_4
XFILLER_163_842 VDD VSS VDD VSS gf180mcu_fd_sc_mcu7t5v0__fillcap_32
XFILLER_190_683 VDD VSS VDD VSS gf180mcu_fd_sc_mcu7t5v0__fillcap_8
XFILLER_174_69 VDD VSS VDD VSS gf180mcu_fd_sc_mcu7t5v0__fillcap_16
XFILLER_131_772 VDD VSS VDD VSS gf180mcu_fd_sc_mcu7t5v0__fillcap_64
XFILLER_88_163 VDD VSS VDD VSS gf180mcu_fd_sc_mcu7t5v0__fillcap_8
XFILLER_92_807 VDD VSS VDD VSS gf180mcu_fd_sc_mcu7t5v0__fillcap_64
XFILLER_217_342 VDD VSS VDD VSS gf180mcu_fd_sc_mcu7t5v0__fillcap_8
XFILLER_184_2 VDD VSS VDD VSS gf180mcu_fd_sc_mcu7t5v0__fillcap_32
XFILLER_189_205 VDD VSS VDD VSS gf180mcu_fd_sc_mcu7t5v0__fillcap_4
XFILLER_60_737 VDD VSS VDD VSS gf180mcu_fd_sc_mcu7t5v0__fillcap_64
XFILLER_72_597 VDD VSS VDD VSS gf180mcu_fd_sc_mcu7t5v0__fillcap_64
XFILLER_185_422 VDD VSS VDD VSS gf180mcu_fd_sc_mcu7t5v0__fillcap_16
XFILLER_197_260 VDD VSS VDD VSS gf180mcu_fd_sc_mcu7t5v0__fillcap_8
XFILLER_8_101 VDD VSS VDD VSS gf180mcu_fd_sc_mcu7t5v0__fillcap_4
XFILLER_181_650 VDD VSS VDD VSS gf180mcu_fd_sc_mcu7t5v0__fillcap_16
XFILLER_153_352 VDD VSS VDD VSS gf180mcu_fd_sc_mcu7t5v0__fillcap_4
XFILLER_5_874 VDD VSS VDD VSS gf180mcu_fd_sc_mcu7t5v0__fillcap_16
X_1460_ VDD VSS _1483_/A2 _3420_/Q _1460_/A2 VDD VSS gf180mcu_fd_sc_mcu7t5v0__nor2_1
X_1391_ VDD VSS _3173_/Q _2274_/A1 VDD VSS gf180mcu_fd_sc_mcu7t5v0__clkinv_1
XFILLER_164_91 VDD VSS VDD VSS gf180mcu_fd_sc_mcu7t5v0__fillcap_4
X_3130_ _3130_/D _3130_/Q wire151/Z VSS _3166_/CLK VDD VDD VSS gf180mcu_fd_sc_mcu7t5v0__dffrnq_1
XFILLER_121_271 VDD VSS VDD VSS gf180mcu_fd_sc_mcu7t5v0__fillcap_8
XFILLER_95_612 VDD VSS VDD VSS gf180mcu_fd_sc_mcu7t5v0__fillcap_16
XFILLER_121_282 VDD VSS VDD VSS gf180mcu_fd_sc_mcu7t5v0__fillcap_64
XFILLER_79_185 VDD VSS VDD VSS gf180mcu_fd_sc_mcu7t5v0__fillcap_16
XFILLER_94_177 VDD VSS VDD VSS gf180mcu_fd_sc_mcu7t5v0__fillcap_64
X_3061_ _3061_/D _3061_/Q _3455_/RN VSS _3462_/CLK VDD VDD VSS gf180mcu_fd_sc_mcu7t5v0__dffrnq_1
XFILLER_82_317 VDD VSS VDD VSS gf180mcu_fd_sc_mcu7t5v0__fillcap_8
X_2012_ _2018_/S VDD VSS _3054_/D wire123/Z _3054_/Q VDD VSS gf180mcu_fd_sc_mcu7t5v0__mux2_2
XFILLER_251_632 VDD VSS VDD VSS gf180mcu_fd_sc_mcu7t5v0__fillcap_64
XFILLER_263_492 VDD VSS VDD VSS gf180mcu_fd_sc_mcu7t5v0__fillcap_64
XFILLER_149_614 VDD VSS VDD VSS gf180mcu_fd_sc_mcu7t5v0__fillcap_4
XFILLER_189_772 VDD VSS VDD VSS gf180mcu_fd_sc_mcu7t5v0__fillcap_64
XFILLER_50_247 VDD VSS VDD VSS gf180mcu_fd_sc_mcu7t5v0__fillcap_64
X_2914_ VDD _2914_/Q _2914_/CLK VSS _2914_/D VDD VSS gf180mcu_fd_sc_mcu7t5v0__dffq_1
XFILLER_176_444 VDD VSS VDD VSS gf180mcu_fd_sc_mcu7t5v0__fillcap_8
X_2845_ VDD _2845_/Q _2914_/CLK VSS _2845_/D VDD VSS gf180mcu_fd_sc_mcu7t5v0__dffq_1
XFILLER_117_500 VDD VSS VDD VSS gf180mcu_fd_sc_mcu7t5v0__fillcap_4
XFILLER_145_842 VDD VSS VDD VSS gf180mcu_fd_sc_mcu7t5v0__fillcap_32
X_2776_ VDD VSS _2776_/I _3329_/D VDD VSS gf180mcu_fd_sc_mcu7t5v0__clkinv_1
XFILLER_117_533 VDD VSS VDD VSS gf180mcu_fd_sc_mcu7t5v0__fillcap_8
X_1727_ _1728_/S VDD VSS _2811_/D _2811_/Q _1794_/I1 VDD VSS gf180mcu_fd_sc_mcu7t5v0__mux2_2
XFILLER_160_801 VDD VSS VDD VSS gf180mcu_fd_sc_mcu7t5v0__fillcap_4
X_1658_ VDD VSS _2337_/A1 _2331_/B _2804_/Q VDD VSS gf180mcu_fd_sc_mcu7t5v0__nor2_1
XFILLER_98_450 VDD VSS VDD VSS gf180mcu_fd_sc_mcu7t5v0__fillcap_4
X_1589_ _1589_/B _1589_/C VDD VSS _1590_/A2 _3186_/Q _1569_/Z VDD VSS gf180mcu_fd_sc_mcu7t5v0__aoi211_1
X_3328_ _3328_/D _3328_/Q _3336_/RN VSS _3328_/CLK VDD VDD VSS gf180mcu_fd_sc_mcu7t5v0__dffrnq_1
XFILLER_113_772 VDD VSS VDD VSS gf180mcu_fd_sc_mcu7t5v0__fillcap_64
XFILLER_112_293 VDD VSS VDD VSS gf180mcu_fd_sc_mcu7t5v0__fillcap_16
XFILLER_98_494 VDD VSS VDD VSS gf180mcu_fd_sc_mcu7t5v0__fillcap_16
XFILLER_74_807 VDD VSS VDD VSS gf180mcu_fd_sc_mcu7t5v0__fillcap_64
XFILLER_86_667 VDD VSS VDD VSS gf180mcu_fd_sc_mcu7t5v0__fillcap_64
X_3259_ _3259_/D _3259_/Q wire165/Z VSS clkload8/I VDD VDD VSS gf180mcu_fd_sc_mcu7t5v0__dffrnq_1
XFILLER_241_142 VDD VSS VDD VSS gf180mcu_fd_sc_mcu7t5v0__fillcap_64
XFILLER_54_597 VDD VSS VDD VSS gf180mcu_fd_sc_mcu7t5v0__fillcap_64
XFILLER_42_737 VDD VSS VDD VSS gf180mcu_fd_sc_mcu7t5v0__fillcap_64
XFILLER_167_422 VDD VSS VDD VSS gf180mcu_fd_sc_mcu7t5v0__fillcap_32
XFILLER_179_282 VDD VSS VDD VSS gf180mcu_fd_sc_mcu7t5v0__fillcap_64
XFILLER_139_135 VDD VSS VDD VSS gf180mcu_fd_sc_mcu7t5v0__fillcap_4
XFILLER_182_403 VDD VSS VDD VSS gf180mcu_fd_sc_mcu7t5v0__fillcap_4
XFILLER_194_252 VDD VSS VDD VSS gf180mcu_fd_sc_mcu7t5v0__fillcap_32
XFILLER_10_667 VDD VSS VDD VSS gf180mcu_fd_sc_mcu7t5v0__fillcap_64
XFILLER_135_352 VDD VSS VDD VSS gf180mcu_fd_sc_mcu7t5v0__fillcap_16
XFILLER_265_702 VDD VSS VDD VSS gf180mcu_fd_sc_mcu7t5v0__fillcap_64
XFILLER_2_877 VDD VSS VDD VSS gf180mcu_fd_sc_mcu7t5v0__fillcap_8
XFILLER_103_282 VDD VSS VDD VSS gf180mcu_fd_sc_mcu7t5v0__fillcap_32
XFILLER_64_317 VDD VSS VDD VSS gf180mcu_fd_sc_mcu7t5v0__fillcap_64
XFILLER_233_632 VDD VSS VDD VSS gf180mcu_fd_sc_mcu7t5v0__fillcap_64
XFILLER_245_492 VDD VSS VDD VSS gf180mcu_fd_sc_mcu7t5v0__fillcap_64
XFILLER_91_158 VDD VSS VDD VSS gf180mcu_fd_sc_mcu7t5v0__fillcap_4
XFILLER_260_451 VDD VSS VDD VSS gf180mcu_fd_sc_mcu7t5v0__fillcap_4
XFILLER_32_247 VDD VSS VDD VSS gf180mcu_fd_sc_mcu7t5v0__fillcap_64
XFILLER_201_551 VDD VSS VDD VSS gf180mcu_fd_sc_mcu7t5v0__fillcap_8
XFILLER_201_562 VDD VSS VDD VSS gf180mcu_fd_sc_mcu7t5v0__fillcap_16
XFILLER_158_499 VDD VSS VDD VSS gf180mcu_fd_sc_mcu7t5v0__fillcap_16
XFILLER_185_274 VDD VSS VDD VSS gf180mcu_fd_sc_mcu7t5v0__fillcap_4
X_2630_ wire46/I VDD VSS _3293_/D _3251_/Q _3293_/Q VDD VSS gf180mcu_fd_sc_mcu7t5v0__mux2_2
XFILLER_185_296 VDD VSS VDD VSS gf180mcu_fd_sc_mcu7t5v0__fillcap_8
XFILLER_127_842 VDD VSS VDD VSS gf180mcu_fd_sc_mcu7t5v0__fillcap_32
XFILLER_173_469 VDD VSS VDD VSS gf180mcu_fd_sc_mcu7t5v0__fillcap_16
XFILLER_142_801 VDD VSS VDD VSS gf180mcu_fd_sc_mcu7t5v0__fillcap_4
XFILLER_126_352 VDD VSS VDD VSS gf180mcu_fd_sc_mcu7t5v0__fillcap_32
X_2561_ _2566_/S VDD VSS _3230_/D _3215_/Q _3230_/Q VDD VSS gf180mcu_fd_sc_mcu7t5v0__mux2_2
X_1512_ VDD VSS _3374_/D _1796_/A2 _1512_/A2 VDD VSS gf180mcu_fd_sc_mcu7t5v0__xor2_1
XFILLER_181_480 VDD VSS VDD VSS gf180mcu_fd_sc_mcu7t5v0__fillcap_8
X_2492_ VDD _2492_/B _2492_/A2 _3211_/D _2492_/A1 VSS VDD VSS gf180mcu_fd_sc_mcu7t5v0__oai21_1
XFILLER_99_203 VDD VSS VDD VSS gf180mcu_fd_sc_mcu7t5v0__fillcap_4
X_1443_ VDD VSS _3131_/Q _2156_/A1 VDD VSS gf180mcu_fd_sc_mcu7t5v0__clkinv_1
XFILLER_141_344 VDD VSS VDD VSS gf180mcu_fd_sc_mcu7t5v0__fillcap_4
XFILLER_110_720 VDD VSS VDD VSS gf180mcu_fd_sc_mcu7t5v0__fillcap_8
XFILLER_255_212 VDD VSS VDD VSS gf180mcu_fd_sc_mcu7t5v0__fillcap_64
X_3113_ _3113_/D _3113_/Q _3359_/RN VSS _3363_/CLK VDD VDD VSS gf180mcu_fd_sc_mcu7t5v0__dffrnq_1
XFILLER_56_807 VDD VSS VDD VSS gf180mcu_fd_sc_mcu7t5v0__fillcap_64
XFILLER_68_667 VDD VSS VDD VSS gf180mcu_fd_sc_mcu7t5v0__fillcap_64
XFILLER_83_626 VDD VSS VDD VSS gf180mcu_fd_sc_mcu7t5v0__fillcap_4
X_3044_ VDD _3044_/Q _3044_/CLK VSS _3044_/D VDD VSS gf180mcu_fd_sc_mcu7t5v0__dffq_1
XFILLER_82_158 VDD VSS VDD VSS gf180mcu_fd_sc_mcu7t5v0__fillcap_8
XFILLER_223_142 VDD VSS VDD VSS gf180mcu_fd_sc_mcu7t5v0__fillcap_64
XFILLER_36_597 VDD VSS VDD VSS gf180mcu_fd_sc_mcu7t5v0__fillcap_64
XFILLER_24_737 VDD VSS VDD VSS gf180mcu_fd_sc_mcu7t5v0__fillcap_64
XFILLER_51_556 VDD VSS VDD VSS gf180mcu_fd_sc_mcu7t5v0__fillcap_4
XFILLER_149_422 VDD VSS VDD VSS gf180mcu_fd_sc_mcu7t5v0__fillcap_64
XFILLER_220_871 VDD VSS VDD VSS gf180mcu_fd_sc_mcu7t5v0__fillcap_4
X_2828_ VDD _2828_/Q _3457_/CLK VSS _2828_/D VDD VSS gf180mcu_fd_sc_mcu7t5v0__dffq_1
XFILLER_219_72 VDD VSS VDD VSS gf180mcu_fd_sc_mcu7t5v0__fillcap_8
XFILLER_117_352 VDD VSS VDD VSS gf180mcu_fd_sc_mcu7t5v0__fillcap_64
XFILLER_129_190 VDD VSS VDD VSS gf180mcu_fd_sc_mcu7t5v0__fillcap_4
X_2759_ wire19/Z _3073_/Q VDD VSS _2760_/A2 _3321_/Q wire37/Z VDD VSS gf180mcu_fd_sc_mcu7t5v0__aoi22_1
XFILLER_144_171 VDD VSS VDD VSS gf180mcu_fd_sc_mcu7t5v0__fillcap_4
XFILLER_132_300 VDD VSS VDD VSS gf180mcu_fd_sc_mcu7t5v0__fillcap_8
XFILLER_2_107 VDD VSS VDD VSS gf180mcu_fd_sc_mcu7t5v0__fillcap_64
XFILLER_144_193 VDD VSS VDD VSS gf180mcu_fd_sc_mcu7t5v0__fillcap_8
XFILLER_247_702 VDD VSS VDD VSS gf180mcu_fd_sc_mcu7t5v0__fillcap_64
XFILLER_259_562 VDD VSS VDD VSS gf180mcu_fd_sc_mcu7t5v0__fillcap_64
XFILLER_58_177 VDD VSS VDD VSS gf180mcu_fd_sc_mcu7t5v0__fillcap_64
XFILLER_46_317 VDD VSS VDD VSS gf180mcu_fd_sc_mcu7t5v0__fillcap_64
XFILLER_215_632 VDD VSS VDD VSS gf180mcu_fd_sc_mcu7t5v0__fillcap_64
XFILLER_242_451 VDD VSS VDD VSS gf180mcu_fd_sc_mcu7t5v0__fillcap_4
XFILLER_227_492 VDD VSS VDD VSS gf180mcu_fd_sc_mcu7t5v0__fillcap_64
XFILLER_14_247 VDD VSS VDD VSS gf180mcu_fd_sc_mcu7t5v0__fillcap_64
XFILLER_187_528 VDD VSS VDD VSS gf180mcu_fd_sc_mcu7t5v0__fillcap_8
XFILLER_147_2 VDD VSS VDD VSS gf180mcu_fd_sc_mcu7t5v0__fillcap_64
XFILLER_80_45 VDD VSS VDD VSS gf180mcu_fd_sc_mcu7t5v0__fillcap_4
XFILLER_210_381 VDD VSS VDD VSS gf180mcu_fd_sc_mcu7t5v0__fillcap_4
XFILLER_109_842 VDD VSS VDD VSS gf180mcu_fd_sc_mcu7t5v0__fillcap_32
XFILLER_13_72 VDD VSS VDD VSS gf180mcu_fd_sc_mcu7t5v0__fillcap_64
XFILLER_6_457 VDD VSS VDD VSS gf180mcu_fd_sc_mcu7t5v0__fillcap_64
XFILLER_124_801 VDD VSS VDD VSS gf180mcu_fd_sc_mcu7t5v0__fillcap_4
XFILLER_89_10 VDD VSS VDD VSS gf180mcu_fd_sc_mcu7t5v0__fillcap_4
XFILLER_104_591 VDD VSS VDD VSS gf180mcu_fd_sc_mcu7t5v0__fillcap_4
XFILLER_237_212 VDD VSS VDD VSS gf180mcu_fd_sc_mcu7t5v0__fillcap_64
XFILLER_38_807 VDD VSS VDD VSS gf180mcu_fd_sc_mcu7t5v0__fillcap_64
XFILLER_65_626 VDD VSS VDD VSS gf180mcu_fd_sc_mcu7t5v0__fillcap_4
XFILLER_77_486 VDD VSS VDD VSS gf180mcu_fd_sc_mcu7t5v0__fillcap_4
XFILLER_205_142 VDD VSS VDD VSS gf180mcu_fd_sc_mcu7t5v0__fillcap_16
XFILLER_18_597 VDD VSS VDD VSS gf180mcu_fd_sc_mcu7t5v0__fillcap_64
XFILLER_33_556 VDD VSS VDD VSS gf180mcu_fd_sc_mcu7t5v0__fillcap_4
XFILLER_221_679 VDD VSS VDD VSS gf180mcu_fd_sc_mcu7t5v0__fillcap_16
XFILLER_202_871 VDD VSS VDD VSS gf180mcu_fd_sc_mcu7t5v0__fillcap_4
X_1992_ VDD VSS _2000_/S _1992_/A1 _2010_/A2 VDD VSS gf180mcu_fd_sc_mcu7t5v0__nand2_1
Xclkload10 VSS clkload10/Z _3316_/CLK VDD VDD VSS gf180mcu_fd_sc_mcu7t5v0__clkbuf_1
Xclkload43 VDD VSS _3441_/CLK clkload43/ZN VDD VSS gf180mcu_fd_sc_mcu7t5v0__clkinv_2
XFILLER_256_37 VDD VSS VDD VSS gf180mcu_fd_sc_mcu7t5v0__fillcap_64
Xclkload21 VSS clkload21/Z _3289_/CLK VDD VDD VSS gf180mcu_fd_sc_mcu7t5v0__clkbuf_1
Xclkload32 VDD VSS _3055_/CLK clkload32/ZN VDD VSS gf180mcu_fd_sc_mcu7t5v0__clkinv_1
X_2613_ VDD VSS _2614_/B _3227_/Q wire46/I VDD VSS gf180mcu_fd_sc_mcu7t5v0__nor2_1
Xclkload76 VDD VSS clkload76/ZN _3457_/CLK VDD VSS gf180mcu_fd_sc_mcu7t5v0__clkinv_8
Xclkload87 VSS clkload87/ZN _3403_/CLK VDD VDD VSS gf180mcu_fd_sc_mcu7t5v0__inv_3
Xclkload54 VSS clkload54/Z _3357_/CLK VDD VDD VSS gf180mcu_fd_sc_mcu7t5v0__clkbuf_1
Xclkload65 VSS clkload65/ZN _3182_/CLK VDD VDD VSS gf180mcu_fd_sc_mcu7t5v0__inv_2
XFILLER_126_171 VDD VSS VDD VSS gf180mcu_fd_sc_mcu7t5v0__fillcap_4
X_2544_ VDD VSS _2544_/Z _2546_/A1 _3222_/Q VDD VSS gf180mcu_fd_sc_mcu7t5v0__xor2_1
XFILLER_133_119 VDD VSS VDD VSS gf180mcu_fd_sc_mcu7t5v0__fillcap_16
XFILLER_114_333 VDD VSS VDD VSS gf180mcu_fd_sc_mcu7t5v0__fillcap_8
XFILLER_126_193 VDD VSS VDD VSS gf180mcu_fd_sc_mcu7t5v0__fillcap_4
X_2475_ VDD VSS _3206_/D _2320_/B _2475_/A2 VDD VSS gf180mcu_fd_sc_mcu7t5v0__nand2_1
XFILLER_102_506 VDD VSS VDD VSS gf180mcu_fd_sc_mcu7t5v0__fillcap_16
X_1426_ VDD VSS _3097_/Q _2302_/A2 VDD VSS gf180mcu_fd_sc_mcu7t5v0__clkinv_1
XFILLER_229_702 VDD VSS VDD VSS gf180mcu_fd_sc_mcu7t5v0__fillcap_64
XFILLER_256_521 VDD VSS VDD VSS gf180mcu_fd_sc_mcu7t5v0__fillcap_4
XFILLER_28_317 VDD VSS VDD VSS gf180mcu_fd_sc_mcu7t5v0__fillcap_64
XFILLER_55_136 VDD VSS VDD VSS gf180mcu_fd_sc_mcu7t5v0__fillcap_4
XFILLER_209_492 VDD VSS VDD VSS gf180mcu_fd_sc_mcu7t5v0__fillcap_16
XFILLER_221_51 VDD VSS VDD VSS gf180mcu_fd_sc_mcu7t5v0__fillcap_8
X_3027_ VDD _3027_/Q _3039_/CLK VSS _3027_/D VDD VSS gf180mcu_fd_sc_mcu7t5v0__dffq_1
XFILLER_212_657 VDD VSS VDD VSS gf180mcu_fd_sc_mcu7t5v0__fillcap_8
XFILLER_169_517 VDD VSS VDD VSS gf180mcu_fd_sc_mcu7t5v0__fillcap_32
XFILLER_11_206 VDD VSS VDD VSS gf180mcu_fd_sc_mcu7t5v0__fillcap_4
Xclkload4 VSS clkload4/ZN clkload4/I VDD VDD VSS gf180mcu_fd_sc_mcu7t5v0__inv_4
Xwire119 VSS wire119/Z wire119/I VDD VDD VSS gf180mcu_fd_sc_mcu7t5v0__buf_2
XFILLER_50_37 VDD VSS VDD VSS gf180mcu_fd_sc_mcu7t5v0__fillcap_64
XFILLER_106_801 VDD VSS VDD VSS gf180mcu_fd_sc_mcu7t5v0__fillcap_4
XFILLER_192_597 VDD VSS VDD VSS gf180mcu_fd_sc_mcu7t5v0__fillcap_16
XFILLER_180_737 VDD VSS VDD VSS gf180mcu_fd_sc_mcu7t5v0__fillcap_64
XFILLER_180_726 VDD VSS VDD VSS gf180mcu_fd_sc_mcu7t5v0__fillcap_8
XFILLER_3_416 VDD VSS VDD VSS gf180mcu_fd_sc_mcu7t5v0__fillcap_4
XFILLER_133_675 VDD VSS VDD VSS gf180mcu_fd_sc_mcu7t5v0__fillcap_8
XFILLER_219_212 VDD VSS VDD VSS gf180mcu_fd_sc_mcu7t5v0__fillcap_64
XFILLER_47_626 VDD VSS VDD VSS gf180mcu_fd_sc_mcu7t5v0__fillcap_4
XFILLER_59_486 VDD VSS VDD VSS gf180mcu_fd_sc_mcu7t5v0__fillcap_4
Xload_slew27 VSS _2138_/S _2137_/S VDD VDD VSS gf180mcu_fd_sc_mcu7t5v0__buf_3
Xload_slew16 _1933_/S VSS VDD _1935_/S VDD VSS gf180mcu_fd_sc_mcu7t5v0__clkbuf_3
XFILLER_264_2 VDD VSS VDD VSS gf180mcu_fd_sc_mcu7t5v0__fillcap_32
XFILLER_15_556 VDD VSS VDD VSS gf180mcu_fd_sc_mcu7t5v0__fillcap_4
XFILLER_202_156 VDD VSS VDD VSS gf180mcu_fd_sc_mcu7t5v0__fillcap_8
XFILLER_91_88 VDD VSS VDD VSS gf180mcu_fd_sc_mcu7t5v0__fillcap_4
XFILLER_128_403 VDD VSS VDD VSS gf180mcu_fd_sc_mcu7t5v0__fillcap_4
XFILLER_128_436 VDD VSS VDD VSS gf180mcu_fd_sc_mcu7t5v0__fillcap_16
XFILLER_155_244 VDD VSS VDD VSS gf180mcu_fd_sc_mcu7t5v0__fillcap_4
XFILLER_143_406 VDD VSS VDD VSS gf180mcu_fd_sc_mcu7t5v0__fillcap_8
XFILLER_7_766 VDD VSS VDD VSS gf180mcu_fd_sc_mcu7t5v0__fillcap_4
XFILLER_109_694 VDD VSS VDD VSS gf180mcu_fd_sc_mcu7t5v0__fillcap_4
XFILLER_69_206 VDD VSS VDD VSS gf180mcu_fd_sc_mcu7t5v0__fillcap_4
X_2260_ VDD _2260_/B _2804_/Q _2263_/B _2803_/Q VSS VDD VSS gf180mcu_fd_sc_mcu7t5v0__oai21_1
XFILLER_111_314 VDD VSS VDD VSS gf180mcu_fd_sc_mcu7t5v0__fillcap_8
XFILLER_238_521 VDD VSS VDD VSS gf180mcu_fd_sc_mcu7t5v0__fillcap_4
XFILLER_266_885 VDD VSS VDD VSS gf180mcu_fd_sc_mcu7t5v0__fillcap_4
X_2191_ _2191_/A3 _2190_/Z VDD VSS _2193_/A2 _3349_/Q _2470_/B VDD VSS gf180mcu_fd_sc_mcu7t5v0__nand4_1
XFILLER_37_136 VDD VSS VDD VSS gf180mcu_fd_sc_mcu7t5v0__fillcap_4
XFILLER_206_451 VDD VSS VDD VSS gf180mcu_fd_sc_mcu7t5v0__fillcap_4
XFILLER_206_473 VDD VSS VDD VSS gf180mcu_fd_sc_mcu7t5v0__fillcap_4
XFILLER_194_807 VDD VSS VDD VSS gf180mcu_fd_sc_mcu7t5v0__fillcap_64
X_1975_ _1981_/S VDD VSS _3022_/D wire123/Z _3022_/Q VDD VSS gf180mcu_fd_sc_mcu7t5v0__mux2_2
XFILLER_162_737 VDD VSS VDD VSS gf180mcu_fd_sc_mcu7t5v0__fillcap_64
X_2527_ _2527_/A3 VDD VSS _2528_/A2 _2546_/A1 _2527_/A2 VDD VSS gf180mcu_fd_sc_mcu7t5v0__nand3_1
X_2458_ _2835_/Q VSS VDD _2819_/Q _2827_/Q _1519_/B _2811_/Q wire76/I _2458_/Z VDD
+ VSS gf180mcu_fd_sc_mcu7t5v0__mux4_1
XFILLER_216_95 VDD VSS VDD VSS gf180mcu_fd_sc_mcu7t5v0__fillcap_8
X_1409_ VDD VSS _3277_/Q _2614_/A1 VDD VSS gf180mcu_fd_sc_mcu7t5v0__clkinv_1
XFILLER_130_667 VDD VSS VDD VSS gf180mcu_fd_sc_mcu7t5v0__fillcap_4
XFILLER_257_874 VDD VSS VDD VSS gf180mcu_fd_sc_mcu7t5v0__fillcap_16
X_2389_ VDD VSS _2392_/A1 _2442_/S _2388_/Z VDD VSS gf180mcu_fd_sc_mcu7t5v0__nand2_1
XFILLER_29_626 VDD VSS VDD VSS gf180mcu_fd_sc_mcu7t5v0__fillcap_4
XFILLER_212_465 VDD VSS VDD VSS gf180mcu_fd_sc_mcu7t5v0__fillcap_4
XFILLER_196_177 VDD VSS VDD VSS gf180mcu_fd_sc_mcu7t5v0__fillcap_16
XFILLER_184_317 VDD VSS VDD VSS gf180mcu_fd_sc_mcu7t5v0__fillcap_16
XFILLER_152_247 VDD VSS VDD VSS gf180mcu_fd_sc_mcu7t5v0__fillcap_16
XFILLER_133_483 VDD VSS VDD VSS gf180mcu_fd_sc_mcu7t5v0__fillcap_4
XFILLER_86_22 VDD VSS VDD VSS gf180mcu_fd_sc_mcu7t5v0__fillcap_8
XFILLER_120_100 VDD VSS VDD VSS gf180mcu_fd_sc_mcu7t5v0__fillcap_4
XFILLER_120_155 VDD VSS VDD VSS gf180mcu_fd_sc_mcu7t5v0__fillcap_16
XFILLER_120_177 VDD VSS VDD VSS gf180mcu_fd_sc_mcu7t5v0__fillcap_16
XFILLER_248_885 VDD VSS VDD VSS gf180mcu_fd_sc_mcu7t5v0__fillcap_4
XFILLER_19_136 VDD VSS VDD VSS gf180mcu_fd_sc_mcu7t5v0__fillcap_4
XFILLER_74_253 VDD VSS VDD VSS gf180mcu_fd_sc_mcu7t5v0__fillcap_4
XFILLER_262_387 VDD VSS VDD VSS gf180mcu_fd_sc_mcu7t5v0__fillcap_64
XFILLER_250_527 VDD VSS VDD VSS gf180mcu_fd_sc_mcu7t5v0__fillcap_64
XFILLER_176_807 VDD VSS VDD VSS gf180mcu_fd_sc_mcu7t5v0__fillcap_64
X_1760_ VDD VSS _1768_/S _1500_/Z _1787_/A2 VDD VSS gf180mcu_fd_sc_mcu7t5v0__nand2_1
XFILLER_156_597 VDD VSS VDD VSS gf180mcu_fd_sc_mcu7t5v0__fillcap_64
XFILLER_144_737 VDD VSS VDD VSS gf180mcu_fd_sc_mcu7t5v0__fillcap_64
X_1691_ _1691_/B VDD VSS _1694_/A1 _2364_/A1 _2239_/C VDD VSS gf180mcu_fd_sc_mcu7t5v0__aoi21_1
X_3430_ _3430_/D _3430_/Q wire161/I VSS _3434_/CLK VDD VDD VSS gf180mcu_fd_sc_mcu7t5v0__dffrnq_1
X_3361_ VSS _3362_/CLK VDD _3361_/D _3362_/D wire153/I VDD VSS gf180mcu_fd_sc_mcu7t5v0__dffsnq_1
X_2312_ _2312_/A3 VDD VSS _2320_/A3 _2274_/C _2232_/B VDD VSS gf180mcu_fd_sc_mcu7t5v0__nor3_1
XFILLER_111_111 VDD VSS VDD VSS gf180mcu_fd_sc_mcu7t5v0__fillcap_16
X_3292_ _3292_/D wire86/I wire165/Z VSS _3328_/CLK VDD VDD VSS gf180mcu_fd_sc_mcu7t5v0__dffrnq_1
XFILLER_112_645 VDD VSS VDD VSS gf180mcu_fd_sc_mcu7t5v0__fillcap_4
XFILLER_100_807 VDD VSS VDD VSS gf180mcu_fd_sc_mcu7t5v0__fillcap_64
XFILLER_112_667 VDD VSS VDD VSS gf180mcu_fd_sc_mcu7t5v0__fillcap_8
XFILLER_239_874 VDD VSS VDD VSS gf180mcu_fd_sc_mcu7t5v0__fillcap_16
X_2243_ VDD _2243_/B _1716_/B _2244_/B _2364_/A1 VSS VDD VSS gf180mcu_fd_sc_mcu7t5v0__oai21_1
XFILLER_25_2 VDD VSS VDD VSS gf180mcu_fd_sc_mcu7t5v0__fillcap_64
X_2174_ VDD VSS _2175_/B _3176_/Q _3348_/D VDD VSS gf180mcu_fd_sc_mcu7t5v0__nand2_1
XFILLER_93_562 VDD VSS VDD VSS gf180mcu_fd_sc_mcu7t5v0__fillcap_16
XFILLER_81_702 VDD VSS VDD VSS gf180mcu_fd_sc_mcu7t5v0__fillcap_64
XFILLER_254_877 VDD VSS VDD VSS gf180mcu_fd_sc_mcu7t5v0__fillcap_8
XFILLER_202_53 VDD VSS VDD VSS gf180mcu_fd_sc_mcu7t5v0__fillcap_8
XFILLER_179_689 VDD VSS VDD VSS gf180mcu_fd_sc_mcu7t5v0__fillcap_8
XFILLER_61_492 VDD VSS VDD VSS gf180mcu_fd_sc_mcu7t5v0__fillcap_64
XFILLER_178_177 VDD VSS VDD VSS gf180mcu_fd_sc_mcu7t5v0__fillcap_32
XFILLER_166_317 VDD VSS VDD VSS gf180mcu_fd_sc_mcu7t5v0__fillcap_64
X_1958_ _1963_/S VDD VSS _3007_/D wire121/Z _3007_/Q VDD VSS gf180mcu_fd_sc_mcu7t5v0__mux2_2
X_1889_ _1889_/A3 VDD VSS _1891_/S _3408_/Q _1889_/A2 VDD VSS gf180mcu_fd_sc_mcu7t5v0__nor3_1
XFILLER_134_247 VDD VSS VDD VSS gf180mcu_fd_sc_mcu7t5v0__fillcap_16
XFILLER_162_589 VDD VSS VDD VSS gf180mcu_fd_sc_mcu7t5v0__fillcap_4
XFILLER_227_72 VDD VSS VDD VSS gf180mcu_fd_sc_mcu7t5v0__fillcap_64
XFILLER_88_323 VDD VSS VDD VSS gf180mcu_fd_sc_mcu7t5v0__fillcap_32
XFILLER_142_291 VDD VSS VDD VSS gf180mcu_fd_sc_mcu7t5v0__fillcap_4
XFILLER_102_177 VDD VSS VDD VSS gf180mcu_fd_sc_mcu7t5v0__fillcap_32
XFILLER_217_524 VDD VSS VDD VSS gf180mcu_fd_sc_mcu7t5v0__fillcap_16
XFILLER_217_579 VDD VSS VDD VSS gf180mcu_fd_sc_mcu7t5v0__fillcap_32
XFILLER_71_212 VDD VSS VDD VSS gf180mcu_fd_sc_mcu7t5v0__fillcap_8
XFILLER_244_387 VDD VSS VDD VSS gf180mcu_fd_sc_mcu7t5v0__fillcap_64
XFILLER_232_527 VDD VSS VDD VSS gf180mcu_fd_sc_mcu7t5v0__fillcap_64
XFILLER_158_807 VDD VSS VDD VSS gf180mcu_fd_sc_mcu7t5v0__fillcap_64
XFILLER_200_457 VDD VSS VDD VSS gf180mcu_fd_sc_mcu7t5v0__fillcap_32
XFILLER_227_2 VDD VSS VDD VSS gf180mcu_fd_sc_mcu7t5v0__fillcap_64
Xclkbuf_leaf_51_clk_i _3023_/CLK VSS VDD clkload1/I VDD VSS gf180mcu_fd_sc_mcu7t5v0__clkbuf_2
XFILLER_138_597 VDD VSS VDD VSS gf180mcu_fd_sc_mcu7t5v0__fillcap_8
XFILLER_126_737 VDD VSS VDD VSS gf180mcu_fd_sc_mcu7t5v0__fillcap_64
XFILLER_21_72 VDD VSS VDD VSS gf180mcu_fd_sc_mcu7t5v0__fillcap_64
Xclkbuf_leaf_66_clk_i _3307_/CLK VSS VDD clkbuf_3_0__f_clk_i/Z VDD VSS gf180mcu_fd_sc_mcu7t5v0__clkbuf_2
XFILLER_0_750 VDD VSS VDD VSS gf180mcu_fd_sc_mcu7t5v0__fillcap_32
XFILLER_254_107 VDD VSS VDD VSS gf180mcu_fd_sc_mcu7t5v0__fillcap_64
XFILLER_208_535 VDD VSS VDD VSS gf180mcu_fd_sc_mcu7t5v0__fillcap_4
XFILLER_63_702 VDD VSS VDD VSS gf180mcu_fd_sc_mcu7t5v0__fillcap_64
XFILLER_75_562 VDD VSS VDD VSS gf180mcu_fd_sc_mcu7t5v0__fillcap_64
XFILLER_236_877 VDD VSS VDD VSS gf180mcu_fd_sc_mcu7t5v0__fillcap_8
XFILLER_251_836 VDD VSS VDD VSS gf180mcu_fd_sc_mcu7t5v0__fillcap_4
XFILLER_263_696 VDD VSS VDD VSS gf180mcu_fd_sc_mcu7t5v0__fillcap_4
X_2930_ VDD _2930_/Q _3369_/CLK VSS _2930_/D VDD VSS gf180mcu_fd_sc_mcu7t5v0__dffq_1
XFILLER_43_492 VDD VSS VDD VSS gf180mcu_fd_sc_mcu7t5v0__fillcap_64
XFILLER_31_632 VDD VSS VDD VSS gf180mcu_fd_sc_mcu7t5v0__fillcap_64
Xclkbuf_leaf_19_clk_i _3362_/CLK VSS VDD clkload4/I VDD VSS gf180mcu_fd_sc_mcu7t5v0__clkbuf_2
X_2861_ VDD _2861_/Q _2914_/CLK VSS _2861_/D VDD VSS gf180mcu_fd_sc_mcu7t5v0__dffq_1
XFILLER_148_317 VDD VSS VDD VSS gf180mcu_fd_sc_mcu7t5v0__fillcap_16
X_1812_ _1814_/S VDD VSS _2882_/D wire130/Z _2882_/Q VDD VSS gf180mcu_fd_sc_mcu7t5v0__mux2_2
XFILLER_176_659 VDD VSS VDD VSS gf180mcu_fd_sc_mcu7t5v0__fillcap_4
XFILLER_175_136 VDD VSS VDD VSS gf180mcu_fd_sc_mcu7t5v0__fillcap_4
X_2792_ VDD VSS _2792_/I _3337_/D VDD VSS gf180mcu_fd_sc_mcu7t5v0__clkinv_1
X_1743_ _1748_/S VDD VSS _2823_/D _2823_/Q _3121_/Q VDD VSS gf180mcu_fd_sc_mcu7t5v0__mux2_2
X_1674_ VDD VSS _2260_/B _2331_/B _2803_/Q VDD VSS gf180mcu_fd_sc_mcu7t5v0__nand2_1
X_3413_ _3413_/D _3431_/D wire163/Z VSS _3414_/CLK VDD VDD VSS gf180mcu_fd_sc_mcu7t5v0__dffrnq_1
XFILLER_264_37 VDD VSS VDD VSS gf180mcu_fd_sc_mcu7t5v0__fillcap_64
XFILLER_171_342 VDD VSS VDD VSS gf180mcu_fd_sc_mcu7t5v0__fillcap_8
XFILLER_116_247 VDD VSS VDD VSS gf180mcu_fd_sc_mcu7t5v0__fillcap_16
X_3344_ _3344_/D _3344_/Q _3344_/RN VSS _3344_/CLK VDD VDD VSS gf180mcu_fd_sc_mcu7t5v0__dffrnq_1
XFILLER_97_142 VDD VSS VDD VSS gf180mcu_fd_sc_mcu7t5v0__fillcap_32
XFILLER_258_457 VDD VSS VDD VSS gf180mcu_fd_sc_mcu7t5v0__fillcap_64
X_3275_ _3275_/D _3275_/Q wire145/Z VSS _3321_/CLK VDD VDD VSS gf180mcu_fd_sc_mcu7t5v0__dffrnq_1
X_2226_ _3353_/Q VDD VSS _2228_/A2 _3353_/D _3352_/D VDD VSS gf180mcu_fd_sc_mcu7t5v0__nand3_1
XFILLER_94_871 VDD VSS VDD VSS gf180mcu_fd_sc_mcu7t5v0__fillcap_4
X_2157_ _2186_/A3 VDD VSS _2157_/Z _2173_/A1 _2175_/A1 VDD VSS gf180mcu_fd_sc_mcu7t5v0__or3_1
XFILLER_53_212 VDD VSS VDD VSS gf180mcu_fd_sc_mcu7t5v0__fillcap_64
XFILLER_226_387 VDD VSS VDD VSS gf180mcu_fd_sc_mcu7t5v0__fillcap_64
XFILLER_214_527 VDD VSS VDD VSS gf180mcu_fd_sc_mcu7t5v0__fillcap_8
X_2088_ _2120_/B _3105_/Q VDD VSS _2089_/B _2125_/A2 _2089_/A3 VDD VSS gf180mcu_fd_sc_mcu7t5v0__oai211_1
XFILLER_241_346 VDD VSS VDD VSS gf180mcu_fd_sc_mcu7t5v0__fillcap_4
XFILLER_21_142 VDD VSS VDD VSS gf180mcu_fd_sc_mcu7t5v0__fillcap_64
XFILLER_194_445 VDD VSS VDD VSS gf180mcu_fd_sc_mcu7t5v0__fillcap_8
Xmax_length45 VSS _2483_/B _2486_/B VDD VDD VSS gf180mcu_fd_sc_mcu7t5v0__buf_2
Xmax_length67 _2718_/S0 _2743_/S0 VDD VSS VDD VSS gf180mcu_fd_sc_mcu7t5v0__buf_4
Xmax_length56 _2732_/C VSS VDD _2744_/S1 VDD VSS gf180mcu_fd_sc_mcu7t5v0__clkbuf_3
XFILLER_194_478 VDD VSS VDD VSS gf180mcu_fd_sc_mcu7t5v0__fillcap_8
XFILLER_181_128 VDD VSS VDD VSS gf180mcu_fd_sc_mcu7t5v0__fillcap_4
XFILLER_108_737 VDD VSS VDD VSS gf180mcu_fd_sc_mcu7t5v0__fillcap_64
XFILLER_135_567 VDD VSS VDD VSS gf180mcu_fd_sc_mcu7t5v0__fillcap_8
XFILLER_174_37 VDD VSS VDD VSS gf180mcu_fd_sc_mcu7t5v0__fillcap_32
XFILLER_162_397 VDD VSS VDD VSS gf180mcu_fd_sc_mcu7t5v0__fillcap_16
XFILLER_122_217 VDD VSS VDD VSS gf180mcu_fd_sc_mcu7t5v0__fillcap_16
XFILLER_89_632 VDD VSS VDD VSS gf180mcu_fd_sc_mcu7t5v0__fillcap_64
XFILLER_236_107 VDD VSS VDD VSS gf180mcu_fd_sc_mcu7t5v0__fillcap_64
XFILLER_57_562 VDD VSS VDD VSS gf180mcu_fd_sc_mcu7t5v0__fillcap_64
XFILLER_45_702 VDD VSS VDD VSS gf180mcu_fd_sc_mcu7t5v0__fillcap_64
XFILLER_218_877 VDD VSS VDD VSS gf180mcu_fd_sc_mcu7t5v0__fillcap_8
XFILLER_177_2 VDD VSS VDD VSS gf180mcu_fd_sc_mcu7t5v0__fillcap_16
XFILLER_84_381 VDD VSS VDD VSS gf180mcu_fd_sc_mcu7t5v0__fillcap_4
XFILLER_72_521 VDD VSS VDD VSS gf180mcu_fd_sc_mcu7t5v0__fillcap_4
XFILLER_245_696 VDD VSS VDD VSS gf180mcu_fd_sc_mcu7t5v0__fillcap_4
XFILLER_233_836 VDD VSS VDD VSS gf180mcu_fd_sc_mcu7t5v0__fillcap_4
XFILLER_25_492 VDD VSS VDD VSS gf180mcu_fd_sc_mcu7t5v0__fillcap_64
XFILLER_13_632 VDD VSS VDD VSS gf180mcu_fd_sc_mcu7t5v0__fillcap_64
XFILLER_40_451 VDD VSS VDD VSS gf180mcu_fd_sc_mcu7t5v0__fillcap_4
XFILLER_201_766 VDD VSS VDD VSS gf180mcu_fd_sc_mcu7t5v0__fillcap_4
XFILLER_173_607 VDD VSS VDD VSS gf180mcu_fd_sc_mcu7t5v0__fillcap_16
XFILLER_200_265 VDD VSS VDD VSS gf180mcu_fd_sc_mcu7t5v0__fillcap_4
XFILLER_5_842 VDD VSS VDD VSS gf180mcu_fd_sc_mcu7t5v0__fillcap_32
X_1390_ VDD VSS _3346_/Q _1563_/A2 VDD VSS gf180mcu_fd_sc_mcu7t5v0__clkinv_1
XFILLER_79_142 VDD VSS VDD VSS gf180mcu_fd_sc_mcu7t5v0__fillcap_4
XFILLER_94_101 VDD VSS VDD VSS gf180mcu_fd_sc_mcu7t5v0__fillcap_4
XFILLER_255_416 VDD VSS VDD VSS gf180mcu_fd_sc_mcu7t5v0__fillcap_4
XFILLER_267_276 VDD VSS VDD VSS gf180mcu_fd_sc_mcu7t5v0__fillcap_4
XFILLER_0_580 VDD VSS VDD VSS gf180mcu_fd_sc_mcu7t5v0__fillcap_32
X_3060_ VDD _3060_/Q _3414_/CLK VSS _3060_/D VDD VSS gf180mcu_fd_sc_mcu7t5v0__dffq_1
X_2011_ _2018_/S VDD VSS _3053_/D _2011_/I0 _3053_/Q VDD VSS gf180mcu_fd_sc_mcu7t5v0__mux2_2
XFILLER_76_871 VDD VSS VDD VSS gf180mcu_fd_sc_mcu7t5v0__fillcap_4
XFILLER_94_156 VDD VSS VDD VSS gf180mcu_fd_sc_mcu7t5v0__fillcap_4
XFILLER_35_212 VDD VSS VDD VSS gf180mcu_fd_sc_mcu7t5v0__fillcap_64
XFILLER_208_387 VDD VSS VDD VSS gf180mcu_fd_sc_mcu7t5v0__fillcap_16
XFILLER_91_874 VDD VSS VDD VSS gf180mcu_fd_sc_mcu7t5v0__fillcap_16
XFILLER_92_2 VDD VSS VDD VSS gf180mcu_fd_sc_mcu7t5v0__fillcap_16
X_2913_ VDD _2913_/Q _2931_/CLK VSS _2913_/D VDD VSS gf180mcu_fd_sc_mcu7t5v0__dffq_1
X_2844_ VDD _2844_/Q _2914_/CLK VSS _2844_/D VDD VSS gf180mcu_fd_sc_mcu7t5v0__dffq_1
X_2775_ wire19/Z _3081_/Q VDD VSS _2776_/I _3329_/Q wire37/Z VDD VSS gf180mcu_fd_sc_mcu7t5v0__aoi22_1
X_1726_ _1728_/S VDD VSS _2810_/D _2810_/Q _3124_/Q VDD VSS gf180mcu_fd_sc_mcu7t5v0__mux2_2
X_1657_ VDD VSS _2239_/A2 wire72/Z _2448_/C VDD VSS gf180mcu_fd_sc_mcu7t5v0__nand2_1
XFILLER_208_96 VDD VSS VDD VSS gf180mcu_fd_sc_mcu7t5v0__fillcap_8
X_1588_ VDD _1588_/B _1588_/A2 _1598_/A1 _3145_/Q VSS VDD VSS gf180mcu_fd_sc_mcu7t5v0__oai21_1
XFILLER_259_766 VDD VSS VDD VSS gf180mcu_fd_sc_mcu7t5v0__fillcap_4
XFILLER_98_462 VDD VSS VDD VSS gf180mcu_fd_sc_mcu7t5v0__fillcap_32
X_3327_ _3327_/D _3327_/Q _3335_/RN VSS _3337_/CLK VDD VDD VSS gf180mcu_fd_sc_mcu7t5v0__dffrnq_1
XFILLER_219_619 VDD VSS VDD VSS gf180mcu_fd_sc_mcu7t5v0__fillcap_8
XFILLER_218_107 VDD VSS VDD VSS gf180mcu_fd_sc_mcu7t5v0__fillcap_16
XFILLER_39_562 VDD VSS VDD VSS gf180mcu_fd_sc_mcu7t5v0__fillcap_64
XFILLER_27_702 VDD VSS VDD VSS gf180mcu_fd_sc_mcu7t5v0__fillcap_64
X_3258_ _3258_/D _3258_/Q _3339_/RN VSS _3339_/CLK VDD VDD VSS gf180mcu_fd_sc_mcu7t5v0__dffrnq_1
X_3189_ _3189_/D _3189_/Q _3344_/RN VSS _3344_/CLK VDD VDD VSS gf180mcu_fd_sc_mcu7t5v0__dffrnq_1
X_2209_ _2221_/S VDD VSS _3155_/D _3289_/Q _3155_/Q VDD VSS gf180mcu_fd_sc_mcu7t5v0__mux2_2
XFILLER_54_521 VDD VSS VDD VSS gf180mcu_fd_sc_mcu7t5v0__fillcap_4
XFILLER_66_381 VDD VSS VDD VSS gf180mcu_fd_sc_mcu7t5v0__fillcap_4
XFILLER_227_696 VDD VSS VDD VSS gf180mcu_fd_sc_mcu7t5v0__fillcap_4
XFILLER_215_836 VDD VSS VDD VSS gf180mcu_fd_sc_mcu7t5v0__fillcap_4
XFILLER_82_885 VDD VSS VDD VSS gf180mcu_fd_sc_mcu7t5v0__fillcap_4
XFILLER_214_379 VDD VSS VDD VSS gf180mcu_fd_sc_mcu7t5v0__fillcap_4
XFILLER_195_710 VDD VSS VDD VSS gf180mcu_fd_sc_mcu7t5v0__fillcap_4
XFILLER_22_451 VDD VSS VDD VSS gf180mcu_fd_sc_mcu7t5v0__fillcap_4
XFILLER_195_765 VDD VSS VDD VSS gf180mcu_fd_sc_mcu7t5v0__fillcap_4
XFILLER_2_801 VDD VSS VDD VSS gf180mcu_fd_sc_mcu7t5v0__fillcap_4
XFILLER_108_589 VDD VSS VDD VSS gf180mcu_fd_sc_mcu7t5v0__fillcap_4
XFILLER_118_52 VDD VSS VDD VSS gf180mcu_fd_sc_mcu7t5v0__fillcap_16
XFILLER_237_416 VDD VSS VDD VSS gf180mcu_fd_sc_mcu7t5v0__fillcap_4
XFILLER_249_276 VDD VSS VDD VSS gf180mcu_fd_sc_mcu7t5v0__fillcap_4
XFILLER_131_592 VDD VSS VDD VSS gf180mcu_fd_sc_mcu7t5v0__fillcap_16
XFILLER_58_871 VDD VSS VDD VSS gf180mcu_fd_sc_mcu7t5v0__fillcap_4
XFILLER_218_641 VDD VSS VDD VSS gf180mcu_fd_sc_mcu7t5v0__fillcap_16
XFILLER_17_212 VDD VSS VDD VSS gf180mcu_fd_sc_mcu7t5v0__fillcap_64
XFILLER_205_346 VDD VSS VDD VSS gf180mcu_fd_sc_mcu7t5v0__fillcap_4
XFILLER_73_874 VDD VSS VDD VSS gf180mcu_fd_sc_mcu7t5v0__fillcap_16
XFILLER_201_530 VDD VSS VDD VSS gf180mcu_fd_sc_mcu7t5v0__fillcap_8
XFILLER_198_570 VDD VSS VDD VSS gf180mcu_fd_sc_mcu7t5v0__fillcap_16
XFILLER_220_349 VDD VSS VDD VSS gf180mcu_fd_sc_mcu7t5v0__fillcap_16
XFILLER_9_422 VDD VSS VDD VSS gf180mcu_fd_sc_mcu7t5v0__fillcap_64
XFILLER_185_220 VDD VSS VDD VSS gf180mcu_fd_sc_mcu7t5v0__fillcap_16
XFILLER_173_437 VDD VSS VDD VSS gf180mcu_fd_sc_mcu7t5v0__fillcap_32
XFILLER_154_651 VDD VSS VDD VSS gf180mcu_fd_sc_mcu7t5v0__fillcap_8
X_2560_ _2566_/S VDD VSS _3229_/D _3214_/Q _3229_/Q VDD VSS gf180mcu_fd_sc_mcu7t5v0__mux2_2
X_1511_ VDD VSS _3370_/D _1728_/S _1514_/A2 VDD VSS gf180mcu_fd_sc_mcu7t5v0__nor2_1
XFILLER_153_150 VDD VSS VDD VSS gf180mcu_fd_sc_mcu7t5v0__fillcap_16
X_2491_ VDD VSS _2492_/B _3211_/Q _2486_/B VDD VSS gf180mcu_fd_sc_mcu7t5v0__nand2_1
X_1442_ VDD VSS _3130_/Q _2152_/A1 VDD VSS gf180mcu_fd_sc_mcu7t5v0__clkinv_1
XFILLER_141_334 VDD VSS VDD VSS gf180mcu_fd_sc_mcu7t5v0__fillcap_4
XFILLER_4_171 VDD VSS VDD VSS gf180mcu_fd_sc_mcu7t5v0__fillcap_4
XFILLER_95_410 VDD VSS VDD VSS gf180mcu_fd_sc_mcu7t5v0__fillcap_8
X_3112_ _3112_/D _3112_/Q wire153/Z VSS _3192_/CLK VDD VDD VSS gf180mcu_fd_sc_mcu7t5v0__dffrnq_1
XFILLER_36_521 VDD VSS VDD VSS gf180mcu_fd_sc_mcu7t5v0__fillcap_4
X_3043_ VDD _3043_/Q _3046_/CLK VSS _3043_/D VDD VSS gf180mcu_fd_sc_mcu7t5v0__dffq_1
XFILLER_48_381 VDD VSS VDD VSS gf180mcu_fd_sc_mcu7t5v0__fillcap_4
XFILLER_208_184 VDD VSS VDD VSS gf180mcu_fd_sc_mcu7t5v0__fillcap_16
XFILLER_64_885 VDD VSS VDD VSS gf180mcu_fd_sc_mcu7t5v0__fillcap_4
XFILLER_196_518 VDD VSS VDD VSS gf180mcu_fd_sc_mcu7t5v0__fillcap_4
XFILLER_176_231 VDD VSS VDD VSS gf180mcu_fd_sc_mcu7t5v0__fillcap_8
X_2827_ VDD _2827_/Q _3458_/CLK VSS _2827_/D VDD VSS gf180mcu_fd_sc_mcu7t5v0__dffq_1
XFILLER_191_212 VDD VSS VDD VSS gf180mcu_fd_sc_mcu7t5v0__fillcap_32
X_2758_ _2758_/A3 VDD VSS _2760_/A1 wire102/Z _2758_/A2 VDD VSS gf180mcu_fd_sc_mcu7t5v0__nand3_1
XFILLER_145_695 VDD VSS VDD VSS gf180mcu_fd_sc_mcu7t5v0__fillcap_4
X_1709_ VDD VSS _1710_/A2 _2331_/B _2274_/C VDD VSS gf180mcu_fd_sc_mcu7t5v0__nor2_1
XFILLER_172_492 VDD VSS VDD VSS gf180mcu_fd_sc_mcu7t5v0__fillcap_8
X_2689_ VDD VSS _2689_/Z _2752_/B _2689_/A2 VDD VSS gf180mcu_fd_sc_mcu7t5v0__or2_1
XFILLER_235_72 VDD VSS VDD VSS gf180mcu_fd_sc_mcu7t5v0__fillcap_64
XFILLER_58_101 VDD VSS VDD VSS gf180mcu_fd_sc_mcu7t5v0__fillcap_4
XFILLER_48_37 VDD VSS VDD VSS gf180mcu_fd_sc_mcu7t5v0__fillcap_64
XFILLER_104_10 VDD VSS VDD VSS gf180mcu_fd_sc_mcu7t5v0__fillcap_4
XFILLER_104_87 VDD VSS VDD VSS gf180mcu_fd_sc_mcu7t5v0__fillcap_16
XFILLER_55_874 VDD VSS VDD VSS gf180mcu_fd_sc_mcu7t5v0__fillcap_16
XFILLER_120_20 VDD VSS VDD VSS gf180mcu_fd_sc_mcu7t5v0__fillcap_8
XFILLER_70_877 VDD VSS VDD VSS gf180mcu_fd_sc_mcu7t5v0__fillcap_8
XFILLER_120_53 VDD VSS VDD VSS gf180mcu_fd_sc_mcu7t5v0__fillcap_4
XFILLER_195_540 VDD VSS VDD VSS gf180mcu_fd_sc_mcu7t5v0__fillcap_8
XFILLER_183_702 VDD VSS VDD VSS gf180mcu_fd_sc_mcu7t5v0__fillcap_64
XFILLER_196_57 VDD VSS VDD VSS gf180mcu_fd_sc_mcu7t5v0__fillcap_4
XFILLER_127_106 VDD VSS VDD VSS gf180mcu_fd_sc_mcu7t5v0__fillcap_32
XFILLER_151_621 VDD VSS VDD VSS gf180mcu_fd_sc_mcu7t5v0__fillcap_8
XFILLER_129_95 VDD VSS VDD VSS gf180mcu_fd_sc_mcu7t5v0__fillcap_4
XFILLER_163_492 VDD VSS VDD VSS gf180mcu_fd_sc_mcu7t5v0__fillcap_64
XFILLER_151_632 VDD VSS VDD VSS gf180mcu_fd_sc_mcu7t5v0__fillcap_16
XFILLER_150_131 VDD VSS VDD VSS gf180mcu_fd_sc_mcu7t5v0__fillcap_4
XFILLER_123_323 VDD VSS VDD VSS gf180mcu_fd_sc_mcu7t5v0__fillcap_16
XFILLER_111_507 VDD VSS VDD VSS gf180mcu_fd_sc_mcu7t5v0__fillcap_8
XFILLER_18_521 VDD VSS VDD VSS gf180mcu_fd_sc_mcu7t5v0__fillcap_4
XFILLER_92_457 VDD VSS VDD VSS gf180mcu_fd_sc_mcu7t5v0__fillcap_64
XFILLER_46_885 VDD VSS VDD VSS gf180mcu_fd_sc_mcu7t5v0__fillcap_4
XFILLER_261_772 VDD VSS VDD VSS gf180mcu_fd_sc_mcu7t5v0__fillcap_64
XFILLER_221_647 VDD VSS VDD VSS gf180mcu_fd_sc_mcu7t5v0__fillcap_32
XFILLER_221_625 VDD VSS VDD VSS gf180mcu_fd_sc_mcu7t5v0__fillcap_4
XFILLER_72_192 VDD VSS VDD VSS gf180mcu_fd_sc_mcu7t5v0__fillcap_4
XFILLER_60_387 VDD VSS VDD VSS gf180mcu_fd_sc_mcu7t5v0__fillcap_64
XFILLER_158_231 VDD VSS VDD VSS gf180mcu_fd_sc_mcu7t5v0__fillcap_8
X_1991_ _1991_/S VDD VSS _3036_/D _3036_/Q wire113/Z VDD VSS gf180mcu_fd_sc_mcu7t5v0__mux2_2
XFILLER_173_212 VDD VSS VDD VSS gf180mcu_fd_sc_mcu7t5v0__fillcap_64
XFILLER_158_275 VDD VSS VDD VSS gf180mcu_fd_sc_mcu7t5v0__fillcap_4
XFILLER_158_286 VDD VSS VDD VSS gf180mcu_fd_sc_mcu7t5v0__fillcap_16
Xclkload44 VSS clkload44/Z _3443_/CLK VDD VDD VSS gf180mcu_fd_sc_mcu7t5v0__clkbuf_1
Xclkload22 VSS clkload22/Z _3281_/CLK VDD VDD VSS gf180mcu_fd_sc_mcu7t5v0__clkbuf_1
X_2612_ VDD VSS _3276_/D wire46/I _2612_/A2 VDD VSS gf180mcu_fd_sc_mcu7t5v0__nand2_1
Xclkload11 VSS clkload11/Z _3307_/CLK VDD VDD VSS gf180mcu_fd_sc_mcu7t5v0__clkbuf_1
Xclkload33 VDD VSS _3039_/CLK clkload33/ZN VDD VSS gf180mcu_fd_sc_mcu7t5v0__clkinv_2
XFILLER_127_640 VDD VSS VDD VSS gf180mcu_fd_sc_mcu7t5v0__fillcap_4
Xclkload77 VDD VSS clkload77/ZN _3458_/CLK VDD VSS gf180mcu_fd_sc_mcu7t5v0__clkinv_4
Xclkload55 VDD VSS _3358_/CLK clkload55/ZN VDD VSS gf180mcu_fd_sc_mcu7t5v0__clkinv_2
Xclkload66 VDD VSS _3202_/CLK clkload66/ZN VDD VSS gf180mcu_fd_sc_mcu7t5v0__clkinv_2
XFILLER_55_2 VDD VSS VDD VSS gf180mcu_fd_sc_mcu7t5v0__fillcap_64
X_2543_ _2543_/B VDD VSS _3221_/D _3221_/Q _2550_/A1 VDD VSS gf180mcu_fd_sc_mcu7t5v0__aoi21_1
Xclkload88 VSS clkload88/ZN _2900_/CLK VDD VDD VSS gf180mcu_fd_sc_mcu7t5v0__inv_4
X_2474_ VDD _2474_/B _2474_/A2 _2475_/A2 _2474_/A1 VSS VDD VSS gf180mcu_fd_sc_mcu7t5v0__oai21_1
XFILLER_141_142 VDD VSS VDD VSS gf180mcu_fd_sc_mcu7t5v0__fillcap_16
XFILLER_141_197 VDD VSS VDD VSS gf180mcu_fd_sc_mcu7t5v0__fillcap_8
X_1425_ VDD VSS _3094_/Q _2305_/A2 VDD VSS gf180mcu_fd_sc_mcu7t5v0__clkinv_1
XFILLER_96_730 VDD VSS VDD VSS gf180mcu_fd_sc_mcu7t5v0__fillcap_4
XFILLER_205_64 VDD VSS VDD VSS gf180mcu_fd_sc_mcu7t5v0__fillcap_4
XFILLER_70_107 VDD VSS VDD VSS gf180mcu_fd_sc_mcu7t5v0__fillcap_16
XFILLER_37_874 VDD VSS VDD VSS gf180mcu_fd_sc_mcu7t5v0__fillcap_16
X_3026_ VDD _3026_/Q _3055_/CLK VSS _3026_/D VDD VSS gf180mcu_fd_sc_mcu7t5v0__dffq_1
XFILLER_251_282 VDD VSS VDD VSS gf180mcu_fd_sc_mcu7t5v0__fillcap_64
XFILLER_211_124 VDD VSS VDD VSS gf180mcu_fd_sc_mcu7t5v0__fillcap_16
XFILLER_52_877 VDD VSS VDD VSS gf180mcu_fd_sc_mcu7t5v0__fillcap_8
XFILLER_177_562 VDD VSS VDD VSS gf180mcu_fd_sc_mcu7t5v0__fillcap_4
XFILLER_165_702 VDD VSS VDD VSS gf180mcu_fd_sc_mcu7t5v0__fillcap_64
Xclkload5 VDD VSS clkload5/ZN clkload5/I VDD VSS gf180mcu_fd_sc_mcu7t5v0__clkinv_8
XFILLER_137_437 VDD VSS VDD VSS gf180mcu_fd_sc_mcu7t5v0__fillcap_16
XFILLER_177_584 VDD VSS VDD VSS gf180mcu_fd_sc_mcu7t5v0__fillcap_32
XFILLER_164_223 VDD VSS VDD VSS gf180mcu_fd_sc_mcu7t5v0__fillcap_16
XFILLER_192_543 VDD VSS VDD VSS gf180mcu_fd_sc_mcu7t5v0__fillcap_8
XFILLER_164_256 VDD VSS VDD VSS gf180mcu_fd_sc_mcu7t5v0__fillcap_8
XFILLER_145_492 VDD VSS VDD VSS gf180mcu_fd_sc_mcu7t5v0__fillcap_8
XFILLER_105_345 VDD VSS VDD VSS gf180mcu_fd_sc_mcu7t5v0__fillcap_4
XFILLER_133_632 VDD VSS VDD VSS gf180mcu_fd_sc_mcu7t5v0__fillcap_8
XFILLER_132_131 VDD VSS VDD VSS gf180mcu_fd_sc_mcu7t5v0__fillcap_4
XFILLER_182_37 VDD VSS VDD VSS gf180mcu_fd_sc_mcu7t5v0__fillcap_16
XFILLER_86_240 VDD VSS VDD VSS gf180mcu_fd_sc_mcu7t5v0__fillcap_4
XFILLER_115_53 VDD VSS VDD VSS gf180mcu_fd_sc_mcu7t5v0__fillcap_16
XFILLER_101_562 VDD VSS VDD VSS gf180mcu_fd_sc_mcu7t5v0__fillcap_16
XFILLER_74_457 VDD VSS VDD VSS gf180mcu_fd_sc_mcu7t5v0__fillcap_64
XFILLER_28_885 VDD VSS VDD VSS gf180mcu_fd_sc_mcu7t5v0__fillcap_4
XFILLER_243_772 VDD VSS VDD VSS gf180mcu_fd_sc_mcu7t5v0__fillcap_64
XFILLER_257_2 VDD VSS VDD VSS gf180mcu_fd_sc_mcu7t5v0__fillcap_64
XFILLER_199_142 VDD VSS VDD VSS gf180mcu_fd_sc_mcu7t5v0__fillcap_32
XFILLER_199_120 VDD VSS VDD VSS gf180mcu_fd_sc_mcu7t5v0__fillcap_4
XFILLER_203_625 VDD VSS VDD VSS gf180mcu_fd_sc_mcu7t5v0__fillcap_4
XFILLER_42_387 VDD VSS VDD VSS gf180mcu_fd_sc_mcu7t5v0__fillcap_64
XFILLER_30_527 VDD VSS VDD VSS gf180mcu_fd_sc_mcu7t5v0__fillcap_64
XFILLER_196_871 VDD VSS VDD VSS gf180mcu_fd_sc_mcu7t5v0__fillcap_4
XFILLER_155_212 VDD VSS VDD VSS gf180mcu_fd_sc_mcu7t5v0__fillcap_32
XFILLER_123_142 VDD VSS VDD VSS gf180mcu_fd_sc_mcu7t5v0__fillcap_16
X_2190_ VDD VSS _2190_/Z _3146_/Q _3147_/Q VDD VSS gf180mcu_fd_sc_mcu7t5v0__xor2_1
XFILLER_265_352 VDD VSS VDD VSS gf180mcu_fd_sc_mcu7t5v0__fillcap_64
XFILLER_77_262 VDD VSS VDD VSS gf180mcu_fd_sc_mcu7t5v0__fillcap_4
XFILLER_120_871 VDD VSS VDD VSS gf180mcu_fd_sc_mcu7t5v0__fillcap_4
XFILLER_93_766 VDD VSS VDD VSS gf180mcu_fd_sc_mcu7t5v0__fillcap_4
XFILLER_19_874 VDD VSS VDD VSS gf180mcu_fd_sc_mcu7t5v0__fillcap_16
XFILLER_52_107 VDD VSS VDD VSS gf180mcu_fd_sc_mcu7t5v0__fillcap_64
XFILLER_233_282 VDD VSS VDD VSS gf180mcu_fd_sc_mcu7t5v0__fillcap_64
XFILLER_221_422 VDD VSS VDD VSS gf180mcu_fd_sc_mcu7t5v0__fillcap_16
XFILLER_34_877 VDD VSS VDD VSS gf180mcu_fd_sc_mcu7t5v0__fillcap_8
XFILLER_61_696 VDD VSS VDD VSS gf180mcu_fd_sc_mcu7t5v0__fillcap_4
XFILLER_159_562 VDD VSS VDD VSS gf180mcu_fd_sc_mcu7t5v0__fillcap_64
X_1974_ _1981_/S VDD VSS _3021_/D _2011_/I0 _3021_/Q VDD VSS gf180mcu_fd_sc_mcu7t5v0__mux2_2
XFILLER_174_521 VDD VSS VDD VSS gf180mcu_fd_sc_mcu7t5v0__fillcap_4
XFILLER_127_481 VDD VSS VDD VSS gf180mcu_fd_sc_mcu7t5v0__fillcap_8
XFILLER_142_451 VDD VSS VDD VSS gf180mcu_fd_sc_mcu7t5v0__fillcap_4
X_2526_ _2526_/A3 VDD VSS _2528_/A1 _3221_/Q _2526_/A2 VDD VSS gf180mcu_fd_sc_mcu7t5v0__nand3_1
X_2457_ _3382_/Q VDD VSS _2463_/A2 _2459_/A1 _2456_/Z VDD VSS gf180mcu_fd_sc_mcu7t5v0__aoi21_1
XFILLER_102_304 VDD VSS VDD VSS gf180mcu_fd_sc_mcu7t5v0__fillcap_8
XFILLER_114_164 VDD VSS VDD VSS gf180mcu_fd_sc_mcu7t5v0__fillcap_8
XFILLER_130_613 VDD VSS VDD VSS gf180mcu_fd_sc_mcu7t5v0__fillcap_4
XFILLER_257_842 VDD VSS VDD VSS gf180mcu_fd_sc_mcu7t5v0__fillcap_32
X_1408_ VDD VSS _3271_/Q _2686_/A1 VDD VSS gf180mcu_fd_sc_mcu7t5v0__clkinv_1
X_2388_ _2926_/Q VSS VDD _2910_/Q _2918_/Q _2454_/S0 _2902_/Q _2454_/S1 _2388_/Z VDD
+ VSS gf180mcu_fd_sc_mcu7t5v0__mux4_1
XFILLER_110_370 VDD VSS VDD VSS gf180mcu_fd_sc_mcu7t5v0__fillcap_8
XFILLER_56_457 VDD VSS VDD VSS gf180mcu_fd_sc_mcu7t5v0__fillcap_64
XFILLER_71_416 VDD VSS VDD VSS gf180mcu_fd_sc_mcu7t5v0__fillcap_4
XFILLER_225_772 VDD VSS VDD VSS gf180mcu_fd_sc_mcu7t5v0__fillcap_64
X_3009_ VDD _3009_/Q _3021_/CLK VSS _3009_/D VDD VSS gf180mcu_fd_sc_mcu7t5v0__dffq_1
XFILLER_240_731 VDD VSS VDD VSS gf180mcu_fd_sc_mcu7t5v0__fillcap_4
XFILLER_252_591 VDD VSS VDD VSS gf180mcu_fd_sc_mcu7t5v0__fillcap_4
XFILLER_196_101 VDD VSS VDD VSS gf180mcu_fd_sc_mcu7t5v0__fillcap_4
XFILLER_24_387 VDD VSS VDD VSS gf180mcu_fd_sc_mcu7t5v0__fillcap_64
XFILLER_196_123 VDD VSS VDD VSS gf180mcu_fd_sc_mcu7t5v0__fillcap_4
XFILLER_12_527 VDD VSS VDD VSS gf180mcu_fd_sc_mcu7t5v0__fillcap_64
XFILLER_101_66 VDD VSS VDD VSS gf180mcu_fd_sc_mcu7t5v0__fillcap_4
XFILLER_197_668 VDD VSS VDD VSS gf180mcu_fd_sc_mcu7t5v0__fillcap_32
XFILLER_178_871 VDD VSS VDD VSS gf180mcu_fd_sc_mcu7t5v0__fillcap_4
XFILLER_137_212 VDD VSS VDD VSS gf180mcu_fd_sc_mcu7t5v0__fillcap_16
XFILLER_193_874 VDD VSS VDD VSS gf180mcu_fd_sc_mcu7t5v0__fillcap_16
XFILLER_4_737 VDD VSS VDD VSS gf180mcu_fd_sc_mcu7t5v0__fillcap_64
XFILLER_105_120 VDD VSS VDD VSS gf180mcu_fd_sc_mcu7t5v0__fillcap_4
XFILLER_105_164 VDD VSS VDD VSS gf180mcu_fd_sc_mcu7t5v0__fillcap_4
XFILLER_106_698 VDD VSS VDD VSS gf180mcu_fd_sc_mcu7t5v0__fillcap_32
XFILLER_120_123 VDD VSS VDD VSS gf180mcu_fd_sc_mcu7t5v0__fillcap_4
XFILLER_102_871 VDD VSS VDD VSS gf180mcu_fd_sc_mcu7t5v0__fillcap_4
XFILLER_247_352 VDD VSS VDD VSS gf180mcu_fd_sc_mcu7t5v0__fillcap_64
XFILLER_19_72 VDD VSS VDD VSS gf180mcu_fd_sc_mcu7t5v0__fillcap_64
XFILLER_262_311 VDD VSS VDD VSS gf180mcu_fd_sc_mcu7t5v0__fillcap_4
XFILLER_75_766 VDD VSS VDD VSS gf180mcu_fd_sc_mcu7t5v0__fillcap_4
XFILLER_34_107 VDD VSS VDD VSS gf180mcu_fd_sc_mcu7t5v0__fillcap_64
XFILLER_215_282 VDD VSS VDD VSS gf180mcu_fd_sc_mcu7t5v0__fillcap_16
XFILLER_16_877 VDD VSS VDD VSS gf180mcu_fd_sc_mcu7t5v0__fillcap_8
XFILLER_230_241 VDD VSS VDD VSS gf180mcu_fd_sc_mcu7t5v0__fillcap_4
XFILLER_31_836 VDD VSS VDD VSS gf180mcu_fd_sc_mcu7t5v0__fillcap_4
XFILLER_43_696 VDD VSS VDD VSS gf180mcu_fd_sc_mcu7t5v0__fillcap_4
XFILLER_129_702 VDD VSS VDD VSS gf180mcu_fd_sc_mcu7t5v0__fillcap_64
XFILLER_156_521 VDD VSS VDD VSS gf180mcu_fd_sc_mcu7t5v0__fillcap_4
XFILLER_184_885 VDD VSS VDD VSS gf180mcu_fd_sc_mcu7t5v0__fillcap_4
X_1690_ VDD VSS _2264_/A1 _2364_/A1 _2239_/C VDD VSS gf180mcu_fd_sc_mcu7t5v0__nand2_1
XFILLER_109_492 VDD VSS VDD VSS gf180mcu_fd_sc_mcu7t5v0__fillcap_32
XFILLER_124_440 VDD VSS VDD VSS gf180mcu_fd_sc_mcu7t5v0__fillcap_8
X_3360_ VSS _3360_/CLK VDD _3360_/D _3361_/D wire153/Z VDD VSS gf180mcu_fd_sc_mcu7t5v0__dffsnq_1
X_2311_ _2330_/A2 VDD VSS _2312_/A3 _2804_/Q _3207_/Q VDD VSS gf180mcu_fd_sc_mcu7t5v0__nand3_1
X_3291_ _3291_/D wire87/I _3336_/RN VSS _3316_/CLK VDD VDD VSS gf180mcu_fd_sc_mcu7t5v0__dffrnq_1
XFILLER_97_368 VDD VSS VDD VSS gf180mcu_fd_sc_mcu7t5v0__fillcap_4
XFILLER_239_842 VDD VSS VDD VSS gf180mcu_fd_sc_mcu7t5v0__fillcap_32
X_2242_ _3171_/Q _1700_/Z VDD VSS _2482_/A3 _2469_/A1 _3172_/Q VDD VSS gf180mcu_fd_sc_mcu7t5v0__nand4_1
XFILLER_254_801 VDD VSS VDD VSS gf180mcu_fd_sc_mcu7t5v0__fillcap_4
XFILLER_266_661 VDD VSS VDD VSS gf180mcu_fd_sc_mcu7t5v0__fillcap_4
X_2173_ VDD _2173_/B _3348_/D _3138_/D _2173_/A1 VSS VDD VSS gf180mcu_fd_sc_mcu7t5v0__oai21_1
XFILLER_18_2 VDD VSS VDD VSS gf180mcu_fd_sc_mcu7t5v0__fillcap_32
XFILLER_38_457 VDD VSS VDD VSS gf180mcu_fd_sc_mcu7t5v0__fillcap_64
XFILLER_207_772 VDD VSS VDD VSS gf180mcu_fd_sc_mcu7t5v0__fillcap_64
XFILLER_65_276 VDD VSS VDD VSS gf180mcu_fd_sc_mcu7t5v0__fillcap_4
XFILLER_53_416 VDD VSS VDD VSS gf180mcu_fd_sc_mcu7t5v0__fillcap_4
XFILLER_222_731 VDD VSS VDD VSS gf180mcu_fd_sc_mcu7t5v0__fillcap_4
XFILLER_234_591 VDD VSS VDD VSS gf180mcu_fd_sc_mcu7t5v0__fillcap_4
XFILLER_178_123 VDD VSS VDD VSS gf180mcu_fd_sc_mcu7t5v0__fillcap_8
XFILLER_21_346 VDD VSS VDD VSS gf180mcu_fd_sc_mcu7t5v0__fillcap_4
XFILLER_119_212 VDD VSS VDD VSS gf180mcu_fd_sc_mcu7t5v0__fillcap_4
X_1957_ _1963_/S VDD VSS _3006_/D wire123/Z _3006_/Q VDD VSS gf180mcu_fd_sc_mcu7t5v0__mux2_2
X_1888_ VDD VSS _2001_/A1 _3408_/Q _1889_/A2 VDD VSS gf180mcu_fd_sc_mcu7t5v0__nor2_1
XFILLER_175_874 VDD VSS VDD VSS gf180mcu_fd_sc_mcu7t5v0__fillcap_16
XFILLER_190_877 VDD VSS VDD VSS gf180mcu_fd_sc_mcu7t5v0__fillcap_8
XFILLER_0_206 VDD VSS VDD VSS gf180mcu_fd_sc_mcu7t5v0__fillcap_32
X_2509_ _2525_/B1 _3324_/Q VDD VSS _2513_/A2 _3316_/Q _1640_/I VDD VSS gf180mcu_fd_sc_mcu7t5v0__aoi22_1
XFILLER_89_836 VDD VSS VDD VSS gf180mcu_fd_sc_mcu7t5v0__fillcap_4
XFILLER_88_379 VDD VSS VDD VSS gf180mcu_fd_sc_mcu7t5v0__fillcap_4
XFILLER_229_352 VDD VSS VDD VSS gf180mcu_fd_sc_mcu7t5v0__fillcap_64
XFILLER_243_72 VDD VSS VDD VSS gf180mcu_fd_sc_mcu7t5v0__fillcap_64
XFILLER_130_498 VDD VSS VDD VSS gf180mcu_fd_sc_mcu7t5v0__fillcap_16
XFILLER_56_37 VDD VSS VDD VSS gf180mcu_fd_sc_mcu7t5v0__fillcap_64
XFILLER_244_311 VDD VSS VDD VSS gf180mcu_fd_sc_mcu7t5v0__fillcap_4
XFILLER_256_171 VDD VSS VDD VSS gf180mcu_fd_sc_mcu7t5v0__fillcap_4
XFILLER_57_766 VDD VSS VDD VSS gf180mcu_fd_sc_mcu7t5v0__fillcap_4
XFILLER_16_107 VDD VSS VDD VSS gf180mcu_fd_sc_mcu7t5v0__fillcap_64
XFILLER_197_410 VDD VSS VDD VSS gf180mcu_fd_sc_mcu7t5v0__fillcap_8
XFILLER_112_98 VDD VSS VDD VSS gf180mcu_fd_sc_mcu7t5v0__fillcap_4
XFILLER_185_616 VDD VSS VDD VSS gf180mcu_fd_sc_mcu7t5v0__fillcap_8
XFILLER_13_836 VDD VSS VDD VSS gf180mcu_fd_sc_mcu7t5v0__fillcap_4
XFILLER_25_696 VDD VSS VDD VSS gf180mcu_fd_sc_mcu7t5v0__fillcap_4
XFILLER_184_126 VDD VSS VDD VSS gf180mcu_fd_sc_mcu7t5v0__fillcap_8
XFILLER_8_317 VDD VSS VDD VSS gf180mcu_fd_sc_mcu7t5v0__fillcap_64
XFILLER_138_543 VDD VSS VDD VSS gf180mcu_fd_sc_mcu7t5v0__fillcap_8
XFILLER_166_885 VDD VSS VDD VSS gf180mcu_fd_sc_mcu7t5v0__fillcap_4
XFILLER_125_237 VDD VSS VDD VSS gf180mcu_fd_sc_mcu7t5v0__fillcap_8
XFILLER_140_229 VDD VSS VDD VSS gf180mcu_fd_sc_mcu7t5v0__fillcap_16
XFILLER_153_50 VDD VSS VDD VSS gf180mcu_fd_sc_mcu7t5v0__fillcap_8
XFILLER_236_801 VDD VSS VDD VSS gf180mcu_fd_sc_mcu7t5v0__fillcap_4
XFILLER_248_661 VDD VSS VDD VSS gf180mcu_fd_sc_mcu7t5v0__fillcap_4
XFILLER_153_72 VDD VSS VDD VSS gf180mcu_fd_sc_mcu7t5v0__fillcap_4
XFILLER_0_784 VDD VSS VDD VSS gf180mcu_fd_sc_mcu7t5v0__fillcap_32
XFILLER_47_276 VDD VSS VDD VSS gf180mcu_fd_sc_mcu7t5v0__fillcap_4
XFILLER_35_416 VDD VSS VDD VSS gf180mcu_fd_sc_mcu7t5v0__fillcap_4
XFILLER_216_591 VDD VSS VDD VSS gf180mcu_fd_sc_mcu7t5v0__fillcap_4
X_2860_ VDD _2860_/Q _3369_/CLK VSS _2860_/D VDD VSS gf180mcu_fd_sc_mcu7t5v0__dffq_1
X_1811_ _1814_/S VDD VSS _2881_/D wire131/Z _2881_/Q VDD VSS gf180mcu_fd_sc_mcu7t5v0__mux2_2
X_2791_ wire19/Z _3089_/Q VDD VSS _2792_/I _3337_/Q wire37/Z VDD VSS gf180mcu_fd_sc_mcu7t5v0__aoi22_1
XFILLER_184_660 VDD VSS VDD VSS gf180mcu_fd_sc_mcu7t5v0__fillcap_4
X_1742_ _1748_/S VDD VSS _2822_/D _2822_/Q _3120_/Q VDD VSS gf180mcu_fd_sc_mcu7t5v0__mux2_2
XFILLER_157_874 VDD VSS VDD VSS gf180mcu_fd_sc_mcu7t5v0__fillcap_16
XFILLER_190_107 VDD VSS VDD VSS gf180mcu_fd_sc_mcu7t5v0__fillcap_32
XFILLER_156_351 VDD VSS VDD VSS gf180mcu_fd_sc_mcu7t5v0__fillcap_32
X_1673_ _1673_/B VDD VSS _1691_/B _2231_/A1 _1673_/A2 VDD VSS gf180mcu_fd_sc_mcu7t5v0__aoi21_1
X_3412_ _3412_/D _3430_/D wire161/I VSS _3441_/CLK VDD VDD VSS gf180mcu_fd_sc_mcu7t5v0__dffrnq_1
XFILLER_172_877 VDD VSS VDD VSS gf180mcu_fd_sc_mcu7t5v0__fillcap_8
X_3343_ _3343_/D _3343_/Q _3344_/RN VSS _3344_/CLK VDD VDD VSS gf180mcu_fd_sc_mcu7t5v0__dffrnq_1
X_3274_ _3274_/D _3274_/Q wire145/I VSS _3274_/CLK VDD VDD VSS gf180mcu_fd_sc_mcu7t5v0__dffrnq_1
XFILLER_100_605 VDD VSS VDD VSS gf180mcu_fd_sc_mcu7t5v0__fillcap_4
X_2225_ _2225_/B VDD VSS _3169_/D _2225_/A1 _2225_/A2 VDD VSS gf180mcu_fd_sc_mcu7t5v0__aoi21_1
XFILLER_226_311 VDD VSS VDD VSS gf180mcu_fd_sc_mcu7t5v0__fillcap_4
XFILLER_238_171 VDD VSS VDD VSS gf180mcu_fd_sc_mcu7t5v0__fillcap_4
XFILLER_39_766 VDD VSS VDD VSS gf180mcu_fd_sc_mcu7t5v0__fillcap_4
X_2156_ _2156_/B1 _2167_/B1 VDD VSS _3131_/D _2156_/A1 _2168_/C VDD VSS gf180mcu_fd_sc_mcu7t5v0__aoi22_1
XFILLER_93_360 VDD VSS VDD VSS gf180mcu_fd_sc_mcu7t5v0__fillcap_4
XFILLER_198_218 VDD VSS VDD VSS gf180mcu_fd_sc_mcu7t5v0__fillcap_4
X_2087_ _2087_/B1 _2074_/Z VDD VSS _3104_/D _2087_/A1 _2087_/A2 VDD VSS gf180mcu_fd_sc_mcu7t5v0__aoi22_1
Xmax_length35 _1887_/S wire36/Z VDD VSS VDD VSS gf180mcu_fd_sc_mcu7t5v0__buf_4
X_2989_ VDD _2989_/Q _3005_/CLK VSS _2989_/D VDD VSS gf180mcu_fd_sc_mcu7t5v0__dffq_1
Xmax_length68 _2741_/S0 _2743_/S0 VDD VSS VDD VSS gf180mcu_fd_sc_mcu7t5v0__buf_4
Xmax_length57 VSS _2744_/S1 _3423_/Q VDD VDD VSS gf180mcu_fd_sc_mcu7t5v0__buf_2
Xmax_length79 wire78/I _1519_/B VDD VSS VDD VSS gf180mcu_fd_sc_mcu7t5v0__buf_4
XFILLER_148_885 VDD VSS VDD VSS gf180mcu_fd_sc_mcu7t5v0__fillcap_4
XFILLER_166_159 VDD VSS VDD VSS gf180mcu_fd_sc_mcu7t5v0__fillcap_16
XFILLER_162_332 VDD VSS VDD VSS gf180mcu_fd_sc_mcu7t5v0__fillcap_4
XFILLER_150_527 VDD VSS VDD VSS gf180mcu_fd_sc_mcu7t5v0__fillcap_4
XFILLER_115_270 VDD VSS VDD VSS gf180mcu_fd_sc_mcu7t5v0__fillcap_8
XFILLER_130_240 VDD VSS VDD VSS gf180mcu_fd_sc_mcu7t5v0__fillcap_4
XFILLER_218_801 VDD VSS VDD VSS gf180mcu_fd_sc_mcu7t5v0__fillcap_4
XFILLER_190_37 VDD VSS VDD VSS gf180mcu_fd_sc_mcu7t5v0__fillcap_32
XFILLER_17_416 VDD VSS VDD VSS gf180mcu_fd_sc_mcu7t5v0__fillcap_4
XFILLER_29_276 VDD VSS VDD VSS gf180mcu_fd_sc_mcu7t5v0__fillcap_4
XFILLER_260_667 VDD VSS VDD VSS gf180mcu_fd_sc_mcu7t5v0__fillcap_64
XFILLER_9_626 VDD VSS VDD VSS gf180mcu_fd_sc_mcu7t5v0__fillcap_4
XFILLER_200_233 VDD VSS VDD VSS gf180mcu_fd_sc_mcu7t5v0__fillcap_4
XFILLER_185_479 VDD VSS VDD VSS gf180mcu_fd_sc_mcu7t5v0__fillcap_8
XFILLER_139_874 VDD VSS VDD VSS gf180mcu_fd_sc_mcu7t5v0__fillcap_16
XFILLER_172_107 VDD VSS VDD VSS gf180mcu_fd_sc_mcu7t5v0__fillcap_8
XFILLER_165_170 VDD VSS VDD VSS gf180mcu_fd_sc_mcu7t5v0__fillcap_32
XFILLER_154_877 VDD VSS VDD VSS gf180mcu_fd_sc_mcu7t5v0__fillcap_8
XFILLER_126_568 VDD VSS VDD VSS gf180mcu_fd_sc_mcu7t5v0__fillcap_4
X_2010_ VDD VSS _2018_/S _2010_/A1 _2010_/A2 VDD VSS gf180mcu_fd_sc_mcu7t5v0__nand2_1
XFILLER_180_81 VDD VSS VDD VSS gf180mcu_fd_sc_mcu7t5v0__fillcap_16
XFILLER_91_842 VDD VSS VDD VSS gf180mcu_fd_sc_mcu7t5v0__fillcap_32
XFILLER_250_177 VDD VSS VDD VSS gf180mcu_fd_sc_mcu7t5v0__fillcap_64
X_2912_ VDD _2912_/Q _2932_/CLK VSS _2912_/D VDD VSS gf180mcu_fd_sc_mcu7t5v0__dffq_1
XFILLER_176_402 VDD VSS VDD VSS gf180mcu_fd_sc_mcu7t5v0__fillcap_8
XFILLER_176_457 VDD VSS VDD VSS gf180mcu_fd_sc_mcu7t5v0__fillcap_64
X_2843_ VDD _2843_/Q _2867_/CLK VSS _2843_/D VDD VSS gf180mcu_fd_sc_mcu7t5v0__dffq_1
XFILLER_85_2 VDD VSS VDD VSS gf180mcu_fd_sc_mcu7t5v0__fillcap_16
Xspi_opentarget_i3c_top_190 sda_pad_SL VDD VSS VDD VSS gf180mcu_fd_sc_mcu7t5v0__tiel
X_2774_ VDD VSS _2774_/I _3328_/D VDD VSS gf180mcu_fd_sc_mcu7t5v0__clkinv_1
X_1725_ _1728_/S VDD VSS _2809_/D _2809_/Q wire132/Z VDD VSS gf180mcu_fd_sc_mcu7t5v0__mux2_2
XFILLER_163_129 VDD VSS VDD VSS gf180mcu_fd_sc_mcu7t5v0__fillcap_8
XFILLER_144_354 VDD VSS VDD VSS gf180mcu_fd_sc_mcu7t5v0__fillcap_8
X_1656_ VDD VSS _2448_/C _3210_/Q _3206_/Q VDD VSS gf180mcu_fd_sc_mcu7t5v0__nor2_1
XFILLER_144_387 VDD VSS VDD VSS gf180mcu_fd_sc_mcu7t5v0__fillcap_4
XFILLER_132_527 VDD VSS VDD VSS gf180mcu_fd_sc_mcu7t5v0__fillcap_64
XFILLER_171_184 VDD VSS VDD VSS gf180mcu_fd_sc_mcu7t5v0__fillcap_8
X_1587_ _1587_/B VDD VSS _1588_/A2 _1587_/A1 _1587_/A2 VDD VSS gf180mcu_fd_sc_mcu7t5v0__aoi21_1
X_3326_ _3326_/D _3326_/Q wire169/Z VSS _3340_/CLK VDD VDD VSS gf180mcu_fd_sc_mcu7t5v0__dffrnq_1
X_3257_ _3257_/D _3257_/Q _3339_/RN VSS _3316_/CLK VDD VDD VSS gf180mcu_fd_sc_mcu7t5v0__dffrnq_1
Xclkbuf_leaf_50_clk_i _3039_/CLK VSS VDD clkload1/I VDD VSS gf180mcu_fd_sc_mcu7t5v0__clkbuf_2
XFILLER_100_457 VDD VSS VDD VSS gf180mcu_fd_sc_mcu7t5v0__fillcap_64
X_3188_ _3188_/D _3188_/Q _3344_/RN VSS _3344_/CLK VDD VDD VSS gf180mcu_fd_sc_mcu7t5v0__dffrnq_1
X_2208_ _2222_/S VDD VSS _3154_/D _3288_/Q _3154_/Q VDD VSS gf180mcu_fd_sc_mcu7t5v0__mux2_2
XFILLER_199_516 VDD VSS VDD VSS gf180mcu_fd_sc_mcu7t5v0__fillcap_4
X_2139_ _3365_/D VDD VSS _3127_/D _3127_/Q _3178_/Q VDD VSS gf180mcu_fd_sc_mcu7t5v0__mux2_2
XFILLER_242_667 VDD VSS VDD VSS gf180mcu_fd_sc_mcu7t5v0__fillcap_64
XFILLER_230_807 VDD VSS VDD VSS gf180mcu_fd_sc_mcu7t5v0__fillcap_64
XFILLER_214_325 VDD VSS VDD VSS gf180mcu_fd_sc_mcu7t5v0__fillcap_4
XFILLER_81_352 VDD VSS VDD VSS gf180mcu_fd_sc_mcu7t5v0__fillcap_64
Xclkbuf_leaf_65_clk_i _3316_/CLK VSS VDD clkbuf_3_0__f_clk_i/Z VDD VSS gf180mcu_fd_sc_mcu7t5v0__clkbuf_2
XFILLER_222_380 VDD VSS VDD VSS gf180mcu_fd_sc_mcu7t5v0__fillcap_4
XFILLER_139_104 VDD VSS VDD VSS gf180mcu_fd_sc_mcu7t5v0__fillcap_16
XFILLER_210_597 VDD VSS VDD VSS gf180mcu_fd_sc_mcu7t5v0__fillcap_16
XFILLER_154_107 VDD VSS VDD VSS gf180mcu_fd_sc_mcu7t5v0__fillcap_64
XFILLER_136_877 VDD VSS VDD VSS gf180mcu_fd_sc_mcu7t5v0__fillcap_8
XFILLER_163_696 VDD VSS VDD VSS gf180mcu_fd_sc_mcu7t5v0__fillcap_4
XFILLER_151_836 VDD VSS VDD VSS gf180mcu_fd_sc_mcu7t5v0__fillcap_4
XFILLER_78_79 VDD VSS VDD VSS gf180mcu_fd_sc_mcu7t5v0__fillcap_16
Xclkbuf_leaf_18_clk_i _3357_/CLK VSS VDD clkload3/I VDD VSS gf180mcu_fd_sc_mcu7t5v0__clkbuf_2
XFILLER_76_157 VDD VSS VDD VSS gf180mcu_fd_sc_mcu7t5v0__fillcap_16
XFILLER_264_247 VDD VSS VDD VSS gf180mcu_fd_sc_mcu7t5v0__fillcap_64
XFILLER_73_842 VDD VSS VDD VSS gf180mcu_fd_sc_mcu7t5v0__fillcap_32
XFILLER_27_72 VDD VSS VDD VSS gf180mcu_fd_sc_mcu7t5v0__fillcap_64
XFILLER_220_317 VDD VSS VDD VSS gf180mcu_fd_sc_mcu7t5v0__fillcap_32
XFILLER_232_177 VDD VSS VDD VSS gf180mcu_fd_sc_mcu7t5v0__fillcap_64
XFILLER_41_772 VDD VSS VDD VSS gf180mcu_fd_sc_mcu7t5v0__fillcap_64
XFILLER_158_457 VDD VSS VDD VSS gf180mcu_fd_sc_mcu7t5v0__fillcap_8
XFILLER_173_416 VDD VSS VDD VSS gf180mcu_fd_sc_mcu7t5v0__fillcap_4
XFILLER_126_387 VDD VSS VDD VSS gf180mcu_fd_sc_mcu7t5v0__fillcap_64
X_1510_ _3370_/Q VDD VSS _1514_/A2 _3369_/Q _1500_/Z VDD VSS gf180mcu_fd_sc_mcu7t5v0__aoi21_1
X_2490_ _2490_/B VDD VSS _2492_/A2 _2316_/C _2490_/A2 VDD VSS gf180mcu_fd_sc_mcu7t5v0__aoi21_1
XFILLER_114_527 VDD VSS VDD VSS gf180mcu_fd_sc_mcu7t5v0__fillcap_64
X_1441_ VDD VSS _3129_/Q _2148_/A1 VDD VSS gf180mcu_fd_sc_mcu7t5v0__clkinv_1
X_3111_ _3111_/D _3111_/Q wire153/Z VSS _3192_/CLK VDD VDD VSS gf180mcu_fd_sc_mcu7t5v0__dffrnq_1
XFILLER_95_422 VDD VSS VDD VSS gf180mcu_fd_sc_mcu7t5v0__fillcap_8
XFILLER_256_737 VDD VSS VDD VSS gf180mcu_fd_sc_mcu7t5v0__fillcap_64
X_3042_ VDD _3042_/Q _3055_/CLK VSS _3042_/D VDD VSS gf180mcu_fd_sc_mcu7t5v0__dffq_1
XFILLER_209_686 VDD VSS VDD VSS gf180mcu_fd_sc_mcu7t5v0__fillcap_8
XFILLER_82_149 VDD VSS VDD VSS gf180mcu_fd_sc_mcu7t5v0__fillcap_4
XFILLER_63_352 VDD VSS VDD VSS gf180mcu_fd_sc_mcu7t5v0__fillcap_64
XFILLER_224_667 VDD VSS VDD VSS gf180mcu_fd_sc_mcu7t5v0__fillcap_64
XFILLER_212_807 VDD VSS VDD VSS gf180mcu_fd_sc_mcu7t5v0__fillcap_64
XFILLER_251_486 VDD VSS VDD VSS gf180mcu_fd_sc_mcu7t5v0__fillcap_4
XFILLER_90_193 VDD VSS VDD VSS gf180mcu_fd_sc_mcu7t5v0__fillcap_4
X_2826_ VDD _2826_/Q _3405_/CLK VSS _2826_/D VDD VSS gf180mcu_fd_sc_mcu7t5v0__dffq_1
XFILLER_177_766 VDD VSS VDD VSS gf180mcu_fd_sc_mcu7t5v0__fillcap_4
XFILLER_31_282 VDD VSS VDD VSS gf180mcu_fd_sc_mcu7t5v0__fillcap_64
XFILLER_136_107 VDD VSS VDD VSS gf180mcu_fd_sc_mcu7t5v0__fillcap_16
XFILLER_191_202 VDD VSS VDD VSS gf180mcu_fd_sc_mcu7t5v0__fillcap_8
XFILLER_164_427 VDD VSS VDD VSS gf180mcu_fd_sc_mcu7t5v0__fillcap_16
XFILLER_219_63 VDD VSS VDD VSS gf180mcu_fd_sc_mcu7t5v0__fillcap_4
X_2757_ _2757_/A3 VDD VSS _3320_/D wire10/I _2757_/A2 VDD VSS gf180mcu_fd_sc_mcu7t5v0__nand3_1
XFILLER_118_877 VDD VSS VDD VSS gf180mcu_fd_sc_mcu7t5v0__fillcap_8
X_1708_ VDD VSS _2336_/B _2488_/B _2486_/B VDD VSS gf180mcu_fd_sc_mcu7t5v0__or2_1
X_2688_ VSS VDD _2758_/A3 _2688_/C1 _3096_/Q _2061_/Z _2026_/Z _3064_/Q _2689_/A2
+ VDD VSS gf180mcu_fd_sc_mcu7t5v0__aoi222_1
XFILLER_105_527 VDD VSS VDD VSS gf180mcu_fd_sc_mcu7t5v0__fillcap_32
XFILLER_133_836 VDD VSS VDD VSS gf180mcu_fd_sc_mcu7t5v0__fillcap_4
X_1639_ _3226_/Q VDD VSS _1640_/I _3224_/Q _2553_/A1 VDD VSS gf180mcu_fd_sc_mcu7t5v0__and3_1
XFILLER_99_772 VDD VSS VDD VSS gf180mcu_fd_sc_mcu7t5v0__fillcap_64
X_3309_ _3309_/D _3309_/Q wire165/Z VSS _3463_/CLK VDD VDD VSS gf180mcu_fd_sc_mcu7t5v0__dffrnq_1
XFILLER_101_766 VDD VSS VDD VSS gf180mcu_fd_sc_mcu7t5v0__fillcap_4
XFILLER_246_247 VDD VSS VDD VSS gf180mcu_fd_sc_mcu7t5v0__fillcap_64
XFILLER_251_72 VDD VSS VDD VSS gf180mcu_fd_sc_mcu7t5v0__fillcap_64
XFILLER_261_206 VDD VSS VDD VSS gf180mcu_fd_sc_mcu7t5v0__fillcap_4
XFILLER_100_298 VDD VSS VDD VSS gf180mcu_fd_sc_mcu7t5v0__fillcap_8
XFILLER_55_842 VDD VSS VDD VSS gf180mcu_fd_sc_mcu7t5v0__fillcap_32
XFILLER_82_661 VDD VSS VDD VSS gf180mcu_fd_sc_mcu7t5v0__fillcap_4
XFILLER_70_801 VDD VSS VDD VSS gf180mcu_fd_sc_mcu7t5v0__fillcap_4
XFILLER_64_37 VDD VSS VDD VSS gf180mcu_fd_sc_mcu7t5v0__fillcap_64
XFILLER_199_346 VDD VSS VDD VSS gf180mcu_fd_sc_mcu7t5v0__fillcap_4
XFILLER_202_317 VDD VSS VDD VSS gf180mcu_fd_sc_mcu7t5v0__fillcap_8
XFILLER_81_193 VDD VSS VDD VSS gf180mcu_fd_sc_mcu7t5v0__fillcap_16
XFILLER_23_772 VDD VSS VDD VSS gf180mcu_fd_sc_mcu7t5v0__fillcap_64
XFILLER_167_265 VDD VSS VDD VSS gf180mcu_fd_sc_mcu7t5v0__fillcap_8
XFILLER_50_591 VDD VSS VDD VSS gf180mcu_fd_sc_mcu7t5v0__fillcap_4
XFILLER_136_641 VDD VSS VDD VSS gf180mcu_fd_sc_mcu7t5v0__fillcap_16
XFILLER_129_63 VDD VSS VDD VSS gf180mcu_fd_sc_mcu7t5v0__fillcap_4
XFILLER_163_460 VDD VSS VDD VSS gf180mcu_fd_sc_mcu7t5v0__fillcap_4
XFILLER_202_2 VDD VSS VDD VSS gf180mcu_fd_sc_mcu7t5v0__fillcap_32
XFILLER_108_387 VDD VSS VDD VSS gf180mcu_fd_sc_mcu7t5v0__fillcap_16
XFILLER_1_142 VDD VSS VDD VSS gf180mcu_fd_sc_mcu7t5v0__fillcap_64
XFILLER_77_422 VDD VSS VDD VSS gf180mcu_fd_sc_mcu7t5v0__fillcap_64
XFILLER_89_282 VDD VSS VDD VSS gf180mcu_fd_sc_mcu7t5v0__fillcap_16
XFILLER_238_737 VDD VSS VDD VSS gf180mcu_fd_sc_mcu7t5v0__fillcap_64
XFILLER_265_556 VDD VSS VDD VSS gf180mcu_fd_sc_mcu7t5v0__fillcap_4
XFILLER_218_472 VDD VSS VDD VSS gf180mcu_fd_sc_mcu7t5v0__fillcap_32
XFILLER_161_72 VDD VSS VDD VSS gf180mcu_fd_sc_mcu7t5v0__fillcap_64
XFILLER_205_111 VDD VSS VDD VSS gf180mcu_fd_sc_mcu7t5v0__fillcap_16
XFILLER_45_352 VDD VSS VDD VSS gf180mcu_fd_sc_mcu7t5v0__fillcap_64
XFILLER_206_667 VDD VSS VDD VSS gf180mcu_fd_sc_mcu7t5v0__fillcap_8
XFILLER_60_311 VDD VSS VDD VSS gf180mcu_fd_sc_mcu7t5v0__fillcap_4
XFILLER_233_486 VDD VSS VDD VSS gf180mcu_fd_sc_mcu7t5v0__fillcap_4
X_1990_ _1991_/S VDD VSS _3035_/D _3035_/Q wire114/Z VDD VSS gf180mcu_fd_sc_mcu7t5v0__mux2_2
XFILLER_220_158 VDD VSS VDD VSS gf180mcu_fd_sc_mcu7t5v0__fillcap_16
XFILLER_159_766 VDD VSS VDD VSS gf180mcu_fd_sc_mcu7t5v0__fillcap_4
XFILLER_13_282 VDD VSS VDD VSS gf180mcu_fd_sc_mcu7t5v0__fillcap_64
XFILLER_118_107 VDD VSS VDD VSS gf180mcu_fd_sc_mcu7t5v0__fillcap_8
Xclkload23 VSS clkload23/Z _3288_/CLK VDD VDD VSS gf180mcu_fd_sc_mcu7t5v0__clkbuf_1
X_2611_ VDD VSS _2612_/A2 _3276_/Q _2703_/A4 VDD VSS gf180mcu_fd_sc_mcu7t5v0__nand2_1
Xclkload12 VSS clkload12/Z _3339_/CLK VDD VDD VSS gf180mcu_fd_sc_mcu7t5v0__clkbuf_1
Xclkload34 VDD VSS _3023_/CLK clkload34/ZN VDD VSS gf180mcu_fd_sc_mcu7t5v0__clkinv_2
Xclkload78 VSS clkload78/ZN _3405_/CLK VDD VDD VSS gf180mcu_fd_sc_mcu7t5v0__inv_4
Xclkload56 VSS clkload56/Z _3362_/CLK VDD VDD VSS gf180mcu_fd_sc_mcu7t5v0__clkbuf_1
Xclkload67 VDD VSS _3365_/CLK clkload67/ZN VDD VSS gf180mcu_fd_sc_mcu7t5v0__clkinv_2
Xclkload45 VDD VSS _3021_/CLK clkload45/ZN VDD VSS gf180mcu_fd_sc_mcu7t5v0__clkinv_1
X_2542_ _3221_/Q VDD VSS _2543_/B _2549_/A2 _2547_/A3 VDD VSS gf180mcu_fd_sc_mcu7t5v0__aoi21_1
Xclkload89 VSS clkload89/ZN _2899_/CLK VDD VDD VSS gf180mcu_fd_sc_mcu7t5v0__inv_4
XFILLER_5_492 VDD VSS VDD VSS gf180mcu_fd_sc_mcu7t5v0__fillcap_64
XFILLER_115_836 VDD VSS VDD VSS gf180mcu_fd_sc_mcu7t5v0__fillcap_4
X_2473_ VDD VSS _2474_/A2 _3137_/Q _2488_/B VDD VSS gf180mcu_fd_sc_mcu7t5v0__nor2_1
XFILLER_48_2 VDD VSS VDD VSS gf180mcu_fd_sc_mcu7t5v0__fillcap_32
X_1424_ VDD VSS _1424_/I _2304_/A1 VDD VSS gf180mcu_fd_sc_mcu7t5v0__clkinv_1
XFILLER_228_247 VDD VSS VDD VSS gf180mcu_fd_sc_mcu7t5v0__fillcap_64
XFILLER_243_206 VDD VSS VDD VSS gf180mcu_fd_sc_mcu7t5v0__fillcap_4
XFILLER_37_842 VDD VSS VDD VSS gf180mcu_fd_sc_mcu7t5v0__fillcap_32
X_3025_ VDD _3025_/Q _3044_/CLK VSS _3025_/D VDD VSS gf180mcu_fd_sc_mcu7t5v0__dffq_1
XFILLER_209_483 VDD VSS VDD VSS gf180mcu_fd_sc_mcu7t5v0__fillcap_4
XFILLER_64_661 VDD VSS VDD VSS gf180mcu_fd_sc_mcu7t5v0__fillcap_4
XFILLER_52_801 VDD VSS VDD VSS gf180mcu_fd_sc_mcu7t5v0__fillcap_4
XFILLER_224_442 VDD VSS VDD VSS gf180mcu_fd_sc_mcu7t5v0__fillcap_8
XFILLER_224_497 VDD VSS VDD VSS gf180mcu_fd_sc_mcu7t5v0__fillcap_16
XFILLER_211_158 VDD VSS VDD VSS gf180mcu_fd_sc_mcu7t5v0__fillcap_8
XFILLER_32_591 VDD VSS VDD VSS gf180mcu_fd_sc_mcu7t5v0__fillcap_4
XFILLER_20_731 VDD VSS VDD VSS gf180mcu_fd_sc_mcu7t5v0__fillcap_4
Xclkload6 VDD VSS clkload6/ZN clkload6/I VDD VSS gf180mcu_fd_sc_mcu7t5v0__clkinv_8
X_2809_ VDD _2809_/Q _3458_/CLK VSS _2809_/D VDD VSS gf180mcu_fd_sc_mcu7t5v0__dffq_1
XFILLER_59_422 VDD VSS VDD VSS gf180mcu_fd_sc_mcu7t5v0__fillcap_64
XFILLER_247_556 VDD VSS VDD VSS gf180mcu_fd_sc_mcu7t5v0__fillcap_4
XFILLER_27_352 VDD VSS VDD VSS gf180mcu_fd_sc_mcu7t5v0__fillcap_64
XFILLER_42_311 VDD VSS VDD VSS gf180mcu_fd_sc_mcu7t5v0__fillcap_4
XFILLER_54_171 VDD VSS VDD VSS gf180mcu_fd_sc_mcu7t5v0__fillcap_4
XFILLER_215_486 VDD VSS VDD VSS gf180mcu_fd_sc_mcu7t5v0__fillcap_4
XFILLER_152_2 VDD VSS VDD VSS gf180mcu_fd_sc_mcu7t5v0__fillcap_32
XFILLER_7_702 VDD VSS VDD VSS gf180mcu_fd_sc_mcu7t5v0__fillcap_64
XFILLER_10_241 VDD VSS VDD VSS gf180mcu_fd_sc_mcu7t5v0__fillcap_4
XFILLER_2_451 VDD VSS VDD VSS gf180mcu_fd_sc_mcu7t5v0__fillcap_4
XFILLER_78_731 VDD VSS VDD VSS gf180mcu_fd_sc_mcu7t5v0__fillcap_4
XFILLER_225_206 VDD VSS VDD VSS gf180mcu_fd_sc_mcu7t5v0__fillcap_4
XFILLER_19_842 VDD VSS VDD VSS gf180mcu_fd_sc_mcu7t5v0__fillcap_32
XFILLER_46_661 VDD VSS VDD VSS gf180mcu_fd_sc_mcu7t5v0__fillcap_4
XFILLER_34_801 VDD VSS VDD VSS gf180mcu_fd_sc_mcu7t5v0__fillcap_4
XFILLER_178_305 VDD VSS VDD VSS gf180mcu_fd_sc_mcu7t5v0__fillcap_8
XFILLER_14_591 VDD VSS VDD VSS gf180mcu_fd_sc_mcu7t5v0__fillcap_4
X_1973_ VDD VSS _1981_/S _2010_/A1 _1945_/Z VDD VSS gf180mcu_fd_sc_mcu7t5v0__nand2_1
XFILLER_147_736 VDD VSS VDD VSS gf180mcu_fd_sc_mcu7t5v0__fillcap_32
XFILLER_119_416 VDD VSS VDD VSS gf180mcu_fd_sc_mcu7t5v0__fillcap_4
XFILLER_146_224 VDD VSS VDD VSS gf180mcu_fd_sc_mcu7t5v0__fillcap_4
X_2525_ _2525_/B1 _3323_/Q VDD VSS _2527_/A3 _3315_/Q _1640_/I VDD VSS gf180mcu_fd_sc_mcu7t5v0__aoi22_1
X_2456_ _2867_/Q VSS VDD _2851_/Q _2859_/Q wire78/Z _2843_/Q wire76/Z _2456_/Z VDD
+ VSS gf180mcu_fd_sc_mcu7t5v0__mux4_1
X_1407_ VDD VSS _3449_/Q _1599_/A1 VDD VSS gf180mcu_fd_sc_mcu7t5v0__clkinv_1
XFILLER_229_556 VDD VSS VDD VSS gf180mcu_fd_sc_mcu7t5v0__fillcap_4
X_2387_ _2387_/A3 VDD VSS _2393_/B1 _3382_/Q _2387_/A2 VDD VSS gf180mcu_fd_sc_mcu7t5v0__nand3_1
XFILLER_68_241 VDD VSS VDD VSS gf180mcu_fd_sc_mcu7t5v0__fillcap_4
XFILLER_83_255 VDD VSS VDD VSS gf180mcu_fd_sc_mcu7t5v0__fillcap_16
X_3008_ VDD _3008_/Q _3022_/CLK VSS _3008_/D VDD VSS gf180mcu_fd_sc_mcu7t5v0__dffq_1
XFILLER_24_311 VDD VSS VDD VSS gf180mcu_fd_sc_mcu7t5v0__fillcap_4
XFILLER_36_171 VDD VSS VDD VSS gf180mcu_fd_sc_mcu7t5v0__fillcap_4
XFILLER_101_34 VDD VSS VDD VSS gf180mcu_fd_sc_mcu7t5v0__fillcap_32
XFILLER_196_168 VDD VSS VDD VSS gf180mcu_fd_sc_mcu7t5v0__fillcap_4
XFILLER_193_842 VDD VSS VDD VSS gf180mcu_fd_sc_mcu7t5v0__fillcap_32
XFILLER_137_246 VDD VSS VDD VSS gf180mcu_fd_sc_mcu7t5v0__fillcap_32
XFILLER_145_290 VDD VSS VDD VSS gf180mcu_fd_sc_mcu7t5v0__fillcap_4
XFILLER_161_772 VDD VSS VDD VSS gf180mcu_fd_sc_mcu7t5v0__fillcap_64
XFILLER_126_53 VDD VSS VDD VSS gf180mcu_fd_sc_mcu7t5v0__fillcap_4
XFILLER_28_661 VDD VSS VDD VSS gf180mcu_fd_sc_mcu7t5v0__fillcap_4
XFILLER_16_801 VDD VSS VDD VSS gf180mcu_fd_sc_mcu7t5v0__fillcap_4
XFILLER_90_737 VDD VSS VDD VSS gf180mcu_fd_sc_mcu7t5v0__fillcap_64
XFILLER_35_72 VDD VSS VDD VSS gf180mcu_fd_sc_mcu7t5v0__fillcap_64
XFILLER_175_319 VDD VSS VDD VSS gf180mcu_fd_sc_mcu7t5v0__fillcap_16
XFILLER_183_352 VDD VSS VDD VSS gf180mcu_fd_sc_mcu7t5v0__fillcap_64
X_2310_ _2472_/A2 VDD VSS _2324_/A2 _2310_/A1 wire21/Z VDD VSS gf180mcu_fd_sc_mcu7t5v0__nor3_1
XFILLER_151_271 VDD VSS VDD VSS gf180mcu_fd_sc_mcu7t5v0__fillcap_8
X_3290_ _3290_/D wire88/I _3335_/RN VSS _3454_/CLK VDD VDD VSS gf180mcu_fd_sc_mcu7t5v0__dffrnq_1
X_2241_ VDD VSS _2484_/B1 _2469_/A1 _1700_/Z VDD VSS gf180mcu_fd_sc_mcu7t5v0__nand2_1
XFILLER_151_282 VDD VSS VDD VSS gf180mcu_fd_sc_mcu7t5v0__fillcap_8
XFILLER_111_135 VDD VSS VDD VSS gf180mcu_fd_sc_mcu7t5v0__fillcap_4
X_2172_ VDD VSS _2173_/B _3175_/Q _3348_/D VDD VSS gf180mcu_fd_sc_mcu7t5v0__nand2_1
XFILLER_18_171 VDD VSS VDD VSS gf180mcu_fd_sc_mcu7t5v0__fillcap_4
XFILLER_178_157 VDD VSS VDD VSS gf180mcu_fd_sc_mcu7t5v0__fillcap_16
X_1956_ _1963_/S VDD VSS _3005_/D _2011_/I0 _3005_/Q VDD VSS gf180mcu_fd_sc_mcu7t5v0__mux2_2
XFILLER_175_842 VDD VSS VDD VSS gf180mcu_fd_sc_mcu7t5v0__fillcap_32
XFILLER_187_691 VDD VSS VDD VSS gf180mcu_fd_sc_mcu7t5v0__fillcap_8
XFILLER_190_801 VDD VSS VDD VSS gf180mcu_fd_sc_mcu7t5v0__fillcap_4
X_1887_ _1887_/S VDD VSS _2948_/D _2948_/Q _3182_/Q VDD VSS gf180mcu_fd_sc_mcu7t5v0__mux2_2
XFILLER_143_772 VDD VSS VDD VSS gf180mcu_fd_sc_mcu7t5v0__fillcap_64
X_2508_ _2508_/A3 VDD VSS _2508_/Z _3223_/Q _2508_/A2 VDD VSS gf180mcu_fd_sc_mcu7t5v0__and3_1
XFILLER_170_591 VDD VSS VDD VSS gf180mcu_fd_sc_mcu7t5v0__fillcap_4
X_2439_ VDD VSS _2452_/B _3202_/Q _2467_/A1 VDD VSS gf180mcu_fd_sc_mcu7t5v0__nand2_1
XFILLER_84_597 VDD VSS VDD VSS gf180mcu_fd_sc_mcu7t5v0__fillcap_64
XFILLER_72_737 VDD VSS VDD VSS gf180mcu_fd_sc_mcu7t5v0__fillcap_64
XFILLER_71_203 VDD VSS VDD VSS gf180mcu_fd_sc_mcu7t5v0__fillcap_4
XFILLER_71_258 VDD VSS VDD VSS gf180mcu_fd_sc_mcu7t5v0__fillcap_16
XFILLER_197_422 VDD VSS VDD VSS gf180mcu_fd_sc_mcu7t5v0__fillcap_8
XFILLER_188_37 VDD VSS VDD VSS gf180mcu_fd_sc_mcu7t5v0__fillcap_4
XFILLER_40_667 VDD VSS VDD VSS gf180mcu_fd_sc_mcu7t5v0__fillcap_64
XFILLER_268_70 VDD VSS VDD VSS gf180mcu_fd_sc_mcu7t5v0__fillcap_32
XFILLER_184_149 VDD VSS VDD VSS gf180mcu_fd_sc_mcu7t5v0__fillcap_4
XFILLER_138_588 VDD VSS VDD VSS gf180mcu_fd_sc_mcu7t5v0__fillcap_4
XFILLER_165_352 VDD VSS VDD VSS gf180mcu_fd_sc_mcu7t5v0__fillcap_32
XFILLER_180_311 VDD VSS VDD VSS gf180mcu_fd_sc_mcu7t5v0__fillcap_4
XFILLER_115_2 VDD VSS VDD VSS gf180mcu_fd_sc_mcu7t5v0__fillcap_16
XFILLER_137_63 VDD VSS VDD VSS gf180mcu_fd_sc_mcu7t5v0__fillcap_4
XFILLER_180_333 VDD VSS VDD VSS gf180mcu_fd_sc_mcu7t5v0__fillcap_8
XFILLER_118_290 VDD VSS VDD VSS gf180mcu_fd_sc_mcu7t5v0__fillcap_16
XFILLER_133_260 VDD VSS VDD VSS gf180mcu_fd_sc_mcu7t5v0__fillcap_4
XFILLER_263_632 VDD VSS VDD VSS gf180mcu_fd_sc_mcu7t5v0__fillcap_64
XFILLER_62_247 VDD VSS VDD VSS gf180mcu_fd_sc_mcu7t5v0__fillcap_64
XFILLER_231_562 VDD VSS VDD VSS gf180mcu_fd_sc_mcu7t5v0__fillcap_64
X_1810_ _1814_/S VDD VSS _2880_/D wire133/Z _2880_/Q VDD VSS gf180mcu_fd_sc_mcu7t5v0__mux2_2
XFILLER_157_842 VDD VSS VDD VSS gf180mcu_fd_sc_mcu7t5v0__fillcap_32
XFILLER_30_177 VDD VSS VDD VSS gf180mcu_fd_sc_mcu7t5v0__fillcap_64
X_2790_ VDD VSS _2790_/I _3336_/D VDD VSS gf180mcu_fd_sc_mcu7t5v0__clkinv_1
X_1741_ _1748_/S VDD VSS _2821_/D _2821_/Q _1788_/I1 VDD VSS gf180mcu_fd_sc_mcu7t5v0__mux2_2
XFILLER_172_801 VDD VSS VDD VSS gf180mcu_fd_sc_mcu7t5v0__fillcap_4
X_1672_ _2804_/Q VDD VSS _1673_/B _2331_/B _1712_/A1 VDD VSS gf180mcu_fd_sc_mcu7t5v0__nand3_1
XFILLER_116_227 VDD VSS VDD VSS gf180mcu_fd_sc_mcu7t5v0__fillcap_4
XFILLER_8_885 VDD VSS VDD VSS gf180mcu_fd_sc_mcu7t5v0__fillcap_4
X_3411_ _3411_/D _3434_/D wire161/I VSS _3441_/CLK VDD VDD VSS gf180mcu_fd_sc_mcu7t5v0__dffrnq_1
X_3342_ VSS _3344_/CLK VDD _3342_/D _3342_/Q _3344_/RN VDD VSS gf180mcu_fd_sc_mcu7t5v0__dffsnq_1
XFILLER_125_772 VDD VSS VDD VSS gf180mcu_fd_sc_mcu7t5v0__fillcap_64
XFILLER_86_807 VDD VSS VDD VSS gf180mcu_fd_sc_mcu7t5v0__fillcap_64
XFILLER_98_667 VDD VSS VDD VSS gf180mcu_fd_sc_mcu7t5v0__fillcap_64
XFILLER_30_2 VDD VSS VDD VSS gf180mcu_fd_sc_mcu7t5v0__fillcap_32
X_3273_ _3273_/D _3273_/Q wire145/Z VSS _3321_/CLK VDD VDD VSS gf180mcu_fd_sc_mcu7t5v0__dffrnq_1
X_2224_ _3356_/Q VDD VSS _2225_/B _3356_/D _3355_/D VDD VSS gf180mcu_fd_sc_mcu7t5v0__nor3_1
XFILLER_97_188 VDD VSS VDD VSS gf180mcu_fd_sc_mcu7t5v0__fillcap_16
X_2155_ VDD VSS _2167_/B1 _2168_/C _2155_/A2 VDD VSS gf180mcu_fd_sc_mcu7t5v0__nor2_1
XFILLER_253_142 VDD VSS VDD VSS gf180mcu_fd_sc_mcu7t5v0__fillcap_64
XFILLER_66_597 VDD VSS VDD VSS gf180mcu_fd_sc_mcu7t5v0__fillcap_64
XFILLER_54_737 VDD VSS VDD VSS gf180mcu_fd_sc_mcu7t5v0__fillcap_64
XFILLER_214_518 VDD VSS VDD VSS gf180mcu_fd_sc_mcu7t5v0__fillcap_4
X_2086_ VDD VSS _2087_/B1 _2075_/Z _2089_/A3 VDD VSS gf180mcu_fd_sc_mcu7t5v0__nand2_1
XFILLER_81_556 VDD VSS VDD VSS gf180mcu_fd_sc_mcu7t5v0__fillcap_4
XFILLER_179_422 VDD VSS VDD VSS gf180mcu_fd_sc_mcu7t5v0__fillcap_4
XFILLER_250_871 VDD VSS VDD VSS gf180mcu_fd_sc_mcu7t5v0__fillcap_4
XFILLER_179_477 VDD VSS VDD VSS gf180mcu_fd_sc_mcu7t5v0__fillcap_8
XFILLER_10_807 VDD VSS VDD VSS gf180mcu_fd_sc_mcu7t5v0__fillcap_64
XFILLER_22_667 VDD VSS VDD VSS gf180mcu_fd_sc_mcu7t5v0__fillcap_64
Xmax_length14 wire12/I _2567_/ZN VDD VSS VDD VSS gf180mcu_fd_sc_mcu7t5v0__buf_4
X_2988_ VDD _2988_/Q _3005_/CLK VSS _2988_/D VDD VSS gf180mcu_fd_sc_mcu7t5v0__dffq_1
Xmax_length47 _2644_/S VSS VDD wire46/I VDD VSS gf180mcu_fd_sc_mcu7t5v0__clkbuf_3
Xmax_length58 _2735_/S wire59/Z VDD VSS VDD VSS gf180mcu_fd_sc_mcu7t5v0__buf_4
XFILLER_147_352 VDD VSS VDD VSS gf180mcu_fd_sc_mcu7t5v0__fillcap_8
X_1939_ _1942_/S VDD VSS _2991_/D wire121/Z _2991_/Q VDD VSS gf180mcu_fd_sc_mcu7t5v0__mux2_2
XFILLER_174_160 VDD VSS VDD VSS gf180mcu_fd_sc_mcu7t5v0__fillcap_4
XFILLER_147_374 VDD VSS VDD VSS gf180mcu_fd_sc_mcu7t5v0__fillcap_4
XFILLER_115_260 VDD VSS VDD VSS gf180mcu_fd_sc_mcu7t5v0__fillcap_4
XFILLER_115_282 VDD VSS VDD VSS gf180mcu_fd_sc_mcu7t5v0__fillcap_16
XFILLER_76_317 VDD VSS VDD VSS gf180mcu_fd_sc_mcu7t5v0__fillcap_64
XFILLER_88_177 VDD VSS VDD VSS gf180mcu_fd_sc_mcu7t5v0__fillcap_16
XFILLER_245_632 VDD VSS VDD VSS gf180mcu_fd_sc_mcu7t5v0__fillcap_64
XFILLER_257_492 VDD VSS VDD VSS gf180mcu_fd_sc_mcu7t5v0__fillcap_64
XFILLER_44_247 VDD VSS VDD VSS gf180mcu_fd_sc_mcu7t5v0__fillcap_64
XFILLER_201_702 VDD VSS VDD VSS gf180mcu_fd_sc_mcu7t5v0__fillcap_64
XFILLER_213_562 VDD VSS VDD VSS gf180mcu_fd_sc_mcu7t5v0__fillcap_8
XFILLER_240_381 VDD VSS VDD VSS gf180mcu_fd_sc_mcu7t5v0__fillcap_4
XFILLER_232_2 VDD VSS VDD VSS gf180mcu_fd_sc_mcu7t5v0__fillcap_32
XFILLER_139_842 VDD VSS VDD VSS gf180mcu_fd_sc_mcu7t5v0__fillcap_32
XFILLER_12_177 VDD VSS VDD VSS gf180mcu_fd_sc_mcu7t5v0__fillcap_64
XFILLER_154_801 VDD VSS VDD VSS gf180mcu_fd_sc_mcu7t5v0__fillcap_4
XFILLER_107_772 VDD VSS VDD VSS gf180mcu_fd_sc_mcu7t5v0__fillcap_64
XFILLER_4_387 VDD VSS VDD VSS gf180mcu_fd_sc_mcu7t5v0__fillcap_64
XFILLER_106_271 VDD VSS VDD VSS gf180mcu_fd_sc_mcu7t5v0__fillcap_4
XFILLER_122_731 VDD VSS VDD VSS gf180mcu_fd_sc_mcu7t5v0__fillcap_4
XFILLER_267_212 VDD VSS VDD VSS gf180mcu_fd_sc_mcu7t5v0__fillcap_64
XFILLER_68_807 VDD VSS VDD VSS gf180mcu_fd_sc_mcu7t5v0__fillcap_64
XFILLER_235_142 VDD VSS VDD VSS gf180mcu_fd_sc_mcu7t5v0__fillcap_64
XFILLER_48_597 VDD VSS VDD VSS gf180mcu_fd_sc_mcu7t5v0__fillcap_64
XFILLER_36_737 VDD VSS VDD VSS gf180mcu_fd_sc_mcu7t5v0__fillcap_64
XFILLER_250_101 VDD VSS VDD VSS gf180mcu_fd_sc_mcu7t5v0__fillcap_4
XFILLER_63_556 VDD VSS VDD VSS gf180mcu_fd_sc_mcu7t5v0__fillcap_4
XFILLER_232_871 VDD VSS VDD VSS gf180mcu_fd_sc_mcu7t5v0__fillcap_4
X_2911_ VDD _2911_/Q _2932_/CLK VSS _2911_/D VDD VSS gf180mcu_fd_sc_mcu7t5v0__dffq_1
XFILLER_188_230 VDD VSS VDD VSS gf180mcu_fd_sc_mcu7t5v0__fillcap_8
XFILLER_149_606 VDD VSS VDD VSS gf180mcu_fd_sc_mcu7t5v0__fillcap_8
XFILLER_188_263 VDD VSS VDD VSS gf180mcu_fd_sc_mcu7t5v0__fillcap_4
X_2842_ VDD _2842_/Q _2867_/CLK VSS _2842_/D VDD VSS gf180mcu_fd_sc_mcu7t5v0__dffq_1
XFILLER_31_486 VDD VSS VDD VSS gf180mcu_fd_sc_mcu7t5v0__fillcap_4
Xspi_opentarget_i3c_top_180 irq_o_SL VDD VSS VDD VSS gf180mcu_fd_sc_mcu7t5v0__tiel
XFILLER_129_352 VDD VSS VDD VSS gf180mcu_fd_sc_mcu7t5v0__fillcap_16
X_2773_ wire20/Z _3080_/Q VDD VSS _2774_/I _3328_/Q _2739_/S VDD VSS gf180mcu_fd_sc_mcu7t5v0__aoi22_1
XFILLER_78_2 VDD VSS VDD VSS gf180mcu_fd_sc_mcu7t5v0__fillcap_8
Xspi_opentarget_i3c_top_191 spi_cs_ni_PD VDD VSS VDD VSS gf180mcu_fd_sc_mcu7t5v0__tiel
X_1724_ _1728_/S VDD VSS _2808_/D _2808_/Q _3122_/Q VDD VSS gf180mcu_fd_sc_mcu7t5v0__mux2_2
XFILLER_144_311 VDD VSS VDD VSS gf180mcu_fd_sc_mcu7t5v0__fillcap_4
X_1655_ VDD VSS _2494_/B _3212_/Q _2367_/A2 VDD VSS gf180mcu_fd_sc_mcu7t5v0__nand2_1
XFILLER_144_377 VDD VSS VDD VSS gf180mcu_fd_sc_mcu7t5v0__fillcap_8
XFILLER_259_702 VDD VSS VDD VSS gf180mcu_fd_sc_mcu7t5v0__fillcap_64
X_1586_ _3144_/Q VDD VSS _1587_/A2 _2182_/A1 _3142_/Q VDD VSS gf180mcu_fd_sc_mcu7t5v0__nor3_1
XFILLER_98_442 VDD VSS VDD VSS gf180mcu_fd_sc_mcu7t5v0__fillcap_8
X_3325_ _3325_/D _3325_/Q wire165/Z VSS clkload7/I VDD VDD VSS gf180mcu_fd_sc_mcu7t5v0__dffrnq_1
XFILLER_58_317 VDD VSS VDD VSS gf180mcu_fd_sc_mcu7t5v0__fillcap_64
X_3256_ _3256_/D _3256_/Q _3335_/RN VSS _3454_/CLK VDD VDD VSS gf180mcu_fd_sc_mcu7t5v0__dffrnq_1
X_2207_ _2221_/S VDD VSS _3153_/D _3287_/Q _3153_/Q VDD VSS gf180mcu_fd_sc_mcu7t5v0__mux2_2
XFILLER_227_632 VDD VSS VDD VSS gf180mcu_fd_sc_mcu7t5v0__fillcap_64
XFILLER_239_492 VDD VSS VDD VSS gf180mcu_fd_sc_mcu7t5v0__fillcap_64
X_3187_ _3187_/D _3187_/Q wire153/I VSS _3358_/CLK VDD VDD VSS gf180mcu_fd_sc_mcu7t5v0__dffrnq_1
XFILLER_254_451 VDD VSS VDD VSS gf180mcu_fd_sc_mcu7t5v0__fillcap_4
X_2138_ _2138_/S VDD VSS _3126_/D wire89/Z _3126_/Q VDD VSS gf180mcu_fd_sc_mcu7t5v0__mux2_2
X_2069_ _2072_/S VDD VSS _3098_/D wire92/Z _3098_/Q VDD VSS gf180mcu_fd_sc_mcu7t5v0__mux2_2
XFILLER_81_342 VDD VSS VDD VSS gf180mcu_fd_sc_mcu7t5v0__fillcap_8
XFILLER_26_247 VDD VSS VDD VSS gf180mcu_fd_sc_mcu7t5v0__fillcap_64
XFILLER_41_206 VDD VSS VDD VSS gf180mcu_fd_sc_mcu7t5v0__fillcap_4
XFILLER_210_521 VDD VSS VDD VSS gf180mcu_fd_sc_mcu7t5v0__fillcap_4
XFILLER_139_127 VDD VSS VDD VSS gf180mcu_fd_sc_mcu7t5v0__fillcap_8
XFILLER_136_801 VDD VSS VDD VSS gf180mcu_fd_sc_mcu7t5v0__fillcap_4
XFILLER_249_72 VDD VSS VDD VSS gf180mcu_fd_sc_mcu7t5v0__fillcap_64
XFILLER_147_171 VDD VSS VDD VSS gf180mcu_fd_sc_mcu7t5v0__fillcap_32
XFILLER_108_558 VDD VSS VDD VSS gf180mcu_fd_sc_mcu7t5v0__fillcap_16
XFILLER_118_10 VDD VSS VDD VSS gf180mcu_fd_sc_mcu7t5v0__fillcap_4
XFILLER_162_185 VDD VSS VDD VSS gf180mcu_fd_sc_mcu7t5v0__fillcap_4
XFILLER_104_731 VDD VSS VDD VSS gf180mcu_fd_sc_mcu7t5v0__fillcap_4
XFILLER_249_212 VDD VSS VDD VSS gf180mcu_fd_sc_mcu7t5v0__fillcap_64
XFILLER_89_453 VDD VSS VDD VSS gf180mcu_fd_sc_mcu7t5v0__fillcap_4
XFILLER_1_346 VDD VSS VDD VSS gf180mcu_fd_sc_mcu7t5v0__fillcap_4
XFILLER_78_69 VDD VSS VDD VSS gf180mcu_fd_sc_mcu7t5v0__fillcap_4
XFILLER_134_53 VDD VSS VDD VSS gf180mcu_fd_sc_mcu7t5v0__fillcap_8
XFILLER_77_626 VDD VSS VDD VSS gf180mcu_fd_sc_mcu7t5v0__fillcap_4
XFILLER_217_120 VDD VSS VDD VSS gf180mcu_fd_sc_mcu7t5v0__fillcap_8
XFILLER_182_2 VDD VSS VDD VSS gf180mcu_fd_sc_mcu7t5v0__fillcap_32
XFILLER_150_30 VDD VSS VDD VSS gf180mcu_fd_sc_mcu7t5v0__fillcap_4
XFILLER_18_737 VDD VSS VDD VSS gf180mcu_fd_sc_mcu7t5v0__fillcap_64
XFILLER_232_101 VDD VSS VDD VSS gf180mcu_fd_sc_mcu7t5v0__fillcap_4
XFILLER_72_364 VDD VSS VDD VSS gf180mcu_fd_sc_mcu7t5v0__fillcap_16
XFILLER_45_556 VDD VSS VDD VSS gf180mcu_fd_sc_mcu7t5v0__fillcap_4
XFILLER_214_871 VDD VSS VDD VSS gf180mcu_fd_sc_mcu7t5v0__fillcap_4
XFILLER_213_381 VDD VSS VDD VSS gf180mcu_fd_sc_mcu7t5v0__fillcap_16
XFILLER_158_403 VDD VSS VDD VSS gf180mcu_fd_sc_mcu7t5v0__fillcap_8
XFILLER_13_486 VDD VSS VDD VSS gf180mcu_fd_sc_mcu7t5v0__fillcap_4
XFILLER_43_72 VDD VSS VDD VSS gf180mcu_fd_sc_mcu7t5v0__fillcap_64
XFILLER_159_72 VDD VSS VDD VSS gf180mcu_fd_sc_mcu7t5v0__fillcap_16
XFILLER_145_119 VDD VSS VDD VSS gf180mcu_fd_sc_mcu7t5v0__fillcap_16
XFILLER_138_171 VDD VSS VDD VSS gf180mcu_fd_sc_mcu7t5v0__fillcap_4
XFILLER_181_450 VDD VSS VDD VSS gf180mcu_fd_sc_mcu7t5v0__fillcap_8
X_1440_ VDD VSS _3104_/Q _2087_/A1 VDD VSS gf180mcu_fd_sc_mcu7t5v0__clkinv_1
XFILLER_153_174 VDD VSS VDD VSS gf180mcu_fd_sc_mcu7t5v0__fillcap_4
XFILLER_99_228 VDD VSS VDD VSS gf180mcu_fd_sc_mcu7t5v0__fillcap_8
XFILLER_5_696 VDD VSS VDD VSS gf180mcu_fd_sc_mcu7t5v0__fillcap_4
X_3110_ _3110_/D _3110_/Q wire153/Z VSS _3363_/CLK VDD VDD VSS gf180mcu_fd_sc_mcu7t5v0__dffrnq_1
XFILLER_67_136 VDD VSS VDD VSS gf180mcu_fd_sc_mcu7t5v0__fillcap_4
XFILLER_209_632 VDD VSS VDD VSS gf180mcu_fd_sc_mcu7t5v0__fillcap_16
X_3041_ VDD _3041_/Q _3059_/CLK VSS _3041_/D VDD VSS gf180mcu_fd_sc_mcu7t5v0__dffq_1
XFILLER_236_451 VDD VSS VDD VSS gf180mcu_fd_sc_mcu7t5v0__fillcap_4
XFILLER_23_206 VDD VSS VDD VSS gf180mcu_fd_sc_mcu7t5v0__fillcap_4
XFILLER_211_329 VDD VSS VDD VSS gf180mcu_fd_sc_mcu7t5v0__fillcap_16
XFILLER_210_88 VDD VSS VDD VSS gf180mcu_fd_sc_mcu7t5v0__fillcap_16
XFILLER_220_885 VDD VSS VDD VSS gf180mcu_fd_sc_mcu7t5v0__fillcap_4
X_2825_ VDD _2825_/Q _3458_/CLK VSS _2825_/D VDD VSS gf180mcu_fd_sc_mcu7t5v0__dffq_1
XFILLER_118_801 VDD VSS VDD VSS gf180mcu_fd_sc_mcu7t5v0__fillcap_4
XFILLER_192_737 VDD VSS VDD VSS gf180mcu_fd_sc_mcu7t5v0__fillcap_64
XFILLER_176_299 VDD VSS VDD VSS gf180mcu_fd_sc_mcu7t5v0__fillcap_16
X_2756_ wire19/Z _3072_/Q VDD VSS _2757_/A3 _3320_/Q wire37/Z VDD VSS gf180mcu_fd_sc_mcu7t5v0__aoi22_1
X_1707_ VDD VSS _2494_/C _2488_/B _2486_/B VDD VSS gf180mcu_fd_sc_mcu7t5v0__nor2_1
X_2687_ VDD VSS _2690_/A3 _3312_/Q _2749_/C VDD VSS gf180mcu_fd_sc_mcu7t5v0__nand2_1
X_1638_ _1638_/A3 VDD VSS _3364_/D _2173_/A1 _1588_/B VDD VSS gf180mcu_fd_sc_mcu7t5v0__nor3_1
XFILLER_160_667 VDD VSS VDD VSS gf180mcu_fd_sc_mcu7t5v0__fillcap_64
X_1569_ _1587_/A1 _1569_/A4 VDD VSS _1569_/Z _3142_/Q _3145_/Q VDD VSS gf180mcu_fd_sc_mcu7t5v0__and4_1
XFILLER_59_626 VDD VSS VDD VSS gf180mcu_fd_sc_mcu7t5v0__fillcap_4
X_3308_ _3308_/D _3308_/Q wire165/I VSS _3340_/CLK VDD VDD VSS gf180mcu_fd_sc_mcu7t5v0__dffrnq_1
Xclkbuf_4_14_0_host_clk_i _2900_/CLK VSS VDD clkbuf_0_host_clk_i/Z VDD VSS gf180mcu_fd_sc_mcu7t5v0__clkbuf_2
X_3239_ _3239_/D _3239_/Q _3452_/RN VSS _3452_/CLK VDD VDD VSS gf180mcu_fd_sc_mcu7t5v0__dffrnq_1
XFILLER_100_255 VDD VSS VDD VSS gf180mcu_fd_sc_mcu7t5v0__fillcap_4
XFILLER_100_266 VDD VSS VDD VSS gf180mcu_fd_sc_mcu7t5v0__fillcap_32
XFILLER_73_106 VDD VSS VDD VSS gf180mcu_fd_sc_mcu7t5v0__fillcap_32
XFILLER_214_123 VDD VSS VDD VSS gf180mcu_fd_sc_mcu7t5v0__fillcap_4
XFILLER_27_556 VDD VSS VDD VSS gf180mcu_fd_sc_mcu7t5v0__fillcap_4
XFILLER_80_37 VDD VSS VDD VSS gf180mcu_fd_sc_mcu7t5v0__fillcap_8
XFILLER_211_874 VDD VSS VDD VSS gf180mcu_fd_sc_mcu7t5v0__fillcap_16
XFILLER_210_340 VDD VSS VDD VSS gf180mcu_fd_sc_mcu7t5v0__fillcap_8
XFILLER_196_37 VDD VSS VDD VSS gf180mcu_fd_sc_mcu7t5v0__fillcap_16
XFILLER_195_586 VDD VSS VDD VSS gf180mcu_fd_sc_mcu7t5v0__fillcap_4
XFILLER_108_355 VDD VSS VDD VSS gf180mcu_fd_sc_mcu7t5v0__fillcap_16
XFILLER_8_2 VDD VSS VDD VSS gf180mcu_fd_sc_mcu7t5v0__fillcap_32
XFILLER_145_41 VDD VSS VDD VSS gf180mcu_fd_sc_mcu7t5v0__fillcap_16
XFILLER_151_689 VDD VSS VDD VSS gf180mcu_fd_sc_mcu7t5v0__fillcap_8
XFILLER_150_177 VDD VSS VDD VSS gf180mcu_fd_sc_mcu7t5v0__fillcap_16
XFILLER_49_136 VDD VSS VDD VSS gf180mcu_fd_sc_mcu7t5v0__fillcap_4
XFILLER_202_885 VDD VSS VDD VSS gf180mcu_fd_sc_mcu7t5v0__fillcap_4
XFILLER_186_597 VDD VSS VDD VSS gf180mcu_fd_sc_mcu7t5v0__fillcap_16
XFILLER_174_737 VDD VSS VDD VSS gf180mcu_fd_sc_mcu7t5v0__fillcap_64
XFILLER_9_276 VDD VSS VDD VSS gf180mcu_fd_sc_mcu7t5v0__fillcap_4
X_2610_ _3449_/Q _3455_/Q VDD VSS _2703_/A4 _3061_/Q _1540_/Z VDD VSS gf180mcu_fd_sc_mcu7t5v0__oai211_1
Xclkload35 VDD VSS _2994_/CLK clkload35/ZN VDD VSS gf180mcu_fd_sc_mcu7t5v0__clkinv_1
Xclkload13 VSS clkload13/Z _3328_/CLK VDD VDD VSS gf180mcu_fd_sc_mcu7t5v0__clkbuf_1
Xclkload24 VDD VSS _3320_/CLK clkload24/ZN VDD VSS gf180mcu_fd_sc_mcu7t5v0__clkinv_2
Xclkload68 VDD VSS _3150_/CLK clkload68/ZN VDD VSS gf180mcu_fd_sc_mcu7t5v0__clkinv_1
Xclkload57 VSS clkload57/Z _3359_/CLK VDD VDD VSS gf180mcu_fd_sc_mcu7t5v0__clkbuf_1
Xclkload46 VSS clkload46/Z _3012_/CLK VDD VDD VSS gf180mcu_fd_sc_mcu7t5v0__clkbuf_1
X_2541_ _2541_/B VDD VSS _2550_/A1 _3454_/D _3454_/Q VDD VSS gf180mcu_fd_sc_mcu7t5v0__aoi21_1
XFILLER_142_634 VDD VSS VDD VSS gf180mcu_fd_sc_mcu7t5v0__fillcap_16
X_2472_ VDD _2472_/B _2472_/A2 _3205_/D wire21/Z VSS VDD VSS gf180mcu_fd_sc_mcu7t5v0__oai21_1
XFILLER_126_163 VDD VSS VDD VSS gf180mcu_fd_sc_mcu7t5v0__fillcap_8
Xclkload79 VSS clkload79/ZN _3461_/CLK VDD VDD VSS gf180mcu_fd_sc_mcu7t5v0__inv_8
XFILLER_142_667 VDD VSS VDD VSS gf180mcu_fd_sc_mcu7t5v0__fillcap_16
X_1423_ VDD VSS wire72/Z _1519_/A1 VDD VSS gf180mcu_fd_sc_mcu7t5v0__clkinv_1
Xclkbuf_leaf_64_clk_i clkload9/I VSS VDD clkbuf_3_0__f_clk_i/Z VDD VSS gf180mcu_fd_sc_mcu7t5v0__clkbuf_2
XFILLER_130_807 VDD VSS VDD VSS gf180mcu_fd_sc_mcu7t5v0__fillcap_64
XFILLER_209_451 VDD VSS VDD VSS gf180mcu_fd_sc_mcu7t5v0__fillcap_32
X_3024_ VDD _3024_/Q _3046_/CLK VSS _3024_/D VDD VSS gf180mcu_fd_sc_mcu7t5v0__dffq_1
XFILLER_110_597 VDD VSS VDD VSS gf180mcu_fd_sc_mcu7t5v0__fillcap_32
XFILLER_212_605 VDD VSS VDD VSS gf180mcu_fd_sc_mcu7t5v0__fillcap_4
XFILLER_91_492 VDD VSS VDD VSS gf180mcu_fd_sc_mcu7t5v0__fillcap_32
XFILLER_177_553 VDD VSS VDD VSS gf180mcu_fd_sc_mcu7t5v0__fillcap_4
Xclkbuf_leaf_17_clk_i _3165_/CLK VSS VDD clkload3/I VDD VSS gf180mcu_fd_sc_mcu7t5v0__clkbuf_2
Xclkload7 VSS clkload7/Z clkload7/I VDD VDD VSS gf180mcu_fd_sc_mcu7t5v0__clkbuf_1
X_2808_ VDD _2808_/Q _3434_/CLK VSS _2808_/D VDD VSS gf180mcu_fd_sc_mcu7t5v0__dffq_1
XFILLER_164_269 VDD VSS VDD VSS gf180mcu_fd_sc_mcu7t5v0__fillcap_16
X_2739_ _2739_/S VDD VSS _3316_/D _2739_/I0 _3316_/Q VDD VSS gf180mcu_fd_sc_mcu7t5v0__mux2_2
XFILLER_145_483 VDD VSS VDD VSS gf180mcu_fd_sc_mcu7t5v0__fillcap_4
XFILLER_117_196 VDD VSS VDD VSS gf180mcu_fd_sc_mcu7t5v0__fillcap_8
XFILLER_120_317 VDD VSS VDD VSS gf180mcu_fd_sc_mcu7t5v0__fillcap_16
XFILLER_132_177 VDD VSS VDD VSS gf180mcu_fd_sc_mcu7t5v0__fillcap_16
XFILLER_219_204 VDD VSS VDD VSS gf180mcu_fd_sc_mcu7t5v0__fillcap_4
XFILLER_262_527 VDD VSS VDD VSS gf180mcu_fd_sc_mcu7t5v0__fillcap_64
XFILLER_188_807 VDD VSS VDD VSS gf180mcu_fd_sc_mcu7t5v0__fillcap_64
XFILLER_230_457 VDD VSS VDD VSS gf180mcu_fd_sc_mcu7t5v0__fillcap_64
XFILLER_145_2 VDD VSS VDD VSS gf180mcu_fd_sc_mcu7t5v0__fillcap_4
XFILLER_211_693 VDD VSS VDD VSS gf180mcu_fd_sc_mcu7t5v0__fillcap_4
XFILLER_168_597 VDD VSS VDD VSS gf180mcu_fd_sc_mcu7t5v0__fillcap_64
XFILLER_156_737 VDD VSS VDD VSS gf180mcu_fd_sc_mcu7t5v0__fillcap_64
XFILLER_183_556 VDD VSS VDD VSS gf180mcu_fd_sc_mcu7t5v0__fillcap_4
XFILLER_156_62 VDD VSS VDD VSS gf180mcu_fd_sc_mcu7t5v0__fillcap_8
XFILLER_109_686 VDD VSS VDD VSS gf180mcu_fd_sc_mcu7t5v0__fillcap_8
XFILLER_112_807 VDD VSS VDD VSS gf180mcu_fd_sc_mcu7t5v0__fillcap_64
XFILLER_124_667 VDD VSS VDD VSS gf180mcu_fd_sc_mcu7t5v0__fillcap_4
XFILLER_93_702 VDD VSS VDD VSS gf180mcu_fd_sc_mcu7t5v0__fillcap_64
XFILLER_266_877 VDD VSS VDD VSS gf180mcu_fd_sc_mcu7t5v0__fillcap_8
XFILLER_73_492 VDD VSS VDD VSS gf180mcu_fd_sc_mcu7t5v0__fillcap_64
XFILLER_61_632 VDD VSS VDD VSS gf180mcu_fd_sc_mcu7t5v0__fillcap_64
XFILLER_221_468 VDD VSS VDD VSS gf180mcu_fd_sc_mcu7t5v0__fillcap_4
X_1972_ _1972_/S VDD VSS _3020_/D wire113/Z _3020_/Q VDD VSS gf180mcu_fd_sc_mcu7t5v0__mux2_2
XFILLER_197_80 VDD VSS VDD VSS gf180mcu_fd_sc_mcu7t5v0__fillcap_8
XFILLER_146_247 VDD VSS VDD VSS gf180mcu_fd_sc_mcu7t5v0__fillcap_16
XFILLER_60_2 VDD VSS VDD VSS gf180mcu_fd_sc_mcu7t5v0__fillcap_32
XFILLER_216_10 VDD VSS VDD VSS gf180mcu_fd_sc_mcu7t5v0__fillcap_8
X_2524_ _2524_/B1 _3339_/Q VDD VSS _2527_/A2 _3331_/Q _2554_/A2 VDD VSS gf180mcu_fd_sc_mcu7t5v0__aoi22_1
X_2455_ VDD VSS _2463_/A1 _2442_/S _2454_/Z VDD VSS gf180mcu_fd_sc_mcu7t5v0__nand2_1
XFILLER_102_317 VDD VSS VDD VSS gf180mcu_fd_sc_mcu7t5v0__fillcap_4
XFILLER_114_177 VDD VSS VDD VSS gf180mcu_fd_sc_mcu7t5v0__fillcap_32
X_2386_ VDD VSS _2387_/A3 _2442_/S _2385_/Z VDD VSS gf180mcu_fd_sc_mcu7t5v0__nand2_1
X_1406_ VDD VSS _3061_/Q _2020_/A1 VDD VSS gf180mcu_fd_sc_mcu7t5v0__clkinv_1
XFILLER_83_212 VDD VSS VDD VSS gf180mcu_fd_sc_mcu7t5v0__fillcap_8
XFILLER_256_387 VDD VSS VDD VSS gf180mcu_fd_sc_mcu7t5v0__fillcap_64
XFILLER_244_527 VDD VSS VDD VSS gf180mcu_fd_sc_mcu7t5v0__fillcap_64
X_3007_ VDD _3007_/Q _3023_/CLK VSS _3007_/D VDD VSS gf180mcu_fd_sc_mcu7t5v0__dffq_1
XFILLER_212_457 VDD VSS VDD VSS gf180mcu_fd_sc_mcu7t5v0__fillcap_8
XFILLER_51_142 VDD VSS VDD VSS gf180mcu_fd_sc_mcu7t5v0__fillcap_64
XFILLER_196_147 VDD VSS VDD VSS gf180mcu_fd_sc_mcu7t5v0__fillcap_4
XFILLER_165_556 VDD VSS VDD VSS gf180mcu_fd_sc_mcu7t5v0__fillcap_4
XFILLER_257_72 VDD VSS VDD VSS gf180mcu_fd_sc_mcu7t5v0__fillcap_64
XFILLER_106_667 VDD VSS VDD VSS gf180mcu_fd_sc_mcu7t5v0__fillcap_16
XFILLER_266_107 VDD VSS VDD VSS gf180mcu_fd_sc_mcu7t5v0__fillcap_64
XFILLER_87_540 VDD VSS VDD VSS gf180mcu_fd_sc_mcu7t5v0__fillcap_16
XFILLER_87_562 VDD VSS VDD VSS gf180mcu_fd_sc_mcu7t5v0__fillcap_64
XFILLER_75_702 VDD VSS VDD VSS gf180mcu_fd_sc_mcu7t5v0__fillcap_64
XFILLER_248_877 VDD VSS VDD VSS gf180mcu_fd_sc_mcu7t5v0__fillcap_8
XFILLER_263_836 VDD VSS VDD VSS gf180mcu_fd_sc_mcu7t5v0__fillcap_4
XFILLER_262_2 VDD VSS VDD VSS gf180mcu_fd_sc_mcu7t5v0__fillcap_32
XFILLER_55_492 VDD VSS VDD VSS gf180mcu_fd_sc_mcu7t5v0__fillcap_64
XFILLER_43_632 VDD VSS VDD VSS gf180mcu_fd_sc_mcu7t5v0__fillcap_64
XFILLER_188_637 VDD VSS VDD VSS gf180mcu_fd_sc_mcu7t5v0__fillcap_16
XFILLER_70_451 VDD VSS VDD VSS gf180mcu_fd_sc_mcu7t5v0__fillcap_4
XFILLER_231_766 VDD VSS VDD VSS gf180mcu_fd_sc_mcu7t5v0__fillcap_4
XFILLER_11_562 VDD VSS VDD VSS gf180mcu_fd_sc_mcu7t5v0__fillcap_64
XFILLER_51_72 VDD VSS VDD VSS gf180mcu_fd_sc_mcu7t5v0__fillcap_64
XFILLER_167_50 VDD VSS VDD VSS gf180mcu_fd_sc_mcu7t5v0__fillcap_8
XFILLER_128_247 VDD VSS VDD VSS gf180mcu_fd_sc_mcu7t5v0__fillcap_16
XFILLER_143_206 VDD VSS VDD VSS gf180mcu_fd_sc_mcu7t5v0__fillcap_4
XFILLER_3_772 VDD VSS VDD VSS gf180mcu_fd_sc_mcu7t5v0__fillcap_64
XFILLER_111_103 VDD VSS VDD VSS gf180mcu_fd_sc_mcu7t5v0__fillcap_4
X_2240_ _2240_/B _2240_/C VDD VSS _2246_/A3 _2485_/A1 _1700_/Z VDD VSS gf180mcu_fd_sc_mcu7t5v0__oai211_1
X_2171_ VDD VSS _3137_/D _2171_/A1 _2171_/A2 VDD VSS gf180mcu_fd_sc_mcu7t5v0__nand2_1
XFILLER_65_212 VDD VSS VDD VSS gf180mcu_fd_sc_mcu7t5v0__fillcap_64
XFILLER_238_387 VDD VSS VDD VSS gf180mcu_fd_sc_mcu7t5v0__fillcap_64
XFILLER_226_527 VDD VSS VDD VSS gf180mcu_fd_sc_mcu7t5v0__fillcap_64
XFILLER_253_346 VDD VSS VDD VSS gf180mcu_fd_sc_mcu7t5v0__fillcap_4
XFILLER_179_626 VDD VSS VDD VSS gf180mcu_fd_sc_mcu7t5v0__fillcap_4
XFILLER_80_259 VDD VSS VDD VSS gf180mcu_fd_sc_mcu7t5v0__fillcap_4
XFILLER_33_142 VDD VSS VDD VSS gf180mcu_fd_sc_mcu7t5v0__fillcap_64
XFILLER_92_90 VDD VSS VDD VSS gf180mcu_fd_sc_mcu7t5v0__fillcap_8
XFILLER_221_276 VDD VSS VDD VSS gf180mcu_fd_sc_mcu7t5v0__fillcap_4
XFILLER_221_298 VDD VSS VDD VSS gf180mcu_fd_sc_mcu7t5v0__fillcap_8
X_1955_ VDD VSS _1963_/S _1992_/A1 _1945_/Z VDD VSS gf180mcu_fd_sc_mcu7t5v0__nand2_1
XFILLER_30_871 VDD VSS VDD VSS gf180mcu_fd_sc_mcu7t5v0__fillcap_4
XFILLER_147_556 VDD VSS VDD VSS gf180mcu_fd_sc_mcu7t5v0__fillcap_4
XFILLER_147_578 VDD VSS VDD VSS gf180mcu_fd_sc_mcu7t5v0__fillcap_8
X_1886_ wire36/Z VDD VSS _2947_/D _2947_/Q _3181_/Q VDD VSS gf180mcu_fd_sc_mcu7t5v0__mux2_2
XFILLER_115_486 VDD VSS VDD VSS gf180mcu_fd_sc_mcu7t5v0__fillcap_4
XFILLER_103_626 VDD VSS VDD VSS gf180mcu_fd_sc_mcu7t5v0__fillcap_4
X_2507_ _2507_/A3 VDD VSS _2508_/A3 _3221_/Q _2507_/A2 VDD VSS gf180mcu_fd_sc_mcu7t5v0__nand3_1
XFILLER_248_107 VDD VSS VDD VSS gf180mcu_fd_sc_mcu7t5v0__fillcap_64
X_2438_ VDD _2438_/B _2438_/A2 _3201_/D _2467_/A1 VSS VDD VSS gf180mcu_fd_sc_mcu7t5v0__oai21_1
XFILLER_57_702 VDD VSS VDD VSS gf180mcu_fd_sc_mcu7t5v0__fillcap_64
XFILLER_69_562 VDD VSS VDD VSS gf180mcu_fd_sc_mcu7t5v0__fillcap_64
XFILLER_102_169 VDD VSS VDD VSS gf180mcu_fd_sc_mcu7t5v0__fillcap_4
X_2369_ _2861_/Q VSS VDD _2845_/Q _2853_/Q wire78/Z _2837_/Q _2454_/S1 _2369_/Z VDD
+ VSS gf180mcu_fd_sc_mcu7t5v0__mux4_1
XFILLER_84_521 VDD VSS VDD VSS gf180mcu_fd_sc_mcu7t5v0__fillcap_4
XFILLER_245_836 VDD VSS VDD VSS gf180mcu_fd_sc_mcu7t5v0__fillcap_4
XFILLER_257_696 VDD VSS VDD VSS gf180mcu_fd_sc_mcu7t5v0__fillcap_4
XFILLER_37_492 VDD VSS VDD VSS gf180mcu_fd_sc_mcu7t5v0__fillcap_64
XFILLER_25_632 VDD VSS VDD VSS gf180mcu_fd_sc_mcu7t5v0__fillcap_64
XFILLER_52_451 VDD VSS VDD VSS gf180mcu_fd_sc_mcu7t5v0__fillcap_4
XFILLER_213_766 VDD VSS VDD VSS gf180mcu_fd_sc_mcu7t5v0__fillcap_4
XFILLER_169_136 VDD VSS VDD VSS gf180mcu_fd_sc_mcu7t5v0__fillcap_4
XFILLER_20_381 VDD VSS VDD VSS gf180mcu_fd_sc_mcu7t5v0__fillcap_4
XFILLER_192_161 VDD VSS VDD VSS gf180mcu_fd_sc_mcu7t5v0__fillcap_8
XFILLER_153_548 VDD VSS VDD VSS gf180mcu_fd_sc_mcu7t5v0__fillcap_4
XFILLER_108_2 VDD VSS VDD VSS gf180mcu_fd_sc_mcu7t5v0__fillcap_32
XFILLER_267_416 VDD VSS VDD VSS gf180mcu_fd_sc_mcu7t5v0__fillcap_4
XFILLER_106_497 VDD VSS VDD VSS gf180mcu_fd_sc_mcu7t5v0__fillcap_8
XFILLER_88_871 VDD VSS VDD VSS gf180mcu_fd_sc_mcu7t5v0__fillcap_4
XFILLER_47_212 VDD VSS VDD VSS gf180mcu_fd_sc_mcu7t5v0__fillcap_64
XFILLER_208_527 VDD VSS VDD VSS gf180mcu_fd_sc_mcu7t5v0__fillcap_8
XFILLER_235_346 VDD VSS VDD VSS gf180mcu_fd_sc_mcu7t5v0__fillcap_4
XFILLER_15_142 VDD VSS VDD VSS gf180mcu_fd_sc_mcu7t5v0__fillcap_64
XFILLER_30_101 VDD VSS VDD VSS gf180mcu_fd_sc_mcu7t5v0__fillcap_4
XFILLER_203_276 VDD VSS VDD VSS gf180mcu_fd_sc_mcu7t5v0__fillcap_4
XFILLER_12_871 VDD VSS VDD VSS gf180mcu_fd_sc_mcu7t5v0__fillcap_4
X_1740_ _1852_/A1 VDD VSS _1748_/S _3369_/Q _3370_/Q VDD VSS gf180mcu_fd_sc_mcu7t5v0__and3_1
X_1671_ VDD VSS _2476_/B2 _2331_/B _1712_/A1 VDD VSS gf180mcu_fd_sc_mcu7t5v0__nand2_1
XFILLER_7_352 VDD VSS VDD VSS gf180mcu_fd_sc_mcu7t5v0__fillcap_64
XFILLER_7_66 VDD VSS VDD VSS gf180mcu_fd_sc_mcu7t5v0__fillcap_4
X_3410_ _3410_/D _3410_/Q wire161/I VSS _3441_/CLK VDD VDD VSS gf180mcu_fd_sc_mcu7t5v0__dffrnq_1
X_3341_ _3341_/D _3341_/Q wire163/I VSS _3341_/CLK VDD VDD VSS gf180mcu_fd_sc_mcu7t5v0__dffrnq_1
X_3272_ _3272_/D _3272_/Q wire147/I VSS _3321_/CLK VDD VDD VSS gf180mcu_fd_sc_mcu7t5v0__dffrnq_1
XFILLER_39_702 VDD VSS VDD VSS gf180mcu_fd_sc_mcu7t5v0__fillcap_64
X_2223_ _3356_/Q VDD VSS _2225_/A2 _3356_/D _3355_/D VDD VSS gf180mcu_fd_sc_mcu7t5v0__nand3_1
XFILLER_85_329 VDD VSS VDD VSS gf180mcu_fd_sc_mcu7t5v0__fillcap_16
XFILLER_66_521 VDD VSS VDD VSS gf180mcu_fd_sc_mcu7t5v0__fillcap_4
XFILLER_23_2 VDD VSS VDD VSS gf180mcu_fd_sc_mcu7t5v0__fillcap_64
XFILLER_239_696 VDD VSS VDD VSS gf180mcu_fd_sc_mcu7t5v0__fillcap_4
XFILLER_227_836 VDD VSS VDD VSS gf180mcu_fd_sc_mcu7t5v0__fillcap_4
X_2154_ _2154_/A3 VDD VSS _2155_/A2 _2186_/A2 _2186_/A3 VDD VSS gf180mcu_fd_sc_mcu7t5v0__nor3_1
XFILLER_213_66 VDD VSS VDD VSS gf180mcu_fd_sc_mcu7t5v0__fillcap_4
XFILLER_94_885 VDD VSS VDD VSS gf180mcu_fd_sc_mcu7t5v0__fillcap_4
X_2085_ _3104_/Q VDD VSS _2089_/A3 _3103_/Q _3102_/Q VDD VSS gf180mcu_fd_sc_mcu7t5v0__nand3_1
XFILLER_93_395 VDD VSS VDD VSS gf180mcu_fd_sc_mcu7t5v0__fillcap_16
XFILLER_19_492 VDD VSS VDD VSS gf180mcu_fd_sc_mcu7t5v0__fillcap_64
XFILLER_34_451 VDD VSS VDD VSS gf180mcu_fd_sc_mcu7t5v0__fillcap_4
Xmax_length15 _2596_/S _2567_/ZN VDD VSS VDD VSS gf180mcu_fd_sc_mcu7t5v0__buf_4
X_2987_ VDD _2987_/Q _3012_/CLK VSS _2987_/D VDD VSS gf180mcu_fd_sc_mcu7t5v0__dffq_1
Xmax_length48 _2626_/S _2625_/S VDD VSS VDD VSS gf180mcu_fd_sc_mcu7t5v0__buf_4
XFILLER_159_191 VDD VSS VDD VSS gf180mcu_fd_sc_mcu7t5v0__fillcap_4
X_1938_ _1942_/S VDD VSS _2990_/D wire123/Z _2990_/Q VDD VSS gf180mcu_fd_sc_mcu7t5v0__mux2_2
X_1869_ _1869_/S VDD VSS _2932_/D _1869_/I0 _2932_/Q VDD VSS gf180mcu_fd_sc_mcu7t5v0__mux2_2
XFILLER_190_654 VDD VSS VDD VSS gf180mcu_fd_sc_mcu7t5v0__fillcap_8
XFILLER_174_18 VDD VSS VDD VSS gf180mcu_fd_sc_mcu7t5v0__fillcap_16
XFILLER_131_710 VDD VSS VDD VSS gf180mcu_fd_sc_mcu7t5v0__fillcap_4
XFILLER_249_416 VDD VSS VDD VSS gf180mcu_fd_sc_mcu7t5v0__fillcap_4
XFILLER_88_123 VDD VSS VDD VSS gf180mcu_fd_sc_mcu7t5v0__fillcap_8
XFILLER_131_765 VDD VSS VDD VSS gf180mcu_fd_sc_mcu7t5v0__fillcap_4
XFILLER_29_212 VDD VSS VDD VSS gf180mcu_fd_sc_mcu7t5v0__fillcap_64
XFILLER_85_874 VDD VSS VDD VSS gf180mcu_fd_sc_mcu7t5v0__fillcap_16
XFILLER_123_66 VDD VSS VDD VSS gf180mcu_fd_sc_mcu7t5v0__fillcap_4
XFILLER_213_530 VDD VSS VDD VSS gf180mcu_fd_sc_mcu7t5v0__fillcap_4
XFILLER_12_101 VDD VSS VDD VSS gf180mcu_fd_sc_mcu7t5v0__fillcap_4
XFILLER_198_776 VDD VSS VDD VSS gf180mcu_fd_sc_mcu7t5v0__fillcap_16
XFILLER_148_30 VDD VSS VDD VSS gf180mcu_fd_sc_mcu7t5v0__fillcap_4
XFILLER_181_632 VDD VSS VDD VSS gf180mcu_fd_sc_mcu7t5v0__fillcap_4
XFILLER_193_492 VDD VSS VDD VSS gf180mcu_fd_sc_mcu7t5v0__fillcap_64
XFILLER_4_311 VDD VSS VDD VSS gf180mcu_fd_sc_mcu7t5v0__fillcap_4
XFILLER_134_581 VDD VSS VDD VSS gf180mcu_fd_sc_mcu7t5v0__fillcap_8
XFILLER_209_836 VDD VSS VDD VSS gf180mcu_fd_sc_mcu7t5v0__fillcap_4
XFILLER_48_521 VDD VSS VDD VSS gf180mcu_fd_sc_mcu7t5v0__fillcap_4
XFILLER_76_885 VDD VSS VDD VSS gf180mcu_fd_sc_mcu7t5v0__fillcap_4
XFILLER_208_379 VDD VSS VDD VSS gf180mcu_fd_sc_mcu7t5v0__fillcap_4
XFILLER_90_332 VDD VSS VDD VSS gf180mcu_fd_sc_mcu7t5v0__fillcap_4
XFILLER_16_451 VDD VSS VDD VSS gf180mcu_fd_sc_mcu7t5v0__fillcap_4
X_2910_ VDD _2910_/Q _2914_/CLK VSS _2910_/D VDD VSS gf180mcu_fd_sc_mcu7t5v0__dffq_1
X_2841_ VDD _2841_/Q _3369_/CLK VSS _2841_/D VDD VSS gf180mcu_fd_sc_mcu7t5v0__dffq_1
Xspi_opentarget_i3c_top_181 rst_ni_PD VDD VSS VDD VSS gf180mcu_fd_sc_mcu7t5v0__tiel
X_2772_ VDD VSS _3327_/D wire10/Z _2772_/A2 VDD VSS gf180mcu_fd_sc_mcu7t5v0__nand2_1
Xspi_opentarget_i3c_top_192 spi_cs_ni_PU VDD VSS VDD VSS gf180mcu_fd_sc_mcu7t5v0__tiel
X_1723_ _1728_/S VDD VSS _2807_/D _2807_/Q _3121_/Q VDD VSS gf180mcu_fd_sc_mcu7t5v0__mux2_2
XFILLER_8_661 VDD VSS VDD VSS gf180mcu_fd_sc_mcu7t5v0__fillcap_4
X_1654_ _1654_/A3 VDD VSS _1654_/Z _2804_/Q _3212_/Q VDD VSS gf180mcu_fd_sc_mcu7t5v0__and3_1
XFILLER_132_507 VDD VSS VDD VSS gf180mcu_fd_sc_mcu7t5v0__fillcap_16
X_1585_ _2179_/A1 _1585_/A4 VDD VSS _1588_/B _2175_/A1 _2177_/A1 VDD VSS gf180mcu_fd_sc_mcu7t5v0__nand4_1
XFILLER_140_551 VDD VSS VDD VSS gf180mcu_fd_sc_mcu7t5v0__fillcap_4
X_3324_ _3324_/D _3324_/Q wire165/Z VSS _3328_/CLK VDD VDD VSS gf180mcu_fd_sc_mcu7t5v0__dffrnq_1
X_3255_ _3255_/D _3255_/Q _3452_/RN VSS _3451_/CLK VDD VDD VSS gf180mcu_fd_sc_mcu7t5v0__dffrnq_1
X_2206_ _2221_/S VDD VSS _3152_/D _3286_/Q _3152_/Q VDD VSS gf180mcu_fd_sc_mcu7t5v0__mux2_2
X_3186_ _3186_/D _3186_/Q wire151/Z VSS _3349_/CLK VDD VDD VSS gf180mcu_fd_sc_mcu7t5v0__dffrnq_1
XFILLER_67_874 VDD VSS VDD VSS gf180mcu_fd_sc_mcu7t5v0__fillcap_16
X_2137_ _2137_/S VDD VSS _3125_/D wire90/Z _3125_/Q VDD VSS gf180mcu_fd_sc_mcu7t5v0__mux2_2
XFILLER_94_682 VDD VSS VDD VSS gf180mcu_fd_sc_mcu7t5v0__fillcap_32
X_2068_ _2068_/B VDD VSS _3097_/D _2302_/A2 _2072_/S VDD VSS gf180mcu_fd_sc_mcu7t5v0__aoi21_1
XFILLER_82_877 VDD VSS VDD VSS gf180mcu_fd_sc_mcu7t5v0__fillcap_8
XFILLER_195_702 VDD VSS VDD VSS gf180mcu_fd_sc_mcu7t5v0__fillcap_8
XFILLER_179_253 VDD VSS VDD VSS gf180mcu_fd_sc_mcu7t5v0__fillcap_8
XFILLER_163_632 VDD VSS VDD VSS gf180mcu_fd_sc_mcu7t5v0__fillcap_64
XFILLER_162_131 VDD VSS VDD VSS gf180mcu_fd_sc_mcu7t5v0__fillcap_4
XFILLER_190_451 VDD VSS VDD VSS gf180mcu_fd_sc_mcu7t5v0__fillcap_4
XFILLER_190_473 VDD VSS VDD VSS gf180mcu_fd_sc_mcu7t5v0__fillcap_8
XFILLER_265_72 VDD VSS VDD VSS gf180mcu_fd_sc_mcu7t5v0__fillcap_64
XFILLER_78_37 VDD VSS VDD VSS gf180mcu_fd_sc_mcu7t5v0__fillcap_32
XFILLER_103_220 VDD VSS VDD VSS gf180mcu_fd_sc_mcu7t5v0__fillcap_4
XFILLER_131_562 VDD VSS VDD VSS gf180mcu_fd_sc_mcu7t5v0__fillcap_8
XFILLER_58_885 VDD VSS VDD VSS gf180mcu_fd_sc_mcu7t5v0__fillcap_4
XFILLER_175_2 VDD VSS VDD VSS gf180mcu_fd_sc_mcu7t5v0__fillcap_16
XFILLER_72_332 VDD VSS VDD VSS gf180mcu_fd_sc_mcu7t5v0__fillcap_32
XFILLER_72_387 VDD VSS VDD VSS gf180mcu_fd_sc_mcu7t5v0__fillcap_64
XFILLER_60_527 VDD VSS VDD VSS gf180mcu_fd_sc_mcu7t5v0__fillcap_64
XFILLER_139_684 VDD VSS VDD VSS gf180mcu_fd_sc_mcu7t5v0__fillcap_16
XFILLER_175_72 VDD VSS VDD VSS gf180mcu_fd_sc_mcu7t5v0__fillcap_4
XFILLER_141_326 VDD VSS VDD VSS gf180mcu_fd_sc_mcu7t5v0__fillcap_8
XFILLER_107_570 VDD VSS VDD VSS gf180mcu_fd_sc_mcu7t5v0__fillcap_4
XFILLER_150_871 VDD VSS VDD VSS gf180mcu_fd_sc_mcu7t5v0__fillcap_4
XFILLER_95_446 VDD VSS VDD VSS gf180mcu_fd_sc_mcu7t5v0__fillcap_16
XFILLER_82_107 VDD VSS VDD VSS gf180mcu_fd_sc_mcu7t5v0__fillcap_16
XFILLER_49_874 VDD VSS VDD VSS gf180mcu_fd_sc_mcu7t5v0__fillcap_16
X_3040_ VDD _3040_/Q _3046_/CLK VSS _3040_/D VDD VSS gf180mcu_fd_sc_mcu7t5v0__dffq_1
XFILLER_251_422 VDD VSS VDD VSS gf180mcu_fd_sc_mcu7t5v0__fillcap_64
XFILLER_263_282 VDD VSS VDD VSS gf180mcu_fd_sc_mcu7t5v0__fillcap_64
XFILLER_64_877 VDD VSS VDD VSS gf180mcu_fd_sc_mcu7t5v0__fillcap_8
XFILLER_91_696 VDD VSS VDD VSS gf180mcu_fd_sc_mcu7t5v0__fillcap_4
XFILLER_189_562 VDD VSS VDD VSS gf180mcu_fd_sc_mcu7t5v0__fillcap_16
XFILLER_189_540 VDD VSS VDD VSS gf180mcu_fd_sc_mcu7t5v0__fillcap_4
XFILLER_177_702 VDD VSS VDD VSS gf180mcu_fd_sc_mcu7t5v0__fillcap_64
XFILLER_204_360 VDD VSS VDD VSS gf180mcu_fd_sc_mcu7t5v0__fillcap_16
XFILLER_90_2 VDD VSS VDD VSS gf180mcu_fd_sc_mcu7t5v0__fillcap_8
X_2824_ VDD _2824_/Q _3434_/CLK VSS _2824_/D VDD VSS gf180mcu_fd_sc_mcu7t5v0__dffq_1
XFILLER_145_610 VDD VSS VDD VSS gf180mcu_fd_sc_mcu7t5v0__fillcap_16
XFILLER_157_492 VDD VSS VDD VSS gf180mcu_fd_sc_mcu7t5v0__fillcap_64
XFILLER_145_632 VDD VSS VDD VSS gf180mcu_fd_sc_mcu7t5v0__fillcap_16
X_2755_ _2758_/A3 VDD VSS _2757_/A2 wire106/Z _2758_/A2 VDD VSS gf180mcu_fd_sc_mcu7t5v0__nand3_1
X_1706_ _2483_/B _1706_/A4 VDD VSS _1710_/B _1720_/A2 _1711_/A4 VDD VSS gf180mcu_fd_sc_mcu7t5v0__nor4_1
X_2686_ _2737_/C VDD VSS wire10/I _2686_/A1 _2758_/A2 VDD VSS gf180mcu_fd_sc_mcu7t5v0__nand3_1
X_1637_ _1638_/A3 VDD VSS _3365_/D _3138_/Q _1588_/B VDD VSS gf180mcu_fd_sc_mcu7t5v0__nor3_1
X_1568_ _2186_/A3 _2146_/A3 _3141_/Q VDD VSS _1589_/C _1568_/A1 VDD VSS gf180mcu_fd_sc_mcu7t5v0__oai22_1
X_3307_ _3307_/D _3307_/Q _3339_/RN VSS _3307_/CLK VDD VDD VSS gf180mcu_fd_sc_mcu7t5v0__dffrnq_1
XFILLER_113_562 VDD VSS VDD VSS gf180mcu_fd_sc_mcu7t5v0__fillcap_64
XFILLER_101_702 VDD VSS VDD VSS gf180mcu_fd_sc_mcu7t5v0__fillcap_64
X_1499_ VDD VSS _1729_/A2 _3368_/Q _1497_/I VDD VSS gf180mcu_fd_sc_mcu7t5v0__nand2_1
XFILLER_100_212 VDD VSS VDD VSS gf180mcu_fd_sc_mcu7t5v0__fillcap_32
XFILLER_86_457 VDD VSS VDD VSS gf180mcu_fd_sc_mcu7t5v0__fillcap_16
X_3238_ _3238_/D _3238_/Q wire145/Z VSS _3279_/CLK VDD VDD VSS gf180mcu_fd_sc_mcu7t5v0__dffrnq_1
XFILLER_255_772 VDD VSS VDD VSS gf180mcu_fd_sc_mcu7t5v0__fillcap_64
X_3169_ VSS _3362_/CLK VDD _3169_/D _3357_/D wire153/I VDD VSS gf180mcu_fd_sc_mcu7t5v0__dffsnq_1
XFILLER_54_387 VDD VSS VDD VSS gf180mcu_fd_sc_mcu7t5v0__fillcap_64
XFILLER_42_527 VDD VSS VDD VSS gf180mcu_fd_sc_mcu7t5v0__fillcap_64
XFILLER_168_713 VDD VSS VDD VSS gf180mcu_fd_sc_mcu7t5v0__fillcap_16
XFILLER_211_842 VDD VSS VDD VSS gf180mcu_fd_sc_mcu7t5v0__fillcap_32
XFILLER_108_301 VDD VSS VDD VSS gf180mcu_fd_sc_mcu7t5v0__fillcap_8
XFILLER_10_457 VDD VSS VDD VSS gf180mcu_fd_sc_mcu7t5v0__fillcap_64
XFILLER_129_87 VDD VSS VDD VSS gf180mcu_fd_sc_mcu7t5v0__fillcap_8
XFILLER_150_123 VDD VSS VDD VSS gf180mcu_fd_sc_mcu7t5v0__fillcap_8
XFILLER_2_667 VDD VSS VDD VSS gf180mcu_fd_sc_mcu7t5v0__fillcap_64
XFILLER_132_871 VDD VSS VDD VSS gf180mcu_fd_sc_mcu7t5v0__fillcap_4
XFILLER_64_107 VDD VSS VDD VSS gf180mcu_fd_sc_mcu7t5v0__fillcap_64
XFILLER_92_427 VDD VSS VDD VSS gf180mcu_fd_sc_mcu7t5v0__fillcap_16
XFILLER_233_422 VDD VSS VDD VSS gf180mcu_fd_sc_mcu7t5v0__fillcap_64
XFILLER_245_282 VDD VSS VDD VSS gf180mcu_fd_sc_mcu7t5v0__fillcap_64
XFILLER_46_877 VDD VSS VDD VSS gf180mcu_fd_sc_mcu7t5v0__fillcap_8
XFILLER_260_241 VDD VSS VDD VSS gf180mcu_fd_sc_mcu7t5v0__fillcap_4
XFILLER_205_135 VDD VSS VDD VSS gf180mcu_fd_sc_mcu7t5v0__fillcap_4
XFILLER_61_836 VDD VSS VDD VSS gf180mcu_fd_sc_mcu7t5v0__fillcap_4
XFILLER_73_696 VDD VSS VDD VSS gf180mcu_fd_sc_mcu7t5v0__fillcap_4
XFILLER_159_702 VDD VSS VDD VSS gf180mcu_fd_sc_mcu7t5v0__fillcap_64
XFILLER_201_352 VDD VSS VDD VSS gf180mcu_fd_sc_mcu7t5v0__fillcap_16
XFILLER_139_492 VDD VSS VDD VSS gf180mcu_fd_sc_mcu7t5v0__fillcap_32
Xclkload25 VSS clkload25/Z _3277_/CLK VDD VDD VSS gf180mcu_fd_sc_mcu7t5v0__clkbuf_1
Xclkload14 VSS clkload14/Z _3336_/CLK VDD VDD VSS gf180mcu_fd_sc_mcu7t5v0__clkbuf_1
XFILLER_127_632 VDD VSS VDD VSS gf180mcu_fd_sc_mcu7t5v0__fillcap_8
XFILLER_62_6 VDD VSS VDD VSS gf180mcu_fd_sc_mcu7t5v0__fillcap_16
Xclkload58 VSS clkload58/Z _3109_/CLK VDD VDD VSS gf180mcu_fd_sc_mcu7t5v0__clkbuf_1
Xclkload47 VSS clkload47/Z _3181_/CLK VDD VDD VSS gf180mcu_fd_sc_mcu7t5v0__clkbuf_1
Xclkload69 VDD VSS _2963_/CLK clkload69/ZN VDD VSS gf180mcu_fd_sc_mcu7t5v0__clkinv_2
Xclkload36 VDD VSS _3006_/CLK clkload36/ZN VDD VSS gf180mcu_fd_sc_mcu7t5v0__clkinv_1
X_2540_ _2547_/A3 VDD VSS _2541_/B _3454_/D _3454_/Q VDD VSS gf180mcu_fd_sc_mcu7t5v0__nor3_1
X_2471_ VDD VSS _2472_/B _3205_/Q _2471_/A2 VDD VSS gf180mcu_fd_sc_mcu7t5v0__nand2_1
XFILLER_114_304 VDD VSS VDD VSS gf180mcu_fd_sc_mcu7t5v0__fillcap_8
X_1422_ VDD VSS _3188_/Q _2335_/A1 VDD VSS gf180mcu_fd_sc_mcu7t5v0__clkinv_1
Xclkbuf_0_clk_i VDD VSS clkbuf_0_clk_i/Z clk_i VDD VSS gf180mcu_fd_sc_mcu7t5v0__clkbuf_16
XFILLER_110_521 VDD VSS VDD VSS gf180mcu_fd_sc_mcu7t5v0__fillcap_4
XFILLER_209_430 VDD VSS VDD VSS gf180mcu_fd_sc_mcu7t5v0__fillcap_4
XFILLER_205_56 VDD VSS VDD VSS gf180mcu_fd_sc_mcu7t5v0__fillcap_8
XFILLER_83_416 VDD VSS VDD VSS gf180mcu_fd_sc_mcu7t5v0__fillcap_4
XFILLER_68_457 VDD VSS VDD VSS gf180mcu_fd_sc_mcu7t5v0__fillcap_64
XFILLER_237_772 VDD VSS VDD VSS gf180mcu_fd_sc_mcu7t5v0__fillcap_64
X_3023_ VDD _3023_/Q _3023_/CLK VSS _3023_/D VDD VSS gf180mcu_fd_sc_mcu7t5v0__dffq_1
XFILLER_252_731 VDD VSS VDD VSS gf180mcu_fd_sc_mcu7t5v0__fillcap_4
XFILLER_264_591 VDD VSS VDD VSS gf180mcu_fd_sc_mcu7t5v0__fillcap_4
XFILLER_36_387 VDD VSS VDD VSS gf180mcu_fd_sc_mcu7t5v0__fillcap_64
XFILLER_24_527 VDD VSS VDD VSS gf180mcu_fd_sc_mcu7t5v0__fillcap_64
XFILLER_51_346 VDD VSS VDD VSS gf180mcu_fd_sc_mcu7t5v0__fillcap_4
XFILLER_149_289 VDD VSS VDD VSS gf180mcu_fd_sc_mcu7t5v0__fillcap_32
Xclkload8 VSS clkload8/Z clkload8/I VDD VDD VSS gf180mcu_fd_sc_mcu7t5v0__clkbuf_1
X_2807_ VDD _2807_/Q _3458_/CLK VSS _2807_/D VDD VSS gf180mcu_fd_sc_mcu7t5v0__dffq_1
XFILLER_145_451 VDD VSS VDD VSS gf180mcu_fd_sc_mcu7t5v0__fillcap_8
X_2738_ _2738_/A3 _2738_/B1 _2020_/B VDD VSS _2739_/I0 wire55/Z _2202_/Z VDD VSS gf180mcu_fd_sc_mcu7t5v0__oai32_1
XFILLER_133_602 VDD VSS VDD VSS gf180mcu_fd_sc_mcu7t5v0__fillcap_4
XFILLER_172_292 VDD VSS VDD VSS gf180mcu_fd_sc_mcu7t5v0__fillcap_4
X_2669_ VDD VSS _2799_/A2 _2703_/A3 _2752_/B VDD VSS gf180mcu_fd_sc_mcu7t5v0__nor2_1
XFILLER_132_123 VDD VSS VDD VSS gf180mcu_fd_sc_mcu7t5v0__fillcap_8
XFILLER_114_871 VDD VSS VDD VSS gf180mcu_fd_sc_mcu7t5v0__fillcap_4
XFILLER_259_352 VDD VSS VDD VSS gf180mcu_fd_sc_mcu7t5v0__fillcap_64
XFILLER_101_532 VDD VSS VDD VSS gf180mcu_fd_sc_mcu7t5v0__fillcap_16
XFILLER_87_766 VDD VSS VDD VSS gf180mcu_fd_sc_mcu7t5v0__fillcap_4
XFILLER_46_107 VDD VSS VDD VSS gf180mcu_fd_sc_mcu7t5v0__fillcap_64
XFILLER_215_422 VDD VSS VDD VSS gf180mcu_fd_sc_mcu7t5v0__fillcap_64
XFILLER_227_282 VDD VSS VDD VSS gf180mcu_fd_sc_mcu7t5v0__fillcap_64
XFILLER_28_877 VDD VSS VDD VSS gf180mcu_fd_sc_mcu7t5v0__fillcap_8
XFILLER_242_241 VDD VSS VDD VSS gf180mcu_fd_sc_mcu7t5v0__fillcap_4
XFILLER_43_836 VDD VSS VDD VSS gf180mcu_fd_sc_mcu7t5v0__fillcap_4
XFILLER_55_696 VDD VSS VDD VSS gf180mcu_fd_sc_mcu7t5v0__fillcap_4
XFILLER_131_44 VDD VSS VDD VSS gf180mcu_fd_sc_mcu7t5v0__fillcap_16
XFILLER_91_26 VDD VSS VDD VSS gf180mcu_fd_sc_mcu7t5v0__fillcap_4
XFILLER_211_661 VDD VSS VDD VSS gf180mcu_fd_sc_mcu7t5v0__fillcap_32
XFILLER_196_885 VDD VSS VDD VSS gf180mcu_fd_sc_mcu7t5v0__fillcap_4
XFILLER_11_766 VDD VSS VDD VSS gf180mcu_fd_sc_mcu7t5v0__fillcap_4
XFILLER_6_247 VDD VSS VDD VSS gf180mcu_fd_sc_mcu7t5v0__fillcap_64
XFILLER_266_801 VDD VSS VDD VSS gf180mcu_fd_sc_mcu7t5v0__fillcap_4
XFILLER_49_72 VDD VSS VDD VSS gf180mcu_fd_sc_mcu7t5v0__fillcap_64
XFILLER_77_254 VDD VSS VDD VSS gf180mcu_fd_sc_mcu7t5v0__fillcap_8
XFILLER_120_885 VDD VSS VDD VSS gf180mcu_fd_sc_mcu7t5v0__fillcap_4
XFILLER_65_416 VDD VSS VDD VSS gf180mcu_fd_sc_mcu7t5v0__fillcap_4
XFILLER_219_772 VDD VSS VDD VSS gf180mcu_fd_sc_mcu7t5v0__fillcap_64
XFILLER_234_731 VDD VSS VDD VSS gf180mcu_fd_sc_mcu7t5v0__fillcap_4
XFILLER_246_591 VDD VSS VDD VSS gf180mcu_fd_sc_mcu7t5v0__fillcap_4
XFILLER_18_387 VDD VSS VDD VSS gf180mcu_fd_sc_mcu7t5v0__fillcap_64
XFILLER_33_346 VDD VSS VDD VSS gf180mcu_fd_sc_mcu7t5v0__fillcap_4
X_1971_ _1972_/S VDD VSS _3019_/D wire114/Z _3019_/Q VDD VSS gf180mcu_fd_sc_mcu7t5v0__mux2_2
XFILLER_187_874 VDD VSS VDD VSS gf180mcu_fd_sc_mcu7t5v0__fillcap_16
XFILLER_186_395 VDD VSS VDD VSS gf180mcu_fd_sc_mcu7t5v0__fillcap_4
XFILLER_53_2 VDD VSS VDD VSS gf180mcu_fd_sc_mcu7t5v0__fillcap_64
X_2523_ _2524_/B1 _3338_/Q VDD VSS _2526_/A3 wire85/Z _1640_/I VDD VSS gf180mcu_fd_sc_mcu7t5v0__aoi22_1
XFILLER_142_443 VDD VSS VDD VSS gf180mcu_fd_sc_mcu7t5v0__fillcap_8
X_2454_ _2931_/Q VSS VDD _2915_/Q _2923_/Q _2454_/S0 _2907_/Q _2454_/S1 _2454_/Z VDD
+ VSS gf180mcu_fd_sc_mcu7t5v0__mux4_1
X_2385_ _2894_/Q VSS VDD _2878_/Q _2886_/Q _2427_/S0 _2870_/Q _2460_/S1 _2385_/Z VDD
+ VSS gf180mcu_fd_sc_mcu7t5v0__mux4_1
X_1405_ VDD VSS _3273_/Q _2607_/A1 VDD VSS gf180mcu_fd_sc_mcu7t5v0__clkinv_1
XFILLER_130_638 VDD VSS VDD VSS gf180mcu_fd_sc_mcu7t5v0__fillcap_16
XFILLER_256_311 VDD VSS VDD VSS gf180mcu_fd_sc_mcu7t5v0__fillcap_4
XFILLER_69_766 VDD VSS VDD VSS gf180mcu_fd_sc_mcu7t5v0__fillcap_4
XFILLER_111_874 VDD VSS VDD VSS gf180mcu_fd_sc_mcu7t5v0__fillcap_16
Xinput1 input1/Z input1/I VDD VSS VDD VSS gf180mcu_fd_sc_mcu7t5v0__buf_8
XFILLER_28_107 VDD VSS VDD VSS gf180mcu_fd_sc_mcu7t5v0__fillcap_64
X_3006_ VDD _3006_/Q _3006_/CLK VSS _3006_/D VDD VSS gf180mcu_fd_sc_mcu7t5v0__dffq_1
XFILLER_209_282 VDD VSS VDD VSS gf180mcu_fd_sc_mcu7t5v0__fillcap_16
XFILLER_224_241 VDD VSS VDD VSS gf180mcu_fd_sc_mcu7t5v0__fillcap_4
XFILLER_37_696 VDD VSS VDD VSS gf180mcu_fd_sc_mcu7t5v0__fillcap_4
XFILLER_25_836 VDD VSS VDD VSS gf180mcu_fd_sc_mcu7t5v0__fillcap_4
XFILLER_178_885 VDD VSS VDD VSS gf180mcu_fd_sc_mcu7t5v0__fillcap_4
XFILLER_165_535 VDD VSS VDD VSS gf180mcu_fd_sc_mcu7t5v0__fillcap_4
XFILLER_118_451 VDD VSS VDD VSS gf180mcu_fd_sc_mcu7t5v0__fillcap_4
XFILLER_192_387 VDD VSS VDD VSS gf180mcu_fd_sc_mcu7t5v0__fillcap_16
XFILLER_3_206 VDD VSS VDD VSS gf180mcu_fd_sc_mcu7t5v0__fillcap_4
XFILLER_193_39 VDD VSS VDD VSS gf180mcu_fd_sc_mcu7t5v0__fillcap_16
XFILLER_160_240 VDD VSS VDD VSS gf180mcu_fd_sc_mcu7t5v0__fillcap_4
XFILLER_105_156 VDD VSS VDD VSS gf180mcu_fd_sc_mcu7t5v0__fillcap_8
XFILLER_248_801 VDD VSS VDD VSS gf180mcu_fd_sc_mcu7t5v0__fillcap_4
XFILLER_86_37 VDD VSS VDD VSS gf180mcu_fd_sc_mcu7t5v0__fillcap_16
XFILLER_126_99 VDD VSS VDD VSS gf180mcu_fd_sc_mcu7t5v0__fillcap_4
XFILLER_102_885 VDD VSS VDD VSS gf180mcu_fd_sc_mcu7t5v0__fillcap_4
XFILLER_59_276 VDD VSS VDD VSS gf180mcu_fd_sc_mcu7t5v0__fillcap_4
XFILLER_47_416 VDD VSS VDD VSS gf180mcu_fd_sc_mcu7t5v0__fillcap_4
XFILLER_216_731 VDD VSS VDD VSS gf180mcu_fd_sc_mcu7t5v0__fillcap_4
XFILLER_228_591 VDD VSS VDD VSS gf180mcu_fd_sc_mcu7t5v0__fillcap_4
XFILLER_203_414 VDD VSS VDD VSS gf180mcu_fd_sc_mcu7t5v0__fillcap_4
XFILLER_255_2 VDD VSS VDD VSS gf180mcu_fd_sc_mcu7t5v0__fillcap_64
XFILLER_15_346 VDD VSS VDD VSS gf180mcu_fd_sc_mcu7t5v0__fillcap_4
Xclkbuf_leaf_63_clk_i clkload8/I VSS VDD clkbuf_3_0__f_clk_i/Z VDD VSS gf180mcu_fd_sc_mcu7t5v0__clkbuf_2
XFILLER_196_660 VDD VSS VDD VSS gf180mcu_fd_sc_mcu7t5v0__fillcap_4
XFILLER_169_874 VDD VSS VDD VSS gf180mcu_fd_sc_mcu7t5v0__fillcap_16
XFILLER_184_877 VDD VSS VDD VSS gf180mcu_fd_sc_mcu7t5v0__fillcap_8
XFILLER_7_556 VDD VSS VDD VSS gf180mcu_fd_sc_mcu7t5v0__fillcap_4
Xclkbuf_leaf_78_clk_i _3274_/CLK VSS VDD clkload0/I VDD VSS gf180mcu_fd_sc_mcu7t5v0__clkbuf_2
XFILLER_167_84 VDD VSS VDD VSS gf180mcu_fd_sc_mcu7t5v0__fillcap_4
XFILLER_238_311 VDD VSS VDD VSS gf180mcu_fd_sc_mcu7t5v0__fillcap_4
X_2170_ VDD VSS _2171_/A2 _3137_/Q _2168_/C VDD VSS gf180mcu_fd_sc_mcu7t5v0__nand2_1
Xclkbuf_leaf_16_clk_i _3166_/CLK VSS VDD clkload3/I VDD VSS gf180mcu_fd_sc_mcu7t5v0__clkbuf_2
XFILLER_219_591 VDD VSS VDD VSS gf180mcu_fd_sc_mcu7t5v0__fillcap_8
XFILLER_19_696 VDD VSS VDD VSS gf180mcu_fd_sc_mcu7t5v0__fillcap_4
XFILLER_206_296 VDD VSS VDD VSS gf180mcu_fd_sc_mcu7t5v0__fillcap_16
X_1954_ _1954_/S VDD VSS _3004_/D _3004_/Q wire113/Z VDD VSS gf180mcu_fd_sc_mcu7t5v0__mux2_2
X_1885_ _1887_/S VDD VSS _2946_/D _2946_/Q _2287_/I0 VDD VSS gf180mcu_fd_sc_mcu7t5v0__mux2_2
XFILLER_174_387 VDD VSS VDD VSS gf180mcu_fd_sc_mcu7t5v0__fillcap_64
XFILLER_162_527 VDD VSS VDD VSS gf180mcu_fd_sc_mcu7t5v0__fillcap_16
XFILLER_142_262 VDD VSS VDD VSS gf180mcu_fd_sc_mcu7t5v0__fillcap_16
X_2506_ VSS VDD _3336_/Q _2517_/C1 _3328_/Q _2554_/A2 _1640_/I _3312_/Q _2507_/A3
+ VDD VSS gf180mcu_fd_sc_mcu7t5v0__aoi222_1
XFILLER_130_435 VDD VSS VDD VSS gf180mcu_fd_sc_mcu7t5v0__fillcap_16
X_2437_ VDD _2437_/B _1654_/Z _2438_/A2 _3200_/Q VSS VDD VSS gf180mcu_fd_sc_mcu7t5v0__oai21_1
XFILLER_130_457 VDD VSS VDD VSS gf180mcu_fd_sc_mcu7t5v0__fillcap_16
X_2368_ VDD VSS _2381_/B _3197_/Q _2467_/A1 VDD VSS gf180mcu_fd_sc_mcu7t5v0__nand2_1
XFILLER_29_416 VDD VSS VDD VSS gf180mcu_fd_sc_mcu7t5v0__fillcap_4
X_2299_ VDD VSS _2303_/A2 _3200_/Q _3098_/Q VDD VSS gf180mcu_fd_sc_mcu7t5v0__xnor2_1
XFILLER_260_807 VDD VSS VDD VSS gf180mcu_fd_sc_mcu7t5v0__fillcap_64
XFILLER_240_597 VDD VSS VDD VSS gf180mcu_fd_sc_mcu7t5v0__fillcap_64
XFILLER_138_502 VDD VSS VDD VSS gf180mcu_fd_sc_mcu7t5v0__fillcap_4
XFILLER_177_170 VDD VSS VDD VSS gf180mcu_fd_sc_mcu7t5v0__fillcap_16
XFILLER_166_877 VDD VSS VDD VSS gf180mcu_fd_sc_mcu7t5v0__fillcap_8
XFILLER_126_708 VDD VSS VDD VSS gf180mcu_fd_sc_mcu7t5v0__fillcap_16
XFILLER_181_836 VDD VSS VDD VSS gf180mcu_fd_sc_mcu7t5v0__fillcap_4
XFILLER_121_413 VDD VSS VDD VSS gf180mcu_fd_sc_mcu7t5v0__fillcap_4
XFILLER_262_177 VDD VSS VDD VSS gf180mcu_fd_sc_mcu7t5v0__fillcap_64
XFILLER_250_317 VDD VSS VDD VSS gf180mcu_fd_sc_mcu7t5v0__fillcap_64
XFILLER_71_772 VDD VSS VDD VSS gf180mcu_fd_sc_mcu7t5v0__fillcap_64
XFILLER_178_50 VDD VSS VDD VSS gf180mcu_fd_sc_mcu7t5v0__fillcap_16
XFILLER_129_524 VDD VSS VDD VSS gf180mcu_fd_sc_mcu7t5v0__fillcap_8
XFILLER_156_387 VDD VSS VDD VSS gf180mcu_fd_sc_mcu7t5v0__fillcap_64
XFILLER_144_527 VDD VSS VDD VSS gf180mcu_fd_sc_mcu7t5v0__fillcap_4
X_1670_ VDD VSS _2330_/A2 _2341_/C _2803_/Q VDD VSS gf180mcu_fd_sc_mcu7t5v0__nor2_1
X_3340_ _3340_/D _3340_/Q wire165/I VSS _3340_/CLK VDD VDD VSS gf180mcu_fd_sc_mcu7t5v0__dffrnq_1
X_3271_ _3271_/D _3271_/Q wire145/Z VSS _3320_/CLK VDD VDD VSS gf180mcu_fd_sc_mcu7t5v0__dffrnq_1
XFILLER_112_457 VDD VSS VDD VSS gf180mcu_fd_sc_mcu7t5v0__fillcap_8
X_2222_ _2222_/S VDD VSS _3168_/D wire89/Z _3168_/Q VDD VSS gf180mcu_fd_sc_mcu7t5v0__mux2_2
X_2153_ _2168_/B1 _3163_/Q VDD VSS _2156_/B1 _3154_/Q _2168_/A2 VDD VSS gf180mcu_fd_sc_mcu7t5v0__aoi22_1
XFILLER_16_2 VDD VSS VDD VSS gf180mcu_fd_sc_mcu7t5v0__fillcap_32
XFILLER_254_667 VDD VSS VDD VSS gf180mcu_fd_sc_mcu7t5v0__fillcap_64
XFILLER_242_807 VDD VSS VDD VSS gf180mcu_fd_sc_mcu7t5v0__fillcap_64
XFILLER_93_352 VDD VSS VDD VSS gf180mcu_fd_sc_mcu7t5v0__fillcap_8
X_2084_ VDD VSS _3103_/D _2087_/A2 _2084_/A2 VDD VSS gf180mcu_fd_sc_mcu7t5v0__and2_1
XFILLER_210_737 VDD VSS VDD VSS gf180mcu_fd_sc_mcu7t5v0__fillcap_64
XFILLER_222_586 VDD VSS VDD VSS gf180mcu_fd_sc_mcu7t5v0__fillcap_8
XFILLER_61_282 VDD VSS VDD VSS gf180mcu_fd_sc_mcu7t5v0__fillcap_64
Xmax_length38 VSS _2739_/S _2749_/C VDD VDD VSS gf180mcu_fd_sc_mcu7t5v0__buf_3
X_2986_ VDD _2986_/Q _2994_/CLK VSS _2986_/D VDD VSS gf180mcu_fd_sc_mcu7t5v0__dffq_1
Xmax_length49 _2625_/S _2619_/S VDD VSS VDD VSS gf180mcu_fd_sc_mcu7t5v0__buf_4
XFILLER_148_877 VDD VSS VDD VSS gf180mcu_fd_sc_mcu7t5v0__fillcap_8
X_1937_ _1942_/S VDD VSS _2989_/D _2011_/I0 _2989_/Q VDD VSS gf180mcu_fd_sc_mcu7t5v0__mux2_2
XFILLER_175_696 VDD VSS VDD VSS gf180mcu_fd_sc_mcu7t5v0__fillcap_4
XFILLER_163_836 VDD VSS VDD VSS gf180mcu_fd_sc_mcu7t5v0__fillcap_4
X_1868_ _1869_/S VDD VSS _2931_/D wire128/Z _2931_/Q VDD VSS gf180mcu_fd_sc_mcu7t5v0__mux2_2
XFILLER_128_590 VDD VSS VDD VSS gf180mcu_fd_sc_mcu7t5v0__fillcap_4
X_1799_ _1805_/S VDD VSS _2870_/D _1863_/I0 _2870_/Q VDD VSS gf180mcu_fd_sc_mcu7t5v0__mux2_2
XFILLER_89_625 VDD VSS VDD VSS gf180mcu_fd_sc_mcu7t5v0__fillcap_4
XFILLER_130_276 VDD VSS VDD VSS gf180mcu_fd_sc_mcu7t5v0__fillcap_32
XFILLER_85_842 VDD VSS VDD VSS gf180mcu_fd_sc_mcu7t5v0__fillcap_32
XFILLER_123_45 VDD VSS VDD VSS gf180mcu_fd_sc_mcu7t5v0__fillcap_4
XFILLER_83_38 VDD VSS VDD VSS gf180mcu_fd_sc_mcu7t5v0__fillcap_32
XFILLER_244_177 VDD VSS VDD VSS gf180mcu_fd_sc_mcu7t5v0__fillcap_64
XFILLER_232_317 VDD VSS VDD VSS gf180mcu_fd_sc_mcu7t5v0__fillcap_64
XFILLER_53_772 VDD VSS VDD VSS gf180mcu_fd_sc_mcu7t5v0__fillcap_64
XFILLER_80_591 VDD VSS VDD VSS gf180mcu_fd_sc_mcu7t5v0__fillcap_4
XFILLER_185_438 VDD VSS VDD VSS gf180mcu_fd_sc_mcu7t5v0__fillcap_8
XFILLER_185_416 VDD VSS VDD VSS gf180mcu_fd_sc_mcu7t5v0__fillcap_4
XFILLER_218_2 VDD VSS VDD VSS gf180mcu_fd_sc_mcu7t5v0__fillcap_32
XFILLER_120_2 VDD VSS VDD VSS gf180mcu_fd_sc_mcu7t5v0__fillcap_8
XFILLER_141_508 VDD VSS VDD VSS gf180mcu_fd_sc_mcu7t5v0__fillcap_4
XFILLER_180_187 VDD VSS VDD VSS gf180mcu_fd_sc_mcu7t5v0__fillcap_16
XFILLER_94_116 VDD VSS VDD VSS gf180mcu_fd_sc_mcu7t5v0__fillcap_16
XFILLER_57_61 VDD VSS VDD VSS gf180mcu_fd_sc_mcu7t5v0__fillcap_8
XFILLER_208_325 VDD VSS VDD VSS gf180mcu_fd_sc_mcu7t5v0__fillcap_4
XFILLER_75_352 VDD VSS VDD VSS gf180mcu_fd_sc_mcu7t5v0__fillcap_64
XFILLER_75_341 VDD VSS VDD VSS gf180mcu_fd_sc_mcu7t5v0__fillcap_8
XFILLER_57_72 VDD VSS VDD VSS gf180mcu_fd_sc_mcu7t5v0__fillcap_64
XFILLER_236_667 VDD VSS VDD VSS gf180mcu_fd_sc_mcu7t5v0__fillcap_64
XFILLER_224_807 VDD VSS VDD VSS gf180mcu_fd_sc_mcu7t5v0__fillcap_64
XFILLER_251_626 VDD VSS VDD VSS gf180mcu_fd_sc_mcu7t5v0__fillcap_4
XFILLER_263_486 VDD VSS VDD VSS gf180mcu_fd_sc_mcu7t5v0__fillcap_4
XFILLER_223_328 VDD VSS VDD VSS gf180mcu_fd_sc_mcu7t5v0__fillcap_4
XFILLER_31_422 VDD VSS VDD VSS gf180mcu_fd_sc_mcu7t5v0__fillcap_64
X_2840_ VDD _2840_/Q _3369_/CLK VSS _2840_/D VDD VSS gf180mcu_fd_sc_mcu7t5v0__dffq_1
XFILLER_43_282 VDD VSS VDD VSS gf180mcu_fd_sc_mcu7t5v0__fillcap_64
XFILLER_148_107 VDD VSS VDD VSS gf180mcu_fd_sc_mcu7t5v0__fillcap_16
Xspi_opentarget_i3c_top_182 rst_ni_PU VDD VSS VDD VSS gf180mcu_fd_sc_mcu7t5v0__tiel
Xspi_opentarget_i3c_top_171 clk_i_PU VDD VSS VDD VSS gf180mcu_fd_sc_mcu7t5v0__tiel
X_2771_ wire19/Z _3079_/Q VDD VSS _2772_/A2 _3327_/Q wire37/Z VDD VSS gf180mcu_fd_sc_mcu7t5v0__aoi22_1
X_1722_ _1728_/S VDD VSS _2806_/D _2806_/Q _3120_/Q VDD VSS gf180mcu_fd_sc_mcu7t5v0__mux2_2
XFILLER_157_696 VDD VSS VDD VSS gf180mcu_fd_sc_mcu7t5v0__fillcap_4
XFILLER_145_836 VDD VSS VDD VSS gf180mcu_fd_sc_mcu7t5v0__fillcap_4
Xspi_opentarget_i3c_top_193 spi_miso_o_CS VDD VSS VDD VSS gf180mcu_fd_sc_mcu7t5v0__tiel
X_1653_ VDD VSS _2238_/A1 _2804_/Q _1654_/A3 VDD VSS gf180mcu_fd_sc_mcu7t5v0__nand2_1
XFILLER_171_198 VDD VSS VDD VSS gf180mcu_fd_sc_mcu7t5v0__fillcap_8
X_1584_ VDD VSS _1591_/A2 _3347_/Q _2470_/B VDD VSS gf180mcu_fd_sc_mcu7t5v0__nand2_1
X_3323_ _3323_/D _3323_/Q _3336_/RN VSS _3336_/CLK VDD VDD VSS gf180mcu_fd_sc_mcu7t5v0__dffrnq_1
XFILLER_113_766 VDD VSS VDD VSS gf180mcu_fd_sc_mcu7t5v0__fillcap_4
XFILLER_258_247 VDD VSS VDD VSS gf180mcu_fd_sc_mcu7t5v0__fillcap_64
XFILLER_224_44 VDD VSS VDD VSS gf180mcu_fd_sc_mcu7t5v0__fillcap_16
X_3254_ _3254_/D _3254_/Q _3339_/RN VSS _3328_/CLK VDD VDD VSS gf180mcu_fd_sc_mcu7t5v0__dffrnq_1
X_2205_ _2205_/A3 _2205_/A4 VDD VSS _2222_/S _3271_/Q _3270_/Q VDD VSS gf180mcu_fd_sc_mcu7t5v0__nand4_1
XFILLER_67_842 VDD VSS VDD VSS gf180mcu_fd_sc_mcu7t5v0__fillcap_32
X_3185_ _3185_/D _3185_/Q wire151/Z VSS _3185_/CLK VDD VDD VSS gf180mcu_fd_sc_mcu7t5v0__dffrnq_1
XFILLER_82_801 VDD VSS VDD VSS gf180mcu_fd_sc_mcu7t5v0__fillcap_4
XFILLER_199_508 VDD VSS VDD VSS gf180mcu_fd_sc_mcu7t5v0__fillcap_8
XFILLER_240_10 VDD VSS VDD VSS gf180mcu_fd_sc_mcu7t5v0__fillcap_16
X_2136_ _2138_/S VDD VSS _3124_/D wire91/Z _3124_/Q VDD VSS gf180mcu_fd_sc_mcu7t5v0__mux2_2
XFILLER_226_177 VDD VSS VDD VSS gf180mcu_fd_sc_mcu7t5v0__fillcap_64
XFILLER_214_317 VDD VSS VDD VSS gf180mcu_fd_sc_mcu7t5v0__fillcap_8
X_2067_ VDD VSS _2068_/B wire94/Z _2072_/S VDD VSS gf180mcu_fd_sc_mcu7t5v0__nor2_1
XFILLER_241_136 VDD VSS VDD VSS gf180mcu_fd_sc_mcu7t5v0__fillcap_4
XFILLER_35_772 VDD VSS VDD VSS gf180mcu_fd_sc_mcu7t5v0__fillcap_64
XFILLER_222_372 VDD VSS VDD VSS gf180mcu_fd_sc_mcu7t5v0__fillcap_8
XFILLER_62_591 VDD VSS VDD VSS gf180mcu_fd_sc_mcu7t5v0__fillcap_4
XFILLER_50_731 VDD VSS VDD VSS gf180mcu_fd_sc_mcu7t5v0__fillcap_4
XFILLER_167_416 VDD VSS VDD VSS gf180mcu_fd_sc_mcu7t5v0__fillcap_4
X_2969_ VDD _2969_/Q _3021_/CLK VSS _2969_/D VDD VSS gf180mcu_fd_sc_mcu7t5v0__dffq_1
XFILLER_210_578 VDD VSS VDD VSS gf180mcu_fd_sc_mcu7t5v0__fillcap_16
XFILLER_194_235 VDD VSS VDD VSS gf180mcu_fd_sc_mcu7t5v0__fillcap_8
XFILLER_108_527 VDD VSS VDD VSS gf180mcu_fd_sc_mcu7t5v0__fillcap_16
XFILLER_150_305 VDD VSS VDD VSS gf180mcu_fd_sc_mcu7t5v0__fillcap_8
XFILLER_135_368 VDD VSS VDD VSS gf180mcu_fd_sc_mcu7t5v0__fillcap_8
XFILLER_135_346 VDD VSS VDD VSS gf180mcu_fd_sc_mcu7t5v0__fillcap_4
XFILLER_134_77 VDD VSS VDD VSS gf180mcu_fd_sc_mcu7t5v0__fillcap_16
XFILLER_57_352 VDD VSS VDD VSS gf180mcu_fd_sc_mcu7t5v0__fillcap_64
XFILLER_94_37 VDD VSS VDD VSS gf180mcu_fd_sc_mcu7t5v0__fillcap_64
XFILLER_218_667 VDD VSS VDD VSS gf180mcu_fd_sc_mcu7t5v0__fillcap_64
XFILLER_206_807 VDD VSS VDD VSS gf180mcu_fd_sc_mcu7t5v0__fillcap_64
XFILLER_91_119 VDD VSS VDD VSS gf180mcu_fd_sc_mcu7t5v0__fillcap_4
XFILLER_84_171 VDD VSS VDD VSS gf180mcu_fd_sc_mcu7t5v0__fillcap_4
XFILLER_245_486 VDD VSS VDD VSS gf180mcu_fd_sc_mcu7t5v0__fillcap_4
XFILLER_233_626 VDD VSS VDD VSS gf180mcu_fd_sc_mcu7t5v0__fillcap_4
XFILLER_168_2 VDD VSS VDD VSS gf180mcu_fd_sc_mcu7t5v0__fillcap_32
XFILLER_13_422 VDD VSS VDD VSS gf180mcu_fd_sc_mcu7t5v0__fillcap_64
XFILLER_25_282 VDD VSS VDD VSS gf180mcu_fd_sc_mcu7t5v0__fillcap_64
XFILLER_40_241 VDD VSS VDD VSS gf180mcu_fd_sc_mcu7t5v0__fillcap_4
XFILLER_201_578 VDD VSS VDD VSS gf180mcu_fd_sc_mcu7t5v0__fillcap_4
XFILLER_158_449 VDD VSS VDD VSS gf180mcu_fd_sc_mcu7t5v0__fillcap_4
XFILLER_127_836 VDD VSS VDD VSS gf180mcu_fd_sc_mcu7t5v0__fillcap_4
XFILLER_5_632 VDD VSS VDD VSS gf180mcu_fd_sc_mcu7t5v0__fillcap_64
XFILLER_114_508 VDD VSS VDD VSS gf180mcu_fd_sc_mcu7t5v0__fillcap_16
XFILLER_268_512 VDD VSS VDD VSS gf180mcu_fd_sc_mcu7t5v0__fillcap_32
XFILLER_255_206 VDD VSS VDD VSS gf180mcu_fd_sc_mcu7t5v0__fillcap_4
XFILLER_191_72 VDD VSS VDD VSS gf180mcu_fd_sc_mcu7t5v0__fillcap_4
XFILLER_49_842 VDD VSS VDD VSS gf180mcu_fd_sc_mcu7t5v0__fillcap_32
XFILLER_76_661 VDD VSS VDD VSS gf180mcu_fd_sc_mcu7t5v0__fillcap_4
XFILLER_64_801 VDD VSS VDD VSS gf180mcu_fd_sc_mcu7t5v0__fillcap_4
XFILLER_223_114 VDD VSS VDD VSS gf180mcu_fd_sc_mcu7t5v0__fillcap_16
XFILLER_17_772 VDD VSS VDD VSS gf180mcu_fd_sc_mcu7t5v0__fillcap_64
XFILLER_44_591 VDD VSS VDD VSS gf180mcu_fd_sc_mcu7t5v0__fillcap_4
XFILLER_32_731 VDD VSS VDD VSS gf180mcu_fd_sc_mcu7t5v0__fillcap_4
X_2823_ VDD _2823_/Q _3405_/CLK VSS _2823_/D VDD VSS gf180mcu_fd_sc_mcu7t5v0__dffq_1
X_2754_ VDD VSS _2754_/I _3319_/D VDD VSS gf180mcu_fd_sc_mcu7t5v0__clkinv_1
XFILLER_219_55 VDD VSS VDD VSS gf180mcu_fd_sc_mcu7t5v0__fillcap_8
X_1705_ VDD VSS _1706_/A4 _1673_/B _2278_/A2 VDD VSS gf180mcu_fd_sc_mcu7t5v0__nand2_1
XFILLER_172_441 VDD VSS VDD VSS gf180mcu_fd_sc_mcu7t5v0__fillcap_8
X_2685_ VDD VSS _2690_/A1 _2724_/C _2684_/Z VDD VSS gf180mcu_fd_sc_mcu7t5v0__nand2_1
X_1636_ _1636_/B VDD VSS _3350_/D _3128_/Q _3364_/Q VDD VSS gf180mcu_fd_sc_mcu7t5v0__aoi21_1
X_1567_ _1568_/A1 _1569_/A4 VDD VSS _2146_/A3 _3142_/Q _3145_/Q VDD VSS gf180mcu_fd_sc_mcu7t5v0__nand4_1
XFILLER_259_556 VDD VSS VDD VSS gf180mcu_fd_sc_mcu7t5v0__fillcap_4
X_3306_ _3306_/D _3306_/Q _3335_/RN VSS _3446_/CLK VDD VDD VSS gf180mcu_fd_sc_mcu7t5v0__dffrnq_1
X_1498_ VDD VSS _1739_/A2 _3367_/Q _1497_/I VDD VSS gf180mcu_fd_sc_mcu7t5v0__nand2_1
X_3237_ _3237_/D _3237_/Q _3452_/RN VSS _3281_/CLK VDD VDD VSS gf180mcu_fd_sc_mcu7t5v0__dffrnq_1
XFILLER_39_352 VDD VSS VDD VSS gf180mcu_fd_sc_mcu7t5v0__fillcap_64
X_3168_ _3168_/D _3168_/Q wire147/I VSS _3348_/CLK VDD VDD VSS gf180mcu_fd_sc_mcu7t5v0__dffrnq_1
XFILLER_54_311 VDD VSS VDD VSS gf180mcu_fd_sc_mcu7t5v0__fillcap_4
XFILLER_66_171 VDD VSS VDD VSS gf180mcu_fd_sc_mcu7t5v0__fillcap_4
XFILLER_227_486 VDD VSS VDD VSS gf180mcu_fd_sc_mcu7t5v0__fillcap_4
XFILLER_215_626 VDD VSS VDD VSS gf180mcu_fd_sc_mcu7t5v0__fillcap_4
X_2119_ _2119_/A3 VDD VSS _2121_/A2 _3113_/Q _2074_/Z VDD VSS gf180mcu_fd_sc_mcu7t5v0__nand3_1
X_3099_ _3099_/D _3099_/Q wire145/Z VSS _3341_/CLK VDD VDD VSS gf180mcu_fd_sc_mcu7t5v0__dffrnq_1
XFILLER_22_241 VDD VSS VDD VSS gf180mcu_fd_sc_mcu7t5v0__fillcap_4
XFILLER_13_66 VDD VSS VDD VSS gf180mcu_fd_sc_mcu7t5v0__fillcap_4
XFILLER_109_836 VDD VSS VDD VSS gf180mcu_fd_sc_mcu7t5v0__fillcap_4
XFILLER_191_772 VDD VSS VDD VSS gf180mcu_fd_sc_mcu7t5v0__fillcap_64
XFILLER_89_48 VDD VSS VDD VSS gf180mcu_fd_sc_mcu7t5v0__fillcap_8
XFILLER_135_165 VDD VSS VDD VSS gf180mcu_fd_sc_mcu7t5v0__fillcap_4
XFILLER_108_379 VDD VSS VDD VSS gf180mcu_fd_sc_mcu7t5v0__fillcap_4
XFILLER_145_87 VDD VSS VDD VSS gf180mcu_fd_sc_mcu7t5v0__fillcap_32
XFILLER_145_65 VDD VSS VDD VSS gf180mcu_fd_sc_mcu7t5v0__fillcap_4
XFILLER_131_360 VDD VSS VDD VSS gf180mcu_fd_sc_mcu7t5v0__fillcap_4
XFILLER_237_206 VDD VSS VDD VSS gf180mcu_fd_sc_mcu7t5v0__fillcap_4
XFILLER_58_661 VDD VSS VDD VSS gf180mcu_fd_sc_mcu7t5v0__fillcap_4
XFILLER_46_801 VDD VSS VDD VSS gf180mcu_fd_sc_mcu7t5v0__fillcap_4
XFILLER_205_158 VDD VSS VDD VSS gf180mcu_fd_sc_mcu7t5v0__fillcap_8
XFILLER_26_591 VDD VSS VDD VSS gf180mcu_fd_sc_mcu7t5v0__fillcap_4
XFILLER_14_731 VDD VSS VDD VSS gf180mcu_fd_sc_mcu7t5v0__fillcap_4
XFILLER_9_212 VDD VSS VDD VSS gf180mcu_fd_sc_mcu7t5v0__fillcap_64
XFILLER_139_471 VDD VSS VDD VSS gf180mcu_fd_sc_mcu7t5v0__fillcap_16
Xclkload26 VSS clkload26/Z _3462_/CLK VDD VDD VSS gf180mcu_fd_sc_mcu7t5v0__clkbuf_1
Xclkload15 VDD VSS _3450_/CLK clkload15/ZN VDD VSS gf180mcu_fd_sc_mcu7t5v0__clkinv_2
Xclkload59 VSS clkload59/Z _3192_/CLK VDD VDD VSS gf180mcu_fd_sc_mcu7t5v0__clkbuf_1
Xclkload48 VSS clkload48/Z _3279_/CLK VDD VDD VSS gf180mcu_fd_sc_mcu7t5v0__clkbuf_1
Xclkload37 VSS clkload37/Z _3022_/CLK VDD VDD VSS gf180mcu_fd_sc_mcu7t5v0__clkbuf_1
X_2470_ VDD _2470_/B _2470_/A2 _2471_/A2 _2486_/B VSS VDD VSS gf180mcu_fd_sc_mcu7t5v0__oai21_1
XFILLER_142_658 VDD VSS VDD VSS gf180mcu_fd_sc_mcu7t5v0__fillcap_4
X_1421_ VDD VSS _3349_/Q _2186_/A1 VDD VSS gf180mcu_fd_sc_mcu7t5v0__clkinv_1
XFILLER_181_282 VDD VSS VDD VSS gf180mcu_fd_sc_mcu7t5v0__fillcap_16
XFILLER_79_81 VDD VSS VDD VSS gf180mcu_fd_sc_mcu7t5v0__fillcap_16
XFILLER_268_342 VDD VSS VDD VSS gf180mcu_fd_sc_mcu7t5v0__fillcap_32
XFILLER_150_680 VDD VSS VDD VSS gf180mcu_fd_sc_mcu7t5v0__fillcap_8
XFILLER_205_79 VDD VSS VDD VSS gf180mcu_fd_sc_mcu7t5v0__fillcap_32
X_3022_ VDD _3022_/Q _3022_/CLK VSS _3022_/D VDD VSS gf180mcu_fd_sc_mcu7t5v0__dffq_1
XFILLER_36_311 VDD VSS VDD VSS gf180mcu_fd_sc_mcu7t5v0__fillcap_4
XFILLER_48_171 VDD VSS VDD VSS gf180mcu_fd_sc_mcu7t5v0__fillcap_4
XFILLER_205_681 VDD VSS VDD VSS gf180mcu_fd_sc_mcu7t5v0__fillcap_16
XFILLER_220_640 VDD VSS VDD VSS gf180mcu_fd_sc_mcu7t5v0__fillcap_16
Xclkload9 VSS clkload9/Z clkload9/I VDD VDD VSS gf180mcu_fd_sc_mcu7t5v0__clkbuf_1
X_2806_ VDD _2806_/Q _2867_/CLK VSS _2806_/D VDD VSS gf180mcu_fd_sc_mcu7t5v0__dffq_1
XFILLER_157_290 VDD VSS VDD VSS gf180mcu_fd_sc_mcu7t5v0__fillcap_16
X_2737_ _3100_/Q _2737_/C VDD VSS _2738_/B1 _3068_/Q _2026_/Z _2061_/Z VDD VSS gf180mcu_fd_sc_mcu7t5v0__aoi221_1
XFILLER_173_772 VDD VSS VDD VSS gf180mcu_fd_sc_mcu7t5v0__fillcap_64
XFILLER_160_411 VDD VSS VDD VSS gf180mcu_fd_sc_mcu7t5v0__fillcap_8
X_2668_ VDD VSS _2668_/Z _2061_/Z _2758_/A2 VDD VSS gf180mcu_fd_sc_mcu7t5v0__and2_1
XFILLER_105_305 VDD VSS VDD VSS gf180mcu_fd_sc_mcu7t5v0__fillcap_4
XFILLER_118_699 VDD VSS VDD VSS gf180mcu_fd_sc_mcu7t5v0__fillcap_32
X_1619_ _1619_/A3 VDD VSS _1621_/A2 _1619_/A1 _1619_/A2 VDD VSS gf180mcu_fd_sc_mcu7t5v0__nand3_1
X_2599_ wire12/Z VDD VSS _3267_/D _3259_/Q _3267_/Q VDD VSS gf180mcu_fd_sc_mcu7t5v0__mux2_2
XFILLER_28_801 VDD VSS VDD VSS gf180mcu_fd_sc_mcu7t5v0__fillcap_4
XFILLER_70_667 VDD VSS VDD VSS gf180mcu_fd_sc_mcu7t5v0__fillcap_64
Xclkbuf_4_0_0_host_clk_i _2867_/CLK VSS VDD clkbuf_0_host_clk_i/Z VDD VSS gf180mcu_fd_sc_mcu7t5v0__clkbuf_2
XFILLER_195_352 VDD VSS VDD VSS gf180mcu_fd_sc_mcu7t5v0__fillcap_16
XFILLER_210_183 VDD VSS VDD VSS gf180mcu_fd_sc_mcu7t5v0__fillcap_32
XFILLER_109_622 VDD VSS VDD VSS gf180mcu_fd_sc_mcu7t5v0__fillcap_8
XFILLER_156_97 VDD VSS VDD VSS gf180mcu_fd_sc_mcu7t5v0__fillcap_8
XFILLER_151_422 VDD VSS VDD VSS gf180mcu_fd_sc_mcu7t5v0__fillcap_16
XFILLER_92_247 VDD VSS VDD VSS gf180mcu_fd_sc_mcu7t5v0__fillcap_64
XFILLER_18_311 VDD VSS VDD VSS gf180mcu_fd_sc_mcu7t5v0__fillcap_4
XFILLER_65_72 VDD VSS VDD VSS gf180mcu_fd_sc_mcu7t5v0__fillcap_64
XFILLER_261_562 VDD VSS VDD VSS gf180mcu_fd_sc_mcu7t5v0__fillcap_64
X_1970_ _1972_/S VDD VSS _3018_/D wire116/Z _3018_/Q VDD VSS gf180mcu_fd_sc_mcu7t5v0__mux2_2
XFILLER_187_842 VDD VSS VDD VSS gf180mcu_fd_sc_mcu7t5v0__fillcap_32
XFILLER_199_691 VDD VSS VDD VSS gf180mcu_fd_sc_mcu7t5v0__fillcap_8
XFILLER_60_177 VDD VSS VDD VSS gf180mcu_fd_sc_mcu7t5v0__fillcap_64
XFILLER_155_772 VDD VSS VDD VSS gf180mcu_fd_sc_mcu7t5v0__fillcap_64
X_2522_ _2525_/B1 _3322_/Q VDD VSS _2526_/A2 _3330_/Q _2554_/A2 VDD VSS gf180mcu_fd_sc_mcu7t5v0__aoi22_1
XFILLER_170_731 VDD VSS VDD VSS gf180mcu_fd_sc_mcu7t5v0__fillcap_4
X_2453_ VDD VSS _2467_/B _3203_/Q _2467_/A1 VDD VSS gf180mcu_fd_sc_mcu7t5v0__nand2_1
XFILLER_46_2 VDD VSS VDD VSS gf180mcu_fd_sc_mcu7t5v0__fillcap_32
X_2384_ VDD VSS _2387_/A2 _2459_/A1 _2383_/Z VDD VSS gf180mcu_fd_sc_mcu7t5v0__nand2_1
X_1404_ VDD VSS _3209_/Q _2483_/A1 VDD VSS gf180mcu_fd_sc_mcu7t5v0__clkinv_1
XFILLER_268_172 VDD VSS VDD VSS gf180mcu_fd_sc_mcu7t5v0__fillcap_32
XFILLER_96_542 VDD VSS VDD VSS gf180mcu_fd_sc_mcu7t5v0__fillcap_4
XFILLER_111_842 VDD VSS VDD VSS gf180mcu_fd_sc_mcu7t5v0__fillcap_32
Xinput2 VDD scl_pad_i VSS input2/Z VDD VSS gf180mcu_fd_sc_mcu7t5v0__dlyb_1
XFILLER_84_737 VDD VSS VDD VSS gf180mcu_fd_sc_mcu7t5v0__fillcap_64
X_3005_ VDD _3005_/Q _3005_/CLK VSS _3005_/D VDD VSS gf180mcu_fd_sc_mcu7t5v0__dffq_1
XFILLER_40_807 VDD VSS VDD VSS gf180mcu_fd_sc_mcu7t5v0__fillcap_64
XFILLER_52_667 VDD VSS VDD VSS gf180mcu_fd_sc_mcu7t5v0__fillcap_64
XFILLER_220_481 VDD VSS VDD VSS gf180mcu_fd_sc_mcu7t5v0__fillcap_4
XFILLER_20_597 VDD VSS VDD VSS gf180mcu_fd_sc_mcu7t5v0__fillcap_64
XFILLER_133_400 VDD VSS VDD VSS gf180mcu_fd_sc_mcu7t5v0__fillcap_8
XFILLER_133_422 VDD VSS VDD VSS gf180mcu_fd_sc_mcu7t5v0__fillcap_32
XFILLER_145_282 VDD VSS VDD VSS gf180mcu_fd_sc_mcu7t5v0__fillcap_8
XFILLER_101_352 VDD VSS VDD VSS gf180mcu_fd_sc_mcu7t5v0__fillcap_64
XFILLER_142_99 VDD VSS VDD VSS gf180mcu_fd_sc_mcu7t5v0__fillcap_4
XFILLER_231_702 VDD VSS VDD VSS gf180mcu_fd_sc_mcu7t5v0__fillcap_64
XFILLER_243_562 VDD VSS VDD VSS gf180mcu_fd_sc_mcu7t5v0__fillcap_64
XFILLER_169_842 VDD VSS VDD VSS gf180mcu_fd_sc_mcu7t5v0__fillcap_32
XFILLER_248_2 VDD VSS VDD VSS gf180mcu_fd_sc_mcu7t5v0__fillcap_32
XFILLER_42_177 VDD VSS VDD VSS gf180mcu_fd_sc_mcu7t5v0__fillcap_64
XFILLER_30_317 VDD VSS VDD VSS gf180mcu_fd_sc_mcu7t5v0__fillcap_64
XFILLER_184_801 VDD VSS VDD VSS gf180mcu_fd_sc_mcu7t5v0__fillcap_4
XFILLER_168_341 VDD VSS VDD VSS gf180mcu_fd_sc_mcu7t5v0__fillcap_4
XFILLER_211_492 VDD VSS VDD VSS gf180mcu_fd_sc_mcu7t5v0__fillcap_32
XFILLER_183_333 VDD VSS VDD VSS gf180mcu_fd_sc_mcu7t5v0__fillcap_16
XFILLER_128_238 VDD VSS VDD VSS gf180mcu_fd_sc_mcu7t5v0__fillcap_4
XFILLER_137_772 VDD VSS VDD VSS gf180mcu_fd_sc_mcu7t5v0__fillcap_64
XFILLER_98_807 VDD VSS VDD VSS gf180mcu_fd_sc_mcu7t5v0__fillcap_64
XFILLER_111_127 VDD VSS VDD VSS gf180mcu_fd_sc_mcu7t5v0__fillcap_8
XFILLER_265_142 VDD VSS VDD VSS gf180mcu_fd_sc_mcu7t5v0__fillcap_64
XFILLER_66_737 VDD VSS VDD VSS gf180mcu_fd_sc_mcu7t5v0__fillcap_64
XFILLER_78_597 VDD VSS VDD VSS gf180mcu_fd_sc_mcu7t5v0__fillcap_64
XFILLER_120_661 VDD VSS VDD VSS gf180mcu_fd_sc_mcu7t5v0__fillcap_4
XFILLER_93_556 VDD VSS VDD VSS gf180mcu_fd_sc_mcu7t5v0__fillcap_4
Xclkbuf_3_2__f_clk_i VDD VSS clkload1/I clkbuf_0_clk_i/Z VDD VSS gf180mcu_fd_sc_mcu7t5v0__clkbuf_16
XFILLER_206_220 VDD VSS VDD VSS gf180mcu_fd_sc_mcu7t5v0__fillcap_8
XFILLER_262_871 VDD VSS VDD VSS gf180mcu_fd_sc_mcu7t5v0__fillcap_4
XFILLER_221_212 VDD VSS VDD VSS gf180mcu_fd_sc_mcu7t5v0__fillcap_64
XFILLER_22_807 VDD VSS VDD VSS gf180mcu_fd_sc_mcu7t5v0__fillcap_64
XFILLER_34_667 VDD VSS VDD VSS gf180mcu_fd_sc_mcu7t5v0__fillcap_64
XFILLER_61_486 VDD VSS VDD VSS gf180mcu_fd_sc_mcu7t5v0__fillcap_4
XFILLER_159_352 VDD VSS VDD VSS gf180mcu_fd_sc_mcu7t5v0__fillcap_16
X_1953_ _1954_/S VDD VSS _3003_/D _3003_/Q wire114/Z VDD VSS gf180mcu_fd_sc_mcu7t5v0__mux2_2
X_1884_ _1887_/S VDD VSS _2945_/D _2945_/Q _3179_/Q VDD VSS gf180mcu_fd_sc_mcu7t5v0__mux2_2
XFILLER_127_260 VDD VSS VDD VSS gf180mcu_fd_sc_mcu7t5v0__fillcap_4
XFILLER_115_422 VDD VSS VDD VSS gf180mcu_fd_sc_mcu7t5v0__fillcap_64
XFILLER_127_282 VDD VSS VDD VSS gf180mcu_fd_sc_mcu7t5v0__fillcap_16
XFILLER_143_753 VDD VSS VDD VSS gf180mcu_fd_sc_mcu7t5v0__fillcap_16
XFILLER_227_66 VDD VSS VDD VSS gf180mcu_fd_sc_mcu7t5v0__fillcap_4
X_2505_ VDD VSS _2508_/A2 _2505_/A1 _2505_/A2 VDD VSS gf180mcu_fd_sc_mcu7t5v0__nand2_1
X_2436_ _2436_/A3 VDD VSS _2437_/B _1654_/Z _2436_/A2 VDD VSS gf180mcu_fd_sc_mcu7t5v0__nand3_1
XFILLER_257_632 VDD VSS VDD VSS gf180mcu_fd_sc_mcu7t5v0__fillcap_64
X_2367_ VDD _3196_/D _2367_/B _2469_/A1 _2367_/A2 VSS _2467_/A1 VDD VSS gf180mcu_fd_sc_mcu7t5v0__oai31_1
X_2298_ VDD VSS _2303_/A1 _3201_/Q _3099_/Q VDD VSS gf180mcu_fd_sc_mcu7t5v0__xnor2_1
XFILLER_56_247 VDD VSS VDD VSS gf180mcu_fd_sc_mcu7t5v0__fillcap_64
XFILLER_213_702 VDD VSS VDD VSS gf180mcu_fd_sc_mcu7t5v0__fillcap_64
XFILLER_225_562 VDD VSS VDD VSS gf180mcu_fd_sc_mcu7t5v0__fillcap_64
XFILLER_240_521 VDD VSS VDD VSS gf180mcu_fd_sc_mcu7t5v0__fillcap_4
XFILLER_252_381 VDD VSS VDD VSS gf180mcu_fd_sc_mcu7t5v0__fillcap_4
XFILLER_212_223 VDD VSS VDD VSS gf180mcu_fd_sc_mcu7t5v0__fillcap_16
XFILLER_24_177 VDD VSS VDD VSS gf180mcu_fd_sc_mcu7t5v0__fillcap_64
XFILLER_12_317 VDD VSS VDD VSS gf180mcu_fd_sc_mcu7t5v0__fillcap_64
XFILLER_166_801 VDD VSS VDD VSS gf180mcu_fd_sc_mcu7t5v0__fillcap_4
XFILLER_138_569 VDD VSS VDD VSS gf180mcu_fd_sc_mcu7t5v0__fillcap_4
XFILLER_119_772 VDD VSS VDD VSS gf180mcu_fd_sc_mcu7t5v0__fillcap_64
XFILLER_106_433 VDD VSS VDD VSS gf180mcu_fd_sc_mcu7t5v0__fillcap_16
XFILLER_4_527 VDD VSS VDD VSS gf180mcu_fd_sc_mcu7t5v0__fillcap_64
XFILLER_21_66 VDD VSS VDD VSS gf180mcu_fd_sc_mcu7t5v0__fillcap_4
XFILLER_97_59 VDD VSS VDD VSS gf180mcu_fd_sc_mcu7t5v0__fillcap_8
XFILLER_247_142 VDD VSS VDD VSS gf180mcu_fd_sc_mcu7t5v0__fillcap_64
XFILLER_48_737 VDD VSS VDD VSS gf180mcu_fd_sc_mcu7t5v0__fillcap_64
XFILLER_262_101 VDD VSS VDD VSS gf180mcu_fd_sc_mcu7t5v0__fillcap_4
XFILLER_90_504 VDD VSS VDD VSS gf180mcu_fd_sc_mcu7t5v0__fillcap_16
XFILLER_75_556 VDD VSS VDD VSS gf180mcu_fd_sc_mcu7t5v0__fillcap_4
XFILLER_244_871 VDD VSS VDD VSS gf180mcu_fd_sc_mcu7t5v0__fillcap_4
XFILLER_203_212 VDD VSS VDD VSS gf180mcu_fd_sc_mcu7t5v0__fillcap_64
XFILLER_16_667 VDD VSS VDD VSS gf180mcu_fd_sc_mcu7t5v0__fillcap_64
XFILLER_43_486 VDD VSS VDD VSS gf180mcu_fd_sc_mcu7t5v0__fillcap_4
XFILLER_31_626 VDD VSS VDD VSS gf180mcu_fd_sc_mcu7t5v0__fillcap_4
XFILLER_168_193 VDD VSS VDD VSS gf180mcu_fd_sc_mcu7t5v0__fillcap_8
XFILLER_184_697 VDD VSS VDD VSS gf180mcu_fd_sc_mcu7t5v0__fillcap_32
XFILLER_116_219 VDD VSS VDD VSS gf180mcu_fd_sc_mcu7t5v0__fillcap_8
XFILLER_8_877 VDD VSS VDD VSS gf180mcu_fd_sc_mcu7t5v0__fillcap_8
XFILLER_137_580 VDD VSS VDD VSS gf180mcu_fd_sc_mcu7t5v0__fillcap_4
XFILLER_183_174 VDD VSS VDD VSS gf180mcu_fd_sc_mcu7t5v0__fillcap_32
XFILLER_109_260 VDD VSS VDD VSS gf180mcu_fd_sc_mcu7t5v0__fillcap_4
XFILLER_194_94 VDD VSS VDD VSS gf180mcu_fd_sc_mcu7t5v0__fillcap_8
X_3270_ _3270_/D _3270_/Q wire145/Z VSS _3288_/CLK VDD VDD VSS gf180mcu_fd_sc_mcu7t5v0__dffrnq_1
X_2221_ _2221_/S VDD VSS _3167_/D wire90/Z _3167_/Q VDD VSS gf180mcu_fd_sc_mcu7t5v0__mux2_2
XFILLER_97_136 VDD VSS VDD VSS gf180mcu_fd_sc_mcu7t5v0__fillcap_4
XFILLER_239_632 VDD VSS VDD VSS gf180mcu_fd_sc_mcu7t5v0__fillcap_64
XFILLER_266_451 VDD VSS VDD VSS gf180mcu_fd_sc_mcu7t5v0__fillcap_4
X_2152_ _2152_/B1 _2163_/A1 VDD VSS _3130_/D _2152_/A1 _2168_/C VDD VSS gf180mcu_fd_sc_mcu7t5v0__aoi22_1
X_2083_ VDD VSS _2084_/A2 _2115_/C _2083_/A2 VDD VSS gf180mcu_fd_sc_mcu7t5v0__nor2_1
XFILLER_38_247 VDD VSS VDD VSS gf180mcu_fd_sc_mcu7t5v0__fillcap_64
XFILLER_207_562 VDD VSS VDD VSS gf180mcu_fd_sc_mcu7t5v0__fillcap_64
XFILLER_53_206 VDD VSS VDD VSS gf180mcu_fd_sc_mcu7t5v0__fillcap_4
XFILLER_234_381 VDD VSS VDD VSS gf180mcu_fd_sc_mcu7t5v0__fillcap_4
XFILLER_222_554 VDD VSS VDD VSS gf180mcu_fd_sc_mcu7t5v0__fillcap_32
XFILLER_250_885 VDD VSS VDD VSS gf180mcu_fd_sc_mcu7t5v0__fillcap_4
XFILLER_167_609 VDD VSS VDD VSS gf180mcu_fd_sc_mcu7t5v0__fillcap_16
XFILLER_148_801 VDD VSS VDD VSS gf180mcu_fd_sc_mcu7t5v0__fillcap_4
XFILLER_21_136 VDD VSS VDD VSS gf180mcu_fd_sc_mcu7t5v0__fillcap_4
Xmax_length17 _1924_/S VSS VDD _1926_/S VDD VSS gf180mcu_fd_sc_mcu7t5v0__clkbuf_3
Xmax_length39 _2749_/C wire37/I VDD VSS VDD VSS gf180mcu_fd_sc_mcu7t5v0__buf_4
X_2985_ VDD _2985_/Q _3021_/CLK VSS _2985_/D VDD VSS gf180mcu_fd_sc_mcu7t5v0__dffq_1
X_1936_ VDD VSS _1944_/S _2010_/A1 _1936_/A2 VDD VSS gf180mcu_fd_sc_mcu7t5v0__nand2_1
X_1867_ _1869_/S VDD VSS _2930_/D wire130/Z _2930_/Q VDD VSS gf180mcu_fd_sc_mcu7t5v0__mux2_2
X_1798_ _1805_/S VDD VSS _2869_/D wire137/Z _2869_/Q VDD VSS gf180mcu_fd_sc_mcu7t5v0__mux2_2
XFILLER_190_667 VDD VSS VDD VSS gf180mcu_fd_sc_mcu7t5v0__fillcap_16
XFILLER_143_594 VDD VSS VDD VSS gf180mcu_fd_sc_mcu7t5v0__fillcap_8
XFILLER_115_252 VDD VSS VDD VSS gf180mcu_fd_sc_mcu7t5v0__fillcap_8
XFILLER_170_380 VDD VSS VDD VSS gf180mcu_fd_sc_mcu7t5v0__fillcap_4
Xclkbuf_leaf_62_clk_i clkload7/I VSS VDD clkbuf_3_0__f_clk_i/Z VDD VSS gf180mcu_fd_sc_mcu7t5v0__clkbuf_2
X_2419_ _2419_/A3 VDD VSS _2420_/B _3382_/Q _2419_/A2 VDD VSS gf180mcu_fd_sc_mcu7t5v0__nand3_1
X_3399_ _3399_/D _3399_/Q wire161/Z VSS _3403_/CLK VDD VDD VSS gf180mcu_fd_sc_mcu7t5v0__dffrnq_1
XFILLER_130_255 VDD VSS VDD VSS gf180mcu_fd_sc_mcu7t5v0__fillcap_4
XFILLER_229_142 VDD VSS VDD VSS gf180mcu_fd_sc_mcu7t5v0__fillcap_64
XFILLER_217_326 VDD VSS VDD VSS gf180mcu_fd_sc_mcu7t5v0__fillcap_16
XFILLER_244_101 VDD VSS VDD VSS gf180mcu_fd_sc_mcu7t5v0__fillcap_4
XFILLER_57_556 VDD VSS VDD VSS gf180mcu_fd_sc_mcu7t5v0__fillcap_4
XFILLER_226_871 VDD VSS VDD VSS gf180mcu_fd_sc_mcu7t5v0__fillcap_4
Xclkbuf_leaf_77_clk_i _3337_/CLK VSS VDD clkload0/I VDD VSS gf180mcu_fd_sc_mcu7t5v0__clkbuf_2
XFILLER_198_745 VDD VSS VDD VSS gf180mcu_fd_sc_mcu7t5v0__fillcap_4
XFILLER_25_486 VDD VSS VDD VSS gf180mcu_fd_sc_mcu7t5v0__fillcap_4
XFILLER_13_626 VDD VSS VDD VSS gf180mcu_fd_sc_mcu7t5v0__fillcap_4
XFILLER_241_874 VDD VSS VDD VSS gf180mcu_fd_sc_mcu7t5v0__fillcap_16
XFILLER_197_244 VDD VSS VDD VSS gf180mcu_fd_sc_mcu7t5v0__fillcap_16
XFILLER_8_107 VDD VSS VDD VSS gf180mcu_fd_sc_mcu7t5v0__fillcap_64
XFILLER_165_130 VDD VSS VDD VSS gf180mcu_fd_sc_mcu7t5v0__fillcap_8
XFILLER_138_333 VDD VSS VDD VSS gf180mcu_fd_sc_mcu7t5v0__fillcap_8
XFILLER_193_483 VDD VSS VDD VSS gf180mcu_fd_sc_mcu7t5v0__fillcap_4
Xclkbuf_leaf_15_clk_i _3349_/CLK VSS VDD clkload3/I VDD VSS gf180mcu_fd_sc_mcu7t5v0__clkbuf_2
XFILLER_153_314 VDD VSS VDD VSS gf180mcu_fd_sc_mcu7t5v0__fillcap_8
XFILLER_5_836 VDD VSS VDD VSS gf180mcu_fd_sc_mcu7t5v0__fillcap_4
XFILLER_180_155 VDD VSS VDD VSS gf180mcu_fd_sc_mcu7t5v0__fillcap_4
XFILLER_268_716 VDD VSS VDD VSS gf180mcu_fd_sc_mcu7t5v0__fillcap_32
XFILLER_106_263 VDD VSS VDD VSS gf180mcu_fd_sc_mcu7t5v0__fillcap_8
XFILLER_164_53 VDD VSS VDD VSS gf180mcu_fd_sc_mcu7t5v0__fillcap_8
XFILLER_121_244 VDD VSS VDD VSS gf180mcu_fd_sc_mcu7t5v0__fillcap_16
XFILLER_79_158 VDD VSS VDD VSS gf180mcu_fd_sc_mcu7t5v0__fillcap_16
XFILLER_248_451 VDD VSS VDD VSS gf180mcu_fd_sc_mcu7t5v0__fillcap_4
XFILLER_87_191 VDD VSS VDD VSS gf180mcu_fd_sc_mcu7t5v0__fillcap_16
XFILLER_35_206 VDD VSS VDD VSS gf180mcu_fd_sc_mcu7t5v0__fillcap_4
XFILLER_73_61 VDD VSS VDD VSS gf180mcu_fd_sc_mcu7t5v0__fillcap_8
XFILLER_232_885 VDD VSS VDD VSS gf180mcu_fd_sc_mcu7t5v0__fillcap_4
XFILLER_189_72 VDD VSS VDD VSS gf180mcu_fd_sc_mcu7t5v0__fillcap_32
XFILLER_188_277 VDD VSS VDD VSS gf180mcu_fd_sc_mcu7t5v0__fillcap_32
Xspi_opentarget_i3c_top_183 scl_pad_i_PD VDD VSS VDD VSS gf180mcu_fd_sc_mcu7t5v0__tiel
X_2770_ VDD VSS _3326_/D wire10/Z _2770_/A2 VDD VSS gf180mcu_fd_sc_mcu7t5v0__nand2_1
Xspi_opentarget_i3c_top_172 host_clk_i_PD VDD VSS VDD VSS gf180mcu_fd_sc_mcu7t5v0__tiel
X_1721_ _1728_/S VDD VSS _2805_/D _2805_/Q _1788_/I1 VDD VSS gf180mcu_fd_sc_mcu7t5v0__mux2_2
Xspi_opentarget_i3c_top_194 spi_miso_o_IE VDD VSS VDD VSS gf180mcu_fd_sc_mcu7t5v0__tiel
XFILLER_191_409 VDD VSS VDD VSS gf180mcu_fd_sc_mcu7t5v0__fillcap_8
X_1652_ VDD VSS _2367_/A2 _1689_/C _1689_/B VDD VSS gf180mcu_fd_sc_mcu7t5v0__nor2_1
XFILLER_172_667 VDD VSS VDD VSS gf180mcu_fd_sc_mcu7t5v0__fillcap_64
XFILLER_160_807 VDD VSS VDD VSS gf180mcu_fd_sc_mcu7t5v0__fillcap_64
X_1583_ _1583_/B VDD VSS _1595_/A2 _3345_/Q _1587_/B VDD VSS gf180mcu_fd_sc_mcu7t5v0__aoi21_1
X_3322_ _3322_/D _3322_/Q wire169/Z VSS _3454_/CLK VDD VDD VSS gf180mcu_fd_sc_mcu7t5v0__dffrnq_1
X_3253_ _3253_/D _3253_/Q wire151/I VSS _3289_/CLK VDD VDD VSS gf180mcu_fd_sc_mcu7t5v0__dffrnq_1
XFILLER_112_255 VDD VSS VDD VSS gf180mcu_fd_sc_mcu7t5v0__fillcap_4
XFILLER_140_597 VDD VSS VDD VSS gf180mcu_fd_sc_mcu7t5v0__fillcap_16
X_3184_ _3184_/D _3184_/Q wire151/Z VSS _3349_/CLK VDD VDD VSS gf180mcu_fd_sc_mcu7t5v0__dffrnq_1
X_2204_ VDD VSS _3151_/D _3459_/D _2204_/A2 VDD VSS gf180mcu_fd_sc_mcu7t5v0__xor2_1
XFILLER_226_101 VDD VSS VDD VSS gf180mcu_fd_sc_mcu7t5v0__fillcap_4
X_2135_ _2138_/S VDD VSS _3123_/D wire92/Z _3123_/Q VDD VSS gf180mcu_fd_sc_mcu7t5v0__mux2_2
XFILLER_39_556 VDD VSS VDD VSS gf180mcu_fd_sc_mcu7t5v0__fillcap_4
XFILLER_208_871 VDD VSS VDD VSS gf180mcu_fd_sc_mcu7t5v0__fillcap_4
X_2066_ _2072_/S VDD VSS _3096_/D wire95/Z _3096_/Q VDD VSS gf180mcu_fd_sc_mcu7t5v0__mux2_2
XFILLER_93_194 VDD VSS VDD VSS gf180mcu_fd_sc_mcu7t5v0__fillcap_16
XFILLER_223_874 VDD VSS VDD VSS gf180mcu_fd_sc_mcu7t5v0__fillcap_16
XFILLER_222_395 VDD VSS VDD VSS gf180mcu_fd_sc_mcu7t5v0__fillcap_4
X_2968_ VDD _2968_/Q clkload8/I VSS _2968_/D VDD VSS gf180mcu_fd_sc_mcu7t5v0__dffq_1
X_1919_ _1924_/S VDD VSS _2973_/D _2011_/I0 _2973_/Q VDD VSS gf180mcu_fd_sc_mcu7t5v0__mux2_2
Xclkbuf_4_5_0_host_clk_i _3427_/CLK VSS VDD clkbuf_0_host_clk_i/Z VDD VSS gf180mcu_fd_sc_mcu7t5v0__clkbuf_2
X_2899_ VDD _2899_/Q _2899_/CLK VSS _2899_/D VDD VSS gf180mcu_fd_sc_mcu7t5v0__dffq_1
XFILLER_135_314 VDD VSS VDD VSS gf180mcu_fd_sc_mcu7t5v0__fillcap_8
XFILLER_162_177 VDD VSS VDD VSS gf180mcu_fd_sc_mcu7t5v0__fillcap_8
XFILLER_150_317 VDD VSS VDD VSS gf180mcu_fd_sc_mcu7t5v0__fillcap_64
XFILLER_218_657 VDD VSS VDD VSS gf180mcu_fd_sc_mcu7t5v0__fillcap_8
XFILLER_150_22 VDD VSS VDD VSS gf180mcu_fd_sc_mcu7t5v0__fillcap_8
XFILLER_17_206 VDD VSS VDD VSS gf180mcu_fd_sc_mcu7t5v0__fillcap_4
XFILLER_260_457 VDD VSS VDD VSS gf180mcu_fd_sc_mcu7t5v0__fillcap_64
XFILLER_150_88 VDD VSS VDD VSS gf180mcu_fd_sc_mcu7t5v0__fillcap_16
XFILLER_214_885 VDD VSS VDD VSS gf180mcu_fd_sc_mcu7t5v0__fillcap_4
XFILLER_158_417 VDD VSS VDD VSS gf180mcu_fd_sc_mcu7t5v0__fillcap_32
XFILLER_198_586 VDD VSS VDD VSS gf180mcu_fd_sc_mcu7t5v0__fillcap_8
XFILLER_198_597 VDD VSS VDD VSS gf180mcu_fd_sc_mcu7t5v0__fillcap_4
XFILLER_186_737 VDD VSS VDD VSS gf180mcu_fd_sc_mcu7t5v0__fillcap_64
XFILLER_9_416 VDD VSS VDD VSS gf180mcu_fd_sc_mcu7t5v0__fillcap_4
XFILLER_230_2 VDD VSS VDD VSS gf180mcu_fd_sc_mcu7t5v0__fillcap_32
XFILLER_185_236 VDD VSS VDD VSS gf180mcu_fd_sc_mcu7t5v0__fillcap_4
XFILLER_154_667 VDD VSS VDD VSS gf180mcu_fd_sc_mcu7t5v0__fillcap_64
XFILLER_142_807 VDD VSS VDD VSS gf180mcu_fd_sc_mcu7t5v0__fillcap_64
XFILLER_153_166 VDD VSS VDD VSS gf180mcu_fd_sc_mcu7t5v0__fillcap_8
XFILLER_268_546 VDD VSS VDD VSS gf180mcu_fd_sc_mcu7t5v0__fillcap_32
XFILLER_110_704 VDD VSS VDD VSS gf180mcu_fd_sc_mcu7t5v0__fillcap_16
XFILLER_122_586 VDD VSS VDD VSS gf180mcu_fd_sc_mcu7t5v0__fillcap_8
XFILLER_122_597 VDD VSS VDD VSS gf180mcu_fd_sc_mcu7t5v0__fillcap_64
XFILLER_110_737 VDD VSS VDD VSS gf180mcu_fd_sc_mcu7t5v0__fillcap_64
XFILLER_91_632 VDD VSS VDD VSS gf180mcu_fd_sc_mcu7t5v0__fillcap_64
XFILLER_205_874 VDD VSS VDD VSS gf180mcu_fd_sc_mcu7t5v0__fillcap_16
XFILLER_210_69 VDD VSS VDD VSS gf180mcu_fd_sc_mcu7t5v0__fillcap_8
XFILLER_220_877 VDD VSS VDD VSS gf180mcu_fd_sc_mcu7t5v0__fillcap_8
X_2822_ VDD _2822_/Q _3458_/CLK VSS _2822_/D VDD VSS gf180mcu_fd_sc_mcu7t5v0__dffq_1
XFILLER_176_247 VDD VSS VDD VSS gf180mcu_fd_sc_mcu7t5v0__fillcap_16
X_2753_ _3071_/Q _2753_/C VDD VSS _2754_/I _3319_/Q wire37/Z _2799_/A2 VDD VSS gf180mcu_fd_sc_mcu7t5v0__aoi221_1
XFILLER_76_2 VDD VSS VDD VSS gf180mcu_fd_sc_mcu7t5v0__fillcap_4
X_1704_ _1704_/A3 VDD VSS _2486_/B _2324_/A1 _3362_/D VDD VSS gf180mcu_fd_sc_mcu7t5v0__nor3_1
XFILLER_129_174 VDD VSS VDD VSS gf180mcu_fd_sc_mcu7t5v0__fillcap_16
X_2684_ _2683_/Z VSS VDD _2681_/Z _2682_/Z wire59/Z _2680_/Z _2732_/C _2684_/Z VDD
+ VSS gf180mcu_fd_sc_mcu7t5v0__mux4_1
X_1635_ wire84/I VDD VSS _1636_/B _3127_/Q _3365_/Q VDD VSS gf180mcu_fd_sc_mcu7t5v0__aoi21_1
XFILLER_132_317 VDD VSS VDD VSS gf180mcu_fd_sc_mcu7t5v0__fillcap_8
X_1566_ _3145_/Q _1566_/A4 VDD VSS _2186_/A3 _3140_/Q _3141_/Q VDD VSS gf180mcu_fd_sc_mcu7t5v0__nand4_1
XFILLER_125_380 VDD VSS VDD VSS gf180mcu_fd_sc_mcu7t5v0__fillcap_32
XFILLER_235_66 VDD VSS VDD VSS gf180mcu_fd_sc_mcu7t5v0__fillcap_4
XFILLER_113_553 VDD VSS VDD VSS gf180mcu_fd_sc_mcu7t5v0__fillcap_4
X_3305_ _3305_/D _3305_/Q _3452_/RN VSS _3337_/CLK VDD VDD VSS gf180mcu_fd_sc_mcu7t5v0__dffrnq_1
X_1497_ VDD VSS _1497_/I _1749_/A3 VDD VSS gf180mcu_fd_sc_mcu7t5v0__clkinv_1
XFILLER_100_247 VDD VSS VDD VSS gf180mcu_fd_sc_mcu7t5v0__fillcap_8
X_3236_ _3236_/D _3236_/Q _3452_/RN VSS _3451_/CLK VDD VDD VSS gf180mcu_fd_sc_mcu7t5v0__dffrnq_1
X_3167_ _3167_/D _3167_/Q wire147/I VSS _3348_/CLK VDD VDD VSS gf180mcu_fd_sc_mcu7t5v0__dffrnq_1
X_3098_ _3098_/D _3098_/Q wire145/Z VSS _3179_/CLK VDD VDD VSS gf180mcu_fd_sc_mcu7t5v0__dffrnq_1
X_2118_ VDD _2118_/B _2123_/B2 _3113_/D _3113_/Q VSS VDD VSS gf180mcu_fd_sc_mcu7t5v0__oai21_1
XFILLER_242_457 VDD VSS VDD VSS gf180mcu_fd_sc_mcu7t5v0__fillcap_64
XFILLER_81_142 VDD VSS VDD VSS gf180mcu_fd_sc_mcu7t5v0__fillcap_16
X_2049_ _2059_/S VDD VSS _3082_/D _3298_/Q _3082_/Q VDD VSS gf180mcu_fd_sc_mcu7t5v0__mux2_2
XFILLER_168_737 VDD VSS VDD VSS gf180mcu_fd_sc_mcu7t5v0__fillcap_64
XFILLER_210_387 VDD VSS VDD VSS gf180mcu_fd_sc_mcu7t5v0__fillcap_16
XFILLER_136_667 VDD VSS VDD VSS gf180mcu_fd_sc_mcu7t5v0__fillcap_16
XFILLER_124_807 VDD VSS VDD VSS gf180mcu_fd_sc_mcu7t5v0__fillcap_64
XFILLER_151_648 VDD VSS VDD VSS gf180mcu_fd_sc_mcu7t5v0__fillcap_4
XFILLER_123_339 VDD VSS VDD VSS gf180mcu_fd_sc_mcu7t5v0__fillcap_8
XFILLER_116_380 VDD VSS VDD VSS gf180mcu_fd_sc_mcu7t5v0__fillcap_4
XFILLER_150_169 VDD VSS VDD VSS gf180mcu_fd_sc_mcu7t5v0__fillcap_4
XFILLER_89_242 VDD VSS VDD VSS gf180mcu_fd_sc_mcu7t5v0__fillcap_16
XFILLER_131_394 VDD VSS VDD VSS gf180mcu_fd_sc_mcu7t5v0__fillcap_8
XFILLER_104_597 VDD VSS VDD VSS gf180mcu_fd_sc_mcu7t5v0__fillcap_32
XFILLER_180_2 VDD VSS VDD VSS gf180mcu_fd_sc_mcu7t5v0__fillcap_32
XFILLER_85_492 VDD VSS VDD VSS gf180mcu_fd_sc_mcu7t5v0__fillcap_64
XFILLER_73_632 VDD VSS VDD VSS gf180mcu_fd_sc_mcu7t5v0__fillcap_64
XFILLER_261_766 VDD VSS VDD VSS gf180mcu_fd_sc_mcu7t5v0__fillcap_4
XFILLER_220_107 VDD VSS VDD VSS gf180mcu_fd_sc_mcu7t5v0__fillcap_4
XFILLER_202_877 VDD VSS VDD VSS gf180mcu_fd_sc_mcu7t5v0__fillcap_8
XFILLER_201_343 VDD VSS VDD VSS gf180mcu_fd_sc_mcu7t5v0__fillcap_4
XFILLER_158_247 VDD VSS VDD VSS gf180mcu_fd_sc_mcu7t5v0__fillcap_4
XFILLER_41_562 VDD VSS VDD VSS gf180mcu_fd_sc_mcu7t5v0__fillcap_64
XFILLER_186_567 VDD VSS VDD VSS gf180mcu_fd_sc_mcu7t5v0__fillcap_4
XFILLER_186_589 VDD VSS VDD VSS gf180mcu_fd_sc_mcu7t5v0__fillcap_4
XFILLER_201_376 VDD VSS VDD VSS gf180mcu_fd_sc_mcu7t5v0__fillcap_4
Xclkload16 VSS clkload16/Z _3332_/CLK VDD VDD VSS gf180mcu_fd_sc_mcu7t5v0__clkbuf_1
Xclkload49 VSS clkload49/Z _3159_/CLK VDD VDD VSS gf180mcu_fd_sc_mcu7t5v0__clkbuf_1
XFILLER_186_73 VDD VSS VDD VSS gf180mcu_fd_sc_mcu7t5v0__fillcap_16
Xclkload38 VSS clkload38/Z _3005_/CLK VDD VDD VSS gf180mcu_fd_sc_mcu7t5v0__clkbuf_1
Xclkload27 VSS clkload27/Z _3337_/CLK VDD VDD VSS gf180mcu_fd_sc_mcu7t5v0__clkbuf_1
XFILLER_114_317 VDD VSS VDD VSS gf180mcu_fd_sc_mcu7t5v0__fillcap_16
XFILLER_126_177 VDD VSS VDD VSS gf180mcu_fd_sc_mcu7t5v0__fillcap_16
X_1420_ VDD VSS _3187_/Q _2328_/B2 VDD VSS gf180mcu_fd_sc_mcu7t5v0__clkinv_1
XFILLER_141_158 VDD VSS VDD VSS gf180mcu_fd_sc_mcu7t5v0__fillcap_4
XFILLER_268_376 VDD VSS VDD VSS gf180mcu_fd_sc_mcu7t5v0__fillcap_32
XFILLER_95_212 VDD VSS VDD VSS gf180mcu_fd_sc_mcu7t5v0__fillcap_32
XFILLER_256_527 VDD VSS VDD VSS gf180mcu_fd_sc_mcu7t5v0__fillcap_64
XFILLER_95_256 VDD VSS VDD VSS gf180mcu_fd_sc_mcu7t5v0__fillcap_4
X_3021_ VDD _3021_/Q _3021_/CLK VSS _3021_/D VDD VSS gf180mcu_fd_sc_mcu7t5v0__dffq_1
XFILLER_63_142 VDD VSS VDD VSS gf180mcu_fd_sc_mcu7t5v0__fillcap_64
XFILLER_224_457 VDD VSS VDD VSS gf180mcu_fd_sc_mcu7t5v0__fillcap_8
XFILLER_91_484 VDD VSS VDD VSS gf180mcu_fd_sc_mcu7t5v0__fillcap_4
XFILLER_251_276 VDD VSS VDD VSS gf180mcu_fd_sc_mcu7t5v0__fillcap_4
XFILLER_177_545 VDD VSS VDD VSS gf180mcu_fd_sc_mcu7t5v0__fillcap_8
XFILLER_204_192 VDD VSS VDD VSS gf180mcu_fd_sc_mcu7t5v0__fillcap_32
XFILLER_60_871 VDD VSS VDD VSS gf180mcu_fd_sc_mcu7t5v0__fillcap_4
X_2805_ VDD _2805_/Q _3370_/CLK VSS _2805_/D VDD VSS gf180mcu_fd_sc_mcu7t5v0__dffq_1
XFILLER_164_239 VDD VSS VDD VSS gf180mcu_fd_sc_mcu7t5v0__fillcap_4
X_2736_ _2736_/B VDD VSS _2738_/A3 _2732_/C _2735_/Z VDD VSS gf180mcu_fd_sc_mcu7t5v0__aoi21_1
XFILLER_117_133 VDD VSS VDD VSS gf180mcu_fd_sc_mcu7t5v0__fillcap_4
XFILLER_106_807 VDD VSS VDD VSS gf180mcu_fd_sc_mcu7t5v0__fillcap_64
XFILLER_145_475 VDD VSS VDD VSS gf180mcu_fd_sc_mcu7t5v0__fillcap_8
X_2667_ VDD VSS _2752_/A1 _3271_/Q _2737_/C VDD VSS gf180mcu_fd_sc_mcu7t5v0__nand2_1
X_1618_ VDD VSS _1619_/A3 _3427_/Q _3418_/D VDD VSS gf180mcu_fd_sc_mcu7t5v0__xnor2_1
XFILLER_120_309 VDD VSS VDD VSS gf180mcu_fd_sc_mcu7t5v0__fillcap_4
XFILLER_132_169 VDD VSS VDD VSS gf180mcu_fd_sc_mcu7t5v0__fillcap_4
XFILLER_99_562 VDD VSS VDD VSS gf180mcu_fd_sc_mcu7t5v0__fillcap_64
XFILLER_87_702 VDD VSS VDD VSS gf180mcu_fd_sc_mcu7t5v0__fillcap_64
X_2598_ wire12/I VDD VSS _3266_/D _3258_/Q _3266_/Q VDD VSS gf180mcu_fd_sc_mcu7t5v0__mux2_2
X_1549_ VDD _1549_/B _3190_/Q _1551_/A2 _3189_/Q VSS VDD VSS gf180mcu_fd_sc_mcu7t5v0__oai21_1
XFILLER_101_556 VDD VSS VDD VSS gf180mcu_fd_sc_mcu7t5v0__fillcap_4
XFILLER_86_278 VDD VSS VDD VSS gf180mcu_fd_sc_mcu7t5v0__fillcap_32
X_3219_ _3219_/D _3219_/Q wire165/Z VSS _3450_/CLK VDD VDD VSS gf180mcu_fd_sc_mcu7t5v0__dffrnq_1
XFILLER_101_578 VDD VSS VDD VSS gf180mcu_fd_sc_mcu7t5v0__fillcap_4
XFILLER_67_492 VDD VSS VDD VSS gf180mcu_fd_sc_mcu7t5v0__fillcap_64
XFILLER_55_632 VDD VSS VDD VSS gf180mcu_fd_sc_mcu7t5v0__fillcap_64
XFILLER_82_451 VDD VSS VDD VSS gf180mcu_fd_sc_mcu7t5v0__fillcap_4
XFILLER_243_766 VDD VSS VDD VSS gf180mcu_fd_sc_mcu7t5v0__fillcap_4
XFILLER_202_118 VDD VSS VDD VSS gf180mcu_fd_sc_mcu7t5v0__fillcap_4
XFILLER_23_562 VDD VSS VDD VSS gf180mcu_fd_sc_mcu7t5v0__fillcap_64
XFILLER_11_702 VDD VSS VDD VSS gf180mcu_fd_sc_mcu7t5v0__fillcap_64
XFILLER_50_381 VDD VSS VDD VSS gf180mcu_fd_sc_mcu7t5v0__fillcap_4
XFILLER_163_261 VDD VSS VDD VSS gf180mcu_fd_sc_mcu7t5v0__fillcap_4
XFILLER_151_401 VDD VSS VDD VSS gf180mcu_fd_sc_mcu7t5v0__fillcap_4
XFILLER_108_177 VDD VSS VDD VSS gf180mcu_fd_sc_mcu7t5v0__fillcap_32
XFILLER_6_2 VDD VSS VDD VSS gf180mcu_fd_sc_mcu7t5v0__fillcap_32
XFILLER_123_158 VDD VSS VDD VSS gf180mcu_fd_sc_mcu7t5v0__fillcap_4
XFILLER_77_212 VDD VSS VDD VSS gf180mcu_fd_sc_mcu7t5v0__fillcap_8
XFILLER_238_527 VDD VSS VDD VSS gf180mcu_fd_sc_mcu7t5v0__fillcap_64
XFILLER_265_346 VDD VSS VDD VSS gf180mcu_fd_sc_mcu7t5v0__fillcap_4
XFILLER_1_59 VDD VSS VDD VSS gf180mcu_fd_sc_mcu7t5v0__fillcap_8
XFILLER_45_142 VDD VSS VDD VSS gf180mcu_fd_sc_mcu7t5v0__fillcap_64
XFILLER_206_457 VDD VSS VDD VSS gf180mcu_fd_sc_mcu7t5v0__fillcap_16
XFILLER_60_101 VDD VSS VDD VSS gf180mcu_fd_sc_mcu7t5v0__fillcap_4
XFILLER_233_276 VDD VSS VDD VSS gf180mcu_fd_sc_mcu7t5v0__fillcap_4
XFILLER_42_871 VDD VSS VDD VSS gf180mcu_fd_sc_mcu7t5v0__fillcap_4
XFILLER_81_72 VDD VSS VDD VSS gf180mcu_fd_sc_mcu7t5v0__fillcap_16
XFILLER_186_342 VDD VSS VDD VSS gf180mcu_fd_sc_mcu7t5v0__fillcap_8
XFILLER_139_291 VDD VSS VDD VSS gf180mcu_fd_sc_mcu7t5v0__fillcap_8
X_2521_ _2546_/B VDD VSS _2529_/A2 _2521_/A1 _2521_/A2 VDD VSS gf180mcu_fd_sc_mcu7t5v0__aoi21_1
XFILLER_5_282 VDD VSS VDD VSS gf180mcu_fd_sc_mcu7t5v0__fillcap_64
X_2452_ VDD _2452_/B _2452_/A2 _3202_/D _2467_/A1 VSS VDD VSS gf180mcu_fd_sc_mcu7t5v0__oai21_1
XFILLER_69_702 VDD VSS VDD VSS gf180mcu_fd_sc_mcu7t5v0__fillcap_64
X_2383_ _2830_/Q VSS VDD _2814_/Q _2822_/Q wire78/I _2806_/Q wire76/Z _2383_/Z VDD
+ VSS gf180mcu_fd_sc_mcu7t5v0__mux4_1
XFILLER_216_79 VDD VSS VDD VSS gf180mcu_fd_sc_mcu7t5v0__fillcap_16
X_1403_ VDD VSS _3197_/Q _2305_/B2 VDD VSS gf180mcu_fd_sc_mcu7t5v0__clkinv_1
XFILLER_39_2 VDD VSS VDD VSS gf180mcu_fd_sc_mcu7t5v0__fillcap_64
XFILLER_257_836 VDD VSS VDD VSS gf180mcu_fd_sc_mcu7t5v0__fillcap_4
Xinput3 VDD sda_pad_IN VSS input3/Z VDD VSS gf180mcu_fd_sc_mcu7t5v0__dlyb_1
XFILLER_49_492 VDD VSS VDD VSS gf180mcu_fd_sc_mcu7t5v0__fillcap_64
X_3004_ VDD _3004_/Q _3012_/CLK VSS _3004_/D VDD VSS gf180mcu_fd_sc_mcu7t5v0__dffq_1
XFILLER_37_632 VDD VSS VDD VSS gf180mcu_fd_sc_mcu7t5v0__fillcap_64
XFILLER_64_451 VDD VSS VDD VSS gf180mcu_fd_sc_mcu7t5v0__fillcap_4
XFILLER_225_766 VDD VSS VDD VSS gf180mcu_fd_sc_mcu7t5v0__fillcap_4
XFILLER_20_521 VDD VSS VDD VSS gf180mcu_fd_sc_mcu7t5v0__fillcap_4
XFILLER_32_381 VDD VSS VDD VSS gf180mcu_fd_sc_mcu7t5v0__fillcap_4
XFILLER_137_228 VDD VSS VDD VSS gf180mcu_fd_sc_mcu7t5v0__fillcap_4
XFILLER_173_570 VDD VSS VDD VSS gf180mcu_fd_sc_mcu7t5v0__fillcap_4
XFILLER_180_518 VDD VSS VDD VSS gf180mcu_fd_sc_mcu7t5v0__fillcap_4
X_2719_ VDD VSS _2720_/B wire59/Z wire53/Z VDD VSS gf180mcu_fd_sc_mcu7t5v0__nand2_1
XFILLER_59_212 VDD VSS VDD VSS gf180mcu_fd_sc_mcu7t5v0__fillcap_64
XFILLER_247_346 VDD VSS VDD VSS gf180mcu_fd_sc_mcu7t5v0__fillcap_4
XFILLER_142_56 VDD VSS VDD VSS gf180mcu_fd_sc_mcu7t5v0__fillcap_8
XFILLER_19_66 VDD VSS VDD VSS gf180mcu_fd_sc_mcu7t5v0__fillcap_4
XFILLER_27_142 VDD VSS VDD VSS gf180mcu_fd_sc_mcu7t5v0__fillcap_64
XFILLER_42_101 VDD VSS VDD VSS gf180mcu_fd_sc_mcu7t5v0__fillcap_4
XFILLER_215_276 VDD VSS VDD VSS gf180mcu_fd_sc_mcu7t5v0__fillcap_4
XFILLER_24_871 VDD VSS VDD VSS gf180mcu_fd_sc_mcu7t5v0__fillcap_4
XFILLER_143_2 VDD VSS VDD VSS gf180mcu_fd_sc_mcu7t5v0__fillcap_8
XFILLER_195_150 VDD VSS VDD VSS gf180mcu_fd_sc_mcu7t5v0__fillcap_4
XFILLER_168_375 VDD VSS VDD VSS gf180mcu_fd_sc_mcu7t5v0__fillcap_8
XFILLER_109_486 VDD VSS VDD VSS gf180mcu_fd_sc_mcu7t5v0__fillcap_4
XFILLER_2_241 VDD VSS VDD VSS gf180mcu_fd_sc_mcu7t5v0__fillcap_4
XFILLER_78_521 VDD VSS VDD VSS gf180mcu_fd_sc_mcu7t5v0__fillcap_4
XFILLER_112_629 VDD VSS VDD VSS gf180mcu_fd_sc_mcu7t5v0__fillcap_16
XFILLER_239_836 VDD VSS VDD VSS gf180mcu_fd_sc_mcu7t5v0__fillcap_4
XFILLER_19_632 VDD VSS VDD VSS gf180mcu_fd_sc_mcu7t5v0__fillcap_64
XFILLER_46_451 VDD VSS VDD VSS gf180mcu_fd_sc_mcu7t5v0__fillcap_4
XFILLER_206_232 VDD VSS VDD VSS gf180mcu_fd_sc_mcu7t5v0__fillcap_4
XFILLER_202_37 VDD VSS VDD VSS gf180mcu_fd_sc_mcu7t5v0__fillcap_16
XFILLER_80_218 VDD VSS VDD VSS gf180mcu_fd_sc_mcu7t5v0__fillcap_8
X_1952_ _1954_/S VDD VSS _3002_/D _3002_/Q wire116/Z VDD VSS gf180mcu_fd_sc_mcu7t5v0__mux2_2
XFILLER_14_381 VDD VSS VDD VSS gf180mcu_fd_sc_mcu7t5v0__fillcap_4
X_1883_ _1887_/S VDD VSS _2944_/D _2944_/Q _3178_/Q VDD VSS gf180mcu_fd_sc_mcu7t5v0__mux2_2
XFILLER_30_885 VDD VSS VDD VSS gf180mcu_fd_sc_mcu7t5v0__fillcap_4
XFILLER_6_591 VDD VSS VDD VSS gf180mcu_fd_sc_mcu7t5v0__fillcap_4
X_2504_ _3321_/Q _3221_/Q VDD VSS _2505_/A2 _3329_/Q _2554_/A2 _2525_/B1 VDD VSS gf180mcu_fd_sc_mcu7t5v0__aoi221_1
X_2435_ VDD VSS _2436_/A3 _2449_/A1 _3133_/Q VDD VSS gf180mcu_fd_sc_mcu7t5v0__nand2_1
XFILLER_102_139 VDD VSS VDD VSS gf180mcu_fd_sc_mcu7t5v0__fillcap_8
XFILLER_229_346 VDD VSS VDD VSS gf180mcu_fd_sc_mcu7t5v0__fillcap_4
XFILLER_243_66 VDD VSS VDD VSS gf180mcu_fd_sc_mcu7t5v0__fillcap_4
X_2366_ VDD VSS _2367_/B _3196_/Q _2467_/A1 VDD VSS gf180mcu_fd_sc_mcu7t5v0__nand2_1
XFILLER_97_874 VDD VSS VDD VSS gf180mcu_fd_sc_mcu7t5v0__fillcap_16
X_2297_ VDD VSS _2302_/B _3202_/Q _3100_/Q VDD VSS gf180mcu_fd_sc_mcu7t5v0__xnor2_1
XFILLER_24_101 VDD VSS VDD VSS gf180mcu_fd_sc_mcu7t5v0__fillcap_4
XFILLER_197_448 VDD VSS VDD VSS gf180mcu_fd_sc_mcu7t5v0__fillcap_32
XFILLER_178_651 VDD VSS VDD VSS gf180mcu_fd_sc_mcu7t5v0__fillcap_8
XFILLER_21_874 VDD VSS VDD VSS gf180mcu_fd_sc_mcu7t5v0__fillcap_16
XFILLER_193_632 VDD VSS VDD VSS gf180mcu_fd_sc_mcu7t5v0__fillcap_16
XFILLER_165_345 VDD VSS VDD VSS gf180mcu_fd_sc_mcu7t5v0__fillcap_4
XFILLER_134_721 VDD VSS VDD VSS gf180mcu_fd_sc_mcu7t5v0__fillcap_8
XFILLER_161_562 VDD VSS VDD VSS gf180mcu_fd_sc_mcu7t5v0__fillcap_8
XFILLER_133_297 VDD VSS VDD VSS gf180mcu_fd_sc_mcu7t5v0__fillcap_8
XFILLER_88_885 VDD VSS VDD VSS gf180mcu_fd_sc_mcu7t5v0__fillcap_4
XFILLER_153_99 VDD VSS VDD VSS gf180mcu_fd_sc_mcu7t5v0__fillcap_16
XFILLER_28_451 VDD VSS VDD VSS gf180mcu_fd_sc_mcu7t5v0__fillcap_4
XFILLER_260_2 VDD VSS VDD VSS gf180mcu_fd_sc_mcu7t5v0__fillcap_32
XFILLER_90_527 VDD VSS VDD VSS gf180mcu_fd_sc_mcu7t5v0__fillcap_16
XFILLER_62_30 VDD VSS VDD VSS gf180mcu_fd_sc_mcu7t5v0__fillcap_4
XFILLER_8_801 VDD VSS VDD VSS gf180mcu_fd_sc_mcu7t5v0__fillcap_4
XFILLER_12_885 VDD VSS VDD VSS gf180mcu_fd_sc_mcu7t5v0__fillcap_4
XFILLER_183_142 VDD VSS VDD VSS gf180mcu_fd_sc_mcu7t5v0__fillcap_16
XFILLER_109_272 VDD VSS VDD VSS gf180mcu_fd_sc_mcu7t5v0__fillcap_8
XFILLER_180_871 VDD VSS VDD VSS gf180mcu_fd_sc_mcu7t5v0__fillcap_4
XFILLER_140_724 VDD VSS VDD VSS gf180mcu_fd_sc_mcu7t5v0__fillcap_4
XFILLER_112_426 VDD VSS VDD VSS gf180mcu_fd_sc_mcu7t5v0__fillcap_8
X_2220_ _2221_/S VDD VSS _3166_/D wire91/Z _3166_/Q VDD VSS gf180mcu_fd_sc_mcu7t5v0__mux2_2
XFILLER_79_874 VDD VSS VDD VSS gf180mcu_fd_sc_mcu7t5v0__fillcap_16
X_2151_ _2154_/A3 VDD VSS _2163_/A1 _3147_/Q _2143_/B VDD VSS gf180mcu_fd_sc_mcu7t5v0__nand3_1
X_2082_ _3103_/Q VDD VSS _2083_/A2 _3102_/Q _2074_/Z VDD VSS gf180mcu_fd_sc_mcu7t5v0__aoi21_1
XFILLER_94_877 VDD VSS VDD VSS gf180mcu_fd_sc_mcu7t5v0__fillcap_8
XFILLER_179_415 VDD VSS VDD VSS gf180mcu_fd_sc_mcu7t5v0__fillcap_4
X_2984_ VDD _2984_/Q _3006_/CLK VSS _2984_/D VDD VSS gf180mcu_fd_sc_mcu7t5v0__dffq_1
X_1935_ _1935_/S VDD VSS _2988_/D wire113/Z _2988_/Q VDD VSS gf180mcu_fd_sc_mcu7t5v0__mux2_2
Xmax_length29 _2059_/S _2058_/S VDD VSS VDD VSS gf180mcu_fd_sc_mcu7t5v0__buf_4
XFILLER_175_632 VDD VSS VDD VSS gf180mcu_fd_sc_mcu7t5v0__fillcap_64
XFILLER_187_492 VDD VSS VDD VSS gf180mcu_fd_sc_mcu7t5v0__fillcap_8
XFILLER_147_345 VDD VSS VDD VSS gf180mcu_fd_sc_mcu7t5v0__fillcap_4
X_1866_ _1869_/S VDD VSS _2929_/D wire131/Z _2929_/Q VDD VSS gf180mcu_fd_sc_mcu7t5v0__mux2_2
X_1797_ VDD VSS _1805_/S _1500_/Z _1796_/Z VDD VSS gf180mcu_fd_sc_mcu7t5v0__nand2_1
XFILLER_143_562 VDD VSS VDD VSS gf180mcu_fd_sc_mcu7t5v0__fillcap_32
XFILLER_131_702 VDD VSS VDD VSS gf180mcu_fd_sc_mcu7t5v0__fillcap_8
X_3398_ _3398_/D _3398_/Q _3403_/RN VSS _3403_/CLK VDD VDD VSS gf180mcu_fd_sc_mcu7t5v0__dffrnq_1
X_2418_ VDD VSS _2419_/A3 _2461_/A1 _2417_/Z VDD VSS gf180mcu_fd_sc_mcu7t5v0__nand2_1
X_2349_ _2351_/A2 VDD VSS _2349_/Z _2480_/A3 _2365_/A2 VDD VSS gf180mcu_fd_sc_mcu7t5v0__or3_1
XFILLER_123_58 VDD VSS VDD VSS gf180mcu_fd_sc_mcu7t5v0__fillcap_8
XFILLER_84_387 VDD VSS VDD VSS gf180mcu_fd_sc_mcu7t5v0__fillcap_64
XFILLER_72_527 VDD VSS VDD VSS gf180mcu_fd_sc_mcu7t5v0__fillcap_64
XFILLER_199_18 VDD VSS VDD VSS gf180mcu_fd_sc_mcu7t5v0__fillcap_8
XFILLER_241_842 VDD VSS VDD VSS gf180mcu_fd_sc_mcu7t5v0__fillcap_32
XFILLER_197_212 VDD VSS VDD VSS gf180mcu_fd_sc_mcu7t5v0__fillcap_32
XFILLER_213_588 VDD VSS VDD VSS gf180mcu_fd_sc_mcu7t5v0__fillcap_4
XFILLER_40_457 VDD VSS VDD VSS gf180mcu_fd_sc_mcu7t5v0__fillcap_64
XFILLER_148_22 VDD VSS VDD VSS gf180mcu_fd_sc_mcu7t5v0__fillcap_8
XFILLER_138_378 VDD VSS VDD VSS gf180mcu_fd_sc_mcu7t5v0__fillcap_4
XFILLER_126_518 VDD VSS VDD VSS gf180mcu_fd_sc_mcu7t5v0__fillcap_4
XFILLER_181_624 VDD VSS VDD VSS gf180mcu_fd_sc_mcu7t5v0__fillcap_4
XFILLER_164_10 VDD VSS VDD VSS gf180mcu_fd_sc_mcu7t5v0__fillcap_16
XFILLER_106_220 VDD VSS VDD VSS gf180mcu_fd_sc_mcu7t5v0__fillcap_8
XFILLER_106_2 VDD VSS VDD VSS gf180mcu_fd_sc_mcu7t5v0__fillcap_32
XFILLER_162_871 VDD VSS VDD VSS gf180mcu_fd_sc_mcu7t5v0__fillcap_4
XFILLER_121_212 VDD VSS VDD VSS gf180mcu_fd_sc_mcu7t5v0__fillcap_32
XFILLER_94_107 VDD VSS VDD VSS gf180mcu_fd_sc_mcu7t5v0__fillcap_4
XFILLER_208_305 VDD VSS VDD VSS gf180mcu_fd_sc_mcu7t5v0__fillcap_8
XFILLER_263_422 VDD VSS VDD VSS gf180mcu_fd_sc_mcu7t5v0__fillcap_64
XFILLER_76_877 VDD VSS VDD VSS gf180mcu_fd_sc_mcu7t5v0__fillcap_8
XFILLER_180_97 VDD VSS VDD VSS gf180mcu_fd_sc_mcu7t5v0__fillcap_8
XFILLER_91_836 VDD VSS VDD VSS gf180mcu_fd_sc_mcu7t5v0__fillcap_4
XFILLER_216_371 VDD VSS VDD VSS gf180mcu_fd_sc_mcu7t5v0__fillcap_8
XFILLER_90_379 VDD VSS VDD VSS gf180mcu_fd_sc_mcu7t5v0__fillcap_4
XFILLER_231_352 VDD VSS VDD VSS gf180mcu_fd_sc_mcu7t5v0__fillcap_64
XFILLER_157_632 VDD VSS VDD VSS gf180mcu_fd_sc_mcu7t5v0__fillcap_64
XFILLER_169_492 VDD VSS VDD VSS gf180mcu_fd_sc_mcu7t5v0__fillcap_8
Xspi_opentarget_i3c_top_173 host_clk_i_PU VDD VSS VDD VSS gf180mcu_fd_sc_mcu7t5v0__tiel
X_1720_ _2274_/C _1720_/C VDD VSS _2804_/D _1689_/C _1720_/A2 VDD VSS gf180mcu_fd_sc_mcu7t5v0__aoi211_1
Xspi_opentarget_i3c_top_184 scl_pad_i_PU VDD VSS VDD VSS gf180mcu_fd_sc_mcu7t5v0__tiel
Xspi_opentarget_i3c_top_195 spi_miso_o_PD VDD VSS VDD VSS gf180mcu_fd_sc_mcu7t5v0__tiel
X_1651_ VDD VSS _1689_/B _2331_/B _2803_/Q VDD VSS gf180mcu_fd_sc_mcu7t5v0__or2_1
X_1582_ _1582_/B _1582_/C VDD VSS _3349_/D _2168_/C _1593_/A2 VDD VSS gf180mcu_fd_sc_mcu7t5v0__oai211_1
X_3321_ _3321_/D _3321_/Q wire147/I VSS _3321_/CLK VDD VDD VSS gf180mcu_fd_sc_mcu7t5v0__dffrnq_1
XFILLER_113_702 VDD VSS VDD VSS gf180mcu_fd_sc_mcu7t5v0__fillcap_64
XFILLER_140_521 VDD VSS VDD VSS gf180mcu_fd_sc_mcu7t5v0__fillcap_4
XFILLER_140_543 VDD VSS VDD VSS gf180mcu_fd_sc_mcu7t5v0__fillcap_8
XFILLER_98_81 VDD VSS VDD VSS gf180mcu_fd_sc_mcu7t5v0__fillcap_16
XFILLER_140_565 VDD VSS VDD VSS gf180mcu_fd_sc_mcu7t5v0__fillcap_8
XFILLER_85_107 VDD VSS VDD VSS gf180mcu_fd_sc_mcu7t5v0__fillcap_32
X_3252_ _3252_/D _3252_/Q wire169/Z VSS _3446_/CLK VDD VDD VSS gf180mcu_fd_sc_mcu7t5v0__dffrnq_1
XFILLER_267_772 VDD VSS VDD VSS gf180mcu_fd_sc_mcu7t5v0__fillcap_64
X_3183_ _3183_/D _3183_/Q _3344_/RN VSS _3349_/CLK VDD VDD VSS gf180mcu_fd_sc_mcu7t5v0__dffrnq_1
X_2203_ _2202_/Z VDD VSS _2204_/A2 _3277_/Q _2203_/A2 VDD VSS gf180mcu_fd_sc_mcu7t5v0__nor3_1
XFILLER_21_2 VDD VSS VDD VSS gf180mcu_fd_sc_mcu7t5v0__fillcap_64
X_2134_ _2138_/S VDD VSS _3122_/D wire94/Z _3122_/Q VDD VSS gf180mcu_fd_sc_mcu7t5v0__mux2_2
XFILLER_66_387 VDD VSS VDD VSS gf180mcu_fd_sc_mcu7t5v0__fillcap_64
XFILLER_54_527 VDD VSS VDD VSS gf180mcu_fd_sc_mcu7t5v0__fillcap_64
X_2065_ _2072_/S VDD VSS _3095_/D wire96/Z _3095_/Q VDD VSS gf180mcu_fd_sc_mcu7t5v0__mux2_2
XFILLER_223_842 VDD VSS VDD VSS gf180mcu_fd_sc_mcu7t5v0__fillcap_32
XFILLER_179_212 VDD VSS VDD VSS gf180mcu_fd_sc_mcu7t5v0__fillcap_16
XFILLER_250_661 VDD VSS VDD VSS gf180mcu_fd_sc_mcu7t5v0__fillcap_4
XFILLER_22_457 VDD VSS VDD VSS gf180mcu_fd_sc_mcu7t5v0__fillcap_64
X_2967_ VDD _2967_/Q _2994_/CLK VSS _2967_/D VDD VSS gf180mcu_fd_sc_mcu7t5v0__dffq_1
XFILLER_195_749 VDD VSS VDD VSS gf180mcu_fd_sc_mcu7t5v0__fillcap_16
X_2898_ VDD _2898_/Q _3370_/CLK VSS _2898_/D VDD VSS gf180mcu_fd_sc_mcu7t5v0__dffq_1
X_1918_ VDD VSS _1926_/S _1992_/A1 _1936_/A2 VDD VSS gf180mcu_fd_sc_mcu7t5v0__nand2_1
X_1849_ _1851_/S VDD VSS _2914_/D wire130/Z _2914_/Q VDD VSS gf180mcu_fd_sc_mcu7t5v0__mux2_2
XFILLER_162_123 VDD VSS VDD VSS gf180mcu_fd_sc_mcu7t5v0__fillcap_8
XFILLER_144_871 VDD VSS VDD VSS gf180mcu_fd_sc_mcu7t5v0__fillcap_4
XFILLER_162_167 VDD VSS VDD VSS gf180mcu_fd_sc_mcu7t5v0__fillcap_8
XFILLER_2_807 VDD VSS VDD VSS gf180mcu_fd_sc_mcu7t5v0__fillcap_64
XFILLER_78_29 VDD VSS VDD VSS gf180mcu_fd_sc_mcu7t5v0__fillcap_4
XFILLER_103_212 VDD VSS VDD VSS gf180mcu_fd_sc_mcu7t5v0__fillcap_8
XFILLER_76_107 VDD VSS VDD VSS gf180mcu_fd_sc_mcu7t5v0__fillcap_16
XFILLER_245_422 VDD VSS VDD VSS gf180mcu_fd_sc_mcu7t5v0__fillcap_64
XFILLER_257_282 VDD VSS VDD VSS gf180mcu_fd_sc_mcu7t5v0__fillcap_64
XFILLER_58_877 VDD VSS VDD VSS gf180mcu_fd_sc_mcu7t5v0__fillcap_8
XFILLER_217_146 VDD VSS VDD VSS gf180mcu_fd_sc_mcu7t5v0__fillcap_64
XFILLER_73_836 VDD VSS VDD VSS gf180mcu_fd_sc_mcu7t5v0__fillcap_4
XFILLER_85_696 VDD VSS VDD VSS gf180mcu_fd_sc_mcu7t5v0__fillcap_4
XFILLER_150_56 VDD VSS VDD VSS gf180mcu_fd_sc_mcu7t5v0__fillcap_32
XFILLER_27_66 VDD VSS VDD VSS gf180mcu_fd_sc_mcu7t5v0__fillcap_4
XFILLER_240_171 VDD VSS VDD VSS gf180mcu_fd_sc_mcu7t5v0__fillcap_4
XFILLER_41_766 VDD VSS VDD VSS gf180mcu_fd_sc_mcu7t5v0__fillcap_4
XFILLER_139_632 VDD VSS VDD VSS gf180mcu_fd_sc_mcu7t5v0__fillcap_16
XFILLER_166_451 VDD VSS VDD VSS gf180mcu_fd_sc_mcu7t5v0__fillcap_4
XFILLER_223_2 VDD VSS VDD VSS gf180mcu_fd_sc_mcu7t5v0__fillcap_16
XFILLER_154_613 VDD VSS VDD VSS gf180mcu_fd_sc_mcu7t5v0__fillcap_4
XFILLER_194_793 VDD VSS VDD VSS gf180mcu_fd_sc_mcu7t5v0__fillcap_8
XFILLER_107_540 VDD VSS VDD VSS gf180mcu_fd_sc_mcu7t5v0__fillcap_16
XFILLER_107_562 VDD VSS VDD VSS gf180mcu_fd_sc_mcu7t5v0__fillcap_8
XFILLER_4_177 VDD VSS VDD VSS gf180mcu_fd_sc_mcu7t5v0__fillcap_64
XFILLER_4_37 VDD VSS VDD VSS gf180mcu_fd_sc_mcu7t5v0__fillcap_64
XFILLER_150_885 VDD VSS VDD VSS gf180mcu_fd_sc_mcu7t5v0__fillcap_4
XFILLER_191_30 VDD VSS VDD VSS gf180mcu_fd_sc_mcu7t5v0__fillcap_4
XFILLER_122_554 VDD VSS VDD VSS gf180mcu_fd_sc_mcu7t5v0__fillcap_32
XFILLER_249_772 VDD VSS VDD VSS gf180mcu_fd_sc_mcu7t5v0__fillcap_64
XFILLER_264_731 VDD VSS VDD VSS gf180mcu_fd_sc_mcu7t5v0__fillcap_4
XFILLER_48_387 VDD VSS VDD VSS gf180mcu_fd_sc_mcu7t5v0__fillcap_64
XFILLER_36_527 VDD VSS VDD VSS gf180mcu_fd_sc_mcu7t5v0__fillcap_64
XFILLER_63_346 VDD VSS VDD VSS gf180mcu_fd_sc_mcu7t5v0__fillcap_4
XFILLER_205_842 VDD VSS VDD VSS gf180mcu_fd_sc_mcu7t5v0__fillcap_32
XFILLER_220_801 VDD VSS VDD VSS gf180mcu_fd_sc_mcu7t5v0__fillcap_4
XFILLER_232_661 VDD VSS VDD VSS gf180mcu_fd_sc_mcu7t5v0__fillcap_4
XFILLER_210_37 VDD VSS VDD VSS gf180mcu_fd_sc_mcu7t5v0__fillcap_32
X_2821_ VDD _2821_/Q _3458_/CLK VSS _2821_/D VDD VSS gf180mcu_fd_sc_mcu7t5v0__dffq_1
Xclkbuf_leaf_61_clk_i _3462_/CLK VSS VDD clkload0/I VDD VSS gf180mcu_fd_sc_mcu7t5v0__clkbuf_2
XFILLER_31_276 VDD VSS VDD VSS gf180mcu_fd_sc_mcu7t5v0__fillcap_4
X_2752_ _2752_/B VDD VSS _2753_/C _2752_/A1 _2752_/A2 VDD VSS gf180mcu_fd_sc_mcu7t5v0__aoi21_1
XFILLER_129_142 VDD VSS VDD VSS gf180mcu_fd_sc_mcu7t5v0__fillcap_32
X_1703_ _2262_/A1 VDD VSS _1711_/A4 _1715_/B _1699_/Z VDD VSS gf180mcu_fd_sc_mcu7t5v0__nor3_1
X_2683_ _3055_/Q VSS VDD _3039_/Q _3047_/Q _2722_/S0 _3031_/Q wire60/Z _2683_/Z VDD
+ VSS gf180mcu_fd_sc_mcu7t5v0__mux4_1
XFILLER_69_2 VDD VSS VDD VSS gf180mcu_fd_sc_mcu7t5v0__fillcap_64
XFILLER_172_476 VDD VSS VDD VSS gf180mcu_fd_sc_mcu7t5v0__fillcap_16
XFILLER_145_679 VDD VSS VDD VSS gf180mcu_fd_sc_mcu7t5v0__fillcap_16
X_1634_ VDD VSS _3359_/D _3118_/Q _2076_/A2 VDD VSS gf180mcu_fd_sc_mcu7t5v0__nor2_1
XFILLER_126_871 VDD VSS VDD VSS gf180mcu_fd_sc_mcu7t5v0__fillcap_4
Xclkbuf_leaf_76_clk_i _3453_/CLK VSS VDD clkbuf_3_0__f_clk_i/Z VDD VSS gf180mcu_fd_sc_mcu7t5v0__clkbuf_2
X_1565_ _1565_/A3 VDD VSS _3345_/D _2470_/B _2184_/S VDD VSS gf180mcu_fd_sc_mcu7t5v0__nand3_1
XFILLER_113_521 VDD VSS VDD VSS gf180mcu_fd_sc_mcu7t5v0__fillcap_32
XFILLER_141_874 VDD VSS VDD VSS gf180mcu_fd_sc_mcu7t5v0__fillcap_16
X_3304_ _3304_/D _3304_/Q _3339_/RN VSS _3339_/CLK VDD VDD VSS gf180mcu_fd_sc_mcu7t5v0__dffrnq_1
XFILLER_99_766 VDD VSS VDD VSS gf180mcu_fd_sc_mcu7t5v0__fillcap_4
X_1496_ VDD VSS _1497_/I _1494_/Z _1500_/A4 VDD VSS gf180mcu_fd_sc_mcu7t5v0__and2_1
XFILLER_58_107 VDD VSS VDD VSS gf180mcu_fd_sc_mcu7t5v0__fillcap_64
X_3235_ _3235_/D _3235_/Q wire145/I VSS _3321_/CLK VDD VDD VSS gf180mcu_fd_sc_mcu7t5v0__dffrnq_1
XFILLER_227_422 VDD VSS VDD VSS gf180mcu_fd_sc_mcu7t5v0__fillcap_64
XFILLER_239_282 VDD VSS VDD VSS gf180mcu_fd_sc_mcu7t5v0__fillcap_64
XFILLER_254_241 VDD VSS VDD VSS gf180mcu_fd_sc_mcu7t5v0__fillcap_4
XFILLER_251_66 VDD VSS VDD VSS gf180mcu_fd_sc_mcu7t5v0__fillcap_4
X_3166_ _3166_/D _3166_/Q wire151/Z VSS _3166_/CLK VDD VDD VSS gf180mcu_fd_sc_mcu7t5v0__dffrnq_1
XFILLER_55_836 VDD VSS VDD VSS gf180mcu_fd_sc_mcu7t5v0__fillcap_4
X_2117_ VDD VSS _2123_/B2 _2075_/Z _2119_/A3 VDD VSS gf180mcu_fd_sc_mcu7t5v0__nand2_1
Xclkbuf_leaf_14_clk_i _3185_/CLK VSS VDD clkload3/I VDD VSS gf180mcu_fd_sc_mcu7t5v0__clkbuf_2
X_3097_ _3097_/D _3097_/Q wire145/Z VSS _3341_/CLK VDD VDD VSS gf180mcu_fd_sc_mcu7t5v0__dffrnq_1
XFILLER_67_696 VDD VSS VDD VSS gf180mcu_fd_sc_mcu7t5v0__fillcap_4
X_2048_ wire28/Z VDD VSS _3081_/D _3297_/Q _3081_/Q VDD VSS gf180mcu_fd_sc_mcu7t5v0__mux2_2
XFILLER_120_37 VDD VSS VDD VSS gf180mcu_fd_sc_mcu7t5v0__fillcap_16
XFILLER_222_171 VDD VSS VDD VSS gf180mcu_fd_sc_mcu7t5v0__fillcap_4
XFILLER_23_766 VDD VSS VDD VSS gf180mcu_fd_sc_mcu7t5v0__fillcap_4
XFILLER_195_524 VDD VSS VDD VSS gf180mcu_fd_sc_mcu7t5v0__fillcap_16
Xclkbuf_leaf_29_clk_i _3202_/CLK VSS VDD clkload5/I VDD VSS gf180mcu_fd_sc_mcu7t5v0__clkbuf_2
XFILLER_148_451 VDD VSS VDD VSS gf180mcu_fd_sc_mcu7t5v0__fillcap_4
XFILLER_136_657 VDD VSS VDD VSS gf180mcu_fd_sc_mcu7t5v0__fillcap_8
XFILLER_135_134 VDD VSS VDD VSS gf180mcu_fd_sc_mcu7t5v0__fillcap_4
XFILLER_1_136 VDD VSS VDD VSS gf180mcu_fd_sc_mcu7t5v0__fillcap_4
XFILLER_89_298 VDD VSS VDD VSS gf180mcu_fd_sc_mcu7t5v0__fillcap_8
XFILLER_77_416 VDD VSS VDD VSS gf180mcu_fd_sc_mcu7t5v0__fillcap_4
XFILLER_132_885 VDD VSS VDD VSS gf180mcu_fd_sc_mcu7t5v0__fillcap_4
XFILLER_218_411 VDD VSS VDD VSS gf180mcu_fd_sc_mcu7t5v0__fillcap_4
XFILLER_218_444 VDD VSS VDD VSS gf180mcu_fd_sc_mcu7t5v0__fillcap_8
XFILLER_246_731 VDD VSS VDD VSS gf180mcu_fd_sc_mcu7t5v0__fillcap_4
XFILLER_258_591 VDD VSS VDD VSS gf180mcu_fd_sc_mcu7t5v0__fillcap_4
XFILLER_92_419 VDD VSS VDD VSS gf180mcu_fd_sc_mcu7t5v0__fillcap_4
XFILLER_161_66 VDD VSS VDD VSS gf180mcu_fd_sc_mcu7t5v0__fillcap_4
XFILLER_18_527 VDD VSS VDD VSS gf180mcu_fd_sc_mcu7t5v0__fillcap_64
XFILLER_205_127 VDD VSS VDD VSS gf180mcu_fd_sc_mcu7t5v0__fillcap_8
XFILLER_45_346 VDD VSS VDD VSS gf180mcu_fd_sc_mcu7t5v0__fillcap_4
XFILLER_202_801 VDD VSS VDD VSS gf180mcu_fd_sc_mcu7t5v0__fillcap_4
XFILLER_199_874 VDD VSS VDD VSS gf180mcu_fd_sc_mcu7t5v0__fillcap_16
XFILLER_13_276 VDD VSS VDD VSS gf180mcu_fd_sc_mcu7t5v0__fillcap_4
Xclkload17 VSS clkload17/Z _3340_/CLK VDD VDD VSS gf180mcu_fd_sc_mcu7t5v0__clkbuf_1
Xclkload39 VSS clkload39/Z _2958_/CLK VDD VDD VSS gf180mcu_fd_sc_mcu7t5v0__clkbuf_1
XFILLER_126_123 VDD VSS VDD VSS gf180mcu_fd_sc_mcu7t5v0__fillcap_8
Xclkload28 VSS clkload28/ZN _3274_/CLK VDD VDD VSS gf180mcu_fd_sc_mcu7t5v0__inv_2
XFILLER_108_871 VDD VSS VDD VSS gf180mcu_fd_sc_mcu7t5v0__fillcap_4
XFILLER_5_486 VDD VSS VDD VSS gf180mcu_fd_sc_mcu7t5v0__fillcap_4
XFILLER_96_714 VDD VSS VDD VSS gf180mcu_fd_sc_mcu7t5v0__fillcap_16
XFILLER_123_874 VDD VSS VDD VSS gf180mcu_fd_sc_mcu7t5v0__fillcap_16
XFILLER_209_422 VDD VSS VDD VSS gf180mcu_fd_sc_mcu7t5v0__fillcap_8
X_3020_ VDD _3020_/Q _3409_/CLK VSS _3020_/D VDD VSS gf180mcu_fd_sc_mcu7t5v0__dffq_1
XFILLER_236_241 VDD VSS VDD VSS gf180mcu_fd_sc_mcu7t5v0__fillcap_4
XFILLER_224_403 VDD VSS VDD VSS gf180mcu_fd_sc_mcu7t5v0__fillcap_8
XFILLER_37_836 VDD VSS VDD VSS gf180mcu_fd_sc_mcu7t5v0__fillcap_4
XFILLER_49_696 VDD VSS VDD VSS gf180mcu_fd_sc_mcu7t5v0__fillcap_4
XFILLER_204_171 VDD VSS VDD VSS gf180mcu_fd_sc_mcu7t5v0__fillcap_4
XFILLER_177_524 VDD VSS VDD VSS gf180mcu_fd_sc_mcu7t5v0__fillcap_4
XFILLER_192_505 VDD VSS VDD VSS gf180mcu_fd_sc_mcu7t5v0__fillcap_4
X_2804_ _2804_/D _2804_/Q wire153/I VSS _3362_/CLK VDD VDD VSS gf180mcu_fd_sc_mcu7t5v0__dffrnq_1
XFILLER_192_527 VDD VSS VDD VSS gf180mcu_fd_sc_mcu7t5v0__fillcap_16
X_2735_ _2735_/S VDD VSS _2735_/Z _2734_/Z _2733_/Z VDD VSS gf180mcu_fd_sc_mcu7t5v0__mux2_2
X_2666_ VDD VSS _3310_/D _2666_/A1 _2666_/A2 VDD VSS gf180mcu_fd_sc_mcu7t5v0__nand2_1
X_1617_ VDD VSS _1619_/A2 _3426_/Q _3417_/D VDD VSS gf180mcu_fd_sc_mcu7t5v0__xnor2_1
XFILLER_160_457 VDD VSS VDD VSS gf180mcu_fd_sc_mcu7t5v0__fillcap_64
X_2597_ wire12/Z VDD VSS _3265_/D _3257_/Q _3265_/Q VDD VSS gf180mcu_fd_sc_mcu7t5v0__mux2_2
X_1548_ _3191_/Q _1549_/B _1551_/A1 VDD VSS _3343_/D _2487_/A2 VDD VSS gf180mcu_fd_sc_mcu7t5v0__oai22_1
XFILLER_114_885 VDD VSS VDD VSS gf180mcu_fd_sc_mcu7t5v0__fillcap_4
XFILLER_59_416 VDD VSS VDD VSS gf180mcu_fd_sc_mcu7t5v0__fillcap_4
X_1479_ VDD VSS _3411_/D _3434_/D _1877_/S VDD VSS gf180mcu_fd_sc_mcu7t5v0__xor2_1
XFILLER_228_731 VDD VSS VDD VSS gf180mcu_fd_sc_mcu7t5v0__fillcap_4
X_3218_ _3218_/D _3218_/Q wire145/I VSS _3329_/CLK VDD VDD VSS gf180mcu_fd_sc_mcu7t5v0__dffrnq_1
X_3149_ _3149_/D _3149_/Q wire153/I VSS _3357_/CLK VDD VDD VSS gf180mcu_fd_sc_mcu7t5v0__dffrnq_1
XFILLER_199_104 VDD VSS VDD VSS gf180mcu_fd_sc_mcu7t5v0__fillcap_16
XFILLER_27_346 VDD VSS VDD VSS gf180mcu_fd_sc_mcu7t5v0__fillcap_4
XFILLER_91_18 VDD VSS VDD VSS gf180mcu_fd_sc_mcu7t5v0__fillcap_8
XFILLER_196_877 VDD VSS VDD VSS gf180mcu_fd_sc_mcu7t5v0__fillcap_8
XFILLER_149_760 VDD VSS VDD VSS gf180mcu_fd_sc_mcu7t5v0__fillcap_8
XFILLER_108_123 VDD VSS VDD VSS gf180mcu_fd_sc_mcu7t5v0__fillcap_8
XFILLER_136_465 VDD VSS VDD VSS gf180mcu_fd_sc_mcu7t5v0__fillcap_4
XFILLER_105_874 VDD VSS VDD VSS gf180mcu_fd_sc_mcu7t5v0__fillcap_16
XFILLER_120_877 VDD VSS VDD VSS gf180mcu_fd_sc_mcu7t5v0__fillcap_8
XFILLER_1_27 VDD VSS VDD VSS gf180mcu_fd_sc_mcu7t5v0__fillcap_32
XFILLER_218_241 VDD VSS VDD VSS gf180mcu_fd_sc_mcu7t5v0__fillcap_4
XFILLER_19_836 VDD VSS VDD VSS gf180mcu_fd_sc_mcu7t5v0__fillcap_4
XFILLER_85_290 VDD VSS VDD VSS gf180mcu_fd_sc_mcu7t5v0__fillcap_4
XFILLER_202_642 VDD VSS VDD VSS gf180mcu_fd_sc_mcu7t5v0__fillcap_8
XFILLER_174_527 VDD VSS VDD VSS gf180mcu_fd_sc_mcu7t5v0__fillcap_16
XFILLER_186_387 VDD VSS VDD VSS gf180mcu_fd_sc_mcu7t5v0__fillcap_8
XFILLER_139_270 VDD VSS VDD VSS gf180mcu_fd_sc_mcu7t5v0__fillcap_8
XFILLER_142_402 VDD VSS VDD VSS gf180mcu_fd_sc_mcu7t5v0__fillcap_8
X_2520_ _2520_/A3 VDD VSS _2529_/A1 _3221_/Q _2520_/A2 VDD VSS gf180mcu_fd_sc_mcu7t5v0__nand3_1
X_2451_ VDD _2451_/B _1654_/Z _2452_/A2 _3201_/Q VSS VDD VSS gf180mcu_fd_sc_mcu7t5v0__oai21_1
XFILLER_114_115 VDD VSS VDD VSS gf180mcu_fd_sc_mcu7t5v0__fillcap_4
XFILLER_142_457 VDD VSS VDD VSS gf180mcu_fd_sc_mcu7t5v0__fillcap_4
XFILLER_216_47 VDD VSS VDD VSS gf180mcu_fd_sc_mcu7t5v0__fillcap_32
X_1402_ VDD VSS _3204_/Q _1716_/A2 VDD VSS gf180mcu_fd_sc_mcu7t5v0__clkinv_1
X_2382_ VDD VSS _2396_/B wire110/Z _2467_/A1 VDD VSS gf180mcu_fd_sc_mcu7t5v0__nand2_1
XFILLER_110_354 VDD VSS VDD VSS gf180mcu_fd_sc_mcu7t5v0__fillcap_16
XFILLER_110_387 VDD VSS VDD VSS gf180mcu_fd_sc_mcu7t5v0__fillcap_32
X_3003_ VDD _3003_/Q _3022_/CLK VSS _3003_/D VDD VSS gf180mcu_fd_sc_mcu7t5v0__dffq_1
Xinput4 VDD spi_cs_ni VSS input4/Z VDD VSS gf180mcu_fd_sc_mcu7t5v0__dlyb_1
XFILLER_240_737 VDD VSS VDD VSS gf180mcu_fd_sc_mcu7t5v0__fillcap_64
XFILLER_252_597 VDD VSS VDD VSS gf180mcu_fd_sc_mcu7t5v0__fillcap_64
XFILLER_196_107 VDD VSS VDD VSS gf180mcu_fd_sc_mcu7t5v0__fillcap_16
XFILLER_91_282 VDD VSS VDD VSS gf180mcu_fd_sc_mcu7t5v0__fillcap_32
XFILLER_189_181 VDD VSS VDD VSS gf180mcu_fd_sc_mcu7t5v0__fillcap_16
XFILLER_178_877 VDD VSS VDD VSS gf180mcu_fd_sc_mcu7t5v0__fillcap_8
XFILLER_165_527 VDD VSS VDD VSS gf180mcu_fd_sc_mcu7t5v0__fillcap_8
XFILLER_193_836 VDD VSS VDD VSS gf180mcu_fd_sc_mcu7t5v0__fillcap_4
X_2718_ _2962_/Q VSS VDD _2946_/Q _2954_/Q _2718_/S0 _2938_/Q _2742_/S1 wire53/I VDD
+ VSS gf180mcu_fd_sc_mcu7t5v0__mux4_1
XFILLER_145_262 VDD VSS VDD VSS gf180mcu_fd_sc_mcu7t5v0__fillcap_16
XFILLER_105_104 VDD VSS VDD VSS gf180mcu_fd_sc_mcu7t5v0__fillcap_16
XFILLER_118_498 VDD VSS VDD VSS gf180mcu_fd_sc_mcu7t5v0__fillcap_8
XFILLER_161_766 VDD VSS VDD VSS gf180mcu_fd_sc_mcu7t5v0__fillcap_4
X_2649_ VDD VSS _2752_/B _2020_/B _2749_/C VDD VSS gf180mcu_fd_sc_mcu7t5v0__or2_1
XFILLER_99_360 VDD VSS VDD VSS gf180mcu_fd_sc_mcu7t5v0__fillcap_4
XFILLER_120_107 VDD VSS VDD VSS gf180mcu_fd_sc_mcu7t5v0__fillcap_16
XFILLER_99_393 VDD VSS VDD VSS gf180mcu_fd_sc_mcu7t5v0__fillcap_8
XFILLER_102_877 VDD VSS VDD VSS gf180mcu_fd_sc_mcu7t5v0__fillcap_8
XFILLER_262_317 VDD VSS VDD VSS gf180mcu_fd_sc_mcu7t5v0__fillcap_64
XFILLER_83_772 VDD VSS VDD VSS gf180mcu_fd_sc_mcu7t5v0__fillcap_64
XFILLER_188_619 VDD VSS VDD VSS gf180mcu_fd_sc_mcu7t5v0__fillcap_4
XFILLER_35_66 VDD VSS VDD VSS gf180mcu_fd_sc_mcu7t5v0__fillcap_4
XFILLER_230_247 VDD VSS VDD VSS gf180mcu_fd_sc_mcu7t5v0__fillcap_64
XFILLER_156_527 VDD VSS VDD VSS gf180mcu_fd_sc_mcu7t5v0__fillcap_64
XFILLER_195_162 VDD VSS VDD VSS gf180mcu_fd_sc_mcu7t5v0__fillcap_4
XFILLER_136_2 VDD VSS VDD VSS gf180mcu_fd_sc_mcu7t5v0__fillcap_8
XFILLER_195_184 VDD VSS VDD VSS gf180mcu_fd_sc_mcu7t5v0__fillcap_8
XFILLER_124_424 VDD VSS VDD VSS gf180mcu_fd_sc_mcu7t5v0__fillcap_16
XFILLER_124_457 VDD VSS VDD VSS gf180mcu_fd_sc_mcu7t5v0__fillcap_64
XFILLER_151_298 VDD VSS VDD VSS gf180mcu_fd_sc_mcu7t5v0__fillcap_32
XFILLER_254_807 VDD VSS VDD VSS gf180mcu_fd_sc_mcu7t5v0__fillcap_64
XFILLER_266_667 VDD VSS VDD VSS gf180mcu_fd_sc_mcu7t5v0__fillcap_64
XFILLER_61_422 VDD VSS VDD VSS gf180mcu_fd_sc_mcu7t5v0__fillcap_64
XFILLER_222_737 VDD VSS VDD VSS gf180mcu_fd_sc_mcu7t5v0__fillcap_64
XFILLER_234_597 VDD VSS VDD VSS gf180mcu_fd_sc_mcu7t5v0__fillcap_64
XFILLER_73_282 VDD VSS VDD VSS gf180mcu_fd_sc_mcu7t5v0__fillcap_16
XFILLER_178_107 VDD VSS VDD VSS gf180mcu_fd_sc_mcu7t5v0__fillcap_16
X_1951_ _1954_/S VDD VSS _3001_/D _3001_/Q _2015_/I0 VDD VSS gf180mcu_fd_sc_mcu7t5v0__mux2_2
XFILLER_175_836 VDD VSS VDD VSS gf180mcu_fd_sc_mcu7t5v0__fillcap_4
XFILLER_186_151 VDD VSS VDD VSS gf180mcu_fd_sc_mcu7t5v0__fillcap_16
X_1882_ wire36/Z VDD VSS _2943_/D _2943_/Q wire122/Z VDD VSS gf180mcu_fd_sc_mcu7t5v0__mux2_2
XFILLER_51_2 VDD VSS VDD VSS gf180mcu_fd_sc_mcu7t5v0__fillcap_64
X_2503_ _2517_/C1 _3337_/Q VDD VSS _2505_/A1 _3313_/Q _1640_/I VDD VSS gf180mcu_fd_sc_mcu7t5v0__aoi22_1
X_2434_ _2434_/B _2448_/C VDD VSS _2436_/A2 _3382_/Q _2428_/Z VDD VSS gf180mcu_fd_sc_mcu7t5v0__oai211_1
X_2365_ _2365_/A3 _2365_/A4 VDD VSS _2467_/A1 _2494_/C _2365_/A2 VDD VSS gf180mcu_fd_sc_mcu7t5v0__nand4_1
XFILLER_97_842 VDD VSS VDD VSS gf180mcu_fd_sc_mcu7t5v0__fillcap_32
X_2296_ VDD VSS _2310_/A1 _2474_/B _2314_/A3 VDD VSS gf180mcu_fd_sc_mcu7t5v0__nor2_1
XFILLER_256_177 VDD VSS VDD VSS gf180mcu_fd_sc_mcu7t5v0__fillcap_64
XFILLER_244_317 VDD VSS VDD VSS gf180mcu_fd_sc_mcu7t5v0__fillcap_64
XFILLER_65_772 VDD VSS VDD VSS gf180mcu_fd_sc_mcu7t5v0__fillcap_64
XFILLER_92_591 VDD VSS VDD VSS gf180mcu_fd_sc_mcu7t5v0__fillcap_4
XFILLER_80_731 VDD VSS VDD VSS gf180mcu_fd_sc_mcu7t5v0__fillcap_4
XFILLER_212_247 VDD VSS VDD VSS gf180mcu_fd_sc_mcu7t5v0__fillcap_64
XFILLER_138_527 VDD VSS VDD VSS gf180mcu_fd_sc_mcu7t5v0__fillcap_16
XFILLER_21_842 VDD VSS VDD VSS gf180mcu_fd_sc_mcu7t5v0__fillcap_32
XFILLER_193_666 VDD VSS VDD VSS gf180mcu_fd_sc_mcu7t5v0__fillcap_32
XFILLER_146_571 VDD VSS VDD VSS gf180mcu_fd_sc_mcu7t5v0__fillcap_16
XFILLER_106_457 VDD VSS VDD VSS gf180mcu_fd_sc_mcu7t5v0__fillcap_8
XFILLER_153_34 VDD VSS VDD VSS gf180mcu_fd_sc_mcu7t5v0__fillcap_16
XFILLER_87_352 VDD VSS VDD VSS gf180mcu_fd_sc_mcu7t5v0__fillcap_64
XFILLER_248_667 VDD VSS VDD VSS gf180mcu_fd_sc_mcu7t5v0__fillcap_64
XFILLER_236_807 VDD VSS VDD VSS gf180mcu_fd_sc_mcu7t5v0__fillcap_64
XFILLER_263_626 VDD VSS VDD VSS gf180mcu_fd_sc_mcu7t5v0__fillcap_4
Xmax_cap33 VSS _1897_/S _1895_/S VDD VDD VSS gf180mcu_fd_sc_mcu7t5v0__buf_2
Xmax_cap22 VSS _2288_/S _2289_/S VDD VDD VSS gf180mcu_fd_sc_mcu7t5v0__buf_2
XFILLER_43_422 VDD VSS VDD VSS gf180mcu_fd_sc_mcu7t5v0__fillcap_64
XFILLER_204_737 VDD VSS VDD VSS gf180mcu_fd_sc_mcu7t5v0__fillcap_64
XFILLER_204_726 VDD VSS VDD VSS gf180mcu_fd_sc_mcu7t5v0__fillcap_8
XFILLER_253_2 VDD VSS VDD VSS gf180mcu_fd_sc_mcu7t5v0__fillcap_64
XFILLER_55_282 VDD VSS VDD VSS gf180mcu_fd_sc_mcu7t5v0__fillcap_64
XFILLER_216_597 VDD VSS VDD VSS gf180mcu_fd_sc_mcu7t5v0__fillcap_64
XFILLER_70_241 VDD VSS VDD VSS gf180mcu_fd_sc_mcu7t5v0__fillcap_4
XFILLER_231_556 VDD VSS VDD VSS gf180mcu_fd_sc_mcu7t5v0__fillcap_4
XFILLER_102_93 VDD VSS VDD VSS gf180mcu_fd_sc_mcu7t5v0__fillcap_4
XFILLER_184_644 VDD VSS VDD VSS gf180mcu_fd_sc_mcu7t5v0__fillcap_16
XFILLER_169_696 VDD VSS VDD VSS gf180mcu_fd_sc_mcu7t5v0__fillcap_4
XFILLER_157_836 VDD VSS VDD VSS gf180mcu_fd_sc_mcu7t5v0__fillcap_4
XFILLER_11_352 VDD VSS VDD VSS gf180mcu_fd_sc_mcu7t5v0__fillcap_64
XFILLER_125_766 VDD VSS VDD VSS gf180mcu_fd_sc_mcu7t5v0__fillcap_4
XFILLER_124_265 VDD VSS VDD VSS gf180mcu_fd_sc_mcu7t5v0__fillcap_8
XFILLER_3_562 VDD VSS VDD VSS gf180mcu_fd_sc_mcu7t5v0__fillcap_64
XFILLER_79_842 VDD VSS VDD VSS gf180mcu_fd_sc_mcu7t5v0__fillcap_32
XFILLER_94_801 VDD VSS VDD VSS gf180mcu_fd_sc_mcu7t5v0__fillcap_4
XFILLER_87_72 VDD VSS VDD VSS gf180mcu_fd_sc_mcu7t5v0__fillcap_16
X_2150_ VDD VSS _2154_/A3 _3148_/Q _3149_/Q VDD VSS gf180mcu_fd_sc_mcu7t5v0__nor2_1
XFILLER_238_177 VDD VSS VDD VSS gf180mcu_fd_sc_mcu7t5v0__fillcap_64
XFILLER_226_317 VDD VSS VDD VSS gf180mcu_fd_sc_mcu7t5v0__fillcap_64
X_2081_ VDD VSS _2120_/B _2074_/Z _2110_/A2 VDD VSS gf180mcu_fd_sc_mcu7t5v0__nand2_1
XFILLER_253_136 VDD VSS VDD VSS gf180mcu_fd_sc_mcu7t5v0__fillcap_4
XFILLER_47_772 VDD VSS VDD VSS gf180mcu_fd_sc_mcu7t5v0__fillcap_64
XFILLER_74_591 VDD VSS VDD VSS gf180mcu_fd_sc_mcu7t5v0__fillcap_4
XFILLER_62_731 VDD VSS VDD VSS gf180mcu_fd_sc_mcu7t5v0__fillcap_4
X_2983_ VDD _2983_/Q _2994_/CLK VSS _2983_/D VDD VSS gf180mcu_fd_sc_mcu7t5v0__dffq_1
X_1934_ _1935_/S VDD VSS _2987_/D wire114/I _2987_/Q VDD VSS gf180mcu_fd_sc_mcu7t5v0__mux2_2
XFILLER_175_622 VDD VSS VDD VSS gf180mcu_fd_sc_mcu7t5v0__fillcap_8
XFILLER_30_661 VDD VSS VDD VSS gf180mcu_fd_sc_mcu7t5v0__fillcap_4
X_1865_ _1869_/S VDD VSS _2928_/D wire133/Z _2928_/Q VDD VSS gf180mcu_fd_sc_mcu7t5v0__mux2_2
X_1796_ VDD VSS _1796_/Z _3369_/Q _1796_/A2 VDD VSS gf180mcu_fd_sc_mcu7t5v0__and2_1
XFILLER_128_582 VDD VSS VDD VSS gf180mcu_fd_sc_mcu7t5v0__fillcap_8
XFILLER_107_38 VDD VSS VDD VSS gf180mcu_fd_sc_mcu7t5v0__fillcap_32
X_2417_ _2896_/Q VSS VDD _2880_/Q _2888_/Q _2460_/S0 _2872_/Q _3381_/Q _2417_/Z VDD
+ VSS gf180mcu_fd_sc_mcu7t5v0__mux4_1
XFILLER_115_298 VDD VSS VDD VSS gf180mcu_fd_sc_mcu7t5v0__fillcap_4
XFILLER_88_149 VDD VSS VDD VSS gf180mcu_fd_sc_mcu7t5v0__fillcap_4
X_3397_ _3397_/D _3397_/Q _3403_/RN VSS _3403_/CLK VDD VDD VSS gf180mcu_fd_sc_mcu7t5v0__dffrnq_1
XFILLER_69_352 VDD VSS VDD VSS gf180mcu_fd_sc_mcu7t5v0__fillcap_64
XFILLER_218_807 VDD VSS VDD VSS gf180mcu_fd_sc_mcu7t5v0__fillcap_64
X_2348_ VDD VSS _2490_/A2 _2484_/B1 _2348_/A2 VDD VSS gf180mcu_fd_sc_mcu7t5v0__nand2_1
XFILLER_84_311 VDD VSS VDD VSS gf180mcu_fd_sc_mcu7t5v0__fillcap_4
XFILLER_245_626 VDD VSS VDD VSS gf180mcu_fd_sc_mcu7t5v0__fillcap_4
XFILLER_257_486 VDD VSS VDD VSS gf180mcu_fd_sc_mcu7t5v0__fillcap_4
X_2279_ VDD VSS _2280_/B _3175_/Q wire24/Z VDD VSS gf180mcu_fd_sc_mcu7t5v0__nor2_1
XFILLER_25_422 VDD VSS VDD VSS gf180mcu_fd_sc_mcu7t5v0__fillcap_64
XFILLER_37_282 VDD VSS VDD VSS gf180mcu_fd_sc_mcu7t5v0__fillcap_64
XFILLER_52_241 VDD VSS VDD VSS gf180mcu_fd_sc_mcu7t5v0__fillcap_4
XFILLER_139_836 VDD VSS VDD VSS gf180mcu_fd_sc_mcu7t5v0__fillcap_4
XFILLER_181_603 VDD VSS VDD VSS gf180mcu_fd_sc_mcu7t5v0__fillcap_4
XFILLER_20_171 VDD VSS VDD VSS gf180mcu_fd_sc_mcu7t5v0__fillcap_4
XFILLER_107_766 VDD VSS VDD VSS gf180mcu_fd_sc_mcu7t5v0__fillcap_4
XFILLER_267_206 VDD VSS VDD VSS gf180mcu_fd_sc_mcu7t5v0__fillcap_4
XFILLER_88_661 VDD VSS VDD VSS gf180mcu_fd_sc_mcu7t5v0__fillcap_4
XFILLER_76_801 VDD VSS VDD VSS gf180mcu_fd_sc_mcu7t5v0__fillcap_4
XFILLER_208_317 VDD VSS VDD VSS gf180mcu_fd_sc_mcu7t5v0__fillcap_8
XFILLER_235_136 VDD VSS VDD VSS gf180mcu_fd_sc_mcu7t5v0__fillcap_4
XFILLER_29_772 VDD VSS VDD VSS gf180mcu_fd_sc_mcu7t5v0__fillcap_64
XFILLER_56_591 VDD VSS VDD VSS gf180mcu_fd_sc_mcu7t5v0__fillcap_4
XFILLER_44_731 VDD VSS VDD VSS gf180mcu_fd_sc_mcu7t5v0__fillcap_4
XFILLER_189_736 VDD VSS VDD VSS gf180mcu_fd_sc_mcu7t5v0__fillcap_32
XFILLER_189_63 VDD VSS VDD VSS gf180mcu_fd_sc_mcu7t5v0__fillcap_4
Xspi_opentarget_i3c_top_174 irq_o_CS VDD VSS VDD VSS gf180mcu_fd_sc_mcu7t5v0__tiel
XFILLER_12_661 VDD VSS VDD VSS gf180mcu_fd_sc_mcu7t5v0__fillcap_4
Xspi_opentarget_i3c_top_185 sda_pad_CS VDD VSS VDD VSS gf180mcu_fd_sc_mcu7t5v0__tiel
Xspi_opentarget_i3c_top_196 spi_miso_o_PDRV0 VDD VSS VDD VSS gf180mcu_fd_sc_mcu7t5v0__tiel
XFILLER_129_346 VDD VSS VDD VSS gf180mcu_fd_sc_mcu7t5v0__fillcap_4
XFILLER_129_368 VDD VSS VDD VSS gf180mcu_fd_sc_mcu7t5v0__fillcap_4
X_1650_ VDD VSS _1654_/A3 _2331_/B _2803_/Q VDD VSS gf180mcu_fd_sc_mcu7t5v0__nor2_1
XFILLER_7_142 VDD VSS VDD VSS gf180mcu_fd_sc_mcu7t5v0__fillcap_64
XFILLER_172_647 VDD VSS VDD VSS gf180mcu_fd_sc_mcu7t5v0__fillcap_16
X_1581_ VDD _2143_/B _2191_/A3 _1593_/A2 _3147_/Q VSS VDD VSS gf180mcu_fd_sc_mcu7t5v0__oai21_1
XFILLER_144_338 VDD VSS VDD VSS gf180mcu_fd_sc_mcu7t5v0__fillcap_16
X_3320_ _3320_/D _3320_/Q wire145/Z VSS _3320_/CLK VDD VDD VSS gf180mcu_fd_sc_mcu7t5v0__dffrnq_1
XFILLER_4_871 VDD VSS VDD VSS gf180mcu_fd_sc_mcu7t5v0__fillcap_4
X_3251_ _3251_/D _3251_/Q wire165/Z VSS clkload7/I VDD VDD VSS gf180mcu_fd_sc_mcu7t5v0__dffrnq_1
X_3182_ VDD _3182_/Q _3182_/CLK VSS _3182_/D VDD VSS gf180mcu_fd_sc_mcu7t5v0__dffq_1
X_2202_ VDD VSS _2202_/Z _2128_/Z _2654_/A3 VDD VSS gf180mcu_fd_sc_mcu7t5v0__or2_1
XFILLER_66_311 VDD VSS VDD VSS gf180mcu_fd_sc_mcu7t5v0__fillcap_4
XFILLER_239_486 VDD VSS VDD VSS gf180mcu_fd_sc_mcu7t5v0__fillcap_4
XFILLER_227_626 VDD VSS VDD VSS gf180mcu_fd_sc_mcu7t5v0__fillcap_4
X_2133_ _2138_/S VDD VSS _3121_/D wire95/Z _3121_/Q VDD VSS gf180mcu_fd_sc_mcu7t5v0__mux2_2
XFILLER_14_2 VDD VSS VDD VSS gf180mcu_fd_sc_mcu7t5v0__fillcap_32
XFILLER_78_193 VDD VSS VDD VSS gf180mcu_fd_sc_mcu7t5v0__fillcap_8
X_2064_ _2064_/B VDD VSS _3094_/D _2305_/A2 _2072_/S VDD VSS gf180mcu_fd_sc_mcu7t5v0__aoi21_1
XFILLER_19_282 VDD VSS VDD VSS gf180mcu_fd_sc_mcu7t5v0__fillcap_64
XFILLER_34_241 VDD VSS VDD VSS gf180mcu_fd_sc_mcu7t5v0__fillcap_4
XFILLER_249_66 VDD VSS VDD VSS gf180mcu_fd_sc_mcu7t5v0__fillcap_4
X_2966_ VDD _2966_/Q clkload9/I VSS _2966_/D VDD VSS gf180mcu_fd_sc_mcu7t5v0__dffq_1
X_2897_ VDD _2897_/Q _2899_/CLK VSS _2897_/D VDD VSS gf180mcu_fd_sc_mcu7t5v0__dffq_1
X_1917_ _1917_/S VDD VSS _2972_/D _2972_/Q wire113/Z VDD VSS gf180mcu_fd_sc_mcu7t5v0__mux2_2
X_1848_ _1851_/S VDD VSS _2913_/D wire131/Z _2913_/Q VDD VSS gf180mcu_fd_sc_mcu7t5v0__mux2_2
XFILLER_135_338 VDD VSS VDD VSS gf180mcu_fd_sc_mcu7t5v0__fillcap_8
XFILLER_162_157 VDD VSS VDD VSS gf180mcu_fd_sc_mcu7t5v0__fillcap_4
X_1779_ _1786_/S VDD VSS _2853_/D _1788_/I1 _2853_/Q VDD VSS gf180mcu_fd_sc_mcu7t5v0__mux2_2
XFILLER_116_574 VDD VSS VDD VSS gf180mcu_fd_sc_mcu7t5v0__fillcap_4
XFILLER_249_206 VDD VSS VDD VSS gf180mcu_fd_sc_mcu7t5v0__fillcap_4
X_3449_ _3449_/D _3449_/Q _3455_/RN VSS clkload7/I VDD VDD VSS gf180mcu_fd_sc_mcu7t5v0__dffrnq_1
XFILLER_58_801 VDD VSS VDD VSS gf180mcu_fd_sc_mcu7t5v0__fillcap_4
XFILLER_38_591 VDD VSS VDD VSS gf180mcu_fd_sc_mcu7t5v0__fillcap_4
XFILLER_26_731 VDD VSS VDD VSS gf180mcu_fd_sc_mcu7t5v0__fillcap_4
XFILLER_84_185 VDD VSS VDD VSS gf180mcu_fd_sc_mcu7t5v0__fillcap_4
XFILLER_213_342 VDD VSS VDD VSS gf180mcu_fd_sc_mcu7t5v0__fillcap_8
XFILLER_159_66 VDD VSS VDD VSS gf180mcu_fd_sc_mcu7t5v0__fillcap_4
XFILLER_43_66 VDD VSS VDD VSS gf180mcu_fd_sc_mcu7t5v0__fillcap_4
XFILLER_159_88 VDD VSS VDD VSS gf180mcu_fd_sc_mcu7t5v0__fillcap_4
XFILLER_193_282 VDD VSS VDD VSS gf180mcu_fd_sc_mcu7t5v0__fillcap_32
XFILLER_4_101 VDD VSS VDD VSS gf180mcu_fd_sc_mcu7t5v0__fillcap_4
XFILLER_181_499 VDD VSS VDD VSS gf180mcu_fd_sc_mcu7t5v0__fillcap_16
XFILLER_1_874 VDD VSS VDD VSS gf180mcu_fd_sc_mcu7t5v0__fillcap_16
XFILLER_110_728 VDD VSS VDD VSS gf180mcu_fd_sc_mcu7t5v0__fillcap_4
XFILLER_48_311 VDD VSS VDD VSS gf180mcu_fd_sc_mcu7t5v0__fillcap_4
XFILLER_209_626 VDD VSS VDD VSS gf180mcu_fd_sc_mcu7t5v0__fillcap_4
XFILLER_209_648 VDD VSS VDD VSS gf180mcu_fd_sc_mcu7t5v0__fillcap_4
XFILLER_16_241 VDD VSS VDD VSS gf180mcu_fd_sc_mcu7t5v0__fillcap_4
XFILLER_90_155 VDD VSS VDD VSS gf180mcu_fd_sc_mcu7t5v0__fillcap_4
XFILLER_84_84 VDD VSS VDD VSS gf180mcu_fd_sc_mcu7t5v0__fillcap_16
XFILLER_90_177 VDD VSS VDD VSS gf180mcu_fd_sc_mcu7t5v0__fillcap_16
X_2820_ VDD _2820_/Q _2867_/CLK VSS _2820_/D VDD VSS gf180mcu_fd_sc_mcu7t5v0__dffq_1
X_2751_ VDD VSS _2752_/A2 wire104/Z _2758_/A3 VDD VSS gf180mcu_fd_sc_mcu7t5v0__nand2_1
XFILLER_185_772 VDD VSS VDD VSS gf180mcu_fd_sc_mcu7t5v0__fillcap_64
X_1702_ VDD VSS _2262_/A1 _3205_/Q _1716_/B VDD VSS gf180mcu_fd_sc_mcu7t5v0__nand2_1
XFILLER_8_451 VDD VSS VDD VSS gf180mcu_fd_sc_mcu7t5v0__fillcap_4
X_2682_ _3023_/Q VSS VDD _3007_/Q _3015_/Q _2722_/S0 _2999_/Q wire60/Z _2682_/Z VDD
+ VSS gf180mcu_fd_sc_mcu7t5v0__mux4_1
X_1633_ _3116_/Q _3117_/Q VDD VSS _2076_/A2 _3115_/Q _1633_/A2 VDD VSS gf180mcu_fd_sc_mcu7t5v0__aoi211_1
XFILLER_132_308 VDD VSS VDD VSS gf180mcu_fd_sc_mcu7t5v0__fillcap_4
XFILLER_141_842 VDD VSS VDD VSS gf180mcu_fd_sc_mcu7t5v0__fillcap_32
X_1564_ VDD VSS _1565_/A3 _3345_/Q _1564_/A2 VDD VSS gf180mcu_fd_sc_mcu7t5v0__nand2_1
XFILLER_125_360 VDD VSS VDD VSS gf180mcu_fd_sc_mcu7t5v0__fillcap_4
X_1495_ _3366_/Q VDD VSS _1500_/A4 _3458_/D _3458_/Q VDD VSS gf180mcu_fd_sc_mcu7t5v0__aoi21_1
XFILLER_98_255 VDD VSS VDD VSS gf180mcu_fd_sc_mcu7t5v0__fillcap_4
X_3303_ _3303_/D _3303_/Q _3335_/RN VSS _3453_/CLK VDD VDD VSS gf180mcu_fd_sc_mcu7t5v0__dffrnq_1
XFILLER_98_299 VDD VSS VDD VSS gf180mcu_fd_sc_mcu7t5v0__fillcap_16
X_3234_ _3234_/D _3234_/Q wire145/I VSS _3274_/CLK VDD VDD VSS gf180mcu_fd_sc_mcu7t5v0__dffrnq_1
X_3165_ _3165_/D _3165_/Q wire151/I VSS _3165_/CLK VDD VDD VSS gf180mcu_fd_sc_mcu7t5v0__dffrnq_1
X_2116_ _2116_/A3 VDD VSS _2118_/B _3113_/Q _2120_/B VDD VSS gf180mcu_fd_sc_mcu7t5v0__nand3_1
X_3096_ _3096_/D _3096_/Q wire145/Z VSS _3159_/CLK VDD VDD VSS gf180mcu_fd_sc_mcu7t5v0__dffrnq_1
X_2047_ _2059_/S VDD VSS _3080_/D _3296_/Q _3080_/Q VDD VSS gf180mcu_fd_sc_mcu7t5v0__mux2_2
XFILLER_70_807 VDD VSS VDD VSS gf180mcu_fd_sc_mcu7t5v0__fillcap_64
XFILLER_82_667 VDD VSS VDD VSS gf180mcu_fd_sc_mcu7t5v0__fillcap_64
X_2949_ VDD _2949_/Q _2958_/CLK VSS _2949_/D VDD VSS gf180mcu_fd_sc_mcu7t5v0__dffq_1
XFILLER_167_249 VDD VSS VDD VSS gf180mcu_fd_sc_mcu7t5v0__fillcap_16
XFILLER_50_597 VDD VSS VDD VSS gf180mcu_fd_sc_mcu7t5v0__fillcap_64
XFILLER_175_260 VDD VSS VDD VSS gf180mcu_fd_sc_mcu7t5v0__fillcap_4
XFILLER_129_47 VDD VSS VDD VSS gf180mcu_fd_sc_mcu7t5v0__fillcap_16
XFILLER_163_422 VDD VSS VDD VSS gf180mcu_fd_sc_mcu7t5v0__fillcap_4
XFILLER_135_157 VDD VSS VDD VSS gf180mcu_fd_sc_mcu7t5v0__fillcap_8
XFILLER_145_57 VDD VSS VDD VSS gf180mcu_fd_sc_mcu7t5v0__fillcap_8
XFILLER_131_352 VDD VSS VDD VSS gf180mcu_fd_sc_mcu7t5v0__fillcap_8
XFILLER_261_702 VDD VSS VDD VSS gf180mcu_fd_sc_mcu7t5v0__fillcap_64
XFILLER_199_842 VDD VSS VDD VSS gf180mcu_fd_sc_mcu7t5v0__fillcap_32
XFILLER_60_317 VDD VSS VDD VSS gf180mcu_fd_sc_mcu7t5v0__fillcap_64
XFILLER_241_492 VDD VSS VDD VSS gf180mcu_fd_sc_mcu7t5v0__fillcap_64
XFILLER_158_216 VDD VSS VDD VSS gf180mcu_fd_sc_mcu7t5v0__fillcap_4
XFILLER_167_772 VDD VSS VDD VSS gf180mcu_fd_sc_mcu7t5v0__fillcap_64
Xclkload29 VSS clkload29/Z _3059_/CLK VDD VDD VSS gf180mcu_fd_sc_mcu7t5v0__clkbuf_1
Xclkload18 VSS clkload18/Z _3448_/CLK VDD VDD VSS gf180mcu_fd_sc_mcu7t5v0__clkbuf_1
XFILLER_135_691 VDD VSS VDD VSS gf180mcu_fd_sc_mcu7t5v0__fillcap_8
XFILLER_123_842 VDD VSS VDD VSS gf180mcu_fd_sc_mcu7t5v0__fillcap_32
XFILLER_96_737 VDD VSS VDD VSS gf180mcu_fd_sc_mcu7t5v0__fillcap_64
XFILLER_251_212 VDD VSS VDD VSS gf180mcu_fd_sc_mcu7t5v0__fillcap_64
XFILLER_224_426 VDD VSS VDD VSS gf180mcu_fd_sc_mcu7t5v0__fillcap_16
XFILLER_91_431 VDD VSS VDD VSS gf180mcu_fd_sc_mcu7t5v0__fillcap_8
XFILLER_52_807 VDD VSS VDD VSS gf180mcu_fd_sc_mcu7t5v0__fillcap_64
XFILLER_64_667 VDD VSS VDD VSS gf180mcu_fd_sc_mcu7t5v0__fillcap_64
XFILLER_205_640 VDD VSS VDD VSS gf180mcu_fd_sc_mcu7t5v0__fillcap_4
XFILLER_221_59 VDD VSS VDD VSS gf180mcu_fd_sc_mcu7t5v0__fillcap_4
XFILLER_189_330 VDD VSS VDD VSS gf180mcu_fd_sc_mcu7t5v0__fillcap_4
X_2803_ _2803_/D _2803_/Q wire153/I VSS _3358_/CLK VDD VDD VSS gf180mcu_fd_sc_mcu7t5v0__dffrnq_1
XFILLER_32_597 VDD VSS VDD VSS gf180mcu_fd_sc_mcu7t5v0__fillcap_64
XFILLER_20_737 VDD VSS VDD VSS gf180mcu_fd_sc_mcu7t5v0__fillcap_64
XFILLER_81_2 VDD VSS VDD VSS gf180mcu_fd_sc_mcu7t5v0__fillcap_16
XFILLER_192_517 VDD VSS VDD VSS gf180mcu_fd_sc_mcu7t5v0__fillcap_8
X_2734_ _2995_/Q VSS VDD _2979_/Q _2987_/Q _2740_/S0 _2971_/Q _2740_/S1 _2734_/Z VDD
+ VSS gf180mcu_fd_sc_mcu7t5v0__mux4_1
X_2665_ VDD VSS _2666_/A2 _2724_/C _2664_/Z VDD VSS gf180mcu_fd_sc_mcu7t5v0__nand2_1
X_1616_ VDD VSS _1619_/A1 _3425_/Q _3416_/D VDD VSS gf180mcu_fd_sc_mcu7t5v0__xnor2_1
X_2596_ _2596_/S VDD VSS _3264_/D _3256_/Q _3264_/Q VDD VSS gf180mcu_fd_sc_mcu7t5v0__mux2_2
X_1547_ VDD VSS _1549_/B _3189_/Q _2214_/A1 VDD VSS gf180mcu_fd_sc_mcu7t5v0__nand2_1
XFILLER_113_352 VDD VSS VDD VSS gf180mcu_fd_sc_mcu7t5v0__fillcap_4
XFILLER_86_247 VDD VSS VDD VSS gf180mcu_fd_sc_mcu7t5v0__fillcap_16
X_1478_ VDD VSS _3414_/D _1945_/A2 _1478_/A2 VDD VSS gf180mcu_fd_sc_mcu7t5v0__xor2_1
X_3217_ _3217_/D _3217_/Q wire145/I VSS _3329_/CLK VDD VDD VSS gf180mcu_fd_sc_mcu7t5v0__dffrnq_1
XFILLER_243_702 VDD VSS VDD VSS gf180mcu_fd_sc_mcu7t5v0__fillcap_64
XFILLER_255_562 VDD VSS VDD VSS gf180mcu_fd_sc_mcu7t5v0__fillcap_64
X_3148_ _3148_/D _3148_/Q wire153/I VSS _3357_/CLK VDD VDD VSS gf180mcu_fd_sc_mcu7t5v0__dffrnq_1
XFILLER_54_177 VDD VSS VDD VSS gf180mcu_fd_sc_mcu7t5v0__fillcap_64
XFILLER_42_317 VDD VSS VDD VSS gf180mcu_fd_sc_mcu7t5v0__fillcap_64
X_3079_ _3079_/D _3079_/Q _3335_/RN VSS _3337_/CLK VDD VDD VSS gf180mcu_fd_sc_mcu7t5v0__dffrnq_1
XFILLER_196_801 VDD VSS VDD VSS gf180mcu_fd_sc_mcu7t5v0__fillcap_4
XFILLER_223_492 VDD VSS VDD VSS gf180mcu_fd_sc_mcu7t5v0__fillcap_8
XFILLER_211_92 VDD VSS VDD VSS gf180mcu_fd_sc_mcu7t5v0__fillcap_32
XFILLER_149_772 VDD VSS VDD VSS gf180mcu_fd_sc_mcu7t5v0__fillcap_64
XFILLER_10_247 VDD VSS VDD VSS gf180mcu_fd_sc_mcu7t5v0__fillcap_64
XFILLER_164_731 VDD VSS VDD VSS gf180mcu_fd_sc_mcu7t5v0__fillcap_4
XFILLER_191_594 VDD VSS VDD VSS gf180mcu_fd_sc_mcu7t5v0__fillcap_16
XFILLER_2_457 VDD VSS VDD VSS gf180mcu_fd_sc_mcu7t5v0__fillcap_64
XFILLER_105_842 VDD VSS VDD VSS gf180mcu_fd_sc_mcu7t5v0__fillcap_32
XFILLER_120_801 VDD VSS VDD VSS gf180mcu_fd_sc_mcu7t5v0__fillcap_4
XFILLER_78_737 VDD VSS VDD VSS gf180mcu_fd_sc_mcu7t5v0__fillcap_64
Xclkbuf_leaf_60_clk_i _3463_/CLK VSS VDD clkload1/I VDD VSS gf180mcu_fd_sc_mcu7t5v0__clkbuf_2
XFILLER_233_212 VDD VSS VDD VSS gf180mcu_fd_sc_mcu7t5v0__fillcap_64
XFILLER_34_807 VDD VSS VDD VSS gf180mcu_fd_sc_mcu7t5v0__fillcap_64
XFILLER_100_591 VDD VSS VDD VSS gf180mcu_fd_sc_mcu7t5v0__fillcap_4
XFILLER_46_667 VDD VSS VDD VSS gf180mcu_fd_sc_mcu7t5v0__fillcap_64
XFILLER_61_626 VDD VSS VDD VSS gf180mcu_fd_sc_mcu7t5v0__fillcap_4
XFILLER_73_486 VDD VSS VDD VSS gf180mcu_fd_sc_mcu7t5v0__fillcap_4
Xclkbuf_leaf_75_clk_i _3454_/CLK VSS VDD clkbuf_3_0__f_clk_i/Z VDD VSS gf180mcu_fd_sc_mcu7t5v0__clkbuf_2
XFILLER_198_171 VDD VSS VDD VSS gf180mcu_fd_sc_mcu7t5v0__fillcap_4
XFILLER_14_597 VDD VSS VDD VSS gf180mcu_fd_sc_mcu7t5v0__fillcap_64
XFILLER_81_96 VDD VSS VDD VSS gf180mcu_fd_sc_mcu7t5v0__fillcap_4
XFILLER_186_366 VDD VSS VDD VSS gf180mcu_fd_sc_mcu7t5v0__fillcap_4
XFILLER_127_400 VDD VSS VDD VSS gf180mcu_fd_sc_mcu7t5v0__fillcap_4
XFILLER_201_197 VDD VSS VDD VSS gf180mcu_fd_sc_mcu7t5v0__fillcap_8
XFILLER_127_422 VDD VSS VDD VSS gf180mcu_fd_sc_mcu7t5v0__fillcap_16
XFILLER_154_241 VDD VSS VDD VSS gf180mcu_fd_sc_mcu7t5v0__fillcap_4
Xclkbuf_leaf_13_clk_i _3348_/CLK VSS VDD clkload3/I VDD VSS gf180mcu_fd_sc_mcu7t5v0__clkbuf_2
X_2450_ _2450_/A3 VDD VSS _2451_/B _1654_/Z _2450_/A2 VDD VSS gf180mcu_fd_sc_mcu7t5v0__nand3_1
X_1401_ VDD VSS _3205_/Q _2232_/A1 VDD VSS gf180mcu_fd_sc_mcu7t5v0__clkinv_1
X_2381_ VDD _2381_/B _2381_/A2 _3197_/D _2467_/A1 VSS VDD VSS gf180mcu_fd_sc_mcu7t5v0__oai21_1
Xclkbuf_leaf_28_clk_i _3211_/CLK VSS VDD clkload4/I VDD VSS gf180mcu_fd_sc_mcu7t5v0__clkbuf_2
XFILLER_68_247 VDD VSS VDD VSS gf180mcu_fd_sc_mcu7t5v0__fillcap_64
XFILLER_225_702 VDD VSS VDD VSS gf180mcu_fd_sc_mcu7t5v0__fillcap_64
XFILLER_237_562 VDD VSS VDD VSS gf180mcu_fd_sc_mcu7t5v0__fillcap_64
X_3002_ VDD _3002_/Q _3039_/CLK VSS _3002_/D VDD VSS gf180mcu_fd_sc_mcu7t5v0__dffq_1
Xinput5 VDD spi_mosi_i VSS input5/Z VDD VSS gf180mcu_fd_sc_mcu7t5v0__dlyb_1
XFILLER_252_521 VDD VSS VDD VSS gf180mcu_fd_sc_mcu7t5v0__fillcap_4
XFILLER_264_381 VDD VSS VDD VSS gf180mcu_fd_sc_mcu7t5v0__fillcap_4
XFILLER_36_177 VDD VSS VDD VSS gf180mcu_fd_sc_mcu7t5v0__fillcap_64
XFILLER_24_317 VDD VSS VDD VSS gf180mcu_fd_sc_mcu7t5v0__fillcap_64
XFILLER_178_801 VDD VSS VDD VSS gf180mcu_fd_sc_mcu7t5v0__fillcap_4
XFILLER_51_136 VDD VSS VDD VSS gf180mcu_fd_sc_mcu7t5v0__fillcap_4
XFILLER_205_492 VDD VSS VDD VSS gf180mcu_fd_sc_mcu7t5v0__fillcap_8
XFILLER_177_344 VDD VSS VDD VSS gf180mcu_fd_sc_mcu7t5v0__fillcap_4
XFILLER_220_473 VDD VSS VDD VSS gf180mcu_fd_sc_mcu7t5v0__fillcap_8
XFILLER_158_591 VDD VSS VDD VSS gf180mcu_fd_sc_mcu7t5v0__fillcap_4
XFILLER_257_66 VDD VSS VDD VSS gf180mcu_fd_sc_mcu7t5v0__fillcap_4
X_2717_ VDD VSS _2717_/I _2720_/A2 VDD VSS gf180mcu_fd_sc_mcu7t5v0__clkinv_1
XFILLER_10_37 VDD VSS VDD VSS gf180mcu_fd_sc_mcu7t5v0__fillcap_64
X_2648_ VDD VSS _2758_/A2 _2020_/B _2749_/C VDD VSS gf180mcu_fd_sc_mcu7t5v0__nor2_1
XFILLER_126_37 VDD VSS VDD VSS gf180mcu_fd_sc_mcu7t5v0__fillcap_16
X_2579_ _2587_/S VDD VSS _3247_/D _3239_/Q _3247_/Q VDD VSS gf180mcu_fd_sc_mcu7t5v0__mux2_2
XFILLER_102_801 VDD VSS VDD VSS gf180mcu_fd_sc_mcu7t5v0__fillcap_4
XFILLER_259_142 VDD VSS VDD VSS gf180mcu_fd_sc_mcu7t5v0__fillcap_64
XFILLER_101_322 VDD VSS VDD VSS gf180mcu_fd_sc_mcu7t5v0__fillcap_4
XFILLER_101_344 VDD VSS VDD VSS gf180mcu_fd_sc_mcu7t5v0__fillcap_4
XFILLER_87_556 VDD VSS VDD VSS gf180mcu_fd_sc_mcu7t5v0__fillcap_4
XFILLER_256_871 VDD VSS VDD VSS gf180mcu_fd_sc_mcu7t5v0__fillcap_4
XFILLER_215_212 VDD VSS VDD VSS gf180mcu_fd_sc_mcu7t5v0__fillcap_64
XFILLER_16_807 VDD VSS VDD VSS gf180mcu_fd_sc_mcu7t5v0__fillcap_64
XFILLER_28_667 VDD VSS VDD VSS gf180mcu_fd_sc_mcu7t5v0__fillcap_64
XFILLER_43_626 VDD VSS VDD VSS gf180mcu_fd_sc_mcu7t5v0__fillcap_4
XFILLER_55_486 VDD VSS VDD VSS gf180mcu_fd_sc_mcu7t5v0__fillcap_4
XFILLER_168_311 VDD VSS VDD VSS gf180mcu_fd_sc_mcu7t5v0__fillcap_4
XFILLER_168_333 VDD VSS VDD VSS gf180mcu_fd_sc_mcu7t5v0__fillcap_8
XFILLER_196_675 VDD VSS VDD VSS gf180mcu_fd_sc_mcu7t5v0__fillcap_4
XFILLER_11_556 VDD VSS VDD VSS gf180mcu_fd_sc_mcu7t5v0__fillcap_4
XFILLER_109_422 VDD VSS VDD VSS gf180mcu_fd_sc_mcu7t5v0__fillcap_64
XFILLER_51_66 VDD VSS VDD VSS gf180mcu_fd_sc_mcu7t5v0__fillcap_4
XFILLER_124_403 VDD VSS VDD VSS gf180mcu_fd_sc_mcu7t5v0__fillcap_4
XFILLER_3_766 VDD VSS VDD VSS gf180mcu_fd_sc_mcu7t5v0__fillcap_4
XFILLER_104_171 VDD VSS VDD VSS gf180mcu_fd_sc_mcu7t5v0__fillcap_4
XFILLER_76_30 VDD VSS VDD VSS gf180mcu_fd_sc_mcu7t5v0__fillcap_4
XFILLER_65_206 VDD VSS VDD VSS gf180mcu_fd_sc_mcu7t5v0__fillcap_4
XFILLER_234_521 VDD VSS VDD VSS gf180mcu_fd_sc_mcu7t5v0__fillcap_4
XFILLER_246_381 VDD VSS VDD VSS gf180mcu_fd_sc_mcu7t5v0__fillcap_4
XFILLER_18_177 VDD VSS VDD VSS gf180mcu_fd_sc_mcu7t5v0__fillcap_64
XFILLER_262_885 VDD VSS VDD VSS gf180mcu_fd_sc_mcu7t5v0__fillcap_4
XFILLER_33_136 VDD VSS VDD VSS gf180mcu_fd_sc_mcu7t5v0__fillcap_4
X_1950_ _1954_/S VDD VSS _3000_/D _3000_/Q wire119/Z VDD VSS gf180mcu_fd_sc_mcu7t5v0__mux2_2
X_1881_ wire36/Z VDD VSS _2942_/D _2942_/Q wire123/I VDD VSS gf180mcu_fd_sc_mcu7t5v0__mux2_2
XFILLER_186_185 VDD VSS VDD VSS gf180mcu_fd_sc_mcu7t5v0__fillcap_4
XFILLER_128_731 VDD VSS VDD VSS gf180mcu_fd_sc_mcu7t5v0__fillcap_4
XFILLER_190_807 VDD VSS VDD VSS gf180mcu_fd_sc_mcu7t5v0__fillcap_64
XFILLER_127_252 VDD VSS VDD VSS gf180mcu_fd_sc_mcu7t5v0__fillcap_8
X_2502_ VDD VSS _2507_/A2 _3320_/Q _2525_/B1 VDD VSS gf180mcu_fd_sc_mcu7t5v0__nand2_1
X_2433_ _2433_/A3 VDD VSS _2434_/B _3382_/Q _2433_/A2 VDD VSS gf180mcu_fd_sc_mcu7t5v0__nand3_1
XFILLER_44_2 VDD VSS VDD VSS gf180mcu_fd_sc_mcu7t5v0__fillcap_32
XFILLER_170_597 VDD VSS VDD VSS gf180mcu_fd_sc_mcu7t5v0__fillcap_8
X_2364_ _2364_/B VDD VSS _2365_/A4 _2364_/A1 _2239_/C VDD VSS gf180mcu_fd_sc_mcu7t5v0__aoi21_1
XFILLER_256_101 VDD VSS VDD VSS gf180mcu_fd_sc_mcu7t5v0__fillcap_4
XFILLER_69_556 VDD VSS VDD VSS gf180mcu_fd_sc_mcu7t5v0__fillcap_4
X_2295_ _1424_/I _2295_/A4 VDD VSS _2314_/A3 _3362_/D _2305_/B2 VDD VSS gf180mcu_fd_sc_mcu7t5v0__nor4_1
XFILLER_238_871 VDD VSS VDD VSS gf180mcu_fd_sc_mcu7t5v0__fillcap_4
XFILLER_253_874 VDD VSS VDD VSS gf180mcu_fd_sc_mcu7t5v0__fillcap_16
XFILLER_37_486 VDD VSS VDD VSS gf180mcu_fd_sc_mcu7t5v0__fillcap_4
XFILLER_25_626 VDD VSS VDD VSS gf180mcu_fd_sc_mcu7t5v0__fillcap_4
XFILLER_180_317 VDD VSS VDD VSS gf180mcu_fd_sc_mcu7t5v0__fillcap_16
XFILLER_118_263 VDD VSS VDD VSS gf180mcu_fd_sc_mcu7t5v0__fillcap_4
XFILLER_97_18 VDD VSS VDD VSS gf180mcu_fd_sc_mcu7t5v0__fillcap_4
XFILLER_133_244 VDD VSS VDD VSS gf180mcu_fd_sc_mcu7t5v0__fillcap_16
XFILLER_79_309 VDD VSS VDD VSS gf180mcu_fd_sc_mcu7t5v0__fillcap_4
XFILLER_47_206 VDD VSS VDD VSS gf180mcu_fd_sc_mcu7t5v0__fillcap_4
Xmax_cap34 VSS _1895_/S _1891_/S VDD VDD VSS gf180mcu_fd_sc_mcu7t5v0__buf_2
XFILLER_228_381 VDD VSS VDD VSS gf180mcu_fd_sc_mcu7t5v0__fillcap_4
Xmax_cap23 VSS _2289_/S wire24/Z VDD VDD VSS gf180mcu_fd_sc_mcu7t5v0__buf_2
XFILLER_244_885 VDD VSS VDD VSS gf180mcu_fd_sc_mcu7t5v0__fillcap_4
XFILLER_15_136 VDD VSS VDD VSS gf180mcu_fd_sc_mcu7t5v0__fillcap_4
XFILLER_246_2 VDD VSS VDD VSS gf180mcu_fd_sc_mcu7t5v0__fillcap_32
XFILLER_184_612 VDD VSS VDD VSS gf180mcu_fd_sc_mcu7t5v0__fillcap_32
XFILLER_184_667 VDD VSS VDD VSS gf180mcu_fd_sc_mcu7t5v0__fillcap_16
XFILLER_172_807 VDD VSS VDD VSS gf180mcu_fd_sc_mcu7t5v0__fillcap_64
XFILLER_7_346 VDD VSS VDD VSS gf180mcu_fd_sc_mcu7t5v0__fillcap_4
XFILLER_124_200 VDD VSS VDD VSS gf180mcu_fd_sc_mcu7t5v0__fillcap_4
XFILLER_152_597 VDD VSS VDD VSS gf180mcu_fd_sc_mcu7t5v0__fillcap_64
XFILLER_140_737 VDD VSS VDD VSS gf180mcu_fd_sc_mcu7t5v0__fillcap_64
XFILLER_238_101 VDD VSS VDD VSS gf180mcu_fd_sc_mcu7t5v0__fillcap_4
X_2080_ VDD VSS _2115_/C _2125_/A2 _2075_/Z VDD VSS gf180mcu_fd_sc_mcu7t5v0__nor2_1
XFILLER_93_345 VDD VSS VDD VSS gf180mcu_fd_sc_mcu7t5v0__fillcap_4
XFILLER_235_874 VDD VSS VDD VSS gf180mcu_fd_sc_mcu7t5v0__fillcap_16
XFILLER_19_486 VDD VSS VDD VSS gf180mcu_fd_sc_mcu7t5v0__fillcap_4
XFILLER_222_535 VDD VSS VDD VSS gf180mcu_fd_sc_mcu7t5v0__fillcap_4
XFILLER_250_877 VDD VSS VDD VSS gf180mcu_fd_sc_mcu7t5v0__fillcap_8
X_2982_ VDD _2982_/Q _2994_/CLK VSS _2982_/D VDD VSS gf180mcu_fd_sc_mcu7t5v0__dffq_1
X_1933_ _1933_/S VDD VSS _2986_/D wire116/Z _2986_/Q VDD VSS gf180mcu_fd_sc_mcu7t5v0__mux2_2
XFILLER_187_483 VDD VSS VDD VSS gf180mcu_fd_sc_mcu7t5v0__fillcap_4
XFILLER_159_174 VDD VSS VDD VSS gf180mcu_fd_sc_mcu7t5v0__fillcap_8
XFILLER_147_325 VDD VSS VDD VSS gf180mcu_fd_sc_mcu7t5v0__fillcap_4
X_1864_ _1869_/S VDD VSS _2927_/D _1864_/I0 _2927_/Q VDD VSS gf180mcu_fd_sc_mcu7t5v0__mux2_2
XFILLER_128_550 VDD VSS VDD VSS gf180mcu_fd_sc_mcu7t5v0__fillcap_32
XFILLER_174_188 VDD VSS VDD VSS gf180mcu_fd_sc_mcu7t5v0__fillcap_32
X_1795_ _1795_/S VDD VSS _2868_/D _2868_/Q _1869_/I0 VDD VSS gf180mcu_fd_sc_mcu7t5v0__mux2_2
X_2416_ VDD VSS _2419_/A2 _2459_/A1 _2415_/Z VDD VSS gf180mcu_fd_sc_mcu7t5v0__nand2_1
XFILLER_130_225 VDD VSS VDD VSS gf180mcu_fd_sc_mcu7t5v0__fillcap_4
X_3396_ _3396_/D _3396_/Q wire161/Z VSS _3403_/CLK VDD VDD VSS gf180mcu_fd_sc_mcu7t5v0__dffrnq_1
XFILLER_130_247 VDD VSS VDD VSS gf180mcu_fd_sc_mcu7t5v0__fillcap_8
XFILLER_97_651 VDD VSS VDD VSS gf180mcu_fd_sc_mcu7t5v0__fillcap_4
X_2347_ VDD _2347_/B _2358_/A3 _2362_/B _2483_/B VSS VDD VSS gf180mcu_fd_sc_mcu7t5v0__oai21_1
XFILLER_97_684 VDD VSS VDD VSS gf180mcu_fd_sc_mcu7t5v0__fillcap_16
XFILLER_29_206 VDD VSS VDD VSS gf180mcu_fd_sc_mcu7t5v0__fillcap_4
X_2278_ _2336_/B _2278_/A4 VDD VSS wire24/I _2363_/A1 _2278_/A2 VDD VSS gf180mcu_fd_sc_mcu7t5v0__nor4_1
XFILLER_226_885 VDD VSS VDD VSS gf180mcu_fd_sc_mcu7t5v0__fillcap_4
XFILLER_203_60 VDD VSS VDD VSS gf180mcu_fd_sc_mcu7t5v0__fillcap_8
XFILLER_198_726 VDD VSS VDD VSS gf180mcu_fd_sc_mcu7t5v0__fillcap_8
XFILLER_198_737 VDD VSS VDD VSS gf180mcu_fd_sc_mcu7t5v0__fillcap_8
XFILLER_240_387 VDD VSS VDD VSS gf180mcu_fd_sc_mcu7t5v0__fillcap_64
XFILLER_166_667 VDD VSS VDD VSS gf180mcu_fd_sc_mcu7t5v0__fillcap_64
XFILLER_154_807 VDD VSS VDD VSS gf180mcu_fd_sc_mcu7t5v0__fillcap_64
XFILLER_193_475 VDD VSS VDD VSS gf180mcu_fd_sc_mcu7t5v0__fillcap_8
XFILLER_153_328 VDD VSS VDD VSS gf180mcu_fd_sc_mcu7t5v0__fillcap_4
XFILLER_146_380 VDD VSS VDD VSS gf180mcu_fd_sc_mcu7t5v0__fillcap_4
XFILLER_134_597 VDD VSS VDD VSS gf180mcu_fd_sc_mcu7t5v0__fillcap_16
XFILLER_122_737 VDD VSS VDD VSS gf180mcu_fd_sc_mcu7t5v0__fillcap_64
XFILLER_196_2 VDD VSS VDD VSS gf180mcu_fd_sc_mcu7t5v0__fillcap_32
XFILLER_102_472 VDD VSS VDD VSS gf180mcu_fd_sc_mcu7t5v0__fillcap_4
XFILLER_87_150 VDD VSS VDD VSS gf180mcu_fd_sc_mcu7t5v0__fillcap_4
XFILLER_217_874 VDD VSS VDD VSS gf180mcu_fd_sc_mcu7t5v0__fillcap_16
XFILLER_250_107 VDD VSS VDD VSS gf180mcu_fd_sc_mcu7t5v0__fillcap_64
Xclkbuf_0_host_clk_i VDD VSS clkbuf_0_host_clk_i/Z host_clk_i VDD VSS gf180mcu_fd_sc_mcu7t5v0__clkbuf_16
XFILLER_232_877 VDD VSS VDD VSS gf180mcu_fd_sc_mcu7t5v0__fillcap_8
XFILLER_188_247 VDD VSS VDD VSS gf180mcu_fd_sc_mcu7t5v0__fillcap_16
XFILLER_71_562 VDD VSS VDD VSS gf180mcu_fd_sc_mcu7t5v0__fillcap_64
Xspi_opentarget_i3c_top_175 irq_o_IE VDD VSS VDD VSS gf180mcu_fd_sc_mcu7t5v0__tiel
Xspi_opentarget_i3c_top_186 sda_pad_PD VDD VSS VDD VSS gf180mcu_fd_sc_mcu7t5v0__tiel
Xspi_opentarget_i3c_top_197 spi_miso_o_PDRV1 VDD VSS VDD VSS gf180mcu_fd_sc_mcu7t5v0__tiel
XFILLER_156_177 VDD VSS VDD VSS gf180mcu_fd_sc_mcu7t5v0__fillcap_64
XFILLER_144_317 VDD VSS VDD VSS gf180mcu_fd_sc_mcu7t5v0__fillcap_4
XFILLER_208_49 VDD VSS VDD VSS gf180mcu_fd_sc_mcu7t5v0__fillcap_8
X_1580_ _2470_/B VDD VSS _2168_/C _3187_/Q _3349_/Q VDD VSS gf180mcu_fd_sc_mcu7t5v0__nand3_1
XFILLER_171_136 VDD VSS VDD VSS gf180mcu_fd_sc_mcu7t5v0__fillcap_4
XFILLER_98_426 VDD VSS VDD VSS gf180mcu_fd_sc_mcu7t5v0__fillcap_16
XFILLER_224_26 VDD VSS VDD VSS gf180mcu_fd_sc_mcu7t5v0__fillcap_4
XFILLER_112_247 VDD VSS VDD VSS gf180mcu_fd_sc_mcu7t5v0__fillcap_8
X_3250_ _3250_/D _3250_/Q wire165/Z VSS _3332_/CLK VDD VDD VSS gf180mcu_fd_sc_mcu7t5v0__dffrnq_1
X_3181_ VDD _3181_/Q _3181_/CLK VSS _3181_/D VDD VSS gf180mcu_fd_sc_mcu7t5v0__dffq_1
X_2201_ _2205_/A3 VDD VSS _2654_/A3 _2686_/A1 _3270_/Q VDD VSS gf180mcu_fd_sc_mcu7t5v0__nand3_1
X_2132_ _2138_/S VDD VSS _3120_/D wire96/Z _3120_/Q VDD VSS gf180mcu_fd_sc_mcu7t5v0__mux2_2
XFILLER_254_457 VDD VSS VDD VSS gf180mcu_fd_sc_mcu7t5v0__fillcap_64
XFILLER_93_142 VDD VSS VDD VSS gf180mcu_fd_sc_mcu7t5v0__fillcap_16
XFILLER_208_885 VDD VSS VDD VSS gf180mcu_fd_sc_mcu7t5v0__fillcap_4
X_2063_ VDD VSS _2064_/B wire97/Z _2072_/S VDD VSS gf180mcu_fd_sc_mcu7t5v0__nor2_1
XFILLER_93_175 VDD VSS VDD VSS gf180mcu_fd_sc_mcu7t5v0__fillcap_8
XFILLER_90_871 VDD VSS VDD VSS gf180mcu_fd_sc_mcu7t5v0__fillcap_4
XFILLER_210_527 VDD VSS VDD VSS gf180mcu_fd_sc_mcu7t5v0__fillcap_4
XFILLER_222_387 VDD VSS VDD VSS gf180mcu_fd_sc_mcu7t5v0__fillcap_8
X_2965_ VDD _2965_/Q _3463_/CLK VSS _2965_/D VDD VSS gf180mcu_fd_sc_mcu7t5v0__dffq_1
XFILLER_148_667 VDD VSS VDD VSS gf180mcu_fd_sc_mcu7t5v0__fillcap_4
X_2896_ VDD _2896_/Q _2899_/CLK VSS _2896_/D VDD VSS gf180mcu_fd_sc_mcu7t5v0__dffq_1
XFILLER_136_807 VDD VSS VDD VSS gf180mcu_fd_sc_mcu7t5v0__fillcap_64
X_1916_ _1917_/S VDD VSS _2971_/D _2971_/Q wire114/I VDD VSS gf180mcu_fd_sc_mcu7t5v0__mux2_2
XFILLER_175_486 VDD VSS VDD VSS gf180mcu_fd_sc_mcu7t5v0__fillcap_4
X_1847_ _1851_/S VDD VSS _2912_/D wire133/Z _2912_/Q VDD VSS gf180mcu_fd_sc_mcu7t5v0__mux2_2
X_1778_ VDD VSS _1786_/S _1852_/A1 _1787_/A2 VDD VSS gf180mcu_fd_sc_mcu7t5v0__nand2_1
XFILLER_190_489 VDD VSS VDD VSS gf180mcu_fd_sc_mcu7t5v0__fillcap_8
XFILLER_265_66 VDD VSS VDD VSS gf180mcu_fd_sc_mcu7t5v0__fillcap_4
XFILLER_89_437 VDD VSS VDD VSS gf180mcu_fd_sc_mcu7t5v0__fillcap_16
XFILLER_116_597 VDD VSS VDD VSS gf180mcu_fd_sc_mcu7t5v0__fillcap_4
XFILLER_104_737 VDD VSS VDD VSS gf180mcu_fd_sc_mcu7t5v0__fillcap_64
XFILLER_103_247 VDD VSS VDD VSS gf180mcu_fd_sc_mcu7t5v0__fillcap_32
X_3448_ _3448_/D _3448_/Q wire169/Z VSS _3448_/CLK VDD VDD VSS gf180mcu_fd_sc_mcu7t5v0__dffrnq_1
XFILLER_131_556 VDD VSS VDD VSS gf180mcu_fd_sc_mcu7t5v0__fillcap_4
X_3379_ _3379_/D _3404_/D wire161/Z VSS _3395_/CLK VDD VDD VSS gf180mcu_fd_sc_mcu7t5v0__dffrnq_1
XFILLER_218_605 VDD VSS VDD VSS gf180mcu_fd_sc_mcu7t5v0__fillcap_4
XFILLER_217_104 VDD VSS VDD VSS gf180mcu_fd_sc_mcu7t5v0__fillcap_16
XFILLER_85_632 VDD VSS VDD VSS gf180mcu_fd_sc_mcu7t5v0__fillcap_64
XFILLER_232_107 VDD VSS VDD VSS gf180mcu_fd_sc_mcu7t5v0__fillcap_64
XFILLER_198_512 VDD VSS VDD VSS gf180mcu_fd_sc_mcu7t5v0__fillcap_4
XFILLER_214_877 VDD VSS VDD VSS gf180mcu_fd_sc_mcu7t5v0__fillcap_8
XFILLER_80_370 VDD VSS VDD VSS gf180mcu_fd_sc_mcu7t5v0__fillcap_8
XFILLER_53_562 VDD VSS VDD VSS gf180mcu_fd_sc_mcu7t5v0__fillcap_64
XFILLER_41_702 VDD VSS VDD VSS gf180mcu_fd_sc_mcu7t5v0__fillcap_64
XFILLER_241_696 VDD VSS VDD VSS gf180mcu_fd_sc_mcu7t5v0__fillcap_4
XFILLER_186_729 VDD VSS VDD VSS gf180mcu_fd_sc_mcu7t5v0__fillcap_4
XFILLER_201_538 VDD VSS VDD VSS gf180mcu_fd_sc_mcu7t5v0__fillcap_4
XFILLER_138_177 VDD VSS VDD VSS gf180mcu_fd_sc_mcu7t5v0__fillcap_32
XFILLER_126_306 VDD VSS VDD VSS gf180mcu_fd_sc_mcu7t5v0__fillcap_4
XFILLER_21_492 VDD VSS VDD VSS gf180mcu_fd_sc_mcu7t5v0__fillcap_64
XFILLER_181_434 VDD VSS VDD VSS gf180mcu_fd_sc_mcu7t5v0__fillcap_16
XFILLER_154_659 VDD VSS VDD VSS gf180mcu_fd_sc_mcu7t5v0__fillcap_4
XFILLER_209_2 VDD VSS VDD VSS gf180mcu_fd_sc_mcu7t5v0__fillcap_16
XFILLER_153_136 VDD VSS VDD VSS gf180mcu_fd_sc_mcu7t5v0__fillcap_4
XFILLER_1_842 VDD VSS VDD VSS gf180mcu_fd_sc_mcu7t5v0__fillcap_32
XFILLER_191_87 VDD VSS VDD VSS gf180mcu_fd_sc_mcu7t5v0__fillcap_16
XFILLER_75_142 VDD VSS VDD VSS gf180mcu_fd_sc_mcu7t5v0__fillcap_64
XFILLER_236_457 VDD VSS VDD VSS gf180mcu_fd_sc_mcu7t5v0__fillcap_64
XFILLER_84_52 VDD VSS VDD VSS gf180mcu_fd_sc_mcu7t5v0__fillcap_16
XFILLER_251_416 VDD VSS VDD VSS gf180mcu_fd_sc_mcu7t5v0__fillcap_4
XFILLER_263_276 VDD VSS VDD VSS gf180mcu_fd_sc_mcu7t5v0__fillcap_4
XFILLER_72_871 VDD VSS VDD VSS gf180mcu_fd_sc_mcu7t5v0__fillcap_4
XFILLER_204_387 VDD VSS VDD VSS gf180mcu_fd_sc_mcu7t5v0__fillcap_4
XFILLER_204_376 VDD VSS VDD VSS gf180mcu_fd_sc_mcu7t5v0__fillcap_8
XFILLER_140_80 VDD VSS VDD VSS gf180mcu_fd_sc_mcu7t5v0__fillcap_16
XFILLER_31_212 VDD VSS VDD VSS gf180mcu_fd_sc_mcu7t5v0__fillcap_64
XFILLER_176_239 VDD VSS VDD VSS gf180mcu_fd_sc_mcu7t5v0__fillcap_4
X_2750_ _2750_/B VDD VSS _3318_/D _2750_/A1 _2749_/C VDD VSS gf180mcu_fd_sc_mcu7t5v0__aoi21_1
XFILLER_118_807 VDD VSS VDD VSS gf180mcu_fd_sc_mcu7t5v0__fillcap_64
XFILLER_157_486 VDD VSS VDD VSS gf180mcu_fd_sc_mcu7t5v0__fillcap_4
XFILLER_145_626 VDD VSS VDD VSS gf180mcu_fd_sc_mcu7t5v0__fillcap_4
X_1701_ VDD VSS _1716_/B wire105/Z _2483_/A1 VDD VSS gf180mcu_fd_sc_mcu7t5v0__nand2_1
X_2681_ _2991_/Q VSS VDD _2975_/Q _2983_/Q _2722_/S0 _2967_/Q wire60/Z _2681_/Z VDD
+ VSS gf180mcu_fd_sc_mcu7t5v0__mux4_1
XFILLER_145_648 VDD VSS VDD VSS gf180mcu_fd_sc_mcu7t5v0__fillcap_4
X_1632_ VDD _1632_/B _1632_/A2 _1633_/A2 _2113_/A2 VSS VDD VSS gf180mcu_fd_sc_mcu7t5v0__oai21_1
XFILLER_99_702 VDD VSS VDD VSS gf180mcu_fd_sc_mcu7t5v0__fillcap_64
X_1563_ _3347_/Q _1587_/B VDD VSS _1564_/A2 _3185_/Q _1563_/A2 VDD VSS gf180mcu_fd_sc_mcu7t5v0__nand4_1
X_1494_ VDD VSS _1494_/Z _3458_/D _3458_/Q VDD VSS gf180mcu_fd_sc_mcu7t5v0__or2_1
X_3302_ _3302_/D _3302_/Q wire165/I VSS _3448_/CLK VDD VDD VSS gf180mcu_fd_sc_mcu7t5v0__dffrnq_1
X_3233_ _3233_/D _3233_/Q wire145/Z VSS _3321_/CLK VDD VDD VSS gf180mcu_fd_sc_mcu7t5v0__dffrnq_1
XFILLER_79_492 VDD VSS VDD VSS gf180mcu_fd_sc_mcu7t5v0__fillcap_64
XFILLER_67_632 VDD VSS VDD VSS gf180mcu_fd_sc_mcu7t5v0__fillcap_64
XFILLER_94_440 VDD VSS VDD VSS gf180mcu_fd_sc_mcu7t5v0__fillcap_8
X_3164_ _3164_/D _3164_/Q wire151/I VSS _3165_/CLK VDD VDD VSS gf180mcu_fd_sc_mcu7t5v0__dffrnq_1
XFILLER_104_29 VDD VSS VDD VSS gf180mcu_fd_sc_mcu7t5v0__fillcap_4
XFILLER_255_766 VDD VSS VDD VSS gf180mcu_fd_sc_mcu7t5v0__fillcap_4
X_2115_ _2115_/B _2115_/C VDD VSS _3112_/D _2074_/Z _2119_/A3 VDD VSS gf180mcu_fd_sc_mcu7t5v0__aoi211_1
X_3095_ _3095_/D _3095_/Q wire145/Z VSS _3159_/CLK VDD VDD VSS gf180mcu_fd_sc_mcu7t5v0__dffrnq_1
XFILLER_214_107 VDD VSS VDD VSS gf180mcu_fd_sc_mcu7t5v0__fillcap_16
XFILLER_81_134 VDD VSS VDD VSS gf180mcu_fd_sc_mcu7t5v0__fillcap_4
X_2046_ wire28/Z VDD VSS _3079_/D _3295_/Q _3079_/Q VDD VSS gf180mcu_fd_sc_mcu7t5v0__mux2_2
XFILLER_35_562 VDD VSS VDD VSS gf180mcu_fd_sc_mcu7t5v0__fillcap_64
XFILLER_23_702 VDD VSS VDD VSS gf180mcu_fd_sc_mcu7t5v0__fillcap_64
XFILLER_120_28 VDD VSS VDD VSS gf180mcu_fd_sc_mcu7t5v0__fillcap_4
XFILLER_211_836 VDD VSS VDD VSS gf180mcu_fd_sc_mcu7t5v0__fillcap_4
XFILLER_50_521 VDD VSS VDD VSS gf180mcu_fd_sc_mcu7t5v0__fillcap_4
XFILLER_62_381 VDD VSS VDD VSS gf180mcu_fd_sc_mcu7t5v0__fillcap_4
XFILLER_223_696 VDD VSS VDD VSS gf180mcu_fd_sc_mcu7t5v0__fillcap_4
XFILLER_168_729 VDD VSS VDD VSS gf180mcu_fd_sc_mcu7t5v0__fillcap_4
XFILLER_167_217 VDD VSS VDD VSS gf180mcu_fd_sc_mcu7t5v0__fillcap_32
XFILLER_195_548 VDD VSS VDD VSS gf180mcu_fd_sc_mcu7t5v0__fillcap_4
XFILLER_200_94 VDD VSS VDD VSS gf180mcu_fd_sc_mcu7t5v0__fillcap_4
X_2948_ VDD _2948_/Q _3365_/CLK VSS _2948_/D VDD VSS gf180mcu_fd_sc_mcu7t5v0__dffq_1
XFILLER_108_317 VDD VSS VDD VSS gf180mcu_fd_sc_mcu7t5v0__fillcap_4
X_2879_ VDD _2879_/Q _2899_/CLK VSS _2879_/D VDD VSS gf180mcu_fd_sc_mcu7t5v0__dffq_1
XFILLER_89_201 VDD VSS VDD VSS gf180mcu_fd_sc_mcu7t5v0__fillcap_4
XFILLER_57_142 VDD VSS VDD VSS gf180mcu_fd_sc_mcu7t5v0__fillcap_64
XFILLER_72_101 VDD VSS VDD VSS gf180mcu_fd_sc_mcu7t5v0__fillcap_4
XFILLER_245_276 VDD VSS VDD VSS gf180mcu_fd_sc_mcu7t5v0__fillcap_4
XFILLER_233_416 VDD VSS VDD VSS gf180mcu_fd_sc_mcu7t5v0__fillcap_4
XFILLER_54_871 VDD VSS VDD VSS gf180mcu_fd_sc_mcu7t5v0__fillcap_4
XFILLER_72_167 VDD VSS VDD VSS gf180mcu_fd_sc_mcu7t5v0__fillcap_8
XFILLER_159_2 VDD VSS VDD VSS gf180mcu_fd_sc_mcu7t5v0__fillcap_64
XFILLER_13_212 VDD VSS VDD VSS gf180mcu_fd_sc_mcu7t5v0__fillcap_64
XFILLER_186_515 VDD VSS VDD VSS gf180mcu_fd_sc_mcu7t5v0__fillcap_8
XFILLER_201_368 VDD VSS VDD VSS gf180mcu_fd_sc_mcu7t5v0__fillcap_8
XFILLER_158_239 VDD VSS VDD VSS gf180mcu_fd_sc_mcu7t5v0__fillcap_4
XFILLER_5_422 VDD VSS VDD VSS gf180mcu_fd_sc_mcu7t5v0__fillcap_64
Xclkload19 VSS clkload19/Z _3446_/CLK VDD VDD VSS gf180mcu_fd_sc_mcu7t5v0__clkbuf_1
XFILLER_181_253 VDD VSS VDD VSS gf180mcu_fd_sc_mcu7t5v0__fillcap_16
XFILLER_49_632 VDD VSS VDD VSS gf180mcu_fd_sc_mcu7t5v0__fillcap_64
XFILLER_76_451 VDD VSS VDD VSS gf180mcu_fd_sc_mcu7t5v0__fillcap_4
XFILLER_237_766 VDD VSS VDD VSS gf180mcu_fd_sc_mcu7t5v0__fillcap_4
Xclkbuf_3_5__f_clk_i VDD VSS clkload4/I clkbuf_0_clk_i/Z VDD VSS gf180mcu_fd_sc_mcu7t5v0__clkbuf_16
XFILLER_17_562 VDD VSS VDD VSS gf180mcu_fd_sc_mcu7t5v0__fillcap_64
XFILLER_32_521 VDD VSS VDD VSS gf180mcu_fd_sc_mcu7t5v0__fillcap_4
XFILLER_44_381 VDD VSS VDD VSS gf180mcu_fd_sc_mcu7t5v0__fillcap_4
XFILLER_149_228 VDD VSS VDD VSS gf180mcu_fd_sc_mcu7t5v0__fillcap_16
XFILLER_60_885 VDD VSS VDD VSS gf180mcu_fd_sc_mcu7t5v0__fillcap_4
X_2802_ _2802_/D _2802_/Q wire153/I VSS _3362_/CLK VDD VDD VSS gf180mcu_fd_sc_mcu7t5v0__dffrnq_1
X_2733_ _2963_/Q VSS VDD _2947_/Q _2955_/Q _2741_/S0 _2939_/Q _2741_/S1 _2733_/Z VDD
+ VSS gf180mcu_fd_sc_mcu7t5v0__mux4_1
XFILLER_9_772 VDD VSS VDD VSS gf180mcu_fd_sc_mcu7t5v0__fillcap_64
XFILLER_74_2 VDD VSS VDD VSS gf180mcu_fd_sc_mcu7t5v0__fillcap_16
X_2664_ _2659_/Z VSS VDD _2658_/Z _2663_/Z _2732_/C _2662_/Z _2735_/S _2664_/Z VDD
+ VSS gf180mcu_fd_sc_mcu7t5v0__mux4_1
X_1615_ VDD VSS _1615_/Z _3429_/Q _3424_/D VDD VSS gf180mcu_fd_sc_mcu7t5v0__xor2_1
X_2595_ _2596_/S VDD VSS _3263_/D _3255_/Q _3263_/Q VDD VSS gf180mcu_fd_sc_mcu7t5v0__mux2_2
X_1546_ VDD _3344_/D _1546_/B _3189_/Q _3190_/Q VSS _1551_/A1 VDD VSS gf180mcu_fd_sc_mcu7t5v0__oai31_1
XFILLER_125_180 VDD VSS VDD VSS gf180mcu_fd_sc_mcu7t5v0__fillcap_16
XFILLER_259_346 VDD VSS VDD VSS gf180mcu_fd_sc_mcu7t5v0__fillcap_4
X_1477_ VDD VSS _3410_/D _1877_/S _1480_/A2 VDD VSS gf180mcu_fd_sc_mcu7t5v0__nor2_1
XFILLER_101_548 VDD VSS VDD VSS gf180mcu_fd_sc_mcu7t5v0__fillcap_8
X_3216_ _3216_/D _3216_/Q wire147/I VSS _3281_/CLK VDD VDD VSS gf180mcu_fd_sc_mcu7t5v0__dffrnq_1
XFILLER_39_142 VDD VSS VDD VSS gf180mcu_fd_sc_mcu7t5v0__fillcap_64
X_3147_ _3147_/D _3147_/Q wire153/I VSS _3357_/CLK VDD VDD VSS gf180mcu_fd_sc_mcu7t5v0__dffrnq_1
XFILLER_54_101 VDD VSS VDD VSS gf180mcu_fd_sc_mcu7t5v0__fillcap_4
XFILLER_227_276 VDD VSS VDD VSS gf180mcu_fd_sc_mcu7t5v0__fillcap_4
XFILLER_215_416 VDD VSS VDD VSS gf180mcu_fd_sc_mcu7t5v0__fillcap_4
XFILLER_36_871 VDD VSS VDD VSS gf180mcu_fd_sc_mcu7t5v0__fillcap_4
X_3078_ _3078_/D _3078_/Q wire165/I VSS _3448_/CLK VDD VDD VSS gf180mcu_fd_sc_mcu7t5v0__dffrnq_1
X_2029_ _2040_/S VDD VSS _3062_/D wire97/Z _3062_/Q VDD VSS gf180mcu_fd_sc_mcu7t5v0__mux2_2
XFILLER_51_874 VDD VSS VDD VSS gf180mcu_fd_sc_mcu7t5v0__fillcap_16
XFILLER_195_345 VDD VSS VDD VSS gf180mcu_fd_sc_mcu7t5v0__fillcap_4
XFILLER_191_562 VDD VSS VDD VSS gf180mcu_fd_sc_mcu7t5v0__fillcap_32
XFILLER_131_150 VDD VSS VDD VSS gf180mcu_fd_sc_mcu7t5v0__fillcap_4
Xclkbuf_leaf_9_clk_i _3277_/CLK VSS VDD clkload0/I VDD VSS gf180mcu_fd_sc_mcu7t5v0__clkbuf_2
XFILLER_49_66 VDD VSS VDD VSS gf180mcu_fd_sc_mcu7t5v0__fillcap_4
XFILLER_58_451 VDD VSS VDD VSS gf180mcu_fd_sc_mcu7t5v0__fillcap_4
XFILLER_219_766 VDD VSS VDD VSS gf180mcu_fd_sc_mcu7t5v0__fillcap_4
XFILLER_105_72 VDD VSS VDD VSS gf180mcu_fd_sc_mcu7t5v0__fillcap_32
XFILLER_14_521 VDD VSS VDD VSS gf180mcu_fd_sc_mcu7t5v0__fillcap_4
XFILLER_26_381 VDD VSS VDD VSS gf180mcu_fd_sc_mcu7t5v0__fillcap_4
XFILLER_121_60 VDD VSS VDD VSS gf180mcu_fd_sc_mcu7t5v0__fillcap_8
XFILLER_159_526 VDD VSS VDD VSS gf180mcu_fd_sc_mcu7t5v0__fillcap_32
XFILLER_42_885 VDD VSS VDD VSS gf180mcu_fd_sc_mcu7t5v0__fillcap_4
XFILLER_81_64 VDD VSS VDD VSS gf180mcu_fd_sc_mcu7t5v0__fillcap_4
XFILLER_201_165 VDD VSS VDD VSS gf180mcu_fd_sc_mcu7t5v0__fillcap_32
XFILLER_6_731 VDD VSS VDD VSS gf180mcu_fd_sc_mcu7t5v0__fillcap_4
X_1400_ VDD VSS _1400_/I _2340_/A1 VDD VSS gf180mcu_fd_sc_mcu7t5v0__clkinv_1
XFILLER_123_640 VDD VSS VDD VSS gf180mcu_fd_sc_mcu7t5v0__fillcap_4
XFILLER_108_692 VDD VSS VDD VSS gf180mcu_fd_sc_mcu7t5v0__fillcap_32
X_2380_ VDD _2380_/B _1654_/Z _2381_/A2 _1424_/I VSS VDD VSS gf180mcu_fd_sc_mcu7t5v0__oai21_1
XFILLER_123_695 VDD VSS VDD VSS gf180mcu_fd_sc_mcu7t5v0__fillcap_4
XFILLER_209_254 VDD VSS VDD VSS gf180mcu_fd_sc_mcu7t5v0__fillcap_4
XFILLER_232_37 VDD VSS VDD VSS gf180mcu_fd_sc_mcu7t5v0__fillcap_64
XFILLER_110_378 VDD VSS VDD VSS gf180mcu_fd_sc_mcu7t5v0__fillcap_4
X_3001_ VDD _3001_/Q _3409_/CLK VSS _3001_/D VDD VSS gf180mcu_fd_sc_mcu7t5v0__dffq_1
XFILLER_36_101 VDD VSS VDD VSS gf180mcu_fd_sc_mcu7t5v0__fillcap_4
XFILLER_209_298 VDD VSS VDD VSS gf180mcu_fd_sc_mcu7t5v0__fillcap_4
XFILLER_18_871 VDD VSS VDD VSS gf180mcu_fd_sc_mcu7t5v0__fillcap_4
XFILLER_33_874 VDD VSS VDD VSS gf180mcu_fd_sc_mcu7t5v0__fillcap_16
X_2716_ _2994_/Q VSS VDD _2978_/Q _2986_/Q _2740_/S0 _2970_/Q _2740_/S1 _2717_/I VDD
+ VSS gf180mcu_fd_sc_mcu7t5v0__mux4_1
XFILLER_173_562 VDD VSS VDD VSS gf180mcu_fd_sc_mcu7t5v0__fillcap_8
XFILLER_161_702 VDD VSS VDD VSS gf180mcu_fd_sc_mcu7t5v0__fillcap_64
X_2647_ VDD VSS wire37/I _3277_/Q _2703_/A4 VDD VSS gf180mcu_fd_sc_mcu7t5v0__or2_2
XFILLER_118_478 VDD VSS VDD VSS gf180mcu_fd_sc_mcu7t5v0__fillcap_4
X_2578_ _2587_/S VDD VSS _3246_/D _3238_/Q wire98/I VDD VSS gf180mcu_fd_sc_mcu7t5v0__mux2_2
X_1529_ VDD VSS _3378_/D _2461_/A1 _1529_/A2 VDD VSS gf180mcu_fd_sc_mcu7t5v0__xor2_1
XFILLER_141_492 VDD VSS VDD VSS gf180mcu_fd_sc_mcu7t5v0__fillcap_16
XFILLER_113_183 VDD VSS VDD VSS gf180mcu_fd_sc_mcu7t5v0__fillcap_16
XFILLER_206_93 VDD VSS VDD VSS gf180mcu_fd_sc_mcu7t5v0__fillcap_8
XFILLER_142_37 VDD VSS VDD VSS gf180mcu_fd_sc_mcu7t5v0__fillcap_4
XFILLER_150_6 VDD VSS VDD VSS gf180mcu_fd_sc_mcu7t5v0__fillcap_16
XFILLER_70_457 VDD VSS VDD VSS gf180mcu_fd_sc_mcu7t5v0__fillcap_64
XFILLER_24_885 VDD VSS VDD VSS gf180mcu_fd_sc_mcu7t5v0__fillcap_4
XFILLER_195_142 VDD VSS VDD VSS gf180mcu_fd_sc_mcu7t5v0__fillcap_8
XFILLER_167_34 VDD VSS VDD VSS gf180mcu_fd_sc_mcu7t5v0__fillcap_16
XFILLER_192_871 VDD VSS VDD VSS gf180mcu_fd_sc_mcu7t5v0__fillcap_4
XFILLER_191_381 VDD VSS VDD VSS gf180mcu_fd_sc_mcu7t5v0__fillcap_16
XFILLER_124_448 VDD VSS VDD VSS gf180mcu_fd_sc_mcu7t5v0__fillcap_4
XFILLER_105_640 VDD VSS VDD VSS gf180mcu_fd_sc_mcu7t5v0__fillcap_4
XFILLER_4_2 VDD VSS VDD VSS gf180mcu_fd_sc_mcu7t5v0__fillcap_32
XFILLER_183_88 VDD VSS VDD VSS gf180mcu_fd_sc_mcu7t5v0__fillcap_16
XFILLER_207_736 VDD VSS VDD VSS gf180mcu_fd_sc_mcu7t5v0__fillcap_32
XFILLER_18_101 VDD VSS VDD VSS gf180mcu_fd_sc_mcu7t5v0__fillcap_4
XFILLER_261_352 VDD VSS VDD VSS gf180mcu_fd_sc_mcu7t5v0__fillcap_64
XFILLER_199_470 VDD VSS VDD VSS gf180mcu_fd_sc_mcu7t5v0__fillcap_8
XFILLER_202_441 VDD VSS VDD VSS gf180mcu_fd_sc_mcu7t5v0__fillcap_8
XFILLER_187_632 VDD VSS VDD VSS gf180mcu_fd_sc_mcu7t5v0__fillcap_16
XFILLER_199_492 VDD VSS VDD VSS gf180mcu_fd_sc_mcu7t5v0__fillcap_16
XFILLER_15_874 VDD VSS VDD VSS gf180mcu_fd_sc_mcu7t5v0__fillcap_16
X_1880_ wire36/Z VDD VSS _2941_/D _2941_/Q _2011_/I0 VDD VSS gf180mcu_fd_sc_mcu7t5v0__mux2_2
XFILLER_202_485 VDD VSS VDD VSS gf180mcu_fd_sc_mcu7t5v0__fillcap_16
XFILLER_186_197 VDD VSS VDD VSS gf180mcu_fd_sc_mcu7t5v0__fillcap_32
XFILLER_30_877 VDD VSS VDD VSS gf180mcu_fd_sc_mcu7t5v0__fillcap_8
XFILLER_155_562 VDD VSS VDD VSS gf180mcu_fd_sc_mcu7t5v0__fillcap_64
XFILLER_143_702 VDD VSS VDD VSS gf180mcu_fd_sc_mcu7t5v0__fillcap_16
X_2501_ _2555_/A1 VDD VSS _2525_/B1 _3224_/Q _3225_/Q VDD VSS gf180mcu_fd_sc_mcu7t5v0__nor3_1
X_2432_ VDD VSS _2433_/A3 _2461_/A1 _2431_/Z VDD VSS gf180mcu_fd_sc_mcu7t5v0__nand2_1
X_2363_ _2345_/I _2363_/B1 _2363_/B2 VDD VSS _3195_/D _2363_/A1 VDD VSS gf180mcu_fd_sc_mcu7t5v0__oai22_1
XFILLER_123_492 VDD VSS VDD VSS gf180mcu_fd_sc_mcu7t5v0__fillcap_8
XFILLER_111_632 VDD VSS VDD VSS gf180mcu_fd_sc_mcu7t5v0__fillcap_4
X_2294_ _2295_/A4 VDD VSS _2307_/B _2305_/B2 _1424_/I VDD VSS gf180mcu_fd_sc_mcu7t5v0__nor3_1
XFILLER_96_387 VDD VSS VDD VSS gf180mcu_fd_sc_mcu7t5v0__fillcap_16
XFILLER_96_365 VDD VSS VDD VSS gf180mcu_fd_sc_mcu7t5v0__fillcap_4
XFILLER_84_527 VDD VSS VDD VSS gf180mcu_fd_sc_mcu7t5v0__fillcap_64
XFILLER_110_153 VDD VSS VDD VSS gf180mcu_fd_sc_mcu7t5v0__fillcap_8
XFILLER_253_842 VDD VSS VDD VSS gf180mcu_fd_sc_mcu7t5v0__fillcap_32
XFILLER_52_457 VDD VSS VDD VSS gf180mcu_fd_sc_mcu7t5v0__fillcap_64
XFILLER_221_772 VDD VSS VDD VSS gf180mcu_fd_sc_mcu7t5v0__fillcap_64
XFILLER_177_186 VDD VSS VDD VSS gf180mcu_fd_sc_mcu7t5v0__fillcap_8
XFILLER_20_387 VDD VSS VDD VSS gf180mcu_fd_sc_mcu7t5v0__fillcap_64
XFILLER_192_145 VDD VSS VDD VSS gf180mcu_fd_sc_mcu7t5v0__fillcap_16
XFILLER_174_871 VDD VSS VDD VSS gf180mcu_fd_sc_mcu7t5v0__fillcap_4
XFILLER_192_189 VDD VSS VDD VSS gf180mcu_fd_sc_mcu7t5v0__fillcap_8
XFILLER_133_212 VDD VSS VDD VSS gf180mcu_fd_sc_mcu7t5v0__fillcap_32
XFILLER_161_554 VDD VSS VDD VSS gf180mcu_fd_sc_mcu7t5v0__fillcap_4
Xclkbuf_leaf_74_clk_i _3446_/CLK VSS VDD clkbuf_3_0__f_clk_i/Z VDD VSS gf180mcu_fd_sc_mcu7t5v0__clkbuf_2
XFILLER_153_58 VDD VSS VDD VSS gf180mcu_fd_sc_mcu7t5v0__fillcap_4
XFILLER_88_877 VDD VSS VDD VSS gf180mcu_fd_sc_mcu7t5v0__fillcap_8
XFILLER_198_6 VDD VSS VDD VSS gf180mcu_fd_sc_mcu7t5v0__fillcap_16
Xmax_cap13 _2587_/S VSS VDD _2596_/S VDD VSS gf180mcu_fd_sc_mcu7t5v0__clkbuf_8
XFILLER_243_352 VDD VSS VDD VSS gf180mcu_fd_sc_mcu7t5v0__fillcap_64
Xclkbuf_leaf_12_clk_i _3182_/CLK VSS VDD clkload5/I VDD VSS gf180mcu_fd_sc_mcu7t5v0__clkbuf_2
XFILLER_169_610 VDD VSS VDD VSS gf180mcu_fd_sc_mcu7t5v0__fillcap_16
XFILLER_71_766 VDD VSS VDD VSS gf180mcu_fd_sc_mcu7t5v0__fillcap_4
XFILLER_169_632 VDD VSS VDD VSS gf180mcu_fd_sc_mcu7t5v0__fillcap_64
XFILLER_62_22 VDD VSS VDD VSS gf180mcu_fd_sc_mcu7t5v0__fillcap_8
XFILLER_30_107 VDD VSS VDD VSS gf180mcu_fd_sc_mcu7t5v0__fillcap_64
XFILLER_239_2 VDD VSS VDD VSS gf180mcu_fd_sc_mcu7t5v0__fillcap_64
XFILLER_141_2 VDD VSS VDD VSS gf180mcu_fd_sc_mcu7t5v0__fillcap_16
Xclkbuf_leaf_27_clk_i _3212_/CLK VSS VDD clkload4/I VDD VSS gf180mcu_fd_sc_mcu7t5v0__clkbuf_2
XFILLER_211_282 VDD VSS VDD VSS gf180mcu_fd_sc_mcu7t5v0__fillcap_16
XFILLER_12_877 VDD VSS VDD VSS gf180mcu_fd_sc_mcu7t5v0__fillcap_8
XFILLER_183_123 VDD VSS VDD VSS gf180mcu_fd_sc_mcu7t5v0__fillcap_16
XFILLER_137_562 VDD VSS VDD VSS gf180mcu_fd_sc_mcu7t5v0__fillcap_8
XFILLER_125_702 VDD VSS VDD VSS gf180mcu_fd_sc_mcu7t5v0__fillcap_64
XFILLER_109_297 VDD VSS VDD VSS gf180mcu_fd_sc_mcu7t5v0__fillcap_16
XFILLER_180_885 VDD VSS VDD VSS gf180mcu_fd_sc_mcu7t5v0__fillcap_4
XFILLER_152_587 VDD VSS VDD VSS gf180mcu_fd_sc_mcu7t5v0__fillcap_8
XFILLER_124_289 VDD VSS VDD VSS gf180mcu_fd_sc_mcu7t5v0__fillcap_16
XFILLER_105_492 VDD VSS VDD VSS gf180mcu_fd_sc_mcu7t5v0__fillcap_8
XFILLER_78_387 VDD VSS VDD VSS gf180mcu_fd_sc_mcu7t5v0__fillcap_64
XFILLER_78_376 VDD VSS VDD VSS gf180mcu_fd_sc_mcu7t5v0__fillcap_8
XFILLER_66_527 VDD VSS VDD VSS gf180mcu_fd_sc_mcu7t5v0__fillcap_64
XFILLER_120_451 VDD VSS VDD VSS gf180mcu_fd_sc_mcu7t5v0__fillcap_4
XFILLER_235_842 VDD VSS VDD VSS gf180mcu_fd_sc_mcu7t5v0__fillcap_32
XFILLER_250_801 VDD VSS VDD VSS gf180mcu_fd_sc_mcu7t5v0__fillcap_4
XFILLER_262_661 VDD VSS VDD VSS gf180mcu_fd_sc_mcu7t5v0__fillcap_4
XFILLER_34_457 VDD VSS VDD VSS gf180mcu_fd_sc_mcu7t5v0__fillcap_64
X_2981_ VDD _2981_/Q _3005_/CLK VSS _2981_/D VDD VSS gf180mcu_fd_sc_mcu7t5v0__dffq_1
XFILLER_61_276 VDD VSS VDD VSS gf180mcu_fd_sc_mcu7t5v0__fillcap_4
XFILLER_203_772 VDD VSS VDD VSS gf180mcu_fd_sc_mcu7t5v0__fillcap_64
XFILLER_159_142 VDD VSS VDD VSS gf180mcu_fd_sc_mcu7t5v0__fillcap_32
X_1932_ _1935_/S VDD VSS _2985_/D _2015_/I0 _2985_/Q VDD VSS gf180mcu_fd_sc_mcu7t5v0__mux2_2
XFILLER_230_591 VDD VSS VDD VSS gf180mcu_fd_sc_mcu7t5v0__fillcap_4
X_1863_ _1869_/S VDD VSS _2926_/D _1863_/I0 _2926_/Q VDD VSS gf180mcu_fd_sc_mcu7t5v0__mux2_2
XFILLER_128_540 VDD VSS VDD VSS gf180mcu_fd_sc_mcu7t5v0__fillcap_4
XFILLER_156_871 VDD VSS VDD VSS gf180mcu_fd_sc_mcu7t5v0__fillcap_4
X_1794_ _1795_/S VDD VSS _2867_/D _2867_/Q _1794_/I1 VDD VSS gf180mcu_fd_sc_mcu7t5v0__mux2_2
XFILLER_115_212 VDD VSS VDD VSS gf180mcu_fd_sc_mcu7t5v0__fillcap_16
XFILLER_116_724 VDD VSS VDD VSS gf180mcu_fd_sc_mcu7t5v0__fillcap_8
XFILLER_171_874 VDD VSS VDD VSS gf180mcu_fd_sc_mcu7t5v0__fillcap_16
XFILLER_170_340 VDD VSS VDD VSS gf180mcu_fd_sc_mcu7t5v0__fillcap_8
X_2415_ _2832_/Q VSS VDD _2816_/Q _2824_/Q _1519_/B _2808_/Q wire76/I _2415_/Z VDD
+ VSS gf180mcu_fd_sc_mcu7t5v0__mux4_1
XFILLER_88_107 VDD VSS VDD VSS gf180mcu_fd_sc_mcu7t5v0__fillcap_16
XFILLER_131_749 VDD VSS VDD VSS gf180mcu_fd_sc_mcu7t5v0__fillcap_16
XFILLER_257_422 VDD VSS VDD VSS gf180mcu_fd_sc_mcu7t5v0__fillcap_64
X_3395_ VSS _3395_/CLK VDD _3395_/D wire72/I wire161/Z VDD VSS gf180mcu_fd_sc_mcu7t5v0__dffsnq_1
X_2346_ VDD VSS _2353_/B _3192_/Q _2345_/I VDD VSS gf180mcu_fd_sc_mcu7t5v0__nor2_1
XFILLER_111_473 VDD VSS VDD VSS gf180mcu_fd_sc_mcu7t5v0__fillcap_16
XFILLER_85_836 VDD VSS VDD VSS gf180mcu_fd_sc_mcu7t5v0__fillcap_4
X_2277_ wire153/I VDD VSS _2278_/A4 _3363_/D _2341_/A2 VDD VSS gf180mcu_fd_sc_mcu7t5v0__nand3_1
XFILLER_225_352 VDD VSS VDD VSS gf180mcu_fd_sc_mcu7t5v0__fillcap_64
XFILLER_203_72 VDD VSS VDD VSS gf180mcu_fd_sc_mcu7t5v0__fillcap_16
XFILLER_240_311 VDD VSS VDD VSS gf180mcu_fd_sc_mcu7t5v0__fillcap_4
XFILLER_252_171 VDD VSS VDD VSS gf180mcu_fd_sc_mcu7t5v0__fillcap_4
XFILLER_53_766 VDD VSS VDD VSS gf180mcu_fd_sc_mcu7t5v0__fillcap_4
XFILLER_16_37 VDD VSS VDD VSS gf180mcu_fd_sc_mcu7t5v0__fillcap_64
XFILLER_12_107 VDD VSS VDD VSS gf180mcu_fd_sc_mcu7t5v0__fillcap_64
Xclkbuf_4_10_0_host_clk_i _2931_/CLK VSS VDD clkbuf_0_host_clk_i/Z VDD VSS gf180mcu_fd_sc_mcu7t5v0__clkbuf_2
XFILLER_21_696 VDD VSS VDD VSS gf180mcu_fd_sc_mcu7t5v0__fillcap_4
XFILLER_181_616 VDD VSS VDD VSS gf180mcu_fd_sc_mcu7t5v0__fillcap_8
XFILLER_119_562 VDD VSS VDD VSS gf180mcu_fd_sc_mcu7t5v0__fillcap_4
XFILLER_107_702 VDD VSS VDD VSS gf180mcu_fd_sc_mcu7t5v0__fillcap_64
XFILLER_134_521 VDD VSS VDD VSS gf180mcu_fd_sc_mcu7t5v0__fillcap_4
XFILLER_4_317 VDD VSS VDD VSS gf180mcu_fd_sc_mcu7t5v0__fillcap_64
XFILLER_113_6 VDD VSS VDD VSS gf180mcu_fd_sc_mcu7t5v0__fillcap_16
XFILLER_134_565 VDD VSS VDD VSS gf180mcu_fd_sc_mcu7t5v0__fillcap_16
XFILLER_162_885 VDD VSS VDD VSS gf180mcu_fd_sc_mcu7t5v0__fillcap_4
XFILLER_0_512 VDD VSS VDD VSS gf180mcu_fd_sc_mcu7t5v0__fillcap_32
XFILLER_48_527 VDD VSS VDD VSS gf180mcu_fd_sc_mcu7t5v0__fillcap_64
XFILLER_102_451 VDD VSS VDD VSS gf180mcu_fd_sc_mcu7t5v0__fillcap_4
XFILLER_217_842 VDD VSS VDD VSS gf180mcu_fd_sc_mcu7t5v0__fillcap_32
XFILLER_232_801 VDD VSS VDD VSS gf180mcu_fd_sc_mcu7t5v0__fillcap_4
XFILLER_244_661 VDD VSS VDD VSS gf180mcu_fd_sc_mcu7t5v0__fillcap_4
XFILLER_113_72 VDD VSS VDD VSS gf180mcu_fd_sc_mcu7t5v0__fillcap_64
XFILLER_16_457 VDD VSS VDD VSS gf180mcu_fd_sc_mcu7t5v0__fillcap_64
XFILLER_31_416 VDD VSS VDD VSS gf180mcu_fd_sc_mcu7t5v0__fillcap_4
XFILLER_43_276 VDD VSS VDD VSS gf180mcu_fd_sc_mcu7t5v0__fillcap_4
XFILLER_197_760 VDD VSS VDD VSS gf180mcu_fd_sc_mcu7t5v0__fillcap_8
Xspi_opentarget_i3c_top_176 irq_o_PD VDD VSS VDD VSS gf180mcu_fd_sc_mcu7t5v0__tiel
Xspi_opentarget_i3c_top_187 sda_pad_PDRV0 VDD VSS VDD VSS gf180mcu_fd_sc_mcu7t5v0__tiel
Xspi_opentarget_i3c_top_198 spi_miso_o_PU VDD VSS VDD VSS gf180mcu_fd_sc_mcu7t5v0__tiel
XFILLER_156_123 VDD VSS VDD VSS gf180mcu_fd_sc_mcu7t5v0__fillcap_4
XFILLER_138_871 VDD VSS VDD VSS gf180mcu_fd_sc_mcu7t5v0__fillcap_4
XFILLER_8_667 VDD VSS VDD VSS gf180mcu_fd_sc_mcu7t5v0__fillcap_64
XFILLER_180_660 VDD VSS VDD VSS gf180mcu_fd_sc_mcu7t5v0__fillcap_4
XFILLER_153_874 VDD VSS VDD VSS gf180mcu_fd_sc_mcu7t5v0__fillcap_16
X_2200_ VDD VSS _3150_/D _3456_/D _2138_/S VDD VSS gf180mcu_fd_sc_mcu7t5v0__xnor2_1
XFILLER_239_422 VDD VSS VDD VSS gf180mcu_fd_sc_mcu7t5v0__fillcap_64
X_3180_ VDD _3180_/Q _3181_/CLK VSS _3180_/D VDD VSS gf180mcu_fd_sc_mcu7t5v0__dffq_1
XFILLER_266_241 VDD VSS VDD VSS gf180mcu_fd_sc_mcu7t5v0__fillcap_4
X_2131_ _2137_/S VDD VSS _3119_/D wire97/Z _3119_/Q VDD VSS gf180mcu_fd_sc_mcu7t5v0__mux2_2
XFILLER_79_696 VDD VSS VDD VSS gf180mcu_fd_sc_mcu7t5v0__fillcap_4
XFILLER_67_836 VDD VSS VDD VSS gf180mcu_fd_sc_mcu7t5v0__fillcap_4
X_2062_ _3277_/Q _2061_/Z VDD VSS _2072_/S _3455_/Q _3276_/Q VDD VSS gf180mcu_fd_sc_mcu7t5v0__nand4_1
XFILLER_94_655 VDD VSS VDD VSS gf180mcu_fd_sc_mcu7t5v0__fillcap_8
XFILLER_207_352 VDD VSS VDD VSS gf180mcu_fd_sc_mcu7t5v0__fillcap_64
XFILLER_240_37 VDD VSS VDD VSS gf180mcu_fd_sc_mcu7t5v0__fillcap_64
XFILLER_240_26 VDD VSS VDD VSS gf180mcu_fd_sc_mcu7t5v0__fillcap_8
XFILLER_234_171 VDD VSS VDD VSS gf180mcu_fd_sc_mcu7t5v0__fillcap_4
XFILLER_35_766 VDD VSS VDD VSS gf180mcu_fd_sc_mcu7t5v0__fillcap_4
XFILLER_179_237 VDD VSS VDD VSS gf180mcu_fd_sc_mcu7t5v0__fillcap_16
X_2964_ VDD _2964_/Q _3150_/CLK VSS _2964_/D VDD VSS gf180mcu_fd_sc_mcu7t5v0__dffq_1
XFILLER_147_101 VDD VSS VDD VSS gf180mcu_fd_sc_mcu7t5v0__fillcap_4
X_1915_ _1917_/S VDD VSS _2970_/D _2970_/Q wire116/Z VDD VSS gf180mcu_fd_sc_mcu7t5v0__mux2_2
X_2895_ VDD _2895_/Q _2899_/CLK VSS _2895_/D VDD VSS gf180mcu_fd_sc_mcu7t5v0__dffq_1
X_1846_ _1851_/S VDD VSS _2911_/D _1864_/I0 _2911_/Q VDD VSS gf180mcu_fd_sc_mcu7t5v0__mux2_2
X_1777_ _1777_/S VDD VSS _2852_/D _3126_/Q _2852_/Q VDD VSS gf180mcu_fd_sc_mcu7t5v0__mux2_2
XFILLER_190_457 VDD VSS VDD VSS gf180mcu_fd_sc_mcu7t5v0__fillcap_16
XFILLER_143_340 VDD VSS VDD VSS gf180mcu_fd_sc_mcu7t5v0__fillcap_8
XFILLER_171_693 VDD VSS VDD VSS gf180mcu_fd_sc_mcu7t5v0__fillcap_4
XFILLER_144_885 VDD VSS VDD VSS gf180mcu_fd_sc_mcu7t5v0__fillcap_4
XFILLER_103_204 VDD VSS VDD VSS gf180mcu_fd_sc_mcu7t5v0__fillcap_4
X_3447_ _3447_/D _3448_/D wire165/I VSS _3448_/CLK VDD VDD VSS gf180mcu_fd_sc_mcu7t5v0__dffrnq_1
XFILLER_258_731 VDD VSS VDD VSS gf180mcu_fd_sc_mcu7t5v0__fillcap_4
X_3378_ _3378_/D _3403_/D _3403_/RN VSS _3392_/CLK VDD VDD VSS gf180mcu_fd_sc_mcu7t5v0__dffrnq_1
XFILLER_97_471 VDD VSS VDD VSS gf180mcu_fd_sc_mcu7t5v0__fillcap_16
X_2329_ _2483_/B VDD VSS _2481_/B _3359_/Q wire84/Z VDD VSS gf180mcu_fd_sc_mcu7t5v0__nand3_1
XFILLER_57_346 VDD VSS VDD VSS gf180mcu_fd_sc_mcu7t5v0__fillcap_4
XFILLER_214_801 VDD VSS VDD VSS gf180mcu_fd_sc_mcu7t5v0__fillcap_4
XFILLER_226_661 VDD VSS VDD VSS gf180mcu_fd_sc_mcu7t5v0__fillcap_4
XFILLER_150_37 VDD VSS VDD VSS gf180mcu_fd_sc_mcu7t5v0__fillcap_4
XFILLER_13_416 VDD VSS VDD VSS gf180mcu_fd_sc_mcu7t5v0__fillcap_4
XFILLER_25_276 VDD VSS VDD VSS gf180mcu_fd_sc_mcu7t5v0__fillcap_4
XFILLER_139_613 VDD VSS VDD VSS gf180mcu_fd_sc_mcu7t5v0__fillcap_16
XFILLER_166_465 VDD VSS VDD VSS gf180mcu_fd_sc_mcu7t5v0__fillcap_4
XFILLER_153_115 VDD VSS VDD VSS gf180mcu_fd_sc_mcu7t5v0__fillcap_8
XFILLER_193_273 VDD VSS VDD VSS gf180mcu_fd_sc_mcu7t5v0__fillcap_4
XFILLER_5_626 VDD VSS VDD VSS gf180mcu_fd_sc_mcu7t5v0__fillcap_4
XFILLER_135_874 VDD VSS VDD VSS gf180mcu_fd_sc_mcu7t5v0__fillcap_16
XFILLER_107_532 VDD VSS VDD VSS gf180mcu_fd_sc_mcu7t5v0__fillcap_4
XFILLER_104_2 VDD VSS VDD VSS gf180mcu_fd_sc_mcu7t5v0__fillcap_8
XFILLER_150_877 VDD VSS VDD VSS gf180mcu_fd_sc_mcu7t5v0__fillcap_8
XFILLER_0_342 VDD VSS VDD VSS gf180mcu_fd_sc_mcu7t5v0__fillcap_32
XFILLER_248_241 VDD VSS VDD VSS gf180mcu_fd_sc_mcu7t5v0__fillcap_4
XFILLER_49_836 VDD VSS VDD VSS gf180mcu_fd_sc_mcu7t5v0__fillcap_4
XFILLER_84_31 VDD VSS VDD VSS gf180mcu_fd_sc_mcu7t5v0__fillcap_4
XFILLER_189_524 VDD VSS VDD VSS gf180mcu_fd_sc_mcu7t5v0__fillcap_16
XFILLER_17_766 VDD VSS VDD VSS gf180mcu_fd_sc_mcu7t5v0__fillcap_4
XFILLER_129_134 VDD VSS VDD VSS gf180mcu_fd_sc_mcu7t5v0__fillcap_4
X_2680_ _2959_/Q VSS VDD _2943_/Q _2951_/Q _2718_/S0 _2935_/Q _2742_/S1 _2680_/Z VDD
+ VSS gf180mcu_fd_sc_mcu7t5v0__mux4_1
XFILLER_185_763 VDD VSS VDD VSS gf180mcu_fd_sc_mcu7t5v0__fillcap_4
X_1700_ VDD VSS _1700_/Z wire105/Z _2483_/A1 VDD VSS gf180mcu_fd_sc_mcu7t5v0__and2_1
X_1631_ VDD VSS _1632_/B _3114_/Q _3113_/Q VDD VSS gf180mcu_fd_sc_mcu7t5v0__nor2_1
XFILLER_172_457 VDD VSS VDD VSS gf180mcu_fd_sc_mcu7t5v0__fillcap_4
X_1562_ _3144_/Q _1556_/Z VDD VSS _1587_/B _3143_/Q _3142_/Q VDD VSS gf180mcu_fd_sc_mcu7t5v0__nor4_1
X_3301_ _3301_/D _3301_/Q wire165/Z VSS clkload8/I VDD VDD VSS gf180mcu_fd_sc_mcu7t5v0__dffrnq_1
XFILLER_126_885 VDD VSS VDD VSS gf180mcu_fd_sc_mcu7t5v0__fillcap_4
X_1493_ VDD VSS _3419_/D _3445_/D _1493_/A2 VDD VSS gf180mcu_fd_sc_mcu7t5v0__xnor2_1
X_3232_ _3232_/D _3232_/Q wire145/I VSS _3329_/CLK VDD VDD VSS gf180mcu_fd_sc_mcu7t5v0__dffrnq_1
X_3163_ _3163_/D _3163_/Q wire147/I VSS _3166_/CLK VDD VDD VSS gf180mcu_fd_sc_mcu7t5v0__dffrnq_1
XFILLER_140_387 VDD VSS VDD VSS gf180mcu_fd_sc_mcu7t5v0__fillcap_16
X_2114_ VDD VSS _2116_/A3 _2074_/Z _2119_/A3 VDD VSS gf180mcu_fd_sc_mcu7t5v0__nand2_1
XFILLER_39_346 VDD VSS VDD VSS gf180mcu_fd_sc_mcu7t5v0__fillcap_4
X_3094_ _3094_/D _3094_/Q wire145/Z VSS _3159_/CLK VDD VDD VSS gf180mcu_fd_sc_mcu7t5v0__dffrnq_1
XFILLER_208_661 VDD VSS VDD VSS gf180mcu_fd_sc_mcu7t5v0__fillcap_4
X_2045_ _2059_/S VDD VSS _3078_/D _3294_/Q _3078_/Q VDD VSS gf180mcu_fd_sc_mcu7t5v0__mux2_2
X_2947_ VDD _2947_/Q _3181_/CLK VSS _2947_/D VDD VSS gf180mcu_fd_sc_mcu7t5v0__dffq_1
X_2878_ VDD _2878_/Q _3369_/CLK VSS _2878_/D VDD VSS gf180mcu_fd_sc_mcu7t5v0__dffq_1
X_1829_ _1832_/S VDD VSS _2897_/D _2897_/Q wire131/Z VDD VSS gf180mcu_fd_sc_mcu7t5v0__mux2_2
XFILLER_150_107 VDD VSS VDD VSS gf180mcu_fd_sc_mcu7t5v0__fillcap_16
XFILLER_117_874 VDD VSS VDD VSS gf180mcu_fd_sc_mcu7t5v0__fillcap_16
XFILLER_131_343 VDD VSS VDD VSS gf180mcu_fd_sc_mcu7t5v0__fillcap_4
XFILLER_132_877 VDD VSS VDD VSS gf180mcu_fd_sc_mcu7t5v0__fillcap_8
XFILLER_218_403 VDD VSS VDD VSS gf180mcu_fd_sc_mcu7t5v0__fillcap_8
XFILLER_260_247 VDD VSS VDD VSS gf180mcu_fd_sc_mcu7t5v0__fillcap_64
XFILLER_198_387 VDD VSS VDD VSS gf180mcu_fd_sc_mcu7t5v0__fillcap_64
XFILLER_186_527 VDD VSS VDD VSS gf180mcu_fd_sc_mcu7t5v0__fillcap_8
XFILLER_9_206 VDD VSS VDD VSS gf180mcu_fd_sc_mcu7t5v0__fillcap_4
XFILLER_154_457 VDD VSS VDD VSS gf180mcu_fd_sc_mcu7t5v0__fillcap_64
XFILLER_108_885 VDD VSS VDD VSS gf180mcu_fd_sc_mcu7t5v0__fillcap_4
XFILLER_134_192 VDD VSS VDD VSS gf180mcu_fd_sc_mcu7t5v0__fillcap_32
XFILLER_79_97 VDD VSS VDD VSS gf180mcu_fd_sc_mcu7t5v0__fillcap_8
XFILLER_110_505 VDD VSS VDD VSS gf180mcu_fd_sc_mcu7t5v0__fillcap_16
XFILLER_122_387 VDD VSS VDD VSS gf180mcu_fd_sc_mcu7t5v0__fillcap_8
XFILLER_110_527 VDD VSS VDD VSS gf180mcu_fd_sc_mcu7t5v0__fillcap_4
XFILLER_0_172 VDD VSS VDD VSS gf180mcu_fd_sc_mcu7t5v0__fillcap_32
XFILLER_252_737 VDD VSS VDD VSS gf180mcu_fd_sc_mcu7t5v0__fillcap_64
XFILLER_264_597 VDD VSS VDD VSS gf180mcu_fd_sc_mcu7t5v0__fillcap_64
XFILLER_189_387 VDD VSS VDD VSS gf180mcu_fd_sc_mcu7t5v0__fillcap_32
XFILLER_220_667 VDD VSS VDD VSS gf180mcu_fd_sc_mcu7t5v0__fillcap_64
XFILLER_220_656 VDD VSS VDD VSS gf180mcu_fd_sc_mcu7t5v0__fillcap_8
X_2801_ VDD VSS _3341_/D _2801_/A1 _2801_/A2 VDD VSS gf180mcu_fd_sc_mcu7t5v0__nand2_1
X_2732_ _2732_/B _2732_/C VDD VSS _2736_/B _2735_/S _2732_/A2 VDD VSS gf180mcu_fd_sc_mcu7t5v0__aoi211_1
XFILLER_117_115 VDD VSS VDD VSS gf180mcu_fd_sc_mcu7t5v0__fillcap_8
XFILLER_173_766 VDD VSS VDD VSS gf180mcu_fd_sc_mcu7t5v0__fillcap_4
XFILLER_67_2 VDD VSS VDD VSS gf180mcu_fd_sc_mcu7t5v0__fillcap_64
X_2663_ _2989_/Q VSS VDD _2973_/Q _2981_/Q _2740_/S0 _2965_/Q _2740_/S1 _2663_/Z VDD
+ VSS gf180mcu_fd_sc_mcu7t5v0__mux4_1
X_1614_ _1612_/Z _1614_/A4 VDD VSS _3366_/D _1609_/Z _1611_/Z VDD VSS gf180mcu_fd_sc_mcu7t5v0__nor4_1
XFILLER_172_276 VDD VSS VDD VSS gf180mcu_fd_sc_mcu7t5v0__fillcap_16
X_2594_ wire12/I VDD VSS _3262_/D _3254_/Q _3262_/Q VDD VSS gf180mcu_fd_sc_mcu7t5v0__mux2_2
XFILLER_132_107 VDD VSS VDD VSS gf180mcu_fd_sc_mcu7t5v0__fillcap_16
XFILLER_160_449 VDD VSS VDD VSS gf180mcu_fd_sc_mcu7t5v0__fillcap_4
X_1545_ _3342_/Q VDD VSS _1546_/B wire84/Z _3188_/Q VDD VSS gf180mcu_fd_sc_mcu7t5v0__nand3_1
XFILLER_5_72 VDD VSS VDD VSS gf180mcu_fd_sc_mcu7t5v0__fillcap_64
XFILLER_113_343 VDD VSS VDD VSS gf180mcu_fd_sc_mcu7t5v0__fillcap_4
XFILLER_114_877 VDD VSS VDD VSS gf180mcu_fd_sc_mcu7t5v0__fillcap_8
X_3215_ _3215_/D _3215_/Q wire147/I VSS _3279_/CLK VDD VDD VSS gf180mcu_fd_sc_mcu7t5v0__dffrnq_1
X_1476_ _3410_/Q VDD VSS _1480_/A2 _3409_/Q _1465_/Z VDD VSS gf180mcu_fd_sc_mcu7t5v0__aoi21_1
X_3146_ _3146_/D _3146_/Q wire153/I VSS _3357_/CLK VDD VDD VSS gf180mcu_fd_sc_mcu7t5v0__dffrnq_1
XFILLER_95_772 VDD VSS VDD VSS gf180mcu_fd_sc_mcu7t5v0__fillcap_64
X_3077_ _3077_/D _3077_/Q wire165/Z VSS clkload7/I VDD VDD VSS gf180mcu_fd_sc_mcu7t5v0__dffrnq_1
XFILLER_242_247 VDD VSS VDD VSS gf180mcu_fd_sc_mcu7t5v0__fillcap_64
X_2028_ _3277_/Q _2026_/Z VDD VSS _2060_/S _3455_/Q _3276_/Q VDD VSS gf180mcu_fd_sc_mcu7t5v0__nand4_2
XFILLER_211_72 VDD VSS VDD VSS gf180mcu_fd_sc_mcu7t5v0__fillcap_8
XFILLER_51_842 VDD VSS VDD VSS gf180mcu_fd_sc_mcu7t5v0__fillcap_32
XFILLER_211_612 VDD VSS VDD VSS gf180mcu_fd_sc_mcu7t5v0__fillcap_16
XFILLER_168_527 VDD VSS VDD VSS gf180mcu_fd_sc_mcu7t5v0__fillcap_4
XFILLER_24_37 VDD VSS VDD VSS gf180mcu_fd_sc_mcu7t5v0__fillcap_64
XFILLER_109_649 VDD VSS VDD VSS gf180mcu_fd_sc_mcu7t5v0__fillcap_4
XFILLER_136_457 VDD VSS VDD VSS gf180mcu_fd_sc_mcu7t5v0__fillcap_8
XFILLER_163_276 VDD VSS VDD VSS gf180mcu_fd_sc_mcu7t5v0__fillcap_4
XFILLER_163_287 VDD VSS VDD VSS gf180mcu_fd_sc_mcu7t5v0__fillcap_16
XFILLER_124_619 VDD VSS VDD VSS gf180mcu_fd_sc_mcu7t5v0__fillcap_4
XFILLER_151_438 VDD VSS VDD VSS gf180mcu_fd_sc_mcu7t5v0__fillcap_8
XFILLER_266_807 VDD VSS VDD VSS gf180mcu_fd_sc_mcu7t5v0__fillcap_64
XFILLER_77_238 VDD VSS VDD VSS gf180mcu_fd_sc_mcu7t5v0__fillcap_16
XFILLER_73_422 VDD VSS VDD VSS gf180mcu_fd_sc_mcu7t5v0__fillcap_64
XFILLER_234_737 VDD VSS VDD VSS gf180mcu_fd_sc_mcu7t5v0__fillcap_64
XFILLER_246_597 VDD VSS VDD VSS gf180mcu_fd_sc_mcu7t5v0__fillcap_64
XFILLER_171_2 VDD VSS VDD VSS gf180mcu_fd_sc_mcu7t5v0__fillcap_64
XFILLER_85_282 VDD VSS VDD VSS gf180mcu_fd_sc_mcu7t5v0__fillcap_8
XFILLER_65_66 VDD VSS VDD VSS gf180mcu_fd_sc_mcu7t5v0__fillcap_4
XFILLER_261_556 VDD VSS VDD VSS gf180mcu_fd_sc_mcu7t5v0__fillcap_4
XFILLER_187_836 VDD VSS VDD VSS gf180mcu_fd_sc_mcu7t5v0__fillcap_4
XFILLER_121_72 VDD VSS VDD VSS gf180mcu_fd_sc_mcu7t5v0__fillcap_32
XFILLER_202_667 VDD VSS VDD VSS gf180mcu_fd_sc_mcu7t5v0__fillcap_64
XFILLER_41_352 VDD VSS VDD VSS gf180mcu_fd_sc_mcu7t5v0__fillcap_64
XFILLER_201_155 VDD VSS VDD VSS gf180mcu_fd_sc_mcu7t5v0__fillcap_4
XFILLER_127_446 VDD VSS VDD VSS gf180mcu_fd_sc_mcu7t5v0__fillcap_4
XFILLER_155_766 VDD VSS VDD VSS gf180mcu_fd_sc_mcu7t5v0__fillcap_4
XFILLER_115_608 VDD VSS VDD VSS gf180mcu_fd_sc_mcu7t5v0__fillcap_4
XFILLER_114_107 VDD VSS VDD VSS gf180mcu_fd_sc_mcu7t5v0__fillcap_8
XFILLER_108_660 VDD VSS VDD VSS gf180mcu_fd_sc_mcu7t5v0__fillcap_4
XFILLER_154_287 VDD VSS VDD VSS gf180mcu_fd_sc_mcu7t5v0__fillcap_16
XFILLER_142_427 VDD VSS VDD VSS gf180mcu_fd_sc_mcu7t5v0__fillcap_16
XFILLER_146_91 VDD VSS VDD VSS gf180mcu_fd_sc_mcu7t5v0__fillcap_8
XFILLER_111_836 VDD VSS VDD VSS gf180mcu_fd_sc_mcu7t5v0__fillcap_4
XFILLER_256_317 VDD VSS VDD VSS gf180mcu_fd_sc_mcu7t5v0__fillcap_64
XFILLER_1_492 VDD VSS VDD VSS gf180mcu_fd_sc_mcu7t5v0__fillcap_64
X_3000_ VDD _3000_/Q _3022_/CLK VSS _3000_/D VDD VSS gf180mcu_fd_sc_mcu7t5v0__dffq_1
XFILLER_77_772 VDD VSS VDD VSS gf180mcu_fd_sc_mcu7t5v0__fillcap_64
XFILLER_209_266 VDD VSS VDD VSS gf180mcu_fd_sc_mcu7t5v0__fillcap_8
XFILLER_92_731 VDD VSS VDD VSS gf180mcu_fd_sc_mcu7t5v0__fillcap_4
XFILLER_224_247 VDD VSS VDD VSS gf180mcu_fd_sc_mcu7t5v0__fillcap_64
XFILLER_33_842 VDD VSS VDD VSS gf180mcu_fd_sc_mcu7t5v0__fillcap_32
XFILLER_60_661 VDD VSS VDD VSS gf180mcu_fd_sc_mcu7t5v0__fillcap_4
Xclkbuf_4_15_0_host_clk_i _2899_/CLK VSS VDD clkbuf_0_host_clk_i/Z VDD VSS gf180mcu_fd_sc_mcu7t5v0__clkbuf_2
XFILLER_177_368 VDD VSS VDD VSS gf180mcu_fd_sc_mcu7t5v0__fillcap_4
X_2715_ _2715_/B _2715_/C VDD VSS _3314_/D _2752_/B _2715_/A2 VDD VSS gf180mcu_fd_sc_mcu7t5v0__oai211_1
XFILLER_118_457 VDD VSS VDD VSS gf180mcu_fd_sc_mcu7t5v0__fillcap_4
X_2646_ wire46/I VDD VSS _3309_/D _3267_/Q _3309_/Q VDD VSS gf180mcu_fd_sc_mcu7t5v0__mux2_2
XFILLER_133_416 VDD VSS VDD VSS gf180mcu_fd_sc_mcu7t5v0__fillcap_4
X_2577_ _2587_/S VDD VSS _3245_/D _3237_/Q _3245_/Q VDD VSS gf180mcu_fd_sc_mcu7t5v0__mux2_2
XFILLER_99_352 VDD VSS VDD VSS gf180mcu_fd_sc_mcu7t5v0__fillcap_8
XFILLER_99_341 VDD VSS VDD VSS gf180mcu_fd_sc_mcu7t5v0__fillcap_8
XFILLER_248_807 VDD VSS VDD VSS gf180mcu_fd_sc_mcu7t5v0__fillcap_64
X_1528_ VDD VSS _3383_/D _3383_/Q _1522_/Z VDD VSS gf180mcu_fd_sc_mcu7t5v0__xor2_1
X_1459_ _1459_/A3 _1457_/Z VDD VSS _1485_/A2 _1459_/A1 wire55/I VDD VSS gf180mcu_fd_sc_mcu7t5v0__nor4_1
XFILLER_55_422 VDD VSS VDD VSS gf180mcu_fd_sc_mcu7t5v0__fillcap_64
XFILLER_67_282 VDD VSS VDD VSS gf180mcu_fd_sc_mcu7t5v0__fillcap_64
XFILLER_216_737 VDD VSS VDD VSS gf180mcu_fd_sc_mcu7t5v0__fillcap_64
XFILLER_228_597 VDD VSS VDD VSS gf180mcu_fd_sc_mcu7t5v0__fillcap_64
X_3129_ _3129_/D _3129_/Q wire151/I VSS _3165_/CLK VDD VDD VSS gf180mcu_fd_sc_mcu7t5v0__dffrnq_1
XFILLER_243_556 VDD VSS VDD VSS gf180mcu_fd_sc_mcu7t5v0__fillcap_4
XFILLER_196_644 VDD VSS VDD VSS gf180mcu_fd_sc_mcu7t5v0__fillcap_16
XFILLER_169_836 VDD VSS VDD VSS gf180mcu_fd_sc_mcu7t5v0__fillcap_4
XFILLER_23_352 VDD VSS VDD VSS gf180mcu_fd_sc_mcu7t5v0__fillcap_64
XFILLER_50_171 VDD VSS VDD VSS gf180mcu_fd_sc_mcu7t5v0__fillcap_4
XFILLER_3_702 VDD VSS VDD VSS gf180mcu_fd_sc_mcu7t5v0__fillcap_64
XFILLER_238_317 VDD VSS VDD VSS gf180mcu_fd_sc_mcu7t5v0__fillcap_64
XFILLER_265_136 VDD VSS VDD VSS gf180mcu_fd_sc_mcu7t5v0__fillcap_4
XFILLER_59_772 VDD VSS VDD VSS gf180mcu_fd_sc_mcu7t5v0__fillcap_64
XFILLER_120_699 VDD VSS VDD VSS gf180mcu_fd_sc_mcu7t5v0__fillcap_32
XFILLER_86_591 VDD VSS VDD VSS gf180mcu_fd_sc_mcu7t5v0__fillcap_4
XFILLER_74_731 VDD VSS VDD VSS gf180mcu_fd_sc_mcu7t5v0__fillcap_4
XFILLER_221_206 VDD VSS VDD VSS gf180mcu_fd_sc_mcu7t5v0__fillcap_4
XFILLER_15_842 VDD VSS VDD VSS gf180mcu_fd_sc_mcu7t5v0__fillcap_32
XFILLER_42_661 VDD VSS VDD VSS gf180mcu_fd_sc_mcu7t5v0__fillcap_4
XFILLER_30_801 VDD VSS VDD VSS gf180mcu_fd_sc_mcu7t5v0__fillcap_4
XFILLER_159_346 VDD VSS VDD VSS gf180mcu_fd_sc_mcu7t5v0__fillcap_4
XFILLER_159_368 VDD VSS VDD VSS gf180mcu_fd_sc_mcu7t5v0__fillcap_8
XFILLER_115_416 VDD VSS VDD VSS gf180mcu_fd_sc_mcu7t5v0__fillcap_4
X_2500_ _3226_/Q VDD VSS _2517_/C1 _3224_/Q _2553_/A1 VDD VSS gf180mcu_fd_sc_mcu7t5v0__nor3_1
XFILLER_10_591 VDD VSS VDD VSS gf180mcu_fd_sc_mcu7t5v0__fillcap_4
X_2431_ _2897_/Q VSS VDD _2881_/Q _2889_/Q _2460_/S0 _2873_/Q _2460_/S1 _2431_/Z VDD
+ VSS gf180mcu_fd_sc_mcu7t5v0__mux4_1
XFILLER_127_298 VDD VSS VDD VSS gf180mcu_fd_sc_mcu7t5v0__fillcap_8
X_2362_ _2362_/B _2362_/C VDD VSS _2363_/B1 _2362_/A1 _2362_/A2 VDD VSS gf180mcu_fd_sc_mcu7t5v0__aoi211_1
XFILLER_96_311 VDD VSS VDD VSS gf180mcu_fd_sc_mcu7t5v0__fillcap_4
XFILLER_257_626 VDD VSS VDD VSS gf180mcu_fd_sc_mcu7t5v0__fillcap_4
X_2293_ VDD _3183_/D _2293_/B _2474_/B _2336_/B VSS _2322_/A1 VDD VSS gf180mcu_fd_sc_mcu7t5v0__oai31_1
XFILLER_96_344 VDD VSS VDD VSS gf180mcu_fd_sc_mcu7t5v0__fillcap_4
XFILLER_37_422 VDD VSS VDD VSS gf180mcu_fd_sc_mcu7t5v0__fillcap_64
XFILLER_49_282 VDD VSS VDD VSS gf180mcu_fd_sc_mcu7t5v0__fillcap_64
XFILLER_64_241 VDD VSS VDD VSS gf180mcu_fd_sc_mcu7t5v0__fillcap_4
XFILLER_225_556 VDD VSS VDD VSS gf180mcu_fd_sc_mcu7t5v0__fillcap_4
XFILLER_212_239 VDD VSS VDD VSS gf180mcu_fd_sc_mcu7t5v0__fillcap_4
XFILLER_20_311 VDD VSS VDD VSS gf180mcu_fd_sc_mcu7t5v0__fillcap_4
XFILLER_32_171 VDD VSS VDD VSS gf180mcu_fd_sc_mcu7t5v0__fillcap_4
Xclkbuf_leaf_8_clk_i _3320_/CLK VSS VDD clkload0/I VDD VSS gf180mcu_fd_sc_mcu7t5v0__clkbuf_2
XFILLER_119_766 VDD VSS VDD VSS gf180mcu_fd_sc_mcu7t5v0__fillcap_4
XFILLER_106_449 VDD VSS VDD VSS gf180mcu_fd_sc_mcu7t5v0__fillcap_4
XFILLER_88_801 VDD VSS VDD VSS gf180mcu_fd_sc_mcu7t5v0__fillcap_4
X_2629_ wire46/Z VDD VSS _3292_/D _3250_/Q wire86/I VDD VSS gf180mcu_fd_sc_mcu7t5v0__mux2_2
XFILLER_161_599 VDD VSS VDD VSS gf180mcu_fd_sc_mcu7t5v0__fillcap_16
XFILLER_0_716 VDD VSS VDD VSS gf180mcu_fd_sc_mcu7t5v0__fillcap_32
XFILLER_141_290 VDD VSS VDD VSS gf180mcu_fd_sc_mcu7t5v0__fillcap_4
XFILLER_101_132 VDD VSS VDD VSS gf180mcu_fd_sc_mcu7t5v0__fillcap_8
XFILLER_247_136 VDD VSS VDD VSS gf180mcu_fd_sc_mcu7t5v0__fillcap_4
XFILLER_68_591 VDD VSS VDD VSS gf180mcu_fd_sc_mcu7t5v0__fillcap_4
XFILLER_56_731 VDD VSS VDD VSS gf180mcu_fd_sc_mcu7t5v0__fillcap_4
XFILLER_101_187 VDD VSS VDD VSS gf180mcu_fd_sc_mcu7t5v0__fillcap_16
Xmax_cap25 _2219_/S _2221_/S VDD VSS VDD VSS gf180mcu_fd_sc_mcu7t5v0__buf_4
XFILLER_24_661 VDD VSS VDD VSS gf180mcu_fd_sc_mcu7t5v0__fillcap_4
XFILLER_12_801 VDD VSS VDD VSS gf180mcu_fd_sc_mcu7t5v0__fillcap_4
XFILLER_102_85 VDD VSS VDD VSS gf180mcu_fd_sc_mcu7t5v0__fillcap_8
XFILLER_134_2 VDD VSS VDD VSS gf180mcu_fd_sc_mcu7t5v0__fillcap_32
XFILLER_239_626 VDD VSS VDD VSS gf180mcu_fd_sc_mcu7t5v0__fillcap_4
XFILLER_78_344 VDD VSS VDD VSS gf180mcu_fd_sc_mcu7t5v0__fillcap_32
XFILLER_19_422 VDD VSS VDD VSS gf180mcu_fd_sc_mcu7t5v0__fillcap_64
XFILLER_219_394 VDD VSS VDD VSS gf180mcu_fd_sc_mcu7t5v0__fillcap_16
XFILLER_46_241 VDD VSS VDD VSS gf180mcu_fd_sc_mcu7t5v0__fillcap_4
XFILLER_207_556 VDD VSS VDD VSS gf180mcu_fd_sc_mcu7t5v0__fillcap_4
X_2980_ VDD _2980_/Q _3341_/CLK VSS _2980_/D VDD VSS gf180mcu_fd_sc_mcu7t5v0__dffq_1
X_1931_ _1933_/S VDD VSS _2984_/D wire119/I _2984_/Q VDD VSS gf180mcu_fd_sc_mcu7t5v0__mux2_2
XFILLER_14_171 VDD VSS VDD VSS gf180mcu_fd_sc_mcu7t5v0__fillcap_4
X_1862_ _1869_/S VDD VSS _2925_/D wire137/Z _2925_/Q VDD VSS gf180mcu_fd_sc_mcu7t5v0__mux2_2
XFILLER_238_37 VDD VSS VDD VSS gf180mcu_fd_sc_mcu7t5v0__fillcap_64
X_1793_ _1795_/S VDD VSS _2866_/D _2866_/Q _3124_/Q VDD VSS gf180mcu_fd_sc_mcu7t5v0__mux2_2
XFILLER_171_842 VDD VSS VDD VSS gf180mcu_fd_sc_mcu7t5v0__fillcap_32
XFILLER_143_555 VDD VSS VDD VSS gf180mcu_fd_sc_mcu7t5v0__fillcap_4
X_3463_ VSS _3463_/CLK VDD _3463_/D _3463_/Q wire163/I VDD VSS gf180mcu_fd_sc_mcu7t5v0__dffsnq_1
XFILLER_89_609 VDD VSS VDD VSS gf180mcu_fd_sc_mcu7t5v0__fillcap_16
XFILLER_6_381 VDD VSS VDD VSS gf180mcu_fd_sc_mcu7t5v0__fillcap_4
X_2414_ _2442_/S VDD VSS _2414_/Z _2412_/Z _2413_/Z VDD VSS gf180mcu_fd_sc_mcu7t5v0__mux2_2
X_3394_ _3394_/D _3394_/Q _3458_/RN VSS _3394_/CLK VDD VDD VSS gf180mcu_fd_sc_mcu7t5v0__dffrnq_1
XFILLER_229_136 VDD VSS VDD VSS gf180mcu_fd_sc_mcu7t5v0__fillcap_4
X_2345_ VDD VSS _2345_/I _2362_/A2 VDD VSS gf180mcu_fd_sc_mcu7t5v0__clkinv_1
X_2276_ _2340_/A3 _2494_/C _2276_/B2 VDD VSS _3174_/D _3210_/Q _2484_/A1 VDD VSS gf180mcu_fd_sc_mcu7t5v0__oai32_1
XFILLER_38_731 VDD VSS VDD VSS gf180mcu_fd_sc_mcu7t5v0__fillcap_4
XFILLER_200_209 VDD VSS VDD VSS gf180mcu_fd_sc_mcu7t5v0__fillcap_16
XFILLER_80_597 VDD VSS VDD VSS gf180mcu_fd_sc_mcu7t5v0__fillcap_64
XFILLER_221_592 VDD VSS VDD VSS gf180mcu_fd_sc_mcu7t5v0__fillcap_4
XFILLER_32_37 VDD VSS VDD VSS gf180mcu_fd_sc_mcu7t5v0__fillcap_64
XFILLER_148_37 VDD VSS VDD VSS gf180mcu_fd_sc_mcu7t5v0__fillcap_32
XFILLER_193_422 VDD VSS VDD VSS gf180mcu_fd_sc_mcu7t5v0__fillcap_16
XFILLER_119_574 VDD VSS VDD VSS gf180mcu_fd_sc_mcu7t5v0__fillcap_16
XFILLER_161_352 VDD VSS VDD VSS gf180mcu_fd_sc_mcu7t5v0__fillcap_8
XFILLER_121_205 VDD VSS VDD VSS gf180mcu_fd_sc_mcu7t5v0__fillcap_4
XFILLER_0_546 VDD VSS VDD VSS gf180mcu_fd_sc_mcu7t5v0__fillcap_32
XFILLER_57_45 VDD VSS VDD VSS gf180mcu_fd_sc_mcu7t5v0__fillcap_16
XFILLER_28_241 VDD VSS VDD VSS gf180mcu_fd_sc_mcu7t5v0__fillcap_4
XFILLER_90_306 VDD VSS VDD VSS gf180mcu_fd_sc_mcu7t5v0__fillcap_8
XFILLER_204_559 VDD VSS VDD VSS gf180mcu_fd_sc_mcu7t5v0__fillcap_4
XFILLER_251_2 VDD VSS VDD VSS gf180mcu_fd_sc_mcu7t5v0__fillcap_64
XFILLER_189_55 VDD VSS VDD VSS gf180mcu_fd_sc_mcu7t5v0__fillcap_8
XFILLER_188_238 VDD VSS VDD VSS gf180mcu_fd_sc_mcu7t5v0__fillcap_4
XFILLER_169_474 VDD VSS VDD VSS gf180mcu_fd_sc_mcu7t5v0__fillcap_16
XFILLER_197_772 VDD VSS VDD VSS gf180mcu_fd_sc_mcu7t5v0__fillcap_64
Xspi_opentarget_i3c_top_177 irq_o_PDRV0 VDD VSS VDD VSS gf180mcu_fd_sc_mcu7t5v0__tiel
Xspi_opentarget_i3c_top_188 sda_pad_PDRV1 VDD VSS VDD VSS gf180mcu_fd_sc_mcu7t5v0__tiel
Xspi_opentarget_i3c_top_199 spi_miso_o_SL VDD VSS VDD VSS gf180mcu_fd_sc_mcu7t5v0__tiel
XFILLER_153_842 VDD VSS VDD VSS gf180mcu_fd_sc_mcu7t5v0__fillcap_32
XFILLER_125_555 VDD VSS VDD VSS gf180mcu_fd_sc_mcu7t5v0__fillcap_4
XFILLER_4_885 VDD VSS VDD VSS gf180mcu_fd_sc_mcu7t5v0__fillcap_4
XFILLER_125_577 VDD VSS VDD VSS gf180mcu_fd_sc_mcu7t5v0__fillcap_4
XFILLER_112_205 VDD VSS VDD VSS gf180mcu_fd_sc_mcu7t5v0__fillcap_4
XFILLER_121_772 VDD VSS VDD VSS gf180mcu_fd_sc_mcu7t5v0__fillcap_64
X_2130_ VDD VSS _2137_/S _2025_/Z _2205_/A4 VDD VSS gf180mcu_fd_sc_mcu7t5v0__nand2_1
X_2061_ _2652_/A3 VDD VSS _2061_/Z _3271_/Q _2061_/A2 VDD VSS gf180mcu_fd_sc_mcu7t5v0__and3_1
XFILLER_82_807 VDD VSS VDD VSS gf180mcu_fd_sc_mcu7t5v0__fillcap_64
XFILLER_219_180 VDD VSS VDD VSS gf180mcu_fd_sc_mcu7t5v0__fillcap_16
Xclkbuf_leaf_73_clk_i _3448_/CLK VSS VDD clkbuf_3_0__f_clk_i/Z VDD VSS gf180mcu_fd_sc_mcu7t5v0__clkbuf_2
X_2963_ VDD _2963_/Q _2963_/CLK VSS _2963_/D VDD VSS gf180mcu_fd_sc_mcu7t5v0__dffq_1
XFILLER_62_597 VDD VSS VDD VSS gf180mcu_fd_sc_mcu7t5v0__fillcap_64
XFILLER_50_737 VDD VSS VDD VSS gf180mcu_fd_sc_mcu7t5v0__fillcap_64
X_1914_ _1914_/S VDD VSS _2969_/D _2969_/Q _2015_/I0 VDD VSS gf180mcu_fd_sc_mcu7t5v0__mux2_2
XFILLER_194_219 VDD VSS VDD VSS gf180mcu_fd_sc_mcu7t5v0__fillcap_16
XFILLER_175_422 VDD VSS VDD VSS gf180mcu_fd_sc_mcu7t5v0__fillcap_64
X_2894_ VDD _2894_/Q _2900_/CLK VSS _2894_/D VDD VSS gf180mcu_fd_sc_mcu7t5v0__dffq_1
XFILLER_187_282 VDD VSS VDD VSS gf180mcu_fd_sc_mcu7t5v0__fillcap_32
X_1845_ _1851_/S VDD VSS _2910_/D _1863_/I0 _2910_/Q VDD VSS gf180mcu_fd_sc_mcu7t5v0__mux2_2
X_1776_ _1777_/S VDD VSS _2851_/D _3125_/Q _2851_/Q VDD VSS gf180mcu_fd_sc_mcu7t5v0__mux2_2
XFILLER_171_661 VDD VSS VDD VSS gf180mcu_fd_sc_mcu7t5v0__fillcap_32
Xclkbuf_leaf_11_clk_i _3179_/CLK VSS VDD clkload5/I VDD VSS gf180mcu_fd_sc_mcu7t5v0__clkbuf_2
XFILLER_143_352 VDD VSS VDD VSS gf180mcu_fd_sc_mcu7t5v0__fillcap_16
XFILLER_116_566 VDD VSS VDD VSS gf180mcu_fd_sc_mcu7t5v0__fillcap_8
X_3446_ spi_sclk_i _3446_/Q wire169/Z VSS _3446_/CLK VDD VDD VSS gf180mcu_fd_sc_mcu7t5v0__dffrnq_1
X_3377_ _3377_/D _3402_/D _3403_/RN VSS _3392_/CLK VDD VDD VSS gf180mcu_fd_sc_mcu7t5v0__dffrnq_1
Xclkbuf_leaf_26_clk_i _3344_/CLK VSS VDD clkload4/I VDD VSS gf180mcu_fd_sc_mcu7t5v0__clkbuf_2
X_2328_ _2492_/A1 _2494_/C _2328_/B2 VDD VSS _3187_/D _2328_/A1 _2326_/Z VDD VSS gf180mcu_fd_sc_mcu7t5v0__oai32_1
XFILLER_111_282 VDD VSS VDD VSS gf180mcu_fd_sc_mcu7t5v0__fillcap_32
XFILLER_84_100 VDD VSS VDD VSS gf180mcu_fd_sc_mcu7t5v0__fillcap_4
X_2259_ VDD VSS _2259_/Z _2494_/B _2259_/A2 VDD VSS gf180mcu_fd_sc_mcu7t5v0__or2_1
XFILLER_84_177 VDD VSS VDD VSS gf180mcu_fd_sc_mcu7t5v0__fillcap_8
XFILLER_241_632 VDD VSS VDD VSS gf180mcu_fd_sc_mcu7t5v0__fillcap_64
XFILLER_253_492 VDD VSS VDD VSS gf180mcu_fd_sc_mcu7t5v0__fillcap_64
XFILLER_179_772 VDD VSS VDD VSS gf180mcu_fd_sc_mcu7t5v0__fillcap_64
XFILLER_40_247 VDD VSS VDD VSS gf180mcu_fd_sc_mcu7t5v0__fillcap_64
XFILLER_147_680 VDD VSS VDD VSS gf180mcu_fd_sc_mcu7t5v0__fillcap_16
XFILLER_181_458 VDD VSS VDD VSS gf180mcu_fd_sc_mcu7t5v0__fillcap_4
XFILLER_135_842 VDD VSS VDD VSS gf180mcu_fd_sc_mcu7t5v0__fillcap_32
XFILLER_150_801 VDD VSS VDD VSS gf180mcu_fd_sc_mcu7t5v0__fillcap_4
XFILLER_209_607 VDD VSS VDD VSS gf180mcu_fd_sc_mcu7t5v0__fillcap_4
XFILLER_130_580 VDD VSS VDD VSS gf180mcu_fd_sc_mcu7t5v0__fillcap_8
XFILLER_103_772 VDD VSS VDD VSS gf180mcu_fd_sc_mcu7t5v0__fillcap_64
XFILLER_0_376 VDD VSS VDD VSS gf180mcu_fd_sc_mcu7t5v0__fillcap_32
XFILLER_263_212 VDD VSS VDD VSS gf180mcu_fd_sc_mcu7t5v0__fillcap_64
XFILLER_64_807 VDD VSS VDD VSS gf180mcu_fd_sc_mcu7t5v0__fillcap_64
XFILLER_76_667 VDD VSS VDD VSS gf180mcu_fd_sc_mcu7t5v0__fillcap_64
XFILLER_84_10 VDD VSS VDD VSS gf180mcu_fd_sc_mcu7t5v0__fillcap_4
XFILLER_91_626 VDD VSS VDD VSS gf180mcu_fd_sc_mcu7t5v0__fillcap_4
XFILLER_90_169 VDD VSS VDD VSS gf180mcu_fd_sc_mcu7t5v0__fillcap_4
XFILLER_231_142 VDD VSS VDD VSS gf180mcu_fd_sc_mcu7t5v0__fillcap_64
XFILLER_44_597 VDD VSS VDD VSS gf180mcu_fd_sc_mcu7t5v0__fillcap_64
XFILLER_32_737 VDD VSS VDD VSS gf180mcu_fd_sc_mcu7t5v0__fillcap_64
XFILLER_157_422 VDD VSS VDD VSS gf180mcu_fd_sc_mcu7t5v0__fillcap_64
XFILLER_169_282 VDD VSS VDD VSS gf180mcu_fd_sc_mcu7t5v0__fillcap_64
XFILLER_219_39 VDD VSS VDD VSS gf180mcu_fd_sc_mcu7t5v0__fillcap_16
XFILLER_172_403 VDD VSS VDD VSS gf180mcu_fd_sc_mcu7t5v0__fillcap_8
X_1630_ _3106_/Q _3107_/Q VDD VSS _1632_/A2 _3108_/Q _3109_/Q VDD VSS gf180mcu_fd_sc_mcu7t5v0__nor4_1
X_1561_ _3144_/Q _3145_/Q VDD VSS _1585_/A4 _3143_/Q _3142_/Q VDD VSS gf180mcu_fd_sc_mcu7t5v0__nor4_1
XFILLER_125_352 VDD VSS VDD VSS gf180mcu_fd_sc_mcu7t5v0__fillcap_8
X_3300_ _3300_/D _3300_/Q _3339_/RN VSS _3328_/CLK VDD VDD VSS gf180mcu_fd_sc_mcu7t5v0__dffrnq_1
X_1492_ VDD VSS _3424_/D _3445_/D _1492_/A2 VDD VSS gf180mcu_fd_sc_mcu7t5v0__xnor2_1
XFILLER_98_247 VDD VSS VDD VSS gf180mcu_fd_sc_mcu7t5v0__fillcap_8
X_3231_ _3231_/D _3231_/Q wire147/I VSS _3321_/CLK VDD VDD VSS gf180mcu_fd_sc_mcu7t5v0__dffrnq_1
XFILLER_255_702 VDD VSS VDD VSS gf180mcu_fd_sc_mcu7t5v0__fillcap_64
XFILLER_267_562 VDD VSS VDD VSS gf180mcu_fd_sc_mcu7t5v0__fillcap_64
X_3162_ _3162_/D _3162_/Q wire151/I VSS _3166_/CLK VDD VDD VSS gf180mcu_fd_sc_mcu7t5v0__dffrnq_1
XFILLER_140_377 VDD VSS VDD VSS gf180mcu_fd_sc_mcu7t5v0__fillcap_8
X_2113_ _2113_/A3 VDD VSS _2119_/A3 _2113_/A1 _2113_/A2 VDD VSS gf180mcu_fd_sc_mcu7t5v0__nor3_1
XFILLER_66_177 VDD VSS VDD VSS gf180mcu_fd_sc_mcu7t5v0__fillcap_64
X_3093_ _3093_/D _3093_/Q wire163/I VSS _3341_/CLK VDD VDD VSS gf180mcu_fd_sc_mcu7t5v0__dffrnq_1
XFILLER_54_317 VDD VSS VDD VSS gf180mcu_fd_sc_mcu7t5v0__fillcap_64
X_2044_ wire28/I VDD VSS _3077_/D _3293_/Q _3077_/Q VDD VSS gf180mcu_fd_sc_mcu7t5v0__mux2_2
XFILLER_94_497 VDD VSS VDD VSS gf180mcu_fd_sc_mcu7t5v0__fillcap_16
XFILLER_223_632 VDD VSS VDD VSS gf180mcu_fd_sc_mcu7t5v0__fillcap_64
XFILLER_235_492 VDD VSS VDD VSS gf180mcu_fd_sc_mcu7t5v0__fillcap_64
XFILLER_250_451 VDD VSS VDD VSS gf180mcu_fd_sc_mcu7t5v0__fillcap_4
XFILLER_22_247 VDD VSS VDD VSS gf180mcu_fd_sc_mcu7t5v0__fillcap_64
XFILLER_188_591 VDD VSS VDD VSS gf180mcu_fd_sc_mcu7t5v0__fillcap_4
X_2946_ VDD _2946_/Q _3415_/CLK VSS _2946_/D VDD VSS gf180mcu_fd_sc_mcu7t5v0__dffq_1
XFILLER_176_731 VDD VSS VDD VSS gf180mcu_fd_sc_mcu7t5v0__fillcap_4
XFILLER_210_348 VDD VSS VDD VSS gf180mcu_fd_sc_mcu7t5v0__fillcap_4
X_2877_ VDD _2877_/Q _2932_/CLK VSS _2877_/D VDD VSS gf180mcu_fd_sc_mcu7t5v0__dffq_1
X_1828_ _1832_/S VDD VSS _2896_/D _2896_/Q wire133/Z VDD VSS gf180mcu_fd_sc_mcu7t5v0__mux2_2
XFILLER_209_72 VDD VSS VDD VSS gf180mcu_fd_sc_mcu7t5v0__fillcap_4
XFILLER_190_255 VDD VSS VDD VSS gf180mcu_fd_sc_mcu7t5v0__fillcap_4
XFILLER_117_842 VDD VSS VDD VSS gf180mcu_fd_sc_mcu7t5v0__fillcap_32
X_1759_ VDD VSS _1787_/A2 _3369_/Q _1796_/A2 VDD VSS gf180mcu_fd_sc_mcu7t5v0__nor2_1
XFILLER_144_661 VDD VSS VDD VSS gf180mcu_fd_sc_mcu7t5v0__fillcap_4
X_3429_ _3429_/D _3429_/Q wire161/I VSS _3434_/CLK VDD VDD VSS gf180mcu_fd_sc_mcu7t5v0__dffrnq_1
XFILLER_245_212 VDD VSS VDD VSS gf180mcu_fd_sc_mcu7t5v0__fillcap_64
XFILLER_46_807 VDD VSS VDD VSS gf180mcu_fd_sc_mcu7t5v0__fillcap_64
XFILLER_100_731 VDD VSS VDD VSS gf180mcu_fd_sc_mcu7t5v0__fillcap_4
XFILLER_58_667 VDD VSS VDD VSS gf180mcu_fd_sc_mcu7t5v0__fillcap_64
XFILLER_73_626 VDD VSS VDD VSS gf180mcu_fd_sc_mcu7t5v0__fillcap_4
XFILLER_85_486 VDD VSS VDD VSS gf180mcu_fd_sc_mcu7t5v0__fillcap_4
XFILLER_214_654 VDD VSS VDD VSS gf180mcu_fd_sc_mcu7t5v0__fillcap_8
XFILLER_213_142 VDD VSS VDD VSS gf180mcu_fd_sc_mcu7t5v0__fillcap_16
XFILLER_26_597 VDD VSS VDD VSS gf180mcu_fd_sc_mcu7t5v0__fillcap_64
XFILLER_14_737 VDD VSS VDD VSS gf180mcu_fd_sc_mcu7t5v0__fillcap_64
XFILLER_41_556 VDD VSS VDD VSS gf180mcu_fd_sc_mcu7t5v0__fillcap_4
XFILLER_139_422 VDD VSS VDD VSS gf180mcu_fd_sc_mcu7t5v0__fillcap_16
XFILLER_210_871 VDD VSS VDD VSS gf180mcu_fd_sc_mcu7t5v0__fillcap_4
XFILLER_186_89 VDD VSS VDD VSS gf180mcu_fd_sc_mcu7t5v0__fillcap_4
XFILLER_119_61 VDD VSS VDD VSS gf180mcu_fd_sc_mcu7t5v0__fillcap_8
XFILLER_107_352 VDD VSS VDD VSS gf180mcu_fd_sc_mcu7t5v0__fillcap_64
XFILLER_95_206 VDD VSS VDD VSS gf180mcu_fd_sc_mcu7t5v0__fillcap_4
XFILLER_237_702 VDD VSS VDD VSS gf180mcu_fd_sc_mcu7t5v0__fillcap_64
XFILLER_249_562 VDD VSS VDD VSS gf180mcu_fd_sc_mcu7t5v0__fillcap_64
XFILLER_1_696 VDD VSS VDD VSS gf180mcu_fd_sc_mcu7t5v0__fillcap_4
XFILLER_264_521 VDD VSS VDD VSS gf180mcu_fd_sc_mcu7t5v0__fillcap_4
XFILLER_88_291 VDD VSS VDD VSS gf180mcu_fd_sc_mcu7t5v0__fillcap_16
XFILLER_48_177 VDD VSS VDD VSS gf180mcu_fd_sc_mcu7t5v0__fillcap_64
XFILLER_36_317 VDD VSS VDD VSS gf180mcu_fd_sc_mcu7t5v0__fillcap_64
XFILLER_63_136 VDD VSS VDD VSS gf180mcu_fd_sc_mcu7t5v0__fillcap_4
XFILLER_217_492 VDD VSS VDD VSS gf180mcu_fd_sc_mcu7t5v0__fillcap_32
XFILLER_205_632 VDD VSS VDD VSS gf180mcu_fd_sc_mcu7t5v0__fillcap_8
XFILLER_232_451 VDD VSS VDD VSS gf180mcu_fd_sc_mcu7t5v0__fillcap_4
XFILLER_204_153 VDD VSS VDD VSS gf180mcu_fd_sc_mcu7t5v0__fillcap_4
X_2800_ _2668_/Z _3101_/Q VDD VSS _2801_/A2 _3341_/Q _2749_/C VDD VSS gf180mcu_fd_sc_mcu7t5v0__aoi22_1
X_2731_ VDD VSS _2732_/B wire59/Z _2730_/Z VDD VSS gf180mcu_fd_sc_mcu7t5v0__nor2_1
XFILLER_200_381 VDD VSS VDD VSS gf180mcu_fd_sc_mcu7t5v0__fillcap_4
X_2662_ _2957_/Q VSS VDD _2941_/Q _2949_/Q _2718_/S0 _2933_/Q _2742_/S1 _2662_/Z VDD
+ VSS gf180mcu_fd_sc_mcu7t5v0__mux4_1
XFILLER_246_37 VDD VSS VDD VSS gf180mcu_fd_sc_mcu7t5v0__fillcap_64
X_1613_ _1613_/B _1613_/C VDD VSS _1614_/A4 _3399_/Q _3375_/D VDD VSS gf180mcu_fd_sc_mcu7t5v0__oai211_1
XFILLER_126_650 VDD VSS VDD VSS gf180mcu_fd_sc_mcu7t5v0__fillcap_4
XFILLER_114_801 VDD VSS VDD VSS gf180mcu_fd_sc_mcu7t5v0__fillcap_4
X_2593_ _2596_/S VDD VSS _3261_/D _3253_/Q _3261_/Q VDD VSS gf180mcu_fd_sc_mcu7t5v0__mux2_2
X_1544_ VDD VSS _1550_/B1 wire84/Z _3188_/Q VDD VSS gf180mcu_fd_sc_mcu7t5v0__nand2_1
X_1475_ _1465_/Z VDD VSS _1877_/S _3409_/Q _3410_/Q VDD VSS gf180mcu_fd_sc_mcu7t5v0__and3_1
X_3214_ _3214_/D _3214_/Q wire145/I VSS _3452_/CLK VDD VDD VSS gf180mcu_fd_sc_mcu7t5v0__dffrnq_1
XFILLER_227_212 VDD VSS VDD VSS gf180mcu_fd_sc_mcu7t5v0__fillcap_64
XFILLER_28_807 VDD VSS VDD VSS gf180mcu_fd_sc_mcu7t5v0__fillcap_64
X_3145_ _3145_/D _3145_/Q _3457_/RN VSS _3364_/CLK VDD VDD VSS gf180mcu_fd_sc_mcu7t5v0__dffrnq_1
XFILLER_55_626 VDD VSS VDD VSS gf180mcu_fd_sc_mcu7t5v0__fillcap_4
XFILLER_67_486 VDD VSS VDD VSS gf180mcu_fd_sc_mcu7t5v0__fillcap_4
X_3076_ _3076_/D _3076_/Q wire165/Z VSS _3336_/CLK VDD VDD VSS gf180mcu_fd_sc_mcu7t5v0__dffrnq_1
X_2027_ VDD VSS _2703_/A3 _2061_/A2 _2025_/Z VDD VSS gf180mcu_fd_sc_mcu7t5v0__nand2_1
XFILLER_23_556 VDD VSS VDD VSS gf180mcu_fd_sc_mcu7t5v0__fillcap_4
X_2929_ VDD _2929_/Q _2932_/CLK VSS _2929_/D VDD VSS gf180mcu_fd_sc_mcu7t5v0__dffq_1
XFILLER_109_606 VDD VSS VDD VSS gf180mcu_fd_sc_mcu7t5v0__fillcap_16
XFILLER_191_542 VDD VSS VDD VSS gf180mcu_fd_sc_mcu7t5v0__fillcap_8
XFILLER_40_37 VDD VSS VDD VSS gf180mcu_fd_sc_mcu7t5v0__fillcap_64
XFILLER_108_149 VDD VSS VDD VSS gf180mcu_fd_sc_mcu7t5v0__fillcap_8
XFILLER_156_37 VDD VSS VDD VSS gf180mcu_fd_sc_mcu7t5v0__fillcap_8
XFILLER_132_631 VDD VSS VDD VSS gf180mcu_fd_sc_mcu7t5v0__fillcap_32
XFILLER_219_702 VDD VSS VDD VSS gf180mcu_fd_sc_mcu7t5v0__fillcap_64
XFILLER_246_521 VDD VSS VDD VSS gf180mcu_fd_sc_mcu7t5v0__fillcap_4
XFILLER_258_381 VDD VSS VDD VSS gf180mcu_fd_sc_mcu7t5v0__fillcap_4
XFILLER_18_317 VDD VSS VDD VSS gf180mcu_fd_sc_mcu7t5v0__fillcap_64
XFILLER_100_583 VDD VSS VDD VSS gf180mcu_fd_sc_mcu7t5v0__fillcap_8
XFILLER_45_136 VDD VSS VDD VSS gf180mcu_fd_sc_mcu7t5v0__fillcap_4
XFILLER_214_451 VDD VSS VDD VSS gf180mcu_fd_sc_mcu7t5v0__fillcap_4
XFILLER_198_163 VDD VSS VDD VSS gf180mcu_fd_sc_mcu7t5v0__fillcap_8
XFILLER_198_185 VDD VSS VDD VSS gf180mcu_fd_sc_mcu7t5v0__fillcap_4
XFILLER_197_88 VDD VSS VDD VSS gf180mcu_fd_sc_mcu7t5v0__fillcap_4
XFILLER_81_88 VDD VSS VDD VSS gf180mcu_fd_sc_mcu7t5v0__fillcap_8
XFILLER_154_255 VDD VSS VDD VSS gf180mcu_fd_sc_mcu7t5v0__fillcap_8
XFILLER_170_737 VDD VSS VDD VSS gf180mcu_fd_sc_mcu7t5v0__fillcap_64
XFILLER_216_18 VDD VSS VDD VSS gf180mcu_fd_sc_mcu7t5v0__fillcap_4
XFILLER_5_276 VDD VSS VDD VSS gf180mcu_fd_sc_mcu7t5v0__fillcap_4
XFILLER_122_185 VDD VSS VDD VSS gf180mcu_fd_sc_mcu7t5v0__fillcap_32
XFILLER_265_874 VDD VSS VDD VSS gf180mcu_fd_sc_mcu7t5v0__fillcap_16
XFILLER_37_626 VDD VSS VDD VSS gf180mcu_fd_sc_mcu7t5v0__fillcap_4
XFILLER_49_486 VDD VSS VDD VSS gf180mcu_fd_sc_mcu7t5v0__fillcap_4
XFILLER_146_712 VDD VSS VDD VSS gf180mcu_fd_sc_mcu7t5v0__fillcap_16
XFILLER_192_317 VDD VSS VDD VSS gf180mcu_fd_sc_mcu7t5v0__fillcap_64
XFILLER_192_306 VDD VSS VDD VSS gf180mcu_fd_sc_mcu7t5v0__fillcap_8
XFILLER_118_403 VDD VSS VDD VSS gf180mcu_fd_sc_mcu7t5v0__fillcap_8
X_2714_ VDD VSS _2715_/C _2724_/C _2713_/Z VDD VSS gf180mcu_fd_sc_mcu7t5v0__nand2_1
X_2645_ wire46/Z VDD VSS _3308_/D _3266_/Q _3308_/Q VDD VSS gf180mcu_fd_sc_mcu7t5v0__mux2_2
XFILLER_99_320 VDD VSS VDD VSS gf180mcu_fd_sc_mcu7t5v0__fillcap_4
XFILLER_160_247 VDD VSS VDD VSS gf180mcu_fd_sc_mcu7t5v0__fillcap_64
X_2576_ _2587_/S VDD VSS _3244_/D _3236_/Q wire99/I VDD VSS gf180mcu_fd_sc_mcu7t5v0__mux2_2
X_1527_ VDD VSS _1530_/A2 _3383_/Q _1522_/Z VDD VSS gf180mcu_fd_sc_mcu7t5v0__nand2_1
XFILLER_101_314 VDD VSS VDD VSS gf180mcu_fd_sc_mcu7t5v0__fillcap_8
XFILLER_59_206 VDD VSS VDD VSS gf180mcu_fd_sc_mcu7t5v0__fillcap_4
X_1458_ _1457_/Z VDD VSS _1460_/A2 wire55/I _1459_/A3 VDD VSS gf180mcu_fd_sc_mcu7t5v0__nor3_1
XFILLER_228_521 VDD VSS VDD VSS gf180mcu_fd_sc_mcu7t5v0__fillcap_4
XFILLER_256_885 VDD VSS VDD VSS gf180mcu_fd_sc_mcu7t5v0__fillcap_4
X_1389_ VDD VSS _3185_/Q _1583_/B VDD VSS gf180mcu_fd_sc_mcu7t5v0__clkinv_1
X_3128_ _3128_/D _3128_/Q _3457_/RN VSS _3364_/CLK VDD VDD VSS gf180mcu_fd_sc_mcu7t5v0__dffrnq_1
XFILLER_27_136 VDD VSS VDD VSS gf180mcu_fd_sc_mcu7t5v0__fillcap_4
X_3059_ VDD _3059_/Q _3059_/CLK VSS _3059_/D VDD VSS gf180mcu_fd_sc_mcu7t5v0__dffq_1
XFILLER_196_667 VDD VSS VDD VSS gf180mcu_fd_sc_mcu7t5v0__fillcap_8
XFILLER_211_454 VDD VSS VDD VSS gf180mcu_fd_sc_mcu7t5v0__fillcap_4
XFILLER_184_807 VDD VSS VDD VSS gf180mcu_fd_sc_mcu7t5v0__fillcap_64
XFILLER_167_58 VDD VSS VDD VSS gf180mcu_fd_sc_mcu7t5v0__fillcap_4
XFILLER_164_597 VDD VSS VDD VSS gf180mcu_fd_sc_mcu7t5v0__fillcap_8
XFILLER_152_737 VDD VSS VDD VSS gf180mcu_fd_sc_mcu7t5v0__fillcap_64
XFILLER_105_620 VDD VSS VDD VSS gf180mcu_fd_sc_mcu7t5v0__fillcap_8
XFILLER_116_84 VDD VSS VDD VSS gf180mcu_fd_sc_mcu7t5v0__fillcap_16
XFILLER_120_667 VDD VSS VDD VSS gf180mcu_fd_sc_mcu7t5v0__fillcap_16
XFILLER_247_874 VDD VSS VDD VSS gf180mcu_fd_sc_mcu7t5v0__fillcap_16
XFILLER_19_626 VDD VSS VDD VSS gf180mcu_fd_sc_mcu7t5v0__fillcap_4
XFILLER_76_88 VDD VSS VDD VSS gf180mcu_fd_sc_mcu7t5v0__fillcap_16
XFILLER_262_877 VDD VSS VDD VSS gf180mcu_fd_sc_mcu7t5v0__fillcap_8
XFILLER_187_612 VDD VSS VDD VSS gf180mcu_fd_sc_mcu7t5v0__fillcap_4
XFILLER_92_98 VDD VSS VDD VSS gf180mcu_fd_sc_mcu7t5v0__fillcap_4
XFILLER_186_177 VDD VSS VDD VSS gf180mcu_fd_sc_mcu7t5v0__fillcap_8
XFILLER_174_317 VDD VSS VDD VSS gf180mcu_fd_sc_mcu7t5v0__fillcap_64
XFILLER_128_723 VDD VSS VDD VSS gf180mcu_fd_sc_mcu7t5v0__fillcap_8
X_2430_ VDD VSS _2433_/A2 _3383_/Q _2429_/Z VDD VSS gf180mcu_fd_sc_mcu7t5v0__nand2_1
XFILLER_142_236 VDD VSS VDD VSS gf180mcu_fd_sc_mcu7t5v0__fillcap_8
X_2361_ _2361_/A3 VDD VSS _2362_/C _1664_/Z _2365_/A2 VDD VSS gf180mcu_fd_sc_mcu7t5v0__nor3_1
X_2292_ VDD VSS _2328_/A1 _2474_/B _2494_/C VDD VSS gf180mcu_fd_sc_mcu7t5v0__nand2_1
XFILLER_238_885 VDD VSS VDD VSS gf180mcu_fd_sc_mcu7t5v0__fillcap_4
XFILLER_110_177 VDD VSS VDD VSS gf180mcu_fd_sc_mcu7t5v0__fillcap_16
XFILLER_252_387 VDD VSS VDD VSS gf180mcu_fd_sc_mcu7t5v0__fillcap_64
XFILLER_240_527 VDD VSS VDD VSS gf180mcu_fd_sc_mcu7t5v0__fillcap_64
XFILLER_178_667 VDD VSS VDD VSS gf180mcu_fd_sc_mcu7t5v0__fillcap_64
XFILLER_166_807 VDD VSS VDD VSS gf180mcu_fd_sc_mcu7t5v0__fillcap_64
XFILLER_193_626 VDD VSS VDD VSS gf180mcu_fd_sc_mcu7t5v0__fillcap_4
XFILLER_193_604 VDD VSS VDD VSS gf180mcu_fd_sc_mcu7t5v0__fillcap_8
XFILLER_177_155 VDD VSS VDD VSS gf180mcu_fd_sc_mcu7t5v0__fillcap_8
XFILLER_193_648 VDD VSS VDD VSS gf180mcu_fd_sc_mcu7t5v0__fillcap_8
XFILLER_192_169 VDD VSS VDD VSS gf180mcu_fd_sc_mcu7t5v0__fillcap_4
XFILLER_134_737 VDD VSS VDD VSS gf180mcu_fd_sc_mcu7t5v0__fillcap_64
XFILLER_146_597 VDD VSS VDD VSS gf180mcu_fd_sc_mcu7t5v0__fillcap_16
XFILLER_133_203 VDD VSS VDD VSS gf180mcu_fd_sc_mcu7t5v0__fillcap_4
X_2628_ _2644_/S VDD VSS _3291_/D _3249_/Q wire87/I VDD VSS gf180mcu_fd_sc_mcu7t5v0__mux2_2
XFILLER_217_72 VDD VSS VDD VSS gf180mcu_fd_sc_mcu7t5v0__fillcap_32
X_2559_ _2566_/S VDD VSS _3228_/D _3452_/Q _3228_/Q VDD VSS gf180mcu_fd_sc_mcu7t5v0__mux2_2
XFILLER_102_645 VDD VSS VDD VSS gf180mcu_fd_sc_mcu7t5v0__fillcap_4
XFILLER_102_667 VDD VSS VDD VSS gf180mcu_fd_sc_mcu7t5v0__fillcap_4
XFILLER_229_874 VDD VSS VDD VSS gf180mcu_fd_sc_mcu7t5v0__fillcap_16
XFILLER_262_107 VDD VSS VDD VSS gf180mcu_fd_sc_mcu7t5v0__fillcap_64
Xmax_cap26 _2221_/S _2222_/S VDD VSS VDD VSS gf180mcu_fd_sc_mcu7t5v0__buf_4
XFILLER_244_877 VDD VSS VDD VSS gf180mcu_fd_sc_mcu7t5v0__fillcap_8
XFILLER_83_562 VDD VSS VDD VSS gf180mcu_fd_sc_mcu7t5v0__fillcap_64
XFILLER_71_702 VDD VSS VDD VSS gf180mcu_fd_sc_mcu7t5v0__fillcap_64
XFILLER_51_492 VDD VSS VDD VSS gf180mcu_fd_sc_mcu7t5v0__fillcap_64
XFILLER_211_262 VDD VSS VDD VSS gf180mcu_fd_sc_mcu7t5v0__fillcap_8
XFILLER_168_177 VDD VSS VDD VSS gf180mcu_fd_sc_mcu7t5v0__fillcap_16
XFILLER_127_2 VDD VSS VDD VSS gf180mcu_fd_sc_mcu7t5v0__fillcap_4
XFILLER_183_158 VDD VSS VDD VSS gf180mcu_fd_sc_mcu7t5v0__fillcap_4
XFILLER_109_244 VDD VSS VDD VSS gf180mcu_fd_sc_mcu7t5v0__fillcap_16
XFILLER_124_214 VDD VSS VDD VSS gf180mcu_fd_sc_mcu7t5v0__fillcap_4
XFILLER_124_247 VDD VSS VDD VSS gf180mcu_fd_sc_mcu7t5v0__fillcap_4
XFILLER_11_72 VDD VSS VDD VSS gf180mcu_fd_sc_mcu7t5v0__fillcap_64
XFILLER_266_457 VDD VSS VDD VSS gf180mcu_fd_sc_mcu7t5v0__fillcap_64
XFILLER_219_340 VDD VSS VDD VSS gf180mcu_fd_sc_mcu7t5v0__fillcap_8
XFILLER_93_337 VDD VSS VDD VSS gf180mcu_fd_sc_mcu7t5v0__fillcap_8
XFILLER_234_387 VDD VSS VDD VSS gf180mcu_fd_sc_mcu7t5v0__fillcap_64
XFILLER_222_527 VDD VSS VDD VSS gf180mcu_fd_sc_mcu7t5v0__fillcap_8
XFILLER_61_212 VDD VSS VDD VSS gf180mcu_fd_sc_mcu7t5v0__fillcap_64
XFILLER_148_807 VDD VSS VDD VSS gf180mcu_fd_sc_mcu7t5v0__fillcap_64
X_1930_ _1933_/S VDD VSS _2983_/D wire121/Z _2983_/Q VDD VSS gf180mcu_fd_sc_mcu7t5v0__mux2_2
X_1861_ VDD VSS _1869_/S _1861_/A1 _1861_/A2 VDD VSS gf180mcu_fd_sc_mcu7t5v0__nand2_1
XFILLER_187_475 VDD VSS VDD VSS gf180mcu_fd_sc_mcu7t5v0__fillcap_8
XFILLER_147_317 VDD VSS VDD VSS gf180mcu_fd_sc_mcu7t5v0__fillcap_8
XFILLER_202_295 VDD VSS VDD VSS gf180mcu_fd_sc_mcu7t5v0__fillcap_4
X_1792_ _1795_/S VDD VSS _2865_/D _2865_/Q wire132/Z VDD VSS gf180mcu_fd_sc_mcu7t5v0__mux2_2
XFILLER_174_147 VDD VSS VDD VSS gf180mcu_fd_sc_mcu7t5v0__fillcap_4
XFILLER_128_597 VDD VSS VDD VSS gf180mcu_fd_sc_mcu7t5v0__fillcap_8
XFILLER_116_737 VDD VSS VDD VSS gf180mcu_fd_sc_mcu7t5v0__fillcap_64
X_3462_ VSS _3462_/CLK VDD wire55/Z _3463_/D wire163/I VDD VSS gf180mcu_fd_sc_mcu7t5v0__dffsnq_1
XFILLER_115_236 VDD VSS VDD VSS gf180mcu_fd_sc_mcu7t5v0__fillcap_16
X_2413_ _2928_/Q VSS VDD _2912_/Q _2920_/Q _2427_/S0 _2904_/Q _2460_/S1 _2413_/Z VDD
+ VSS gf180mcu_fd_sc_mcu7t5v0__mux4_1
X_3393_ _3393_/D _3393_/Q _3403_/RN VSS _3395_/CLK VDD VDD VSS gf180mcu_fd_sc_mcu7t5v0__dffrnq_1
XFILLER_254_37 VDD VSS VDD VSS gf180mcu_fd_sc_mcu7t5v0__fillcap_64
XFILLER_42_2 VDD VSS VDD VSS gf180mcu_fd_sc_mcu7t5v0__fillcap_32
X_2344_ _2358_/A3 VDD VSS _2345_/I _2494_/C _2365_/A2 VDD VSS gf180mcu_fd_sc_mcu7t5v0__nand3_1
XFILLER_97_632 VDD VSS VDD VSS gf180mcu_fd_sc_mcu7t5v0__fillcap_4
X_2275_ _2488_/A1 VDD VSS _2340_/A3 _2347_/B _1664_/Z VDD VSS gf180mcu_fd_sc_mcu7t5v0__nand3_1
XFILLER_244_107 VDD VSS VDD VSS gf180mcu_fd_sc_mcu7t5v0__fillcap_64
XFILLER_226_877 VDD VSS VDD VSS gf180mcu_fd_sc_mcu7t5v0__fillcap_8
XFILLER_65_562 VDD VSS VDD VSS gf180mcu_fd_sc_mcu7t5v0__fillcap_64
XFILLER_53_702 VDD VSS VDD VSS gf180mcu_fd_sc_mcu7t5v0__fillcap_64
XFILLER_241_836 VDD VSS VDD VSS gf180mcu_fd_sc_mcu7t5v0__fillcap_4
XFILLER_253_696 VDD VSS VDD VSS gf180mcu_fd_sc_mcu7t5v0__fillcap_4
XFILLER_80_521 VDD VSS VDD VSS gf180mcu_fd_sc_mcu7t5v0__fillcap_4
XFILLER_138_317 VDD VSS VDD VSS gf180mcu_fd_sc_mcu7t5v0__fillcap_16
XFILLER_33_492 VDD VSS VDD VSS gf180mcu_fd_sc_mcu7t5v0__fillcap_64
XFILLER_21_632 VDD VSS VDD VSS gf180mcu_fd_sc_mcu7t5v0__fillcap_64
XFILLER_166_659 VDD VSS VDD VSS gf180mcu_fd_sc_mcu7t5v0__fillcap_4
XFILLER_165_114 VDD VSS VDD VSS gf180mcu_fd_sc_mcu7t5v0__fillcap_16
XFILLER_119_542 VDD VSS VDD VSS gf180mcu_fd_sc_mcu7t5v0__fillcap_16
XFILLER_106_247 VDD VSS VDD VSS gf180mcu_fd_sc_mcu7t5v0__fillcap_16
XFILLER_134_589 VDD VSS VDD VSS gf180mcu_fd_sc_mcu7t5v0__fillcap_4
XFILLER_164_26 VDD VSS VDD VSS gf180mcu_fd_sc_mcu7t5v0__fillcap_8
XFILLER_164_37 VDD VSS VDD VSS gf180mcu_fd_sc_mcu7t5v0__fillcap_16
XFILLER_87_142 VDD VSS VDD VSS gf180mcu_fd_sc_mcu7t5v0__fillcap_8
XFILLER_248_457 VDD VSS VDD VSS gf180mcu_fd_sc_mcu7t5v0__fillcap_64
XFILLER_263_416 VDD VSS VDD VSS gf180mcu_fd_sc_mcu7t5v0__fillcap_4
XFILLER_216_332 VDD VSS VDD VSS gf180mcu_fd_sc_mcu7t5v0__fillcap_8
XFILLER_84_871 VDD VSS VDD VSS gf180mcu_fd_sc_mcu7t5v0__fillcap_4
XFILLER_204_527 VDD VSS VDD VSS gf180mcu_fd_sc_mcu7t5v0__fillcap_32
XFILLER_216_387 VDD VSS VDD VSS gf180mcu_fd_sc_mcu7t5v0__fillcap_16
XFILLER_43_212 VDD VSS VDD VSS gf180mcu_fd_sc_mcu7t5v0__fillcap_64
XFILLER_231_346 VDD VSS VDD VSS gf180mcu_fd_sc_mcu7t5v0__fillcap_4
Xwire90 VSS wire90/Z wire90/I VDD VDD VSS gf180mcu_fd_sc_mcu7t5v0__buf_2
XFILLER_244_2 VDD VSS VDD VSS gf180mcu_fd_sc_mcu7t5v0__fillcap_32
XFILLER_157_626 VDD VSS VDD VSS gf180mcu_fd_sc_mcu7t5v0__fillcap_4
XFILLER_184_445 VDD VSS VDD VSS gf180mcu_fd_sc_mcu7t5v0__fillcap_8
Xspi_opentarget_i3c_top_178 irq_o_PDRV1 VDD VSS VDD VSS gf180mcu_fd_sc_mcu7t5v0__tiel
Xspi_opentarget_i3c_top_189 sda_pad_PU VDD VSS VDD VSS gf180mcu_fd_sc_mcu7t5v0__tiel
XFILLER_11_142 VDD VSS VDD VSS gf180mcu_fd_sc_mcu7t5v0__fillcap_64
XFILLER_3_352 VDD VSS VDD VSS gf180mcu_fd_sc_mcu7t5v0__fillcap_64
XFILLER_224_18 VDD VSS VDD VSS gf180mcu_fd_sc_mcu7t5v0__fillcap_8
XFILLER_79_632 VDD VSS VDD VSS gf180mcu_fd_sc_mcu7t5v0__fillcap_64
XFILLER_267_766 VDD VSS VDD VSS gf180mcu_fd_sc_mcu7t5v0__fillcap_4
Xclkbuf_leaf_7_clk_i _3288_/CLK VSS VDD clkload0/I VDD VSS gf180mcu_fd_sc_mcu7t5v0__clkbuf_2
XFILLER_226_107 VDD VSS VDD VSS gf180mcu_fd_sc_mcu7t5v0__fillcap_64
X_2060_ _2060_/S VDD VSS _3093_/D _3309_/Q _3093_/Q VDD VSS gf180mcu_fd_sc_mcu7t5v0__mux2_2
XFILLER_47_562 VDD VSS VDD VSS gf180mcu_fd_sc_mcu7t5v0__fillcap_64
XFILLER_35_702 VDD VSS VDD VSS gf180mcu_fd_sc_mcu7t5v0__fillcap_64
XFILLER_208_877 VDD VSS VDD VSS gf180mcu_fd_sc_mcu7t5v0__fillcap_8
XFILLER_62_521 VDD VSS VDD VSS gf180mcu_fd_sc_mcu7t5v0__fillcap_4
XFILLER_235_696 VDD VSS VDD VSS gf180mcu_fd_sc_mcu7t5v0__fillcap_4
XFILLER_223_836 VDD VSS VDD VSS gf180mcu_fd_sc_mcu7t5v0__fillcap_4
XFILLER_179_206 VDD VSS VDD VSS gf180mcu_fd_sc_mcu7t5v0__fillcap_4
XFILLER_90_885 VDD VSS VDD VSS gf180mcu_fd_sc_mcu7t5v0__fillcap_4
X_2962_ VDD _2962_/Q _3415_/CLK VSS _2962_/D VDD VSS gf180mcu_fd_sc_mcu7t5v0__dffq_1
X_1913_ _1917_/S VDD VSS _2968_/D _2968_/Q wire119/I VDD VSS gf180mcu_fd_sc_mcu7t5v0__mux2_2
XFILLER_15_492 VDD VSS VDD VSS gf180mcu_fd_sc_mcu7t5v0__fillcap_64
X_2893_ VDD _2893_/Q _2900_/CLK VSS _2893_/D VDD VSS gf180mcu_fd_sc_mcu7t5v0__dffq_1
XFILLER_30_451 VDD VSS VDD VSS gf180mcu_fd_sc_mcu7t5v0__fillcap_4
X_1844_ _1851_/S VDD VSS _2909_/D wire137/Z _2909_/Q VDD VSS gf180mcu_fd_sc_mcu7t5v0__mux2_2
X_1775_ _1777_/S VDD VSS _2850_/D _3124_/Q _2850_/Q VDD VSS gf180mcu_fd_sc_mcu7t5v0__mux2_2
X_3445_ _3445_/D _3445_/Q wire161/I VSS _3445_/CLK VDD VDD VSS gf180mcu_fd_sc_mcu7t5v0__dffrnq_1
XFILLER_170_150 VDD VSS VDD VSS gf180mcu_fd_sc_mcu7t5v0__fillcap_16
X_3376_ _3376_/D _3401_/D _3403_/RN VSS _3395_/CLK VDD VDD VSS gf180mcu_fd_sc_mcu7t5v0__dffrnq_1
XFILLER_69_142 VDD VSS VDD VSS gf180mcu_fd_sc_mcu7t5v0__fillcap_64
X_2327_ _1664_/Z VDD VSS _2492_/A1 _2341_/C _2803_/Q VDD VSS gf180mcu_fd_sc_mcu7t5v0__nand3_1
XFILLER_245_416 VDD VSS VDD VSS gf180mcu_fd_sc_mcu7t5v0__fillcap_4
XFILLER_257_276 VDD VSS VDD VSS gf180mcu_fd_sc_mcu7t5v0__fillcap_4
X_2258_ _2258_/B1 _2258_/B2 VDD VSS _2259_/A2 _3206_/Q _3136_/Q VDD VSS gf180mcu_fd_sc_mcu7t5v0__aoi22_1
XFILLER_66_871 VDD VSS VDD VSS gf180mcu_fd_sc_mcu7t5v0__fillcap_4
XFILLER_198_504 VDD VSS VDD VSS gf180mcu_fd_sc_mcu7t5v0__fillcap_8
X_2189_ _2189_/S VDD VSS _3146_/D _3146_/Q _2189_/I1 VDD VSS gf180mcu_fd_sc_mcu7t5v0__mux2_2
XFILLER_25_212 VDD VSS VDD VSS gf180mcu_fd_sc_mcu7t5v0__fillcap_64
XFILLER_81_874 VDD VSS VDD VSS gf180mcu_fd_sc_mcu7t5v0__fillcap_16
XFILLER_201_508 VDD VSS VDD VSS gf180mcu_fd_sc_mcu7t5v0__fillcap_8
XFILLER_181_404 VDD VSS VDD VSS gf180mcu_fd_sc_mcu7t5v0__fillcap_4
XFILLER_107_556 VDD VSS VDD VSS gf180mcu_fd_sc_mcu7t5v0__fillcap_4
XFILLER_108_52 VDD VSS VDD VSS gf180mcu_fd_sc_mcu7t5v0__fillcap_16
XFILLER_249_766 VDD VSS VDD VSS gf180mcu_fd_sc_mcu7t5v0__fillcap_4
XFILLER_194_2 VDD VSS VDD VSS gf180mcu_fd_sc_mcu7t5v0__fillcap_8
XFILLER_88_473 VDD VSS VDD VSS gf180mcu_fd_sc_mcu7t5v0__fillcap_4
XFILLER_208_107 VDD VSS VDD VSS gf180mcu_fd_sc_mcu7t5v0__fillcap_16
XFILLER_75_134 VDD VSS VDD VSS gf180mcu_fd_sc_mcu7t5v0__fillcap_4
XFILLER_124_62 VDD VSS VDD VSS gf180mcu_fd_sc_mcu7t5v0__fillcap_8
XFILLER_29_562 VDD VSS VDD VSS gf180mcu_fd_sc_mcu7t5v0__fillcap_64
XFILLER_17_702 VDD VSS VDD VSS gf180mcu_fd_sc_mcu7t5v0__fillcap_64
XFILLER_44_521 VDD VSS VDD VSS gf180mcu_fd_sc_mcu7t5v0__fillcap_4
XFILLER_56_381 VDD VSS VDD VSS gf180mcu_fd_sc_mcu7t5v0__fillcap_4
XFILLER_217_696 VDD VSS VDD VSS gf180mcu_fd_sc_mcu7t5v0__fillcap_4
XFILLER_205_836 VDD VSS VDD VSS gf180mcu_fd_sc_mcu7t5v0__fillcap_4
XFILLER_140_61 VDD VSS VDD VSS gf180mcu_fd_sc_mcu7t5v0__fillcap_4
XFILLER_72_885 VDD VSS VDD VSS gf180mcu_fd_sc_mcu7t5v0__fillcap_4
XFILLER_12_451 VDD VSS VDD VSS gf180mcu_fd_sc_mcu7t5v0__fillcap_4
XFILLER_219_18 VDD VSS VDD VSS gf180mcu_fd_sc_mcu7t5v0__fillcap_4
X_1560_ VDD VSS _1571_/A1 _1556_/Z _1560_/A2 VDD VSS gf180mcu_fd_sc_mcu7t5v0__nor2_1
XFILLER_153_673 VDD VSS VDD VSS gf180mcu_fd_sc_mcu7t5v0__fillcap_16
XFILLER_4_661 VDD VSS VDD VSS gf180mcu_fd_sc_mcu7t5v0__fillcap_4
X_1491_ VDD VSS _3418_/D _3423_/Q _1491_/A2 VDD VSS gf180mcu_fd_sc_mcu7t5v0__xnor2_1
X_3230_ _3230_/D _3230_/Q wire145/Z VSS _3288_/CLK VDD VDD VSS gf180mcu_fd_sc_mcu7t5v0__dffrnq_1
X_3161_ _3161_/D _3161_/Q wire151/I VSS _3165_/CLK VDD VDD VSS gf180mcu_fd_sc_mcu7t5v0__dffrnq_1
XFILLER_121_570 VDD VSS VDD VSS gf180mcu_fd_sc_mcu7t5v0__fillcap_16
XFILLER_66_101 VDD VSS VDD VSS gf180mcu_fd_sc_mcu7t5v0__fillcap_4
XFILLER_239_276 VDD VSS VDD VSS gf180mcu_fd_sc_mcu7t5v0__fillcap_4
XFILLER_227_416 VDD VSS VDD VSS gf180mcu_fd_sc_mcu7t5v0__fillcap_4
X_2112_ _3112_/Q VDD VSS _2115_/B _3111_/Q _2112_/A2 VDD VSS gf180mcu_fd_sc_mcu7t5v0__aoi21_1
XFILLER_48_871 VDD VSS VDD VSS gf180mcu_fd_sc_mcu7t5v0__fillcap_4
X_3092_ _3092_/D _3092_/Q wire165/I VSS _3340_/CLK VDD VDD VSS gf180mcu_fd_sc_mcu7t5v0__dffrnq_1
X_2043_ _2058_/S VDD VSS _3076_/D wire86/I _3076_/Q VDD VSS gf180mcu_fd_sc_mcu7t5v0__mux2_2
XFILLER_207_184 VDD VSS VDD VSS gf180mcu_fd_sc_mcu7t5v0__fillcap_16
XFILLER_63_874 VDD VSS VDD VSS gf180mcu_fd_sc_mcu7t5v0__fillcap_16
X_2945_ VDD _2945_/Q _2958_/CLK VSS _2945_/D VDD VSS gf180mcu_fd_sc_mcu7t5v0__dffq_1
X_2876_ VDD _2876_/Q _2932_/CLK VSS _2876_/D VDD VSS gf180mcu_fd_sc_mcu7t5v0__dffq_1
XFILLER_191_702 VDD VSS VDD VSS gf180mcu_fd_sc_mcu7t5v0__fillcap_16
X_1827_ _1832_/S VDD VSS _2895_/D _2895_/Q _1864_/I0 VDD VSS gf180mcu_fd_sc_mcu7t5v0__mux2_2
XFILLER_108_309 VDD VSS VDD VSS gf180mcu_fd_sc_mcu7t5v0__fillcap_4
XFILLER_190_234 VDD VSS VDD VSS gf180mcu_fd_sc_mcu7t5v0__fillcap_8
X_1758_ _1758_/S VDD VSS _2836_/D _3126_/Q _2836_/Q VDD VSS gf180mcu_fd_sc_mcu7t5v0__mux2_2
XFILLER_209_95 VDD VSS VDD VSS gf180mcu_fd_sc_mcu7t5v0__fillcap_32
XFILLER_116_364 VDD VSS VDD VSS gf180mcu_fd_sc_mcu7t5v0__fillcap_16
XFILLER_171_492 VDD VSS VDD VSS gf180mcu_fd_sc_mcu7t5v0__fillcap_32
X_1689_ _1689_/B _1689_/C VDD VSS _2342_/A3 _1704_/A3 _3363_/Q VDD VSS gf180mcu_fd_sc_mcu7t5v0__aoi211_1
X_3428_ _3428_/D _3428_/Q wire161/I VSS _3435_/CLK VDD VDD VSS gf180mcu_fd_sc_mcu7t5v0__dffrnq_1
XFILLER_104_559 VDD VSS VDD VSS gf180mcu_fd_sc_mcu7t5v0__fillcap_32
X_3359_ _3359_/D _3359_/Q _3359_/RN VSS _3359_/CLK VDD VDD VSS gf180mcu_fd_sc_mcu7t5v0__dffrnq_1
XFILLER_225_72 VDD VSS VDD VSS gf180mcu_fd_sc_mcu7t5v0__fillcap_4
XFILLER_225_94 VDD VSS VDD VSS gf180mcu_fd_sc_mcu7t5v0__fillcap_32
XFILLER_38_37 VDD VSS VDD VSS gf180mcu_fd_sc_mcu7t5v0__fillcap_64
XFILLER_26_521 VDD VSS VDD VSS gf180mcu_fd_sc_mcu7t5v0__fillcap_4
XFILLER_38_381 VDD VSS VDD VSS gf180mcu_fd_sc_mcu7t5v0__fillcap_4
XFILLER_166_6 VDD VSS VDD VSS gf180mcu_fd_sc_mcu7t5v0__fillcap_16
XFILLER_54_885 VDD VSS VDD VSS gf180mcu_fd_sc_mcu7t5v0__fillcap_4
XFILLER_201_327 VDD VSS VDD VSS gf180mcu_fd_sc_mcu7t5v0__fillcap_16
XFILLER_110_31 VDD VSS VDD VSS gf180mcu_fd_sc_mcu7t5v0__fillcap_4
XFILLER_110_53 VDD VSS VDD VSS gf180mcu_fd_sc_mcu7t5v0__fillcap_8
XFILLER_213_198 VDD VSS VDD VSS gf180mcu_fd_sc_mcu7t5v0__fillcap_8
XFILLER_182_702 VDD VSS VDD VSS gf180mcu_fd_sc_mcu7t5v0__fillcap_4
XFILLER_181_212 VDD VSS VDD VSS gf180mcu_fd_sc_mcu7t5v0__fillcap_32
XFILLER_207_2 VDD VSS VDD VSS gf180mcu_fd_sc_mcu7t5v0__fillcap_8
Xclkbuf_leaf_72_clk_i _3340_/CLK VSS VDD clkbuf_3_0__f_clk_i/Z VDD VSS gf180mcu_fd_sc_mcu7t5v0__clkbuf_2
XFILLER_135_72 VDD VSS VDD VSS gf180mcu_fd_sc_mcu7t5v0__fillcap_16
XFILLER_48_101 VDD VSS VDD VSS gf180mcu_fd_sc_mcu7t5v0__fillcap_4
XFILLER_209_416 VDD VSS VDD VSS gf180mcu_fd_sc_mcu7t5v0__fillcap_4
XFILLER_217_482 VDD VSS VDD VSS gf180mcu_fd_sc_mcu7t5v0__fillcap_8
XFILLER_45_874 VDD VSS VDD VSS gf180mcu_fd_sc_mcu7t5v0__fillcap_16
XFILLER_91_468 VDD VSS VDD VSS gf180mcu_fd_sc_mcu7t5v0__fillcap_16
Xclkbuf_leaf_10_clk_i _3159_/CLK VSS VDD clkload3/I VDD VSS gf180mcu_fd_sc_mcu7t5v0__clkbuf_2
XFILLER_60_877 VDD VSS VDD VSS gf180mcu_fd_sc_mcu7t5v0__fillcap_8
X_2730_ _3059_/Q VSS VDD _3043_/Q _3051_/Q _2730_/S0 _3035_/Q wire60/Z _2730_/Z VDD
+ VSS gf180mcu_fd_sc_mcu7t5v0__mux4_1
XFILLER_185_562 VDD VSS VDD VSS gf180mcu_fd_sc_mcu7t5v0__fillcap_8
XFILLER_173_702 VDD VSS VDD VSS gf180mcu_fd_sc_mcu7t5v0__fillcap_64
Xclkbuf_leaf_25_clk_i _3363_/CLK VSS VDD clkload4/I VDD VSS gf180mcu_fd_sc_mcu7t5v0__clkbuf_2
X_2661_ _2749_/C VDD VSS _2724_/C wire55/Z _2202_/Z VDD VSS gf180mcu_fd_sc_mcu7t5v0__nor3_1
XFILLER_118_629 VDD VSS VDD VSS gf180mcu_fd_sc_mcu7t5v0__fillcap_4
XFILLER_8_241 VDD VSS VDD VSS gf180mcu_fd_sc_mcu7t5v0__fillcap_4
X_1612_ VDD VSS _1612_/Z _3398_/Q _3374_/D VDD VSS gf180mcu_fd_sc_mcu7t5v0__xor2_1
X_2592_ _2596_/S VDD VSS _3260_/D _3252_/Q _3260_/Q VDD VSS gf180mcu_fd_sc_mcu7t5v0__mux2_2
XFILLER_153_492 VDD VSS VDD VSS gf180mcu_fd_sc_mcu7t5v0__fillcap_8
X_1543_ VDD VSS _1543_/I _3455_/D VDD VSS gf180mcu_fd_sc_mcu7t5v0__clkinv_1
X_1474_ VDD VSS _1889_/A3 _3409_/Q _3410_/Q VDD VSS gf180mcu_fd_sc_mcu7t5v0__nand2_1
XFILLER_262_37 VDD VSS VDD VSS gf180mcu_fd_sc_mcu7t5v0__fillcap_64
X_3213_ _3213_/D _3213_/Q wire169/Z VSS _3332_/CLK VDD VDD VSS gf180mcu_fd_sc_mcu7t5v0__dffrnq_1
X_3144_ _3144_/D _3144_/Q _3457_/RN VSS _3364_/CLK VDD VDD VSS gf180mcu_fd_sc_mcu7t5v0__dffrnq_1
X_3075_ _3075_/D _3075_/Q _3336_/RN VSS _3336_/CLK VDD VDD VSS gf180mcu_fd_sc_mcu7t5v0__dffrnq_1
X_2026_ VDD VSS _2026_/Z _2061_/A2 _2025_/Z VDD VSS gf180mcu_fd_sc_mcu7t5v0__and2_1
XFILLER_82_457 VDD VSS VDD VSS gf180mcu_fd_sc_mcu7t5v0__fillcap_64
XFILLER_211_41 VDD VSS VDD VSS gf180mcu_fd_sc_mcu7t5v0__fillcap_16
XFILLER_36_885 VDD VSS VDD VSS gf180mcu_fd_sc_mcu7t5v0__fillcap_4
XFILLER_251_772 VDD VSS VDD VSS gf180mcu_fd_sc_mcu7t5v0__fillcap_64
XFILLER_50_387 VDD VSS VDD VSS gf180mcu_fd_sc_mcu7t5v0__fillcap_64
X_2928_ VDD _2928_/Q _2932_/CLK VSS _2928_/D VDD VSS gf180mcu_fd_sc_mcu7t5v0__dffq_1
XFILLER_163_212 VDD VSS VDD VSS gf180mcu_fd_sc_mcu7t5v0__fillcap_8
X_2859_ VDD _2859_/Q _2867_/CLK VSS _2859_/D VDD VSS gf180mcu_fd_sc_mcu7t5v0__dffq_1
XFILLER_163_245 VDD VSS VDD VSS gf180mcu_fd_sc_mcu7t5v0__fillcap_16
Xhold230 _3396_/D VSS _3401_/Q VDD VDD VSS gf180mcu_fd_sc_mcu7t5v0__dlyc_1
XFILLER_172_37 VDD VSS VDD VSS gf180mcu_fd_sc_mcu7t5v0__fillcap_64
XFILLER_131_142 VDD VSS VDD VSS gf180mcu_fd_sc_mcu7t5v0__fillcap_8
XFILLER_199_621 VDD VSS VDD VSS gf180mcu_fd_sc_mcu7t5v0__fillcap_8
XFILLER_199_632 VDD VSS VDD VSS gf180mcu_fd_sc_mcu7t5v0__fillcap_16
XFILLER_27_874 VDD VSS VDD VSS gf180mcu_fd_sc_mcu7t5v0__fillcap_16
XFILLER_60_107 VDD VSS VDD VSS gf180mcu_fd_sc_mcu7t5v0__fillcap_64
XFILLER_157_2 VDD VSS VDD VSS gf180mcu_fd_sc_mcu7t5v0__fillcap_64
XFILLER_241_282 VDD VSS VDD VSS gf180mcu_fd_sc_mcu7t5v0__fillcap_64
XFILLER_42_877 VDD VSS VDD VSS gf180mcu_fd_sc_mcu7t5v0__fillcap_8
XFILLER_81_56 VDD VSS VDD VSS gf180mcu_fd_sc_mcu7t5v0__fillcap_8
XFILLER_155_702 VDD VSS VDD VSS gf180mcu_fd_sc_mcu7t5v0__fillcap_64
XFILLER_135_492 VDD VSS VDD VSS gf180mcu_fd_sc_mcu7t5v0__fillcap_16
XFILLER_123_632 VDD VSS VDD VSS gf180mcu_fd_sc_mcu7t5v0__fillcap_8
XFILLER_150_451 VDD VSS VDD VSS gf180mcu_fd_sc_mcu7t5v0__fillcap_4
XFILLER_96_516 VDD VSS VDD VSS gf180mcu_fd_sc_mcu7t5v0__fillcap_8
XFILLER_123_687 VDD VSS VDD VSS gf180mcu_fd_sc_mcu7t5v0__fillcap_8
XFILLER_265_842 VDD VSS VDD VSS gf180mcu_fd_sc_mcu7t5v0__fillcap_32
XFILLER_209_246 VDD VSS VDD VSS gf180mcu_fd_sc_mcu7t5v0__fillcap_8
XFILLER_91_254 VDD VSS VDD VSS gf180mcu_fd_sc_mcu7t5v0__fillcap_8
XFILLER_64_457 VDD VSS VDD VSS gf180mcu_fd_sc_mcu7t5v0__fillcap_64
XFILLER_217_290 VDD VSS VDD VSS gf180mcu_fd_sc_mcu7t5v0__fillcap_4
XFILLER_189_120 VDD VSS VDD VSS gf180mcu_fd_sc_mcu7t5v0__fillcap_4
XFILLER_18_885 VDD VSS VDD VSS gf180mcu_fd_sc_mcu7t5v0__fillcap_4
XFILLER_233_772 VDD VSS VDD VSS gf180mcu_fd_sc_mcu7t5v0__fillcap_64
XFILLER_189_142 VDD VSS VDD VSS gf180mcu_fd_sc_mcu7t5v0__fillcap_16
XFILLER_260_591 VDD VSS VDD VSS gf180mcu_fd_sc_mcu7t5v0__fillcap_4
XFILLER_32_387 VDD VSS VDD VSS gf180mcu_fd_sc_mcu7t5v0__fillcap_64
XFILLER_189_197 VDD VSS VDD VSS gf180mcu_fd_sc_mcu7t5v0__fillcap_8
XFILLER_20_527 VDD VSS VDD VSS gf180mcu_fd_sc_mcu7t5v0__fillcap_64
XFILLER_186_871 VDD VSS VDD VSS gf180mcu_fd_sc_mcu7t5v0__fillcap_4
XFILLER_72_2 VDD VSS VDD VSS gf180mcu_fd_sc_mcu7t5v0__fillcap_32
XFILLER_173_521 VDD VSS VDD VSS gf180mcu_fd_sc_mcu7t5v0__fillcap_4
XFILLER_145_212 VDD VSS VDD VSS gf180mcu_fd_sc_mcu7t5v0__fillcap_16
X_2713_ _2712_/Z VSS VDD _2709_/Z _2711_/Z _2735_/S _2710_/Z _2732_/C _2713_/Z VDD
+ VSS gf180mcu_fd_sc_mcu7t5v0__mux4_1
XFILLER_173_554 VDD VSS VDD VSS gf180mcu_fd_sc_mcu7t5v0__fillcap_4
X_2644_ _2644_/S VDD VSS _3307_/D _3265_/Q _3307_/Q VDD VSS gf180mcu_fd_sc_mcu7t5v0__mux2_2
X_2575_ wire12/Z VDD VSS _3243_/D _3220_/Q _3243_/Q VDD VSS gf180mcu_fd_sc_mcu7t5v0__mux2_2
X_1526_ VDD VSS _1531_/A2 _3383_/Q _1522_/Z VDD VSS gf180mcu_fd_sc_mcu7t5v0__nor2_1
X_1457_ VDD VSS _1457_/Z _3461_/D _3461_/Q VDD VSS gf180mcu_fd_sc_mcu7t5v0__and2_1
X_1388_ VDD VSS _3184_/Q _2320_/A1 VDD VSS gf180mcu_fd_sc_mcu7t5v0__clkinv_1
XFILLER_110_871 VDD VSS VDD VSS gf180mcu_fd_sc_mcu7t5v0__fillcap_4
XFILLER_255_352 VDD VSS VDD VSS gf180mcu_fd_sc_mcu7t5v0__fillcap_64
X_3127_ _3127_/D _3127_/Q _3457_/RN VSS _3365_/CLK VDD VDD VSS gf180mcu_fd_sc_mcu7t5v0__dffrnq_1
XFILLER_83_766 VDD VSS VDD VSS gf180mcu_fd_sc_mcu7t5v0__fillcap_4
X_3058_ VDD _3058_/Q _3058_/CLK VSS _3058_/D VDD VSS gf180mcu_fd_sc_mcu7t5v0__dffq_1
XFILLER_42_107 VDD VSS VDD VSS gf180mcu_fd_sc_mcu7t5v0__fillcap_64
X_2009_ _2009_/S VDD VSS _3052_/D wire113/Z _3052_/Q VDD VSS gf180mcu_fd_sc_mcu7t5v0__mux2_2
XFILLER_223_282 VDD VSS VDD VSS gf180mcu_fd_sc_mcu7t5v0__fillcap_16
XFILLER_195_112 VDD VSS VDD VSS gf180mcu_fd_sc_mcu7t5v0__fillcap_8
XFILLER_24_877 VDD VSS VDD VSS gf180mcu_fd_sc_mcu7t5v0__fillcap_8
XFILLER_149_540 VDD VSS VDD VSS gf180mcu_fd_sc_mcu7t5v0__fillcap_4
XFILLER_195_134 VDD VSS VDD VSS gf180mcu_fd_sc_mcu7t5v0__fillcap_4
XFILLER_51_696 VDD VSS VDD VSS gf180mcu_fd_sc_mcu7t5v0__fillcap_4
XFILLER_149_562 VDD VSS VDD VSS gf180mcu_fd_sc_mcu7t5v0__fillcap_16
XFILLER_176_381 VDD VSS VDD VSS gf180mcu_fd_sc_mcu7t5v0__fillcap_4
XFILLER_164_576 VDD VSS VDD VSS gf180mcu_fd_sc_mcu7t5v0__fillcap_4
XFILLER_192_885 VDD VSS VDD VSS gf180mcu_fd_sc_mcu7t5v0__fillcap_4
XFILLER_117_492 VDD VSS VDD VSS gf180mcu_fd_sc_mcu7t5v0__fillcap_8
XFILLER_105_632 VDD VSS VDD VSS gf180mcu_fd_sc_mcu7t5v0__fillcap_8
XFILLER_2_247 VDD VSS VDD VSS gf180mcu_fd_sc_mcu7t5v0__fillcap_64
XFILLER_132_451 VDD VSS VDD VSS gf180mcu_fd_sc_mcu7t5v0__fillcap_4
XFILLER_78_527 VDD VSS VDD VSS gf180mcu_fd_sc_mcu7t5v0__fillcap_64
XFILLER_116_52 VDD VSS VDD VSS gf180mcu_fd_sc_mcu7t5v0__fillcap_32
XFILLER_247_842 VDD VSS VDD VSS gf180mcu_fd_sc_mcu7t5v0__fillcap_32
XFILLER_262_801 VDD VSS VDD VSS gf180mcu_fd_sc_mcu7t5v0__fillcap_4
XFILLER_219_599 VDD VSS VDD VSS gf180mcu_fd_sc_mcu7t5v0__fillcap_4
XFILLER_46_457 VDD VSS VDD VSS gf180mcu_fd_sc_mcu7t5v0__fillcap_64
XFILLER_61_416 VDD VSS VDD VSS gf180mcu_fd_sc_mcu7t5v0__fillcap_4
XFILLER_215_772 VDD VSS VDD VSS gf180mcu_fd_sc_mcu7t5v0__fillcap_64
XFILLER_230_731 VDD VSS VDD VSS gf180mcu_fd_sc_mcu7t5v0__fillcap_4
XFILLER_242_591 VDD VSS VDD VSS gf180mcu_fd_sc_mcu7t5v0__fillcap_4
XFILLER_14_387 VDD VSS VDD VSS gf180mcu_fd_sc_mcu7t5v0__fillcap_64
XFILLER_168_871 VDD VSS VDD VSS gf180mcu_fd_sc_mcu7t5v0__fillcap_4
XFILLER_186_167 VDD VSS VDD VSS gf180mcu_fd_sc_mcu7t5v0__fillcap_8
XFILLER_127_212 VDD VSS VDD VSS gf180mcu_fd_sc_mcu7t5v0__fillcap_4
XFILLER_183_874 VDD VSS VDD VSS gf180mcu_fd_sc_mcu7t5v0__fillcap_16
XFILLER_6_597 VDD VSS VDD VSS gf180mcu_fd_sc_mcu7t5v0__fillcap_64
X_2360_ _2360_/B VDD VSS _3194_/D _2360_/A1 _2360_/A2 VDD VSS gf180mcu_fd_sc_mcu7t5v0__aoi21_1
XFILLER_97_836 VDD VSS VDD VSS gf180mcu_fd_sc_mcu7t5v0__fillcap_4
X_2291_ VDD VSS _2293_/B _3183_/Q _2336_/B VDD VSS gf180mcu_fd_sc_mcu7t5v0__nand2_1
XFILLER_173_80 VDD VSS VDD VSS gf180mcu_fd_sc_mcu7t5v0__fillcap_4
XFILLER_237_352 VDD VSS VDD VSS gf180mcu_fd_sc_mcu7t5v0__fillcap_64
XFILLER_252_311 VDD VSS VDD VSS gf180mcu_fd_sc_mcu7t5v0__fillcap_4
XFILLER_264_171 VDD VSS VDD VSS gf180mcu_fd_sc_mcu7t5v0__fillcap_4
XFILLER_65_766 VDD VSS VDD VSS gf180mcu_fd_sc_mcu7t5v0__fillcap_4
XFILLER_24_107 VDD VSS VDD VSS gf180mcu_fd_sc_mcu7t5v0__fillcap_64
XFILLER_205_282 VDD VSS VDD VSS gf180mcu_fd_sc_mcu7t5v0__fillcap_32
XFILLER_220_241 VDD VSS VDD VSS gf180mcu_fd_sc_mcu7t5v0__fillcap_4
XFILLER_268_36 VDD VSS VDD VSS gf180mcu_fd_sc_mcu7t5v0__fillcap_32
XFILLER_33_696 VDD VSS VDD VSS gf180mcu_fd_sc_mcu7t5v0__fillcap_4
XFILLER_21_836 VDD VSS VDD VSS gf180mcu_fd_sc_mcu7t5v0__fillcap_4
XFILLER_119_702 VDD VSS VDD VSS gf180mcu_fd_sc_mcu7t5v0__fillcap_64
XFILLER_146_521 VDD VSS VDD VSS gf180mcu_fd_sc_mcu7t5v0__fillcap_4
XFILLER_165_329 VDD VSS VDD VSS gf180mcu_fd_sc_mcu7t5v0__fillcap_16
XFILLER_158_381 VDD VSS VDD VSS gf180mcu_fd_sc_mcu7t5v0__fillcap_4
XFILLER_134_705 VDD VSS VDD VSS gf180mcu_fd_sc_mcu7t5v0__fillcap_16
XFILLER_118_234 VDD VSS VDD VSS gf180mcu_fd_sc_mcu7t5v0__fillcap_4
XFILLER_146_587 VDD VSS VDD VSS gf180mcu_fd_sc_mcu7t5v0__fillcap_8
XFILLER_174_885 VDD VSS VDD VSS gf180mcu_fd_sc_mcu7t5v0__fillcap_4
X_2627_ _2642_/S VDD VSS _3290_/D _3248_/Q wire88/I VDD VSS gf180mcu_fd_sc_mcu7t5v0__mux2_2
Xclkbuf_4_1_0_host_clk_i _3457_/CLK VSS VDD clkbuf_0_host_clk_i/Z VDD VSS gf180mcu_fd_sc_mcu7t5v0__clkbuf_2
X_2558_ _2558_/S VDD VSS _3227_/D _3220_/Q _3227_/Q VDD VSS gf180mcu_fd_sc_mcu7t5v0__mux2_2
X_1509_ _1500_/Z VDD VSS _1728_/S _3369_/Q _3370_/Q VDD VSS gf180mcu_fd_sc_mcu7t5v0__and3_1
X_2489_ _2489_/S VDD VSS _3210_/D _1400_/I _2489_/I1 VDD VSS gf180mcu_fd_sc_mcu7t5v0__mux2_2
XFILLER_99_195 VDD VSS VDD VSS gf180mcu_fd_sc_mcu7t5v0__fillcap_8
XFILLER_229_842 VDD VSS VDD VSS gf180mcu_fd_sc_mcu7t5v0__fillcap_32
XFILLER_101_156 VDD VSS VDD VSS gf180mcu_fd_sc_mcu7t5v0__fillcap_16
XFILLER_244_801 VDD VSS VDD VSS gf180mcu_fd_sc_mcu7t5v0__fillcap_4
XFILLER_256_661 VDD VSS VDD VSS gf180mcu_fd_sc_mcu7t5v0__fillcap_4
XFILLER_233_72 VDD VSS VDD VSS gf180mcu_fd_sc_mcu7t5v0__fillcap_64
XFILLER_28_457 VDD VSS VDD VSS gf180mcu_fd_sc_mcu7t5v0__fillcap_64
XFILLER_46_37 VDD VSS VDD VSS gf180mcu_fd_sc_mcu7t5v0__fillcap_64
XFILLER_55_276 VDD VSS VDD VSS gf180mcu_fd_sc_mcu7t5v0__fillcap_4
XFILLER_43_416 VDD VSS VDD VSS gf180mcu_fd_sc_mcu7t5v0__fillcap_4
XFILLER_212_731 VDD VSS VDD VSS gf180mcu_fd_sc_mcu7t5v0__fillcap_4
XFILLER_224_591 VDD VSS VDD VSS gf180mcu_fd_sc_mcu7t5v0__fillcap_4
XFILLER_211_252 VDD VSS VDD VSS gf180mcu_fd_sc_mcu7t5v0__fillcap_4
XFILLER_183_104 VDD VSS VDD VSS gf180mcu_fd_sc_mcu7t5v0__fillcap_8
XFILLER_8_807 VDD VSS VDD VSS gf180mcu_fd_sc_mcu7t5v0__fillcap_64
XFILLER_11_346 VDD VSS VDD VSS gf180mcu_fd_sc_mcu7t5v0__fillcap_4
XFILLER_109_212 VDD VSS VDD VSS gf180mcu_fd_sc_mcu7t5v0__fillcap_32
XFILLER_137_543 VDD VSS VDD VSS gf180mcu_fd_sc_mcu7t5v0__fillcap_8
XFILLER_165_874 VDD VSS VDD VSS gf180mcu_fd_sc_mcu7t5v0__fillcap_16
XFILLER_124_226 VDD VSS VDD VSS gf180mcu_fd_sc_mcu7t5v0__fillcap_16
XFILLER_127_40 VDD VSS VDD VSS gf180mcu_fd_sc_mcu7t5v0__fillcap_16
XFILLER_180_877 VDD VSS VDD VSS gf180mcu_fd_sc_mcu7t5v0__fillcap_8
XFILLER_3_556 VDD VSS VDD VSS gf180mcu_fd_sc_mcu7t5v0__fillcap_4
XFILLER_2_2 VDD VSS VDD VSS gf180mcu_fd_sc_mcu7t5v0__fillcap_32
XFILLER_105_484 VDD VSS VDD VSS gf180mcu_fd_sc_mcu7t5v0__fillcap_4
XFILLER_79_836 VDD VSS VDD VSS gf180mcu_fd_sc_mcu7t5v0__fillcap_4
XFILLER_87_88 VDD VSS VDD VSS gf180mcu_fd_sc_mcu7t5v0__fillcap_4
XFILLER_219_352 VDD VSS VDD VSS gf180mcu_fd_sc_mcu7t5v0__fillcap_16
XFILLER_143_61 VDD VSS VDD VSS gf180mcu_fd_sc_mcu7t5v0__fillcap_8
XFILLER_143_72 VDD VSS VDD VSS gf180mcu_fd_sc_mcu7t5v0__fillcap_16
XFILLER_234_311 VDD VSS VDD VSS gf180mcu_fd_sc_mcu7t5v0__fillcap_4
XFILLER_246_171 VDD VSS VDD VSS gf180mcu_fd_sc_mcu7t5v0__fillcap_4
XFILLER_47_766 VDD VSS VDD VSS gf180mcu_fd_sc_mcu7t5v0__fillcap_4
XFILLER_15_696 VDD VSS VDD VSS gf180mcu_fd_sc_mcu7t5v0__fillcap_4
X_1860_ _1860_/S VDD VSS _2924_/D _1869_/I0 _2924_/Q VDD VSS gf180mcu_fd_sc_mcu7t5v0__mux2_2
X_1791_ _1795_/S VDD VSS _2864_/D _2864_/Q wire133/I VDD VSS gf180mcu_fd_sc_mcu7t5v0__mux2_2
XFILLER_156_885 VDD VSS VDD VSS gf180mcu_fd_sc_mcu7t5v0__fillcap_4
X_3461_ _3461_/D _3461_/Q wire163/Z VSS _3461_/CLK VDD VDD VSS gf180mcu_fd_sc_mcu7t5v0__dffrnq_1
X_2412_ _2864_/Q VSS VDD _2848_/Q _2856_/Q wire78/Z _2840_/Q wire76/Z _2412_/Z VDD
+ VSS gf180mcu_fd_sc_mcu7t5v0__mux4_1
X_3392_ _3392_/D _3392_/Q _3403_/RN VSS _3392_/CLK VDD VDD VSS gf180mcu_fd_sc_mcu7t5v0__dffrnq_1
X_2343_ VDD VSS _2361_/A3 _2494_/C _2358_/A3 VDD VSS gf180mcu_fd_sc_mcu7t5v0__nand2_1
XFILLER_35_2 VDD VSS VDD VSS gf180mcu_fd_sc_mcu7t5v0__fillcap_64
XFILLER_69_346 VDD VSS VDD VSS gf180mcu_fd_sc_mcu7t5v0__fillcap_4
XFILLER_226_801 VDD VSS VDD VSS gf180mcu_fd_sc_mcu7t5v0__fillcap_4
XFILLER_238_661 VDD VSS VDD VSS gf180mcu_fd_sc_mcu7t5v0__fillcap_4
X_2274_ _2274_/B _2274_/C VDD VSS _3173_/D _2274_/A1 _2272_/Z VDD VSS gf180mcu_fd_sc_mcu7t5v0__aoi211_1
XFILLER_25_416 VDD VSS VDD VSS gf180mcu_fd_sc_mcu7t5v0__fillcap_4
XFILLER_37_276 VDD VSS VDD VSS gf180mcu_fd_sc_mcu7t5v0__fillcap_4
XFILLER_206_591 VDD VSS VDD VSS gf180mcu_fd_sc_mcu7t5v0__fillcap_4
XFILLER_166_605 VDD VSS VDD VSS gf180mcu_fd_sc_mcu7t5v0__fillcap_4
XFILLER_166_627 VDD VSS VDD VSS gf180mcu_fd_sc_mcu7t5v0__fillcap_32
XFILLER_147_874 VDD VSS VDD VSS gf180mcu_fd_sc_mcu7t5v0__fillcap_16
X_1989_ _1991_/S VDD VSS _3034_/D _3034_/Q wire116/Z VDD VSS gf180mcu_fd_sc_mcu7t5v0__mux2_2
XFILLER_134_513 VDD VSS VDD VSS gf180mcu_fd_sc_mcu7t5v0__fillcap_8
XFILLER_161_343 VDD VSS VDD VSS gf180mcu_fd_sc_mcu7t5v0__fillcap_4
XFILLER_162_877 VDD VSS VDD VSS gf180mcu_fd_sc_mcu7t5v0__fillcap_8
XFILLER_142_590 VDD VSS VDD VSS gf180mcu_fd_sc_mcu7t5v0__fillcap_4
XFILLER_130_730 VDD VSS VDD VSS gf180mcu_fd_sc_mcu7t5v0__fillcap_4
XFILLER_102_443 VDD VSS VDD VSS gf180mcu_fd_sc_mcu7t5v0__fillcap_8
XFILLER_180_37 VDD VSS VDD VSS gf180mcu_fd_sc_mcu7t5v0__fillcap_4
XFILLER_216_311 VDD VSS VDD VSS gf180mcu_fd_sc_mcu7t5v0__fillcap_4
XFILLER_228_171 VDD VSS VDD VSS gf180mcu_fd_sc_mcu7t5v0__fillcap_4
XFILLER_29_766 VDD VSS VDD VSS gf180mcu_fd_sc_mcu7t5v0__fillcap_4
Xwire91 VSS wire91/Z wire91/I VDD VDD VSS gf180mcu_fd_sc_mcu7t5v0__buf_2
XFILLER_237_2 VDD VSS VDD VSS gf180mcu_fd_sc_mcu7t5v0__fillcap_64
Xspi_opentarget_i3c_top_179 irq_o_PU VDD VSS VDD VSS gf180mcu_fd_sc_mcu7t5v0__tiel
XFILLER_184_457 VDD VSS VDD VSS gf180mcu_fd_sc_mcu7t5v0__fillcap_32
XFILLER_7_136 VDD VSS VDD VSS gf180mcu_fd_sc_mcu7t5v0__fillcap_4
XFILLER_138_885 VDD VSS VDD VSS gf180mcu_fd_sc_mcu7t5v0__fillcap_4
XFILLER_140_527 VDD VSS VDD VSS gf180mcu_fd_sc_mcu7t5v0__fillcap_16
XFILLER_152_387 VDD VSS VDD VSS gf180mcu_fd_sc_mcu7t5v0__fillcap_16
XFILLER_208_801 VDD VSS VDD VSS gf180mcu_fd_sc_mcu7t5v0__fillcap_4
XFILLER_19_276 VDD VSS VDD VSS gf180mcu_fd_sc_mcu7t5v0__fillcap_4
XFILLER_250_667 VDD VSS VDD VSS gf180mcu_fd_sc_mcu7t5v0__fillcap_64
X_2961_ VDD _2961_/Q _3409_/CLK VSS _2961_/D VDD VSS gf180mcu_fd_sc_mcu7t5v0__dffq_1
XFILLER_187_251 VDD VSS VDD VSS gf180mcu_fd_sc_mcu7t5v0__fillcap_8
X_1912_ _1917_/S VDD VSS _2967_/D _2967_/Q wire121/Z VDD VSS gf180mcu_fd_sc_mcu7t5v0__mux2_2
X_2892_ VDD _2892_/Q _2900_/CLK VSS _2892_/D VDD VSS gf180mcu_fd_sc_mcu7t5v0__dffq_1
XFILLER_187_273 VDD VSS VDD VSS gf180mcu_fd_sc_mcu7t5v0__fillcap_4
X_1843_ VDD VSS _1851_/S _1843_/A1 _1861_/A2 VDD VSS gf180mcu_fd_sc_mcu7t5v0__nand2_1
XFILLER_162_107 VDD VSS VDD VSS gf180mcu_fd_sc_mcu7t5v0__fillcap_16
X_1774_ _1777_/S VDD VSS _2849_/D wire132/Z _2849_/Q VDD VSS gf180mcu_fd_sc_mcu7t5v0__mux2_2
XFILLER_129_874 VDD VSS VDD VSS gf180mcu_fd_sc_mcu7t5v0__fillcap_16
X_3444_ _3444_/D _3444_/Q wire161/I VSS _3445_/CLK VDD VDD VSS gf180mcu_fd_sc_mcu7t5v0__dffrnq_1
XFILLER_144_877 VDD VSS VDD VSS gf180mcu_fd_sc_mcu7t5v0__fillcap_8
X_3375_ _3375_/D _3393_/D _3403_/RN VSS _3405_/CLK VDD VDD VSS gf180mcu_fd_sc_mcu7t5v0__dffrnq_1
XFILLER_214_30 VDD VSS VDD VSS gf180mcu_fd_sc_mcu7t5v0__fillcap_4
X_2326_ VDD VSS _2326_/Z _2316_/C _2348_/A2 VDD VSS gf180mcu_fd_sc_mcu7t5v0__and2_1
X_2257_ _3210_/Q _3206_/Q VDD VSS _2258_/B2 _2257_/A1 _2257_/A2 VDD VSS gf180mcu_fd_sc_mcu7t5v0__aoi211_1
X_2188_ VDD VSS _2189_/I1 _3146_/Q _2168_/C VDD VSS gf180mcu_fd_sc_mcu7t5v0__nor2_1
XFILLER_81_842 VDD VSS VDD VSS gf180mcu_fd_sc_mcu7t5v0__fillcap_32
XFILLER_240_177 VDD VSS VDD VSS gf180mcu_fd_sc_mcu7t5v0__fillcap_64
XFILLER_166_457 VDD VSS VDD VSS gf180mcu_fd_sc_mcu7t5v0__fillcap_8
XFILLER_194_777 VDD VSS VDD VSS gf180mcu_fd_sc_mcu7t5v0__fillcap_16
XFILLER_193_265 VDD VSS VDD VSS gf180mcu_fd_sc_mcu7t5v0__fillcap_8
XFILLER_134_321 VDD VSS VDD VSS gf180mcu_fd_sc_mcu7t5v0__fillcap_8
XFILLER_162_641 VDD VSS VDD VSS gf180mcu_fd_sc_mcu7t5v0__fillcap_16
XFILLER_107_524 VDD VSS VDD VSS gf180mcu_fd_sc_mcu7t5v0__fillcap_8
XFILLER_134_387 VDD VSS VDD VSS gf180mcu_fd_sc_mcu7t5v0__fillcap_64
XFILLER_264_737 VDD VSS VDD VSS gf180mcu_fd_sc_mcu7t5v0__fillcap_64
XFILLER_187_2 VDD VSS VDD VSS gf180mcu_fd_sc_mcu7t5v0__fillcap_8
XFILLER_204_325 VDD VSS VDD VSS gf180mcu_fd_sc_mcu7t5v0__fillcap_4
XFILLER_71_352 VDD VSS VDD VSS gf180mcu_fd_sc_mcu7t5v0__fillcap_64
XFILLER_17_72 VDD VSS VDD VSS gf180mcu_fd_sc_mcu7t5v0__fillcap_64
XFILLER_83_190 VDD VSS VDD VSS gf180mcu_fd_sc_mcu7t5v0__fillcap_4
XFILLER_232_667 VDD VSS VDD VSS gf180mcu_fd_sc_mcu7t5v0__fillcap_64
XFILLER_220_807 VDD VSS VDD VSS gf180mcu_fd_sc_mcu7t5v0__fillcap_64
XFILLER_200_597 VDD VSS VDD VSS gf180mcu_fd_sc_mcu7t5v0__fillcap_16
XFILLER_144_107 VDD VSS VDD VSS gf180mcu_fd_sc_mcu7t5v0__fillcap_64
XFILLER_172_449 VDD VSS VDD VSS gf180mcu_fd_sc_mcu7t5v0__fillcap_4
XFILLER_137_170 VDD VSS VDD VSS gf180mcu_fd_sc_mcu7t5v0__fillcap_4
XFILLER_126_877 VDD VSS VDD VSS gf180mcu_fd_sc_mcu7t5v0__fillcap_8
XFILLER_141_836 VDD VSS VDD VSS gf180mcu_fd_sc_mcu7t5v0__fillcap_4
XFILLER_98_227 VDD VSS VDD VSS gf180mcu_fd_sc_mcu7t5v0__fillcap_16
X_1490_ VDD VSS _3423_/D _3423_/Q _1484_/Z VDD VSS gf180mcu_fd_sc_mcu7t5v0__xor2_1
X_3160_ _3160_/D _3160_/Q _3344_/RN VSS _3344_/CLK VDD VDD VSS gf180mcu_fd_sc_mcu7t5v0__dffrnq_1
X_2111_ VDD VSS _2112_/A2 _2125_/A2 _2111_/A2 VDD VSS gf180mcu_fd_sc_mcu7t5v0__nor2_1
X_3091_ _3091_/D _3091_/Q _3339_/RN VSS _3307_/CLK VDD VDD VSS gf180mcu_fd_sc_mcu7t5v0__dffrnq_1
XFILLER_254_247 VDD VSS VDD VSS gf180mcu_fd_sc_mcu7t5v0__fillcap_64
X_2042_ _2058_/S VDD VSS _3075_/D wire87/I _3075_/Q VDD VSS gf180mcu_fd_sc_mcu7t5v0__mux2_2
XFILLER_223_612 VDD VSS VDD VSS gf180mcu_fd_sc_mcu7t5v0__fillcap_16
XFILLER_63_842 VDD VSS VDD VSS gf180mcu_fd_sc_mcu7t5v0__fillcap_32
XFILLER_90_661 VDD VSS VDD VSS gf180mcu_fd_sc_mcu7t5v0__fillcap_4
XFILLER_222_177 VDD VSS VDD VSS gf180mcu_fd_sc_mcu7t5v0__fillcap_64
X_2944_ VDD _2944_/Q _3150_/CLK VSS _2944_/D VDD VSS gf180mcu_fd_sc_mcu7t5v0__dffq_1
XFILLER_31_772 VDD VSS VDD VSS gf180mcu_fd_sc_mcu7t5v0__fillcap_64
X_2875_ VDD _2875_/Q _2900_/CLK VSS _2875_/D VDD VSS gf180mcu_fd_sc_mcu7t5v0__dffq_1
XFILLER_148_457 VDD VSS VDD VSS gf180mcu_fd_sc_mcu7t5v0__fillcap_64
X_1826_ _1832_/S VDD VSS _2894_/D _2894_/Q _1863_/I0 VDD VSS gf180mcu_fd_sc_mcu7t5v0__mux2_2
XFILLER_135_118 VDD VSS VDD VSS gf180mcu_fd_sc_mcu7t5v0__fillcap_16
XFILLER_209_41 VDD VSS VDD VSS gf180mcu_fd_sc_mcu7t5v0__fillcap_16
XFILLER_175_287 VDD VSS VDD VSS gf180mcu_fd_sc_mcu7t5v0__fillcap_16
X_1757_ _1758_/S VDD VSS _2835_/D _1794_/I1 _2835_/Q VDD VSS gf180mcu_fd_sc_mcu7t5v0__mux2_2
XFILLER_116_332 VDD VSS VDD VSS gf180mcu_fd_sc_mcu7t5v0__fillcap_32
X_1688_ VDD VSS _2239_/C _3212_/Q _2238_/A1 VDD VSS gf180mcu_fd_sc_mcu7t5v0__nor2_1
XFILLER_116_387 VDD VSS VDD VSS gf180mcu_fd_sc_mcu7t5v0__fillcap_16
XFILLER_131_335 VDD VSS VDD VSS gf180mcu_fd_sc_mcu7t5v0__fillcap_8
X_3427_ _3427_/D _3427_/Q wire161/I VSS _3427_/CLK VDD VDD VSS gf180mcu_fd_sc_mcu7t5v0__dffrnq_1
X_3358_ VSS _3358_/CLK VDD _3358_/D _3363_/D wire153/I VDD VSS gf180mcu_fd_sc_mcu7t5v0__dffsnq_1
XFILLER_85_422 VDD VSS VDD VSS gf180mcu_fd_sc_mcu7t5v0__fillcap_64
XFILLER_246_737 VDD VSS VDD VSS gf180mcu_fd_sc_mcu7t5v0__fillcap_64
X_2309_ VDD VSS _2472_/A2 _2494_/C _2470_/A2 VDD VSS gf180mcu_fd_sc_mcu7t5v0__nand2_1
XFILLER_97_293 VDD VSS VDD VSS gf180mcu_fd_sc_mcu7t5v0__fillcap_4
XFILLER_258_597 VDD VSS VDD VSS gf180mcu_fd_sc_mcu7t5v0__fillcap_64
X_3289_ _3289_/D _3289_/Q wire151/I VSS _3289_/CLK VDD VDD VSS gf180mcu_fd_sc_mcu7t5v0__dffrnq_1
XFILLER_199_836 VDD VSS VDD VSS gf180mcu_fd_sc_mcu7t5v0__fillcap_4
XFILLER_241_72 VDD VSS VDD VSS gf180mcu_fd_sc_mcu7t5v0__fillcap_64
XFILLER_54_37 VDD VSS VDD VSS gf180mcu_fd_sc_mcu7t5v0__fillcap_64
XFILLER_214_667 VDD VSS VDD VSS gf180mcu_fd_sc_mcu7t5v0__fillcap_64
XFILLER_202_807 VDD VSS VDD VSS gf180mcu_fd_sc_mcu7t5v0__fillcap_64
XFILLER_53_352 VDD VSS VDD VSS gf180mcu_fd_sc_mcu7t5v0__fillcap_64
XFILLER_110_10 VDD VSS VDD VSS gf180mcu_fd_sc_mcu7t5v0__fillcap_4
XFILLER_241_486 VDD VSS VDD VSS gf180mcu_fd_sc_mcu7t5v0__fillcap_4
XFILLER_198_379 VDD VSS VDD VSS gf180mcu_fd_sc_mcu7t5v0__fillcap_4
XFILLER_80_171 VDD VSS VDD VSS gf180mcu_fd_sc_mcu7t5v0__fillcap_4
XFILLER_167_766 VDD VSS VDD VSS gf180mcu_fd_sc_mcu7t5v0__fillcap_4
XFILLER_21_282 VDD VSS VDD VSS gf180mcu_fd_sc_mcu7t5v0__fillcap_64
Xclkbuf_leaf_6_clk_i _3279_/CLK VSS VDD clkload3/I VDD VSS gf180mcu_fd_sc_mcu7t5v0__clkbuf_2
XFILLER_126_107 VDD VSS VDD VSS gf180mcu_fd_sc_mcu7t5v0__fillcap_16
XFILLER_107_343 VDD VSS VDD VSS gf180mcu_fd_sc_mcu7t5v0__fillcap_4
XFILLER_108_877 VDD VSS VDD VSS gf180mcu_fd_sc_mcu7t5v0__fillcap_8
XFILLER_102_2 VDD VSS VDD VSS gf180mcu_fd_sc_mcu7t5v0__fillcap_32
XFILLER_122_302 VDD VSS VDD VSS gf180mcu_fd_sc_mcu7t5v0__fillcap_4
XFILLER_123_836 VDD VSS VDD VSS gf180mcu_fd_sc_mcu7t5v0__fillcap_4
XFILLER_1_632 VDD VSS VDD VSS gf180mcu_fd_sc_mcu7t5v0__fillcap_64
XFILLER_150_688 VDD VSS VDD VSS gf180mcu_fd_sc_mcu7t5v0__fillcap_4
XFILLER_89_772 VDD VSS VDD VSS gf180mcu_fd_sc_mcu7t5v0__fillcap_64
XFILLER_236_247 VDD VSS VDD VSS gf180mcu_fd_sc_mcu7t5v0__fillcap_64
XFILLER_251_206 VDD VSS VDD VSS gf180mcu_fd_sc_mcu7t5v0__fillcap_4
XFILLER_45_842 VDD VSS VDD VSS gf180mcu_fd_sc_mcu7t5v0__fillcap_32
XFILLER_72_661 VDD VSS VDD VSS gf180mcu_fd_sc_mcu7t5v0__fillcap_4
XFILLER_60_801 VDD VSS VDD VSS gf180mcu_fd_sc_mcu7t5v0__fillcap_4
XFILLER_204_177 VDD VSS VDD VSS gf180mcu_fd_sc_mcu7t5v0__fillcap_8
XFILLER_13_772 VDD VSS VDD VSS gf180mcu_fd_sc_mcu7t5v0__fillcap_64
X_2660_ VDD VSS _2745_/B2 wire55/Z _2202_/Z VDD VSS gf180mcu_fd_sc_mcu7t5v0__nor2_1
XFILLER_40_591 VDD VSS VDD VSS gf180mcu_fd_sc_mcu7t5v0__fillcap_4
X_1611_ VDD VSS _1611_/Z _3399_/Q _3375_/D VDD VSS gf180mcu_fd_sc_mcu7t5v0__and2_1
X_2591_ wire12/Z VDD VSS _3259_/D _3251_/Q _3259_/Q VDD VSS gf180mcu_fd_sc_mcu7t5v0__mux2_2
XFILLER_153_471 VDD VSS VDD VSS gf180mcu_fd_sc_mcu7t5v0__fillcap_4
X_1542_ VDD VSS _1543_/I _3449_/Q _1542_/A2 VDD VSS gf180mcu_fd_sc_mcu7t5v0__nand2_1
X_1473_ VDD VSS _3413_/D _3409_/Q _1473_/A2 VDD VSS gf180mcu_fd_sc_mcu7t5v0__xnor2_1
X_3212_ _3212_/D _3212_/Q _3344_/RN VSS _3212_/CLK VDD VDD VSS gf180mcu_fd_sc_mcu7t5v0__dffrnq_1
XFILLER_79_260 VDD VSS VDD VSS gf180mcu_fd_sc_mcu7t5v0__fillcap_8
XFILLER_101_508 VDD VSS VDD VSS gf180mcu_fd_sc_mcu7t5v0__fillcap_8
XFILLER_67_422 VDD VSS VDD VSS gf180mcu_fd_sc_mcu7t5v0__fillcap_64
Xclkbuf_4_6_0_host_clk_i _3434_/CLK VSS VDD clkbuf_0_host_clk_i/Z VDD VSS gf180mcu_fd_sc_mcu7t5v0__clkbuf_2
XFILLER_79_293 VDD VSS VDD VSS gf180mcu_fd_sc_mcu7t5v0__fillcap_16
XFILLER_228_737 VDD VSS VDD VSS gf180mcu_fd_sc_mcu7t5v0__fillcap_64
X_3143_ _3143_/D _3143_/Q wire147/Z VSS _3364_/CLK VDD VDD VSS gf180mcu_fd_sc_mcu7t5v0__dffrnq_1
XFILLER_94_241 VDD VSS VDD VSS gf180mcu_fd_sc_mcu7t5v0__fillcap_4
XFILLER_255_556 VDD VSS VDD VSS gf180mcu_fd_sc_mcu7t5v0__fillcap_4
X_3074_ _3074_/D _3074_/Q wire145/I VSS _3453_/CLK VDD VDD VSS gf180mcu_fd_sc_mcu7t5v0__dffrnq_1
X_2025_ VDD VSS _2025_/Z _2686_/A1 _2652_/A3 VDD VSS gf180mcu_fd_sc_mcu7t5v0__and2_1
XFILLER_35_352 VDD VSS VDD VSS gf180mcu_fd_sc_mcu7t5v0__fillcap_64
XFILLER_223_486 VDD VSS VDD VSS gf180mcu_fd_sc_mcu7t5v0__fillcap_4
XFILLER_50_311 VDD VSS VDD VSS gf180mcu_fd_sc_mcu7t5v0__fillcap_4
XFILLER_62_171 VDD VSS VDD VSS gf180mcu_fd_sc_mcu7t5v0__fillcap_4
X_2927_ VDD _2927_/Q _2932_/CLK VSS _2927_/D VDD VSS gf180mcu_fd_sc_mcu7t5v0__dffq_1
XFILLER_149_744 VDD VSS VDD VSS gf180mcu_fd_sc_mcu7t5v0__fillcap_16
XFILLER_108_107 VDD VSS VDD VSS gf180mcu_fd_sc_mcu7t5v0__fillcap_16
X_2858_ VDD _2858_/Q _2867_/CLK VSS _2858_/D VDD VSS gf180mcu_fd_sc_mcu7t5v0__dffq_1
Xhold220 _3389_/D VSS _3394_/Q VDD VDD VSS gf180mcu_fd_sc_mcu7t5v0__dlyc_1
X_1809_ _1814_/S VDD VSS _2879_/D _1864_/I0 _2879_/Q VDD VSS gf180mcu_fd_sc_mcu7t5v0__mux2_2
X_2789_ wire20/Z _3088_/Q VDD VSS _2790_/I _3336_/Q _2739_/S VDD VSS gf180mcu_fd_sc_mcu7t5v0__aoi22_1
Xhold231 _3460_/D VSS _3459_/Q VDD VDD VSS gf180mcu_fd_sc_mcu7t5v0__dlyc_1
XFILLER_117_696 VDD VSS VDD VSS gf180mcu_fd_sc_mcu7t5v0__fillcap_4
XFILLER_105_836 VDD VSS VDD VSS gf180mcu_fd_sc_mcu7t5v0__fillcap_4
XFILLER_98_591 VDD VSS VDD VSS gf180mcu_fd_sc_mcu7t5v0__fillcap_4
XFILLER_86_731 VDD VSS VDD VSS gf180mcu_fd_sc_mcu7t5v0__fillcap_4
XFILLER_218_247 VDD VSS VDD VSS gf180mcu_fd_sc_mcu7t5v0__fillcap_64
XFILLER_233_206 VDD VSS VDD VSS gf180mcu_fd_sc_mcu7t5v0__fillcap_4
XFILLER_27_842 VDD VSS VDD VSS gf180mcu_fd_sc_mcu7t5v0__fillcap_32
XFILLER_54_661 VDD VSS VDD VSS gf180mcu_fd_sc_mcu7t5v0__fillcap_4
XFILLER_42_801 VDD VSS VDD VSS gf180mcu_fd_sc_mcu7t5v0__fillcap_4
XFILLER_198_132 VDD VSS VDD VSS gf180mcu_fd_sc_mcu7t5v0__fillcap_16
XFILLER_201_147 VDD VSS VDD VSS gf180mcu_fd_sc_mcu7t5v0__fillcap_8
XFILLER_22_591 VDD VSS VDD VSS gf180mcu_fd_sc_mcu7t5v0__fillcap_4
XFILLER_10_731 VDD VSS VDD VSS gf180mcu_fd_sc_mcu7t5v0__fillcap_4
XFILLER_127_438 VDD VSS VDD VSS gf180mcu_fd_sc_mcu7t5v0__fillcap_8
XFILLER_5_212 VDD VSS VDD VSS gf180mcu_fd_sc_mcu7t5v0__fillcap_64
XFILLER_108_652 VDD VSS VDD VSS gf180mcu_fd_sc_mcu7t5v0__fillcap_8
XFILLER_182_588 VDD VSS VDD VSS gf180mcu_fd_sc_mcu7t5v0__fillcap_4
XFILLER_49_422 VDD VSS VDD VSS gf180mcu_fd_sc_mcu7t5v0__fillcap_64
XFILLER_237_556 VDD VSS VDD VSS gf180mcu_fd_sc_mcu7t5v0__fillcap_4
XFILLER_17_352 VDD VSS VDD VSS gf180mcu_fd_sc_mcu7t5v0__fillcap_64
XFILLER_32_311 VDD VSS VDD VSS gf180mcu_fd_sc_mcu7t5v0__fillcap_4
XFILLER_44_171 VDD VSS VDD VSS gf180mcu_fd_sc_mcu7t5v0__fillcap_4
XFILLER_9_562 VDD VSS VDD VSS gf180mcu_fd_sc_mcu7t5v0__fillcap_64
X_2712_ _3057_/Q VSS VDD _3041_/Q _3049_/Q _2730_/S0 _3033_/Q wire60/I _2712_/Z VDD
+ VSS gf180mcu_fd_sc_mcu7t5v0__mux4_1
XFILLER_145_202 VDD VSS VDD VSS gf180mcu_fd_sc_mcu7t5v0__fillcap_8
XFILLER_65_2 VDD VSS VDD VSS gf180mcu_fd_sc_mcu7t5v0__fillcap_64
X_2643_ wire46/Z VDD VSS _3306_/D _3264_/Q _3306_/Q VDD VSS gf180mcu_fd_sc_mcu7t5v0__mux2_2
X_2574_ wire12/I VDD VSS _3242_/D _3219_/Q _3242_/Q VDD VSS gf180mcu_fd_sc_mcu7t5v0__mux2_2
X_1525_ VDD VSS _3377_/D _3382_/Q _1525_/A2 VDD VSS gf180mcu_fd_sc_mcu7t5v0__xnor2_1
XFILLER_114_655 VDD VSS VDD VSS gf180mcu_fd_sc_mcu7t5v0__fillcap_8
XFILLER_259_136 VDD VSS VDD VSS gf180mcu_fd_sc_mcu7t5v0__fillcap_4
X_1456_ VDD VSS _1459_/A3 _3461_/D _3461_/Q VDD VSS gf180mcu_fd_sc_mcu7t5v0__nor2_1
XFILLER_68_731 VDD VSS VDD VSS gf180mcu_fd_sc_mcu7t5v0__fillcap_4
X_1387_ VDD VSS _3363_/D _1704_/A3 VDD VSS gf180mcu_fd_sc_mcu7t5v0__clkinv_1
X_3126_ _3126_/D _3126_/Q wire147/Z VSS _3202_/CLK VDD VDD VSS gf180mcu_fd_sc_mcu7t5v0__dffrnq_1
XFILLER_215_206 VDD VSS VDD VSS gf180mcu_fd_sc_mcu7t5v0__fillcap_4
XFILLER_36_661 VDD VSS VDD VSS gf180mcu_fd_sc_mcu7t5v0__fillcap_4
XFILLER_24_801 VDD VSS VDD VSS gf180mcu_fd_sc_mcu7t5v0__fillcap_4
X_3057_ VDD _3057_/Q _3059_/CLK VSS _3057_/D VDD VSS gf180mcu_fd_sc_mcu7t5v0__dffq_1
XFILLER_82_288 VDD VSS VDD VSS gf180mcu_fd_sc_mcu7t5v0__fillcap_16
X_2008_ _2009_/S VDD VSS _3051_/D wire114/Z _3051_/Q VDD VSS gf180mcu_fd_sc_mcu7t5v0__mux2_2
Xclkbuf_leaf_71_clk_i _3332_/CLK VSS VDD clkbuf_3_0__f_clk_i/Z VDD VSS gf180mcu_fd_sc_mcu7t5v0__clkbuf_2
XFILLER_136_224 VDD VSS VDD VSS gf180mcu_fd_sc_mcu7t5v0__fillcap_4
XFILLER_109_416 VDD VSS VDD VSS gf180mcu_fd_sc_mcu7t5v0__fillcap_4
XFILLER_191_341 VDD VSS VDD VSS gf180mcu_fd_sc_mcu7t5v0__fillcap_8
XFILLER_191_352 VDD VSS VDD VSS gf180mcu_fd_sc_mcu7t5v0__fillcap_16
XFILLER_117_471 VDD VSS VDD VSS gf180mcu_fd_sc_mcu7t5v0__fillcap_4
XFILLER_104_198 VDD VSS VDD VSS gf180mcu_fd_sc_mcu7t5v0__fillcap_4
XFILLER_58_241 VDD VSS VDD VSS gf180mcu_fd_sc_mcu7t5v0__fillcap_4
Xclkbuf_leaf_24_clk_i _3192_/CLK VSS VDD clkload4/I VDD VSS gf180mcu_fd_sc_mcu7t5v0__clkbuf_2
XFILLER_267_2 VDD VSS VDD VSS gf180mcu_fd_sc_mcu7t5v0__fillcap_64
XFILLER_132_85 VDD VSS VDD VSS gf180mcu_fd_sc_mcu7t5v0__fillcap_4
XFILLER_14_311 VDD VSS VDD VSS gf180mcu_fd_sc_mcu7t5v0__fillcap_4
XFILLER_26_171 VDD VSS VDD VSS gf180mcu_fd_sc_mcu7t5v0__fillcap_4
Xclkbuf_leaf_39_clk_i _2963_/CLK VSS VDD clkload5/I VDD VSS gf180mcu_fd_sc_mcu7t5v0__clkbuf_2
XFILLER_25_72 VDD VSS VDD VSS gf180mcu_fd_sc_mcu7t5v0__fillcap_64
XFILLER_183_842 VDD VSS VDD VSS gf180mcu_fd_sc_mcu7t5v0__fillcap_32
XFILLER_6_521 VDD VSS VDD VSS gf180mcu_fd_sc_mcu7t5v0__fillcap_4
XFILLER_151_772 VDD VSS VDD VSS gf180mcu_fd_sc_mcu7t5v0__fillcap_64
XFILLER_96_303 VDD VSS VDD VSS gf180mcu_fd_sc_mcu7t5v0__fillcap_8
X_2290_ VDD VSS _2322_/A1 _2477_/A2 _2234_/B VDD VSS gf180mcu_fd_sc_mcu7t5v0__nand2_1
XFILLER_96_325 VDD VSS VDD VSS gf180mcu_fd_sc_mcu7t5v0__fillcap_4
XFILLER_96_336 VDD VSS VDD VSS gf180mcu_fd_sc_mcu7t5v0__fillcap_8
XFILLER_111_614 VDD VSS VDD VSS gf180mcu_fd_sc_mcu7t5v0__fillcap_16
XFILLER_37_6 VDD VSS VDD VSS gf180mcu_fd_sc_mcu7t5v0__fillcap_64
XFILLER_18_661 VDD VSS VDD VSS gf180mcu_fd_sc_mcu7t5v0__fillcap_4
XFILLER_205_250 VDD VSS VDD VSS gf180mcu_fd_sc_mcu7t5v0__fillcap_8
XFILLER_92_597 VDD VSS VDD VSS gf180mcu_fd_sc_mcu7t5v0__fillcap_64
XFILLER_80_737 VDD VSS VDD VSS gf180mcu_fd_sc_mcu7t5v0__fillcap_64
X_2626_ _2626_/S VDD VSS _3289_/D _3247_/Q _3289_/Q VDD VSS gf180mcu_fd_sc_mcu7t5v0__mux2_2
XFILLER_173_352 VDD VSS VDD VSS gf180mcu_fd_sc_mcu7t5v0__fillcap_64
X_2557_ VDD VSS _2558_/S _2567_/B _2557_/A2 VDD VSS gf180mcu_fd_sc_mcu7t5v0__nand2_1
X_1508_ VDD VSS _3373_/D _3369_/Q _1508_/A2 VDD VSS gf180mcu_fd_sc_mcu7t5v0__xnor2_1
X_2488_ _2488_/B VDD VSS _2489_/I1 _2488_/A1 _2488_/A2 VDD VSS gf180mcu_fd_sc_mcu7t5v0__aoi21_1
XFILLER_141_282 VDD VSS VDD VSS gf180mcu_fd_sc_mcu7t5v0__fillcap_8
XFILLER_99_174 VDD VSS VDD VSS gf180mcu_fd_sc_mcu7t5v0__fillcap_4
X_1439_ VDD VSS _3149_/Q _2142_/A1 VDD VSS gf180mcu_fd_sc_mcu7t5v0__clkinv_1
X_3109_ _3109_/D _3109_/Q wire153/Z VSS _3109_/CLK VDD VDD VSS gf180mcu_fd_sc_mcu7t5v0__dffrnq_1
XFILLER_70_247 VDD VSS VDD VSS gf180mcu_fd_sc_mcu7t5v0__fillcap_64
XFILLER_62_37 VDD VSS VDD VSS gf180mcu_fd_sc_mcu7t5v0__fillcap_64
XFILLER_178_37 VDD VSS VDD VSS gf180mcu_fd_sc_mcu7t5v0__fillcap_8
XFILLER_168_157 VDD VSS VDD VSS gf180mcu_fd_sc_mcu7t5v0__fillcap_16
XFILLER_137_500 VDD VSS VDD VSS gf180mcu_fd_sc_mcu7t5v0__fillcap_4
XFILLER_165_842 VDD VSS VDD VSS gf180mcu_fd_sc_mcu7t5v0__fillcap_32
XFILLER_137_599 VDD VSS VDD VSS gf180mcu_fd_sc_mcu7t5v0__fillcap_16
XFILLER_180_801 VDD VSS VDD VSS gf180mcu_fd_sc_mcu7t5v0__fillcap_4
XFILLER_194_69 VDD VSS VDD VSS gf180mcu_fd_sc_mcu7t5v0__fillcap_16
XFILLER_133_772 VDD VSS VDD VSS gf180mcu_fd_sc_mcu7t5v0__fillcap_64
XFILLER_94_807 VDD VSS VDD VSS gf180mcu_fd_sc_mcu7t5v0__fillcap_64
XFILLER_261_142 VDD VSS VDD VSS gf180mcu_fd_sc_mcu7t5v0__fillcap_64
XFILLER_62_737 VDD VSS VDD VSS gf180mcu_fd_sc_mcu7t5v0__fillcap_64
XFILLER_74_597 VDD VSS VDD VSS gf180mcu_fd_sc_mcu7t5v0__fillcap_64
XFILLER_203_765 VDD VSS VDD VSS gf180mcu_fd_sc_mcu7t5v0__fillcap_4
XFILLER_199_282 VDD VSS VDD VSS gf180mcu_fd_sc_mcu7t5v0__fillcap_64
XFILLER_175_606 VDD VSS VDD VSS gf180mcu_fd_sc_mcu7t5v0__fillcap_16
X_1790_ _1795_/S VDD VSS _2863_/D _2863_/Q _1864_/I0 VDD VSS gf180mcu_fd_sc_mcu7t5v0__mux2_2
XFILLER_128_511 VDD VSS VDD VSS gf180mcu_fd_sc_mcu7t5v0__fillcap_8
XFILLER_30_667 VDD VSS VDD VSS gf180mcu_fd_sc_mcu7t5v0__fillcap_64
XFILLER_155_352 VDD VSS VDD VSS gf180mcu_fd_sc_mcu7t5v0__fillcap_4
XFILLER_155_374 VDD VSS VDD VSS gf180mcu_fd_sc_mcu7t5v0__fillcap_4
XFILLER_7_874 VDD VSS VDD VSS gf180mcu_fd_sc_mcu7t5v0__fillcap_16
XFILLER_143_547 VDD VSS VDD VSS gf180mcu_fd_sc_mcu7t5v0__fillcap_8
XFILLER_182_171 VDD VSS VDD VSS gf180mcu_fd_sc_mcu7t5v0__fillcap_4
XFILLER_155_396 VDD VSS VDD VSS gf180mcu_fd_sc_mcu7t5v0__fillcap_16
X_3460_ _3460_/D _3461_/D wire163/Z VSS _3461_/CLK VDD VDD VSS gf180mcu_fd_sc_mcu7t5v0__dffrnq_1
X_3391_ _3391_/D _3391_/Q _3403_/RN VSS _3392_/CLK VDD VDD VSS gf180mcu_fd_sc_mcu7t5v0__dffrnq_1
X_2411_ VDD VSS _2424_/B _3200_/Q _2467_/A1 VDD VSS gf180mcu_fd_sc_mcu7t5v0__nand2_1
X_2342_ _2342_/A3 _2364_/B VDD VSS _2358_/A3 _1654_/Z _1693_/C VDD VSS gf180mcu_fd_sc_mcu7t5v0__nor4_1
XFILLER_111_422 VDD VSS VDD VSS gf180mcu_fd_sc_mcu7t5v0__fillcap_4
XFILLER_97_623 VDD VSS VDD VSS gf180mcu_fd_sc_mcu7t5v0__fillcap_4
XFILLER_151_591 VDD VSS VDD VSS gf180mcu_fd_sc_mcu7t5v0__fillcap_16
XFILLER_123_282 VDD VSS VDD VSS gf180mcu_fd_sc_mcu7t5v0__fillcap_4
X_2273_ _2478_/A1 VDD VSS _2274_/B _2367_/A2 _2268_/C VDD VSS gf180mcu_fd_sc_mcu7t5v0__nor3_1
XFILLER_84_317 VDD VSS VDD VSS gf180mcu_fd_sc_mcu7t5v0__fillcap_64
XFILLER_96_177 VDD VSS VDD VSS gf180mcu_fd_sc_mcu7t5v0__fillcap_16
XFILLER_253_632 VDD VSS VDD VSS gf180mcu_fd_sc_mcu7t5v0__fillcap_64
XFILLER_265_492 VDD VSS VDD VSS gf180mcu_fd_sc_mcu7t5v0__fillcap_64
XFILLER_52_247 VDD VSS VDD VSS gf180mcu_fd_sc_mcu7t5v0__fillcap_64
XFILLER_221_584 VDD VSS VDD VSS gf180mcu_fd_sc_mcu7t5v0__fillcap_8
XFILLER_221_562 VDD VSS VDD VSS gf180mcu_fd_sc_mcu7t5v0__fillcap_4
XFILLER_178_488 VDD VSS VDD VSS gf180mcu_fd_sc_mcu7t5v0__fillcap_32
XFILLER_147_842 VDD VSS VDD VSS gf180mcu_fd_sc_mcu7t5v0__fillcap_32
XFILLER_20_177 VDD VSS VDD VSS gf180mcu_fd_sc_mcu7t5v0__fillcap_64
X_1988_ _1991_/S VDD VSS _3033_/D _3033_/Q _2015_/I0 VDD VSS gf180mcu_fd_sc_mcu7t5v0__mux2_2
XFILLER_174_661 VDD VSS VDD VSS gf180mcu_fd_sc_mcu7t5v0__fillcap_4
XFILLER_162_801 VDD VSS VDD VSS gf180mcu_fd_sc_mcu7t5v0__fillcap_4
X_2609_ _2619_/S VDD VSS _3275_/D _3235_/Q _3275_/Q VDD VSS gf180mcu_fd_sc_mcu7t5v0__mux2_2
XFILLER_115_772 VDD VSS VDD VSS gf180mcu_fd_sc_mcu7t5v0__fillcap_64
XFILLER_76_807 VDD VSS VDD VSS gf180mcu_fd_sc_mcu7t5v0__fillcap_64
XFILLER_88_667 VDD VSS VDD VSS gf180mcu_fd_sc_mcu7t5v0__fillcap_64
XFILLER_180_49 VDD VSS VDD VSS gf180mcu_fd_sc_mcu7t5v0__fillcap_32
XFILLER_113_54 VDD VSS VDD VSS gf180mcu_fd_sc_mcu7t5v0__fillcap_16
XFILLER_243_142 VDD VSS VDD VSS gf180mcu_fd_sc_mcu7t5v0__fillcap_64
XFILLER_56_597 VDD VSS VDD VSS gf180mcu_fd_sc_mcu7t5v0__fillcap_64
XFILLER_44_737 VDD VSS VDD VSS gf180mcu_fd_sc_mcu7t5v0__fillcap_64
XFILLER_188_219 VDD VSS VDD VSS gf180mcu_fd_sc_mcu7t5v0__fillcap_4
XFILLER_71_556 VDD VSS VDD VSS gf180mcu_fd_sc_mcu7t5v0__fillcap_4
XFILLER_169_422 VDD VSS VDD VSS gf180mcu_fd_sc_mcu7t5v0__fillcap_4
Xwire92 VSS wire92/Z wire92/I VDD VDD VSS gf180mcu_fd_sc_mcu7t5v0__buf_1
XFILLER_240_871 VDD VSS VDD VSS gf180mcu_fd_sc_mcu7t5v0__fillcap_4
XFILLER_200_724 VDD VSS VDD VSS gf180mcu_fd_sc_mcu7t5v0__fillcap_8
XFILLER_200_713 VDD VSS VDD VSS gf180mcu_fd_sc_mcu7t5v0__fillcap_4
XFILLER_196_241 VDD VSS VDD VSS gf180mcu_fd_sc_mcu7t5v0__fillcap_4
XFILLER_184_403 VDD VSS VDD VSS gf180mcu_fd_sc_mcu7t5v0__fillcap_8
XFILLER_12_667 VDD VSS VDD VSS gf180mcu_fd_sc_mcu7t5v0__fillcap_64
XFILLER_132_2 VDD VSS VDD VSS gf180mcu_fd_sc_mcu7t5v0__fillcap_32
XFILLER_192_491 VDD VSS VDD VSS gf180mcu_fd_sc_mcu7t5v0__fillcap_4
XFILLER_164_160 VDD VSS VDD VSS gf180mcu_fd_sc_mcu7t5v0__fillcap_8
XFILLER_4_877 VDD VSS VDD VSS gf180mcu_fd_sc_mcu7t5v0__fillcap_8
XFILLER_267_702 VDD VSS VDD VSS gf180mcu_fd_sc_mcu7t5v0__fillcap_64
XFILLER_105_260 VDD VSS VDD VSS gf180mcu_fd_sc_mcu7t5v0__fillcap_4
XFILLER_78_111 VDD VSS VDD VSS gf180mcu_fd_sc_mcu7t5v0__fillcap_64
XFILLER_120_230 VDD VSS VDD VSS gf180mcu_fd_sc_mcu7t5v0__fillcap_4
XFILLER_120_263 VDD VSS VDD VSS gf180mcu_fd_sc_mcu7t5v0__fillcap_4
XFILLER_66_317 VDD VSS VDD VSS gf180mcu_fd_sc_mcu7t5v0__fillcap_64
XFILLER_78_177 VDD VSS VDD VSS gf180mcu_fd_sc_mcu7t5v0__fillcap_16
XFILLER_235_632 VDD VSS VDD VSS gf180mcu_fd_sc_mcu7t5v0__fillcap_64
XFILLER_247_492 VDD VSS VDD VSS gf180mcu_fd_sc_mcu7t5v0__fillcap_64
XFILLER_93_158 VDD VSS VDD VSS gf180mcu_fd_sc_mcu7t5v0__fillcap_4
XFILLER_262_451 VDD VSS VDD VSS gf180mcu_fd_sc_mcu7t5v0__fillcap_4
XFILLER_34_247 VDD VSS VDD VSS gf180mcu_fd_sc_mcu7t5v0__fillcap_64
X_2960_ VDD _2960_/Q _3415_/CLK VSS _2960_/D VDD VSS gf180mcu_fd_sc_mcu7t5v0__dffq_1
X_2891_ VDD _2891_/Q _2900_/CLK VSS _2891_/D VDD VSS gf180mcu_fd_sc_mcu7t5v0__dffq_1
XFILLER_203_562 VDD VSS VDD VSS gf180mcu_fd_sc_mcu7t5v0__fillcap_16
X_1911_ _1917_/S VDD VSS _2966_/D _2966_/Q wire123/Z VDD VSS gf180mcu_fd_sc_mcu7t5v0__mux2_2
X_1842_ _1842_/S VDD VSS _2908_/D _1869_/I0 _2908_/Q VDD VSS gf180mcu_fd_sc_mcu7t5v0__mux2_2
XFILLER_230_381 VDD VSS VDD VSS gf180mcu_fd_sc_mcu7t5v0__fillcap_4
XFILLER_129_842 VDD VSS VDD VSS gf180mcu_fd_sc_mcu7t5v0__fillcap_32
XFILLER_156_661 VDD VSS VDD VSS gf180mcu_fd_sc_mcu7t5v0__fillcap_4
XFILLER_144_801 VDD VSS VDD VSS gf180mcu_fd_sc_mcu7t5v0__fillcap_4
X_1773_ _1777_/S VDD VSS _2848_/D wire133/I _2848_/Q VDD VSS gf180mcu_fd_sc_mcu7t5v0__mux2_2
X_3443_ _3443_/D _3443_/Q wire161/I VSS _3443_/CLK VDD VDD VSS gf180mcu_fd_sc_mcu7t5v0__dffrnq_1
XFILLER_170_185 VDD VSS VDD VSS gf180mcu_fd_sc_mcu7t5v0__fillcap_4
X_3374_ _3374_/D _3392_/D _3403_/RN VSS _3403_/CLK VDD VDD VSS gf180mcu_fd_sc_mcu7t5v0__dffrnq_1
XFILLER_257_212 VDD VSS VDD VSS gf180mcu_fd_sc_mcu7t5v0__fillcap_64
XFILLER_58_807 VDD VSS VDD VSS gf180mcu_fd_sc_mcu7t5v0__fillcap_64
X_2325_ _1716_/B VDD VSS _2348_/A2 _3205_/Q _1699_/Z VDD VSS gf180mcu_fd_sc_mcu7t5v0__nand3_1
XFILLER_111_241 VDD VSS VDD VSS gf180mcu_fd_sc_mcu7t5v0__fillcap_16
XFILLER_85_626 VDD VSS VDD VSS gf180mcu_fd_sc_mcu7t5v0__fillcap_4
X_2256_ _2256_/A3 VDD VSS _2258_/B1 _3382_/Q _2256_/A2 VDD VSS gf180mcu_fd_sc_mcu7t5v0__nand3_1
XFILLER_225_142 VDD VSS VDD VSS gf180mcu_fd_sc_mcu7t5v0__fillcap_64
X_2187_ _2187_/A3 VDD VSS _2189_/S _1582_/C _2187_/A2 VDD VSS gf180mcu_fd_sc_mcu7t5v0__and3_1
XFILLER_38_597 VDD VSS VDD VSS gf180mcu_fd_sc_mcu7t5v0__fillcap_64
XFILLER_26_737 VDD VSS VDD VSS gf180mcu_fd_sc_mcu7t5v0__fillcap_64
XFILLER_213_326 VDD VSS VDD VSS gf180mcu_fd_sc_mcu7t5v0__fillcap_16
XFILLER_240_101 VDD VSS VDD VSS gf180mcu_fd_sc_mcu7t5v0__fillcap_4
XFILLER_53_556 VDD VSS VDD VSS gf180mcu_fd_sc_mcu7t5v0__fillcap_4
XFILLER_222_871 VDD VSS VDD VSS gf180mcu_fd_sc_mcu7t5v0__fillcap_4
XFILLER_194_745 VDD VSS VDD VSS gf180mcu_fd_sc_mcu7t5v0__fillcap_4
XFILLER_21_486 VDD VSS VDD VSS gf180mcu_fd_sc_mcu7t5v0__fillcap_4
XFILLER_239_72 VDD VSS VDD VSS gf180mcu_fd_sc_mcu7t5v0__fillcap_64
XFILLER_175_27 VDD VSS VDD VSS gf180mcu_fd_sc_mcu7t5v0__fillcap_4
XFILLER_4_107 VDD VSS VDD VSS gf180mcu_fd_sc_mcu7t5v0__fillcap_64
XFILLER_134_377 VDD VSS VDD VSS gf180mcu_fd_sc_mcu7t5v0__fillcap_8
XFILLER_249_702 VDD VSS VDD VSS gf180mcu_fd_sc_mcu7t5v0__fillcap_64
XFILLER_1_836 VDD VSS VDD VSS gf180mcu_fd_sc_mcu7t5v0__fillcap_4
XFILLER_108_76 VDD VSS VDD VSS gf180mcu_fd_sc_mcu7t5v0__fillcap_4
XFILLER_48_317 VDD VSS VDD VSS gf180mcu_fd_sc_mcu7t5v0__fillcap_64
XFILLER_217_632 VDD VSS VDD VSS gf180mcu_fd_sc_mcu7t5v0__fillcap_64
XFILLER_229_492 VDD VSS VDD VSS gf180mcu_fd_sc_mcu7t5v0__fillcap_64
XFILLER_124_86 VDD VSS VDD VSS gf180mcu_fd_sc_mcu7t5v0__fillcap_16
XFILLER_244_451 VDD VSS VDD VSS gf180mcu_fd_sc_mcu7t5v0__fillcap_4
XFILLER_84_68 VDD VSS VDD VSS gf180mcu_fd_sc_mcu7t5v0__fillcap_4
XFILLER_16_247 VDD VSS VDD VSS gf180mcu_fd_sc_mcu7t5v0__fillcap_64
XFILLER_90_139 VDD VSS VDD VSS gf180mcu_fd_sc_mcu7t5v0__fillcap_16
XFILLER_31_206 VDD VSS VDD VSS gf180mcu_fd_sc_mcu7t5v0__fillcap_4
XFILLER_140_96 VDD VSS VDD VSS gf180mcu_fd_sc_mcu7t5v0__fillcap_8
XFILLER_200_510 VDD VSS VDD VSS gf180mcu_fd_sc_mcu7t5v0__fillcap_8
XFILLER_149_50 VDD VSS VDD VSS gf180mcu_fd_sc_mcu7t5v0__fillcap_16
XFILLER_184_233 VDD VSS VDD VSS gf180mcu_fd_sc_mcu7t5v0__fillcap_4
XFILLER_33_72 VDD VSS VDD VSS gf180mcu_fd_sc_mcu7t5v0__fillcap_64
XFILLER_200_576 VDD VSS VDD VSS gf180mcu_fd_sc_mcu7t5v0__fillcap_16
XFILLER_149_72 VDD VSS VDD VSS gf180mcu_fd_sc_mcu7t5v0__fillcap_64
XFILLER_8_457 VDD VSS VDD VSS gf180mcu_fd_sc_mcu7t5v0__fillcap_64
XFILLER_126_801 VDD VSS VDD VSS gf180mcu_fd_sc_mcu7t5v0__fillcap_4
XFILLER_239_212 VDD VSS VDD VSS gf180mcu_fd_sc_mcu7t5v0__fillcap_64
XFILLER_106_591 VDD VSS VDD VSS gf180mcu_fd_sc_mcu7t5v0__fillcap_4
XFILLER_67_626 VDD VSS VDD VSS gf180mcu_fd_sc_mcu7t5v0__fillcap_4
X_2110_ VDD _3111_/D _2110_/B _3111_/Q _2110_/A2 VSS _2111_/A2 VDD VSS gf180mcu_fd_sc_mcu7t5v0__oai31_1
XFILLER_79_486 VDD VSS VDD VSS gf180mcu_fd_sc_mcu7t5v0__fillcap_4
X_3090_ _3090_/D _3090_/Q _3335_/RN VSS _3454_/CLK VDD VDD VSS gf180mcu_fd_sc_mcu7t5v0__dffrnq_1
X_2041_ wire28/Z VDD VSS _3074_/D wire88/I _3074_/Q VDD VSS gf180mcu_fd_sc_mcu7t5v0__mux2_2
XFILLER_207_142 VDD VSS VDD VSS gf180mcu_fd_sc_mcu7t5v0__fillcap_16
XFILLER_222_101 VDD VSS VDD VSS gf180mcu_fd_sc_mcu7t5v0__fillcap_4
XFILLER_35_556 VDD VSS VDD VSS gf180mcu_fd_sc_mcu7t5v0__fillcap_4
XFILLER_204_871 VDD VSS VDD VSS gf180mcu_fd_sc_mcu7t5v0__fillcap_4
X_2943_ VDD _2943_/Q _3181_/CLK VSS _2943_/D VDD VSS gf180mcu_fd_sc_mcu7t5v0__dffq_1
XFILLER_203_381 VDD VSS VDD VSS gf180mcu_fd_sc_mcu7t5v0__fillcap_4
X_2874_ VDD _2874_/Q _3370_/CLK VSS _2874_/D VDD VSS gf180mcu_fd_sc_mcu7t5v0__dffq_1
XFILLER_175_244 VDD VSS VDD VSS gf180mcu_fd_sc_mcu7t5v0__fillcap_8
X_1825_ _1832_/S VDD VSS _2893_/D _2893_/Q wire137/Z VDD VSS gf180mcu_fd_sc_mcu7t5v0__mux2_2
X_1756_ _1758_/S VDD VSS _2834_/D _3124_/Q _2834_/Q VDD VSS gf180mcu_fd_sc_mcu7t5v0__mux2_2
XFILLER_191_759 VDD VSS VDD VSS gf180mcu_fd_sc_mcu7t5v0__fillcap_8
XFILLER_190_247 VDD VSS VDD VSS gf180mcu_fd_sc_mcu7t5v0__fillcap_8
X_1687_ VDD VSS _2239_/B _2278_/A2 _2482_/A2 VDD VSS gf180mcu_fd_sc_mcu7t5v0__nand2_1
X_3426_ _3426_/D _3426_/Q wire161/I VSS _3427_/CLK VDD VDD VSS gf180mcu_fd_sc_mcu7t5v0__dffrnq_1
XFILLER_258_521 VDD VSS VDD VSS gf180mcu_fd_sc_mcu7t5v0__fillcap_4
X_3357_ VSS _3357_/CLK VDD _3357_/D _3358_/D wire153/I VDD VSS gf180mcu_fd_sc_mcu7t5v0__dffsnq_1
X_2308_ VDD VSS _2470_/A2 _1683_/Z _2482_/A2 VDD VSS gf180mcu_fd_sc_mcu7t5v0__nor2_1
X_3288_ _3288_/D _3288_/Q wire147/I VSS _3288_/CLK VDD VDD VSS gf180mcu_fd_sc_mcu7t5v0__dffrnq_1
XFILLER_57_136 VDD VSS VDD VSS gf180mcu_fd_sc_mcu7t5v0__fillcap_4
XFILLER_226_451 VDD VSS VDD VSS gf180mcu_fd_sc_mcu7t5v0__fillcap_4
X_2239_ _2239_/B _2239_/C VDD VSS _2240_/C _2367_/A2 _2239_/A2 VDD VSS gf180mcu_fd_sc_mcu7t5v0__aoi211_1
XFILLER_13_206 VDD VSS VDD VSS gf180mcu_fd_sc_mcu7t5v0__fillcap_4
XFILLER_139_414 VDD VSS VDD VSS gf180mcu_fd_sc_mcu7t5v0__fillcap_4
XFILLER_70_37 VDD VSS VDD VSS gf180mcu_fd_sc_mcu7t5v0__fillcap_64
XFILLER_210_885 VDD VSS VDD VSS gf180mcu_fd_sc_mcu7t5v0__fillcap_4
XFILLER_194_575 VDD VSS VDD VSS gf180mcu_fd_sc_mcu7t5v0__fillcap_16
XFILLER_108_801 VDD VSS VDD VSS gf180mcu_fd_sc_mcu7t5v0__fillcap_4
XFILLER_182_737 VDD VSS VDD VSS gf180mcu_fd_sc_mcu7t5v0__fillcap_64
XFILLER_181_203 VDD VSS VDD VSS gf180mcu_fd_sc_mcu7t5v0__fillcap_4
XFILLER_107_322 VDD VSS VDD VSS gf180mcu_fd_sc_mcu7t5v0__fillcap_4
XFILLER_5_416 VDD VSS VDD VSS gf180mcu_fd_sc_mcu7t5v0__fillcap_4
XFILLER_134_141 VDD VSS VDD VSS gf180mcu_fd_sc_mcu7t5v0__fillcap_32
XFILLER_181_269 VDD VSS VDD VSS gf180mcu_fd_sc_mcu7t5v0__fillcap_8
XFILLER_135_96 VDD VSS VDD VSS gf180mcu_fd_sc_mcu7t5v0__fillcap_4
XFILLER_49_626 VDD VSS VDD VSS gf180mcu_fd_sc_mcu7t5v0__fillcap_4
XFILLER_151_95 VDD VSS VDD VSS gf180mcu_fd_sc_mcu7t5v0__fillcap_4
XFILLER_17_556 VDD VSS VDD VSS gf180mcu_fd_sc_mcu7t5v0__fillcap_4
XFILLER_204_145 VDD VSS VDD VSS gf180mcu_fd_sc_mcu7t5v0__fillcap_8
XFILLER_201_874 VDD VSS VDD VSS gf180mcu_fd_sc_mcu7t5v0__fillcap_16
XFILLER_157_244 VDD VSS VDD VSS gf180mcu_fd_sc_mcu7t5v0__fillcap_4
XFILLER_9_766 VDD VSS VDD VSS gf180mcu_fd_sc_mcu7t5v0__fillcap_4
X_1610_ VDD VSS _1613_/C _3400_/Q _3371_/D VDD VSS gf180mcu_fd_sc_mcu7t5v0__xor2_1
XFILLER_172_247 VDD VSS VDD VSS gf180mcu_fd_sc_mcu7t5v0__fillcap_16
XFILLER_126_642 VDD VSS VDD VSS gf180mcu_fd_sc_mcu7t5v0__fillcap_8
X_2590_ wire12/I VDD VSS _3258_/D _3250_/Q _3258_/Q VDD VSS gf180mcu_fd_sc_mcu7t5v0__mux2_2
XFILLER_125_130 VDD VSS VDD VSS gf180mcu_fd_sc_mcu7t5v0__fillcap_4
X_1541_ VDD _3455_/Q _1540_/Z _1542_/A2 _3061_/Q VSS VDD VSS gf180mcu_fd_sc_mcu7t5v0__oai21_1
XFILLER_125_196 VDD VSS VDD VSS gf180mcu_fd_sc_mcu7t5v0__fillcap_4
X_1472_ VDD VSS _3409_/D _3409_/Q _1465_/Z VDD VSS gf180mcu_fd_sc_mcu7t5v0__xor2_1
XFILLER_268_852 VDD VSS VDD VSS gf180mcu_fd_sc_mcu7t5v0__fillcap_32
X_3211_ _3211_/D _3211_/Q _3344_/RN VSS _3211_/CLK VDD VDD VSS gf180mcu_fd_sc_mcu7t5v0__dffrnq_1
X_3142_ _3142_/D _3142_/Q wire147/Z VSS _3364_/CLK VDD VDD VSS gf180mcu_fd_sc_mcu7t5v0__dffrnq_1
XFILLER_10_2 VDD VSS VDD VSS gf180mcu_fd_sc_mcu7t5v0__fillcap_32
XFILLER_39_136 VDD VSS VDD VSS gf180mcu_fd_sc_mcu7t5v0__fillcap_4
X_3073_ _3073_/D _3073_/Q _3452_/RN VSS _3281_/CLK VDD VDD VSS gf180mcu_fd_sc_mcu7t5v0__dffrnq_1
X_2024_ _3270_/Q VDD VSS _2652_/A3 _3269_/Q _3268_/Q VDD VSS gf180mcu_fd_sc_mcu7t5v0__nor3_1
XFILLER_196_807 VDD VSS VDD VSS gf180mcu_fd_sc_mcu7t5v0__fillcap_64
XFILLER_211_65 VDD VSS VDD VSS gf180mcu_fd_sc_mcu7t5v0__fillcap_4
X_2926_ VDD _2926_/Q _2931_/CLK VSS _2926_/D VDD VSS gf180mcu_fd_sc_mcu7t5v0__dffq_1
XFILLER_188_380 VDD VSS VDD VSS gf180mcu_fd_sc_mcu7t5v0__fillcap_4
X_2857_ VDD _2857_/Q _3369_/CLK VSS _2857_/D VDD VSS gf180mcu_fd_sc_mcu7t5v0__dffq_1
X_1808_ _1814_/S VDD VSS _2878_/D _1863_/I0 _2878_/Q VDD VSS gf180mcu_fd_sc_mcu7t5v0__mux2_2
XFILLER_176_597 VDD VSS VDD VSS gf180mcu_fd_sc_mcu7t5v0__fillcap_16
XFILLER_164_737 VDD VSS VDD VSS gf180mcu_fd_sc_mcu7t5v0__fillcap_64
Xhold210 _3428_/D VSS _3433_/Q VDD VDD VSS gf180mcu_fd_sc_mcu7t5v0__dlyc_1
X_2788_ VDD VSS _3335_/D wire10/Z _2788_/A2 VDD VSS gf180mcu_fd_sc_mcu7t5v0__nand2_1
X_1739_ VDD VSS _1852_/A1 _3368_/Q _1739_/A2 VDD VSS gf180mcu_fd_sc_mcu7t5v0__nor2_1
Xhold221 _3437_/D VSS _3442_/Q VDD VDD VSS gf180mcu_fd_sc_mcu7t5v0__dlyc_1
X_3409_ _3409_/D _3409_/Q wire163/Z VSS _3409_/CLK VDD VDD VSS gf180mcu_fd_sc_mcu7t5v0__dffrnq_1
XFILLER_120_807 VDD VSS VDD VSS gf180mcu_fd_sc_mcu7t5v0__fillcap_64
XFILLER_132_667 VDD VSS VDD VSS gf180mcu_fd_sc_mcu7t5v0__fillcap_8
XFILLER_259_874 VDD VSS VDD VSS gf180mcu_fd_sc_mcu7t5v0__fillcap_16
XFILLER_100_597 VDD VSS VDD VSS gf180mcu_fd_sc_mcu7t5v0__fillcap_8
XFILLER_81_492 VDD VSS VDD VSS gf180mcu_fd_sc_mcu7t5v0__fillcap_64
XFILLER_201_115 VDD VSS VDD VSS gf180mcu_fd_sc_mcu7t5v0__fillcap_4
XFILLER_198_177 VDD VSS VDD VSS gf180mcu_fd_sc_mcu7t5v0__fillcap_8
XFILLER_186_317 VDD VSS VDD VSS gf180mcu_fd_sc_mcu7t5v0__fillcap_4
XFILLER_212_2 VDD VSS VDD VSS gf180mcu_fd_sc_mcu7t5v0__fillcap_16
XFILLER_139_299 VDD VSS VDD VSS gf180mcu_fd_sc_mcu7t5v0__fillcap_4
XFILLER_182_556 VDD VSS VDD VSS gf180mcu_fd_sc_mcu7t5v0__fillcap_32
XFILLER_268_104 VDD VSS VDD VSS gf180mcu_fd_sc_mcu7t5v0__fillcap_32
XFILLER_122_100 VDD VSS VDD VSS gf180mcu_fd_sc_mcu7t5v0__fillcap_4
XFILLER_162_94 VDD VSS VDD VSS gf180mcu_fd_sc_mcu7t5v0__fillcap_8
XFILLER_264_387 VDD VSS VDD VSS gf180mcu_fd_sc_mcu7t5v0__fillcap_64
XFILLER_252_527 VDD VSS VDD VSS gf180mcu_fd_sc_mcu7t5v0__fillcap_64
XFILLER_91_212 VDD VSS VDD VSS gf180mcu_fd_sc_mcu7t5v0__fillcap_16
XFILLER_205_454 VDD VSS VDD VSS gf180mcu_fd_sc_mcu7t5v0__fillcap_4
XFILLER_178_807 VDD VSS VDD VSS gf180mcu_fd_sc_mcu7t5v0__fillcap_64
XFILLER_189_133 VDD VSS VDD VSS gf180mcu_fd_sc_mcu7t5v0__fillcap_4
XFILLER_177_328 VDD VSS VDD VSS gf180mcu_fd_sc_mcu7t5v0__fillcap_16
XFILLER_220_457 VDD VSS VDD VSS gf180mcu_fd_sc_mcu7t5v0__fillcap_16
X_2711_ _3025_/Q VSS VDD _3009_/Q _3017_/Q _2743_/S0 _3001_/Q _2743_/S1 _2711_/Z VDD
+ VSS gf180mcu_fd_sc_mcu7t5v0__mux4_1
XFILLER_158_597 VDD VSS VDD VSS gf180mcu_fd_sc_mcu7t5v0__fillcap_64
XFILLER_146_737 VDD VSS VDD VSS gf180mcu_fd_sc_mcu7t5v0__fillcap_64
X_2642_ _2642_/S VDD VSS _3305_/D _3263_/Q _3305_/Q VDD VSS gf180mcu_fd_sc_mcu7t5v0__mux2_2
X_2573_ wire12/Z VDD VSS _3241_/D wire100/Z _3241_/Q VDD VSS gf180mcu_fd_sc_mcu7t5v0__mux2_2
XFILLER_58_2 VDD VSS VDD VSS gf180mcu_fd_sc_mcu7t5v0__fillcap_32
X_1524_ VDD VSS _3382_/D _1522_/Z _1529_/A2 VDD VSS gf180mcu_fd_sc_mcu7t5v0__nor2_1
XFILLER_160_228 VDD VSS VDD VSS gf180mcu_fd_sc_mcu7t5v0__fillcap_4
XFILLER_102_807 VDD VSS VDD VSS gf180mcu_fd_sc_mcu7t5v0__fillcap_64
XFILLER_114_667 VDD VSS VDD VSS gf180mcu_fd_sc_mcu7t5v0__fillcap_64
XFILLER_141_486 VDD VSS VDD VSS gf180mcu_fd_sc_mcu7t5v0__fillcap_4
X_1455_ VDD VSS _3406_/Q _1465_/A4 VDD VSS gf180mcu_fd_sc_mcu7t5v0__clkinv_1
XFILLER_113_199 VDD VSS VDD VSS gf180mcu_fd_sc_mcu7t5v0__fillcap_8
XFILLER_268_682 VDD VSS VDD VSS gf180mcu_fd_sc_mcu7t5v0__fillcap_32
X_1386_ VDD VSS _3362_/D _2469_/A1 VDD VSS gf180mcu_fd_sc_mcu7t5v0__clkinv_1
XFILLER_256_877 VDD VSS VDD VSS gf180mcu_fd_sc_mcu7t5v0__fillcap_8
Xclkbuf_leaf_5_clk_i _3281_/CLK VSS VDD clkload0/I VDD VSS gf180mcu_fd_sc_mcu7t5v0__clkbuf_2
X_3125_ _3125_/D _3125_/Q wire147/Z VSS _3182_/CLK VDD VDD VSS gf180mcu_fd_sc_mcu7t5v0__dffrnq_1
XFILLER_95_562 VDD VSS VDD VSS gf180mcu_fd_sc_mcu7t5v0__fillcap_8
XFILLER_83_702 VDD VSS VDD VSS gf180mcu_fd_sc_mcu7t5v0__fillcap_64
X_3056_ VDD _3056_/Q _3058_/CLK VSS _3056_/D VDD VSS gf180mcu_fd_sc_mcu7t5v0__dffq_1
X_2007_ _2009_/S VDD VSS _3050_/D wire116/Z _3050_/Q VDD VSS gf180mcu_fd_sc_mcu7t5v0__mux2_2
XFILLER_63_492 VDD VSS VDD VSS gf180mcu_fd_sc_mcu7t5v0__fillcap_64
XFILLER_51_632 VDD VSS VDD VSS gf180mcu_fd_sc_mcu7t5v0__fillcap_64
XFILLER_168_317 VDD VSS VDD VSS gf180mcu_fd_sc_mcu7t5v0__fillcap_16
XFILLER_149_586 VDD VSS VDD VSS gf180mcu_fd_sc_mcu7t5v0__fillcap_4
X_2909_ VDD _2909_/Q _2931_/CLK VSS _2909_/D VDD VSS gf180mcu_fd_sc_mcu7t5v0__dffq_1
XFILLER_136_247 VDD VSS VDD VSS gf180mcu_fd_sc_mcu7t5v0__fillcap_64
XFILLER_247_72 VDD VSS VDD VSS gf180mcu_fd_sc_mcu7t5v0__fillcap_64
XFILLER_151_239 VDD VSS VDD VSS gf180mcu_fd_sc_mcu7t5v0__fillcap_32
XFILLER_105_667 VDD VSS VDD VSS gf180mcu_fd_sc_mcu7t5v0__fillcap_4
XFILLER_104_177 VDD VSS VDD VSS gf180mcu_fd_sc_mcu7t5v0__fillcap_4
XFILLER_246_387 VDD VSS VDD VSS gf180mcu_fd_sc_mcu7t5v0__fillcap_64
XFILLER_234_527 VDD VSS VDD VSS gf180mcu_fd_sc_mcu7t5v0__fillcap_64
XFILLER_73_212 VDD VSS VDD VSS gf180mcu_fd_sc_mcu7t5v0__fillcap_8
XFILLER_261_346 VDD VSS VDD VSS gf180mcu_fd_sc_mcu7t5v0__fillcap_4
XFILLER_162_2 VDD VSS VDD VSS gf180mcu_fd_sc_mcu7t5v0__fillcap_32
XFILLER_187_648 VDD VSS VDD VSS gf180mcu_fd_sc_mcu7t5v0__fillcap_8
XFILLER_41_142 VDD VSS VDD VSS gf180mcu_fd_sc_mcu7t5v0__fillcap_64
XFILLER_128_737 VDD VSS VDD VSS gf180mcu_fd_sc_mcu7t5v0__fillcap_64
XFILLER_155_556 VDD VSS VDD VSS gf180mcu_fd_sc_mcu7t5v0__fillcap_4
XFILLER_127_236 VDD VSS VDD VSS gf180mcu_fd_sc_mcu7t5v0__fillcap_16
XFILLER_41_72 VDD VSS VDD VSS gf180mcu_fd_sc_mcu7t5v0__fillcap_64
XFILLER_143_718 VDD VSS VDD VSS gf180mcu_fd_sc_mcu7t5v0__fillcap_8
XFILLER_157_72 VDD VSS VDD VSS gf180mcu_fd_sc_mcu7t5v0__fillcap_16
XFILLER_108_450 VDD VSS VDD VSS gf180mcu_fd_sc_mcu7t5v0__fillcap_4
XFILLER_123_486 VDD VSS VDD VSS gf180mcu_fd_sc_mcu7t5v0__fillcap_4
XFILLER_256_107 VDD VSS VDD VSS gf180mcu_fd_sc_mcu7t5v0__fillcap_64
XFILLER_1_282 VDD VSS VDD VSS gf180mcu_fd_sc_mcu7t5v0__fillcap_64
XFILLER_238_877 VDD VSS VDD VSS gf180mcu_fd_sc_mcu7t5v0__fillcap_8
XFILLER_65_702 VDD VSS VDD VSS gf180mcu_fd_sc_mcu7t5v0__fillcap_64
XFILLER_77_562 VDD VSS VDD VSS gf180mcu_fd_sc_mcu7t5v0__fillcap_64
XFILLER_253_836 VDD VSS VDD VSS gf180mcu_fd_sc_mcu7t5v0__fillcap_4
XFILLER_265_696 VDD VSS VDD VSS gf180mcu_fd_sc_mcu7t5v0__fillcap_4
XFILLER_92_521 VDD VSS VDD VSS gf180mcu_fd_sc_mcu7t5v0__fillcap_4
XFILLER_45_492 VDD VSS VDD VSS gf180mcu_fd_sc_mcu7t5v0__fillcap_64
XFILLER_33_632 VDD VSS VDD VSS gf180mcu_fd_sc_mcu7t5v0__fillcap_64
XFILLER_221_766 VDD VSS VDD VSS gf180mcu_fd_sc_mcu7t5v0__fillcap_4
XFILLER_178_659 VDD VSS VDD VSS gf180mcu_fd_sc_mcu7t5v0__fillcap_4
XFILLER_177_114 VDD VSS VDD VSS gf180mcu_fd_sc_mcu7t5v0__fillcap_4
XFILLER_60_451 VDD VSS VDD VSS gf180mcu_fd_sc_mcu7t5v0__fillcap_4
XFILLER_198_90 VDD VSS VDD VSS gf180mcu_fd_sc_mcu7t5v0__fillcap_8
XFILLER_118_247 VDD VSS VDD VSS gf180mcu_fd_sc_mcu7t5v0__fillcap_8
XFILLER_134_729 VDD VSS VDD VSS gf180mcu_fd_sc_mcu7t5v0__fillcap_4
X_2625_ _2625_/S VDD VSS _3288_/D wire98/I _3288_/Q VDD VSS gf180mcu_fd_sc_mcu7t5v0__mux2_2
XFILLER_217_20 VDD VSS VDD VSS gf180mcu_fd_sc_mcu7t5v0__fillcap_8
XFILLER_99_142 VDD VSS VDD VSS gf180mcu_fd_sc_mcu7t5v0__fillcap_32
X_2556_ _3226_/Q VDD VSS _2557_/A2 _3224_/Q _3225_/Q VDD VSS gf180mcu_fd_sc_mcu7t5v0__nor3_1
X_1507_ VDD VSS _3369_/D _3369_/Q _1500_/Z VDD VSS gf180mcu_fd_sc_mcu7t5v0__xor2_1
X_2487_ VDD VSS _2488_/A2 _1400_/I _2487_/A2 VDD VSS gf180mcu_fd_sc_mcu7t5v0__nand2_1
X_1438_ VDD VSS _3191_/Q _2340_/B2 VDD VSS gf180mcu_fd_sc_mcu7t5v0__clkinv_1
XFILLER_96_871 VDD VSS VDD VSS gf180mcu_fd_sc_mcu7t5v0__fillcap_4
XFILLER_216_527 VDD VSS VDD VSS gf180mcu_fd_sc_mcu7t5v0__fillcap_64
XFILLER_216_505 VDD VSS VDD VSS gf180mcu_fd_sc_mcu7t5v0__fillcap_4
X_3108_ _3108_/D _3108_/Q wire153/Z VSS _3109_/CLK VDD VDD VSS gf180mcu_fd_sc_mcu7t5v0__dffrnq_1
XFILLER_55_212 VDD VSS VDD VSS gf180mcu_fd_sc_mcu7t5v0__fillcap_64
Xmax_cap18 _2566_/S _2565_/S VDD VSS VDD VSS gf180mcu_fd_sc_mcu7t5v0__buf_4
XFILLER_228_387 VDD VSS VDD VSS gf180mcu_fd_sc_mcu7t5v0__fillcap_64
XFILLER_243_346 VDD VSS VDD VSS gf180mcu_fd_sc_mcu7t5v0__fillcap_4
X_3039_ VDD _3039_/Q _3039_/CLK VSS _3039_/D VDD VSS gf180mcu_fd_sc_mcu7t5v0__dffq_1
XFILLER_169_626 VDD VSS VDD VSS gf180mcu_fd_sc_mcu7t5v0__fillcap_4
XFILLER_23_142 VDD VSS VDD VSS gf180mcu_fd_sc_mcu7t5v0__fillcap_64
XFILLER_109_203 VDD VSS VDD VSS gf180mcu_fd_sc_mcu7t5v0__fillcap_4
XFILLER_137_556 VDD VSS VDD VSS gf180mcu_fd_sc_mcu7t5v0__fillcap_4
XFILLER_192_651 VDD VSS VDD VSS gf180mcu_fd_sc_mcu7t5v0__fillcap_4
XFILLER_20_871 VDD VSS VDD VSS gf180mcu_fd_sc_mcu7t5v0__fillcap_4
XFILLER_194_37 VDD VSS VDD VSS gf180mcu_fd_sc_mcu7t5v0__fillcap_32
XFILLER_164_375 VDD VSS VDD VSS gf180mcu_fd_sc_mcu7t5v0__fillcap_8
XFILLER_127_64 VDD VSS VDD VSS gf180mcu_fd_sc_mcu7t5v0__fillcap_4
XFILLER_87_46 VDD VSS VDD VSS gf180mcu_fd_sc_mcu7t5v0__fillcap_16
XFILLER_238_107 VDD VSS VDD VSS gf180mcu_fd_sc_mcu7t5v0__fillcap_64
XFILLER_59_562 VDD VSS VDD VSS gf180mcu_fd_sc_mcu7t5v0__fillcap_64
XFILLER_47_702 VDD VSS VDD VSS gf180mcu_fd_sc_mcu7t5v0__fillcap_64
XFILLER_120_489 VDD VSS VDD VSS gf180mcu_fd_sc_mcu7t5v0__fillcap_8
XFILLER_74_521 VDD VSS VDD VSS gf180mcu_fd_sc_mcu7t5v0__fillcap_4
XFILLER_235_836 VDD VSS VDD VSS gf180mcu_fd_sc_mcu7t5v0__fillcap_4
XFILLER_247_696 VDD VSS VDD VSS gf180mcu_fd_sc_mcu7t5v0__fillcap_4
XFILLER_27_492 VDD VSS VDD VSS gf180mcu_fd_sc_mcu7t5v0__fillcap_64
XFILLER_15_632 VDD VSS VDD VSS gf180mcu_fd_sc_mcu7t5v0__fillcap_64
XFILLER_42_451 VDD VSS VDD VSS gf180mcu_fd_sc_mcu7t5v0__fillcap_4
XFILLER_159_136 VDD VSS VDD VSS gf180mcu_fd_sc_mcu7t5v0__fillcap_4
XFILLER_168_681 VDD VSS VDD VSS gf180mcu_fd_sc_mcu7t5v0__fillcap_32
XFILLER_202_287 VDD VSS VDD VSS gf180mcu_fd_sc_mcu7t5v0__fillcap_8
XFILLER_174_139 VDD VSS VDD VSS gf180mcu_fd_sc_mcu7t5v0__fillcap_8
XFILLER_7_842 VDD VSS VDD VSS gf180mcu_fd_sc_mcu7t5v0__fillcap_32
XFILLER_10_381 VDD VSS VDD VSS gf180mcu_fd_sc_mcu7t5v0__fillcap_4
X_2410_ VDD _2410_/B _2410_/A2 _3199_/D _2467_/A1 VSS VDD VSS gf180mcu_fd_sc_mcu7t5v0__oai21_1
X_3390_ _3390_/D _3390_/Q _3403_/RN VSS _3394_/CLK VDD VDD VSS gf180mcu_fd_sc_mcu7t5v0__dffrnq_1
X_2341_ _2804_/Q _2341_/C VDD VSS _2364_/B _3363_/D _2341_/A2 VDD VSS gf180mcu_fd_sc_mcu7t5v0__aoi211_1
XFILLER_130_209 VDD VSS VDD VSS gf180mcu_fd_sc_mcu7t5v0__fillcap_16
XFILLER_257_416 VDD VSS VDD VSS gf180mcu_fd_sc_mcu7t5v0__fillcap_4
X_2272_ VDD VSS _2272_/Z _2268_/C _2478_/A1 VDD VSS gf180mcu_fd_sc_mcu7t5v0__or2_1
XFILLER_2_591 VDD VSS VDD VSS gf180mcu_fd_sc_mcu7t5v0__fillcap_4
Xclkbuf_leaf_70_clk_i _3450_/CLK VSS VDD clkbuf_3_0__f_clk_i/Z VDD VSS gf180mcu_fd_sc_mcu7t5v0__clkbuf_2
XFILLER_78_871 VDD VSS VDD VSS gf180mcu_fd_sc_mcu7t5v0__fillcap_4
XFILLER_37_212 VDD VSS VDD VSS gf180mcu_fd_sc_mcu7t5v0__fillcap_64
XFILLER_203_44 VDD VSS VDD VSS gf180mcu_fd_sc_mcu7t5v0__fillcap_16
XFILLER_93_874 VDD VSS VDD VSS gf180mcu_fd_sc_mcu7t5v0__fillcap_16
XFILLER_225_346 VDD VSS VDD VSS gf180mcu_fd_sc_mcu7t5v0__fillcap_4
XFILLER_203_88 VDD VSS VDD VSS gf180mcu_fd_sc_mcu7t5v0__fillcap_8
XFILLER_20_101 VDD VSS VDD VSS gf180mcu_fd_sc_mcu7t5v0__fillcap_4
XFILLER_138_309 VDD VSS VDD VSS gf180mcu_fd_sc_mcu7t5v0__fillcap_4
X_1987_ _1991_/S VDD VSS _3032_/D _3032_/Q wire119/Z VDD VSS gf180mcu_fd_sc_mcu7t5v0__mux2_2
XFILLER_193_459 VDD VSS VDD VSS gf180mcu_fd_sc_mcu7t5v0__fillcap_16
Xclkbuf_leaf_23_clk_i _3109_/CLK VSS VDD clkload4/I VDD VSS gf180mcu_fd_sc_mcu7t5v0__clkbuf_2
X_2608_ _2619_/S VDD VSS _3274_/D _3234_/Q _3274_/Q VDD VSS gf180mcu_fd_sc_mcu7t5v0__mux2_2
XFILLER_114_272 VDD VSS VDD VSS gf180mcu_fd_sc_mcu7t5v0__fillcap_32
X_2539_ _2539_/S VDD VSS _3220_/D _3219_/Q _3220_/Q VDD VSS gf180mcu_fd_sc_mcu7t5v0__mux2_2
Xclkbuf_leaf_38_clk_i _3150_/CLK VSS VDD clkload5/I VDD VSS gf180mcu_fd_sc_mcu7t5v0__clkbuf_2
XFILLER_29_702 VDD VSS VDD VSS gf180mcu_fd_sc_mcu7t5v0__fillcap_64
XFILLER_68_381 VDD VSS VDD VSS gf180mcu_fd_sc_mcu7t5v0__fillcap_4
XFILLER_56_521 VDD VSS VDD VSS gf180mcu_fd_sc_mcu7t5v0__fillcap_4
XFILLER_113_22 VDD VSS VDD VSS gf180mcu_fd_sc_mcu7t5v0__fillcap_4
XFILLER_229_696 VDD VSS VDD VSS gf180mcu_fd_sc_mcu7t5v0__fillcap_4
XFILLER_217_836 VDD VSS VDD VSS gf180mcu_fd_sc_mcu7t5v0__fillcap_4
XFILLER_84_885 VDD VSS VDD VSS gf180mcu_fd_sc_mcu7t5v0__fillcap_4
XFILLER_204_519 VDD VSS VDD VSS gf180mcu_fd_sc_mcu7t5v0__fillcap_4
XFILLER_216_379 VDD VSS VDD VSS gf180mcu_fd_sc_mcu7t5v0__fillcap_4
Xwire60 VSS wire60/Z wire60/I VDD VDD VSS gf180mcu_fd_sc_mcu7t5v0__buf_2
XFILLER_24_451 VDD VSS VDD VSS gf180mcu_fd_sc_mcu7t5v0__fillcap_4
XFILLER_125_2 VDD VSS VDD VSS gf180mcu_fd_sc_mcu7t5v0__fillcap_16
XFILLER_4_801 VDD VSS VDD VSS gf180mcu_fd_sc_mcu7t5v0__fillcap_4
XFILLER_192_481 VDD VSS VDD VSS gf180mcu_fd_sc_mcu7t5v0__fillcap_4
XFILLER_137_375 VDD VSS VDD VSS gf180mcu_fd_sc_mcu7t5v0__fillcap_4
XFILLER_239_416 VDD VSS VDD VSS gf180mcu_fd_sc_mcu7t5v0__fillcap_4
XFILLER_19_212 VDD VSS VDD VSS gf180mcu_fd_sc_mcu7t5v0__fillcap_64
XFILLER_75_874 VDD VSS VDD VSS gf180mcu_fd_sc_mcu7t5v0__fillcap_16
XFILLER_207_346 VDD VSS VDD VSS gf180mcu_fd_sc_mcu7t5v0__fillcap_4
XFILLER_90_877 VDD VSS VDD VSS gf180mcu_fd_sc_mcu7t5v0__fillcap_8
X_2890_ VDD _2890_/Q _3370_/CLK VSS _2890_/D VDD VSS gf180mcu_fd_sc_mcu7t5v0__dffq_1
X_1910_ _1917_/S VDD VSS _2965_/D _2965_/Q _2011_/I0 VDD VSS gf180mcu_fd_sc_mcu7t5v0__mux2_2
X_1841_ _1842_/S VDD VSS _2907_/D wire128/Z _2907_/Q VDD VSS gf180mcu_fd_sc_mcu7t5v0__mux2_2
X_1772_ _1777_/S VDD VSS _2847_/D _3121_/Q _2847_/Q VDD VSS gf180mcu_fd_sc_mcu7t5v0__mux2_2
XFILLER_155_183 VDD VSS VDD VSS gf180mcu_fd_sc_mcu7t5v0__fillcap_16
XFILLER_6_171 VDD VSS VDD VSS gf180mcu_fd_sc_mcu7t5v0__fillcap_4
X_3442_ _3442_/D _3442_/Q wire161/I VSS _3443_/CLK VDD VDD VSS gf180mcu_fd_sc_mcu7t5v0__dffrnq_1
X_3373_ _3373_/D _3391_/D _3403_/RN VSS _3403_/CLK VDD VDD VSS gf180mcu_fd_sc_mcu7t5v0__dffrnq_1
XFILLER_40_2 VDD VSS VDD VSS gf180mcu_fd_sc_mcu7t5v0__fillcap_32
X_2324_ _2324_/B VDD VSS _3186_/D _2324_/A1 _2324_/A2 VDD VSS gf180mcu_fd_sc_mcu7t5v0__aoi21_1
X_2255_ VDD VSS _2256_/A3 _2461_/A1 _2254_/Z VDD VSS gf180mcu_fd_sc_mcu7t5v0__nand2_1
XFILLER_111_275 VDD VSS VDD VSS gf180mcu_fd_sc_mcu7t5v0__fillcap_4
XFILLER_38_521 VDD VSS VDD VSS gf180mcu_fd_sc_mcu7t5v0__fillcap_4
X_2186_ VDD _2187_/A3 _2186_/B _2186_/A1 _2186_/A2 VSS _2186_/A3 VDD VSS gf180mcu_fd_sc_mcu7t5v0__oai31_1
XFILLER_66_885 VDD VSS VDD VSS gf180mcu_fd_sc_mcu7t5v0__fillcap_4
XFILLER_93_693 VDD VSS VDD VSS gf180mcu_fd_sc_mcu7t5v0__fillcap_4
XFILLER_80_354 VDD VSS VDD VSS gf180mcu_fd_sc_mcu7t5v0__fillcap_16
XFILLER_80_387 VDD VSS VDD VSS gf180mcu_fd_sc_mcu7t5v0__fillcap_64
XFILLER_193_212 VDD VSS VDD VSS gf180mcu_fd_sc_mcu7t5v0__fillcap_4
XFILLER_119_364 VDD VSS VDD VSS gf180mcu_fd_sc_mcu7t5v0__fillcap_16
XFILLER_134_345 VDD VSS VDD VSS gf180mcu_fd_sc_mcu7t5v0__fillcap_32
XFILLER_161_142 VDD VSS VDD VSS gf180mcu_fd_sc_mcu7t5v0__fillcap_16
XFILLER_255_72 VDD VSS VDD VSS gf180mcu_fd_sc_mcu7t5v0__fillcap_64
XFILLER_68_37 VDD VSS VDD VSS gf180mcu_fd_sc_mcu7t5v0__fillcap_64
XFILLER_217_611 VDD VSS VDD VSS gf180mcu_fd_sc_mcu7t5v0__fillcap_16
XFILLER_90_107 VDD VSS VDD VSS gf180mcu_fd_sc_mcu7t5v0__fillcap_32
XFILLER_57_874 VDD VSS VDD VSS gf180mcu_fd_sc_mcu7t5v0__fillcap_16
XFILLER_140_31 VDD VSS VDD VSS gf180mcu_fd_sc_mcu7t5v0__fillcap_4
XFILLER_140_53 VDD VSS VDD VSS gf180mcu_fd_sc_mcu7t5v0__fillcap_8
XFILLER_72_877 VDD VSS VDD VSS gf180mcu_fd_sc_mcu7t5v0__fillcap_8
XFILLER_197_562 VDD VSS VDD VSS gf180mcu_fd_sc_mcu7t5v0__fillcap_4
XFILLER_169_264 VDD VSS VDD VSS gf180mcu_fd_sc_mcu7t5v0__fillcap_8
XFILLER_153_632 VDD VSS VDD VSS gf180mcu_fd_sc_mcu7t5v0__fillcap_4
XFILLER_137_150 VDD VSS VDD VSS gf180mcu_fd_sc_mcu7t5v0__fillcap_4
XFILLER_165_492 VDD VSS VDD VSS gf180mcu_fd_sc_mcu7t5v0__fillcap_4
XFILLER_152_142 VDD VSS VDD VSS gf180mcu_fd_sc_mcu7t5v0__fillcap_4
XFILLER_121_540 VDD VSS VDD VSS gf180mcu_fd_sc_mcu7t5v0__fillcap_16
XFILLER_121_562 VDD VSS VDD VSS gf180mcu_fd_sc_mcu7t5v0__fillcap_4
XFILLER_94_424 VDD VSS VDD VSS gf180mcu_fd_sc_mcu7t5v0__fillcap_16
X_2040_ _2040_/S VDD VSS _3073_/D _3289_/Q _3073_/Q VDD VSS gf180mcu_fd_sc_mcu7t5v0__mux2_2
XFILLER_94_457 VDD VSS VDD VSS gf180mcu_fd_sc_mcu7t5v0__fillcap_8
XFILLER_12_6 VDD VSS VDD VSS gf180mcu_fd_sc_mcu7t5v0__fillcap_16
XFILLER_48_885 VDD VSS VDD VSS gf180mcu_fd_sc_mcu7t5v0__fillcap_4
XFILLER_263_772 VDD VSS VDD VSS gf180mcu_fd_sc_mcu7t5v0__fillcap_64
XFILLER_62_387 VDD VSS VDD VSS gf180mcu_fd_sc_mcu7t5v0__fillcap_64
X_2942_ VDD _2942_/Q _3012_/CLK VSS _2942_/D VDD VSS gf180mcu_fd_sc_mcu7t5v0__dffq_1
XFILLER_50_527 VDD VSS VDD VSS gf180mcu_fd_sc_mcu7t5v0__fillcap_64
X_2873_ VDD _2873_/Q _2900_/CLK VSS _2873_/D VDD VSS gf180mcu_fd_sc_mcu7t5v0__dffq_1
XFILLER_175_212 VDD VSS VDD VSS gf180mcu_fd_sc_mcu7t5v0__fillcap_32
XFILLER_90_90 VDD VSS VDD VSS gf180mcu_fd_sc_mcu7t5v0__fillcap_8
X_1824_ VDD VSS _1832_/S _1861_/A1 _1796_/Z VDD VSS gf180mcu_fd_sc_mcu7t5v0__and2_1
X_1755_ _1758_/S VDD VSS _2833_/D wire132/Z _2833_/Q VDD VSS gf180mcu_fd_sc_mcu7t5v0__mux2_2
XFILLER_128_161 VDD VSS VDD VSS gf180mcu_fd_sc_mcu7t5v0__fillcap_8
XFILLER_209_65 VDD VSS VDD VSS gf180mcu_fd_sc_mcu7t5v0__fillcap_4
XFILLER_171_484 VDD VSS VDD VSS gf180mcu_fd_sc_mcu7t5v0__fillcap_4
X_1686_ _1689_/C VDD VSS _2482_/A2 _2331_/B _1712_/A1 VDD VSS gf180mcu_fd_sc_mcu7t5v0__nand3_1
XFILLER_143_142 VDD VSS VDD VSS gf180mcu_fd_sc_mcu7t5v0__fillcap_64
X_3425_ _3425_/D _3425_/Q wire161/I VSS _3427_/CLK VDD VDD VSS gf180mcu_fd_sc_mcu7t5v0__dffrnq_1
XFILLER_140_871 VDD VSS VDD VSS gf180mcu_fd_sc_mcu7t5v0__fillcap_4
XFILLER_225_42 VDD VSS VDD VSS gf180mcu_fd_sc_mcu7t5v0__fillcap_16
X_3356_ VSS _3362_/CLK VDD _3356_/D _3356_/Q wire153/I VDD VSS gf180mcu_fd_sc_mcu7t5v0__dffsnq_1
X_3287_ _3287_/D _3287_/Q wire151/I VSS _3289_/CLK VDD VDD VSS gf180mcu_fd_sc_mcu7t5v0__dffrnq_1
X_2307_ _2307_/B VDD VSS wire21/I _2307_/A1 _2307_/A2 VDD VSS gf180mcu_fd_sc_mcu7t5v0__aoi21_1
X_2238_ _2482_/A2 VDD VSS _2365_/A2 _2238_/A1 _2278_/A2 VDD VSS gf180mcu_fd_sc_mcu7t5v0__nand3_1
XFILLER_72_107 VDD VSS VDD VSS gf180mcu_fd_sc_mcu7t5v0__fillcap_8
XFILLER_39_874 VDD VSS VDD VSS gf180mcu_fd_sc_mcu7t5v0__fillcap_16
X_2169_ _2169_/B VDD VSS _3136_/D _2169_/A1 _2168_/C VDD VSS gf180mcu_fd_sc_mcu7t5v0__aoi21_1
XFILLER_241_422 VDD VSS VDD VSS gf180mcu_fd_sc_mcu7t5v0__fillcap_64
XFILLER_253_282 VDD VSS VDD VSS gf180mcu_fd_sc_mcu7t5v0__fillcap_64
XFILLER_54_877 VDD VSS VDD VSS gf180mcu_fd_sc_mcu7t5v0__fillcap_8
XFILLER_81_696 VDD VSS VDD VSS gf180mcu_fd_sc_mcu7t5v0__fillcap_4
XFILLER_167_702 VDD VSS VDD VSS gf180mcu_fd_sc_mcu7t5v0__fillcap_64
XFILLER_214_6 VDD VSS VDD VSS gf180mcu_fd_sc_mcu7t5v0__fillcap_16
XFILLER_147_492 VDD VSS VDD VSS gf180mcu_fd_sc_mcu7t5v0__fillcap_64
XFILLER_119_87 VDD VSS VDD VSS gf180mcu_fd_sc_mcu7t5v0__fillcap_8
XFILLER_150_613 VDD VSS VDD VSS gf180mcu_fd_sc_mcu7t5v0__fillcap_8
XFILLER_268_308 VDD VSS VDD VSS gf180mcu_fd_sc_mcu7t5v0__fillcap_32
XFILLER_192_2 VDD VSS VDD VSS gf180mcu_fd_sc_mcu7t5v0__fillcap_8
XFILLER_76_457 VDD VSS VDD VSS gf180mcu_fd_sc_mcu7t5v0__fillcap_64
XFILLER_217_430 VDD VSS VDD VSS gf180mcu_fd_sc_mcu7t5v0__fillcap_4
XFILLER_245_772 VDD VSS VDD VSS gf180mcu_fd_sc_mcu7t5v0__fillcap_64
XFILLER_151_63 VDD VSS VDD VSS gf180mcu_fd_sc_mcu7t5v0__fillcap_4
XFILLER_260_731 VDD VSS VDD VSS gf180mcu_fd_sc_mcu7t5v0__fillcap_4
XFILLER_44_387 VDD VSS VDD VSS gf180mcu_fd_sc_mcu7t5v0__fillcap_64
XFILLER_32_527 VDD VSS VDD VSS gf180mcu_fd_sc_mcu7t5v0__fillcap_64
XFILLER_198_871 VDD VSS VDD VSS gf180mcu_fd_sc_mcu7t5v0__fillcap_4
XFILLER_158_702 VDD VSS VDD VSS gf180mcu_fd_sc_mcu7t5v0__fillcap_32
XFILLER_71_195 VDD VSS VDD VSS gf180mcu_fd_sc_mcu7t5v0__fillcap_8
XFILLER_201_842 VDD VSS VDD VSS gf180mcu_fd_sc_mcu7t5v0__fillcap_32
XFILLER_157_212 VDD VSS VDD VSS gf180mcu_fd_sc_mcu7t5v0__fillcap_32
XFILLER_185_554 VDD VSS VDD VSS gf180mcu_fd_sc_mcu7t5v0__fillcap_4
X_1540_ _3275_/Q VDD VSS _1540_/Z _3273_/Q _3274_/Q VDD VSS gf180mcu_fd_sc_mcu7t5v0__or3_1
X_1471_ VDD VSS _1478_/A2 _3409_/Q _1465_/Z VDD VSS gf180mcu_fd_sc_mcu7t5v0__nor2_1
XFILLER_5_66 VDD VSS VDD VSS gf180mcu_fd_sc_mcu7t5v0__fillcap_4
X_3210_ _3210_/D _3210_/Q _3344_/RN VSS _3344_/CLK VDD VDD VSS gf180mcu_fd_sc_mcu7t5v0__dffrnq_1
XFILLER_268_886 VDD VSS VDD VSS gf180mcu_fd_sc_mcu7t5v0__fillcap_4
XFILLER_267_352 VDD VSS VDD VSS gf180mcu_fd_sc_mcu7t5v0__fillcap_64
X_3141_ _3141_/D _3141_/Q wire147/Z VSS _3182_/CLK VDD VDD VSS gf180mcu_fd_sc_mcu7t5v0__dffrnq_1
XFILLER_122_871 VDD VSS VDD VSS gf180mcu_fd_sc_mcu7t5v0__fillcap_4
XFILLER_95_766 VDD VSS VDD VSS gf180mcu_fd_sc_mcu7t5v0__fillcap_4
X_3072_ _3072_/D _3072_/Q wire147/I VSS _3279_/CLK VDD VDD VSS gf180mcu_fd_sc_mcu7t5v0__dffrnq_1
XFILLER_54_107 VDD VSS VDD VSS gf180mcu_fd_sc_mcu7t5v0__fillcap_64
X_2023_ VDD VSS _2205_/A3 _3269_/Q _3268_/Q VDD VSS gf180mcu_fd_sc_mcu7t5v0__nor2_1
XFILLER_223_422 VDD VSS VDD VSS gf180mcu_fd_sc_mcu7t5v0__fillcap_64
XFILLER_235_282 VDD VSS VDD VSS gf180mcu_fd_sc_mcu7t5v0__fillcap_64
XFILLER_223_411 VDD VSS VDD VSS gf180mcu_fd_sc_mcu7t5v0__fillcap_8
XFILLER_36_877 VDD VSS VDD VSS gf180mcu_fd_sc_mcu7t5v0__fillcap_8
XFILLER_250_241 VDD VSS VDD VSS gf180mcu_fd_sc_mcu7t5v0__fillcap_4
XFILLER_51_836 VDD VSS VDD VSS gf180mcu_fd_sc_mcu7t5v0__fillcap_4
XFILLER_63_696 VDD VSS VDD VSS gf180mcu_fd_sc_mcu7t5v0__fillcap_4
XFILLER_149_702 VDD VSS VDD VSS gf180mcu_fd_sc_mcu7t5v0__fillcap_16
XFILLER_176_521 VDD VSS VDD VSS gf180mcu_fd_sc_mcu7t5v0__fillcap_4
X_2925_ VDD _2925_/Q _2931_/CLK VSS _2925_/D VDD VSS gf180mcu_fd_sc_mcu7t5v0__dffq_1
XFILLER_176_576 VDD VSS VDD VSS gf180mcu_fd_sc_mcu7t5v0__fillcap_16
X_2856_ VDD _2856_/Q _3369_/CLK VSS _2856_/D VDD VSS gf180mcu_fd_sc_mcu7t5v0__dffq_1
X_1807_ _1814_/S VDD VSS _2877_/D wire137/Z _2877_/Q VDD VSS gf180mcu_fd_sc_mcu7t5v0__mux2_2
XFILLER_117_610 VDD VSS VDD VSS gf180mcu_fd_sc_mcu7t5v0__fillcap_16
Xhold211 _3436_/D VSS _3441_/Q VDD VDD VSS gf180mcu_fd_sc_mcu7t5v0__dlyc_1
XFILLER_129_492 VDD VSS VDD VSS gf180mcu_fd_sc_mcu7t5v0__fillcap_32
XFILLER_117_632 VDD VSS VDD VSS gf180mcu_fd_sc_mcu7t5v0__fillcap_16
X_2787_ wire19/Z _3087_/Q VDD VSS _2788_/A2 _3335_/Q wire37/Z VDD VSS gf180mcu_fd_sc_mcu7t5v0__aoi22_1
X_1738_ _1738_/S VDD VSS _2820_/D _2820_/Q _3126_/Q VDD VSS gf180mcu_fd_sc_mcu7t5v0__mux2_2
XFILLER_144_451 VDD VSS VDD VSS gf180mcu_fd_sc_mcu7t5v0__fillcap_4
XFILLER_116_153 VDD VSS VDD VSS gf180mcu_fd_sc_mcu7t5v0__fillcap_16
Xhold222 _3438_/D VSS _3443_/Q VDD VDD VSS gf180mcu_fd_sc_mcu7t5v0__dlyc_1
X_1669_ _2316_/C _2488_/B VDD VSS _2486_/C _2231_/A1 _1673_/A2 VDD VSS gf180mcu_fd_sc_mcu7t5v0__aoi211_1
XFILLER_259_842 VDD VSS VDD VSS gf180mcu_fd_sc_mcu7t5v0__fillcap_32
X_3408_ _3408_/D _3408_/Q wire163/Z VSS _3414_/CLK VDD VDD VSS gf180mcu_fd_sc_mcu7t5v0__dffrnq_1
XFILLER_131_189 VDD VSS VDD VSS gf180mcu_fd_sc_mcu7t5v0__fillcap_16
X_3339_ _3339_/D _3339_/Q _3339_/RN VSS _3339_/CLK VDD VDD VSS gf180mcu_fd_sc_mcu7t5v0__dffrnq_1
XFILLER_58_457 VDD VSS VDD VSS gf180mcu_fd_sc_mcu7t5v0__fillcap_64
XFILLER_100_521 VDD VSS VDD VSS gf180mcu_fd_sc_mcu7t5v0__fillcap_4
XFILLER_85_276 VDD VSS VDD VSS gf180mcu_fd_sc_mcu7t5v0__fillcap_4
XFILLER_73_416 VDD VSS VDD VSS gf180mcu_fd_sc_mcu7t5v0__fillcap_4
XFILLER_227_772 VDD VSS VDD VSS gf180mcu_fd_sc_mcu7t5v0__fillcap_64
XFILLER_242_731 VDD VSS VDD VSS gf180mcu_fd_sc_mcu7t5v0__fillcap_4
XFILLER_254_591 VDD VSS VDD VSS gf180mcu_fd_sc_mcu7t5v0__fillcap_4
XFILLER_26_387 VDD VSS VDD VSS gf180mcu_fd_sc_mcu7t5v0__fillcap_64
XFILLER_14_527 VDD VSS VDD VSS gf180mcu_fd_sc_mcu7t5v0__fillcap_64
XFILLER_41_346 VDD VSS VDD VSS gf180mcu_fd_sc_mcu7t5v0__fillcap_4
XFILLER_167_521 VDD VSS VDD VSS gf180mcu_fd_sc_mcu7t5v0__fillcap_4
XFILLER_167_554 VDD VSS VDD VSS gf180mcu_fd_sc_mcu7t5v0__fillcap_4
XFILLER_195_874 VDD VSS VDD VSS gf180mcu_fd_sc_mcu7t5v0__fillcap_16
XFILLER_6_737 VDD VSS VDD VSS gf180mcu_fd_sc_mcu7t5v0__fillcap_64
XFILLER_205_2 VDD VSS VDD VSS gf180mcu_fd_sc_mcu7t5v0__fillcap_8
XFILLER_107_142 VDD VSS VDD VSS gf180mcu_fd_sc_mcu7t5v0__fillcap_16
XFILLER_150_465 VDD VSS VDD VSS gf180mcu_fd_sc_mcu7t5v0__fillcap_4
XFILLER_268_138 VDD VSS VDD VSS gf180mcu_fd_sc_mcu7t5v0__fillcap_32
XFILLER_150_487 VDD VSS VDD VSS gf180mcu_fd_sc_mcu7t5v0__fillcap_8
XFILLER_249_352 VDD VSS VDD VSS gf180mcu_fd_sc_mcu7t5v0__fillcap_64
XFILLER_1_486 VDD VSS VDD VSS gf180mcu_fd_sc_mcu7t5v0__fillcap_4
XFILLER_104_871 VDD VSS VDD VSS gf180mcu_fd_sc_mcu7t5v0__fillcap_4
XFILLER_264_311 VDD VSS VDD VSS gf180mcu_fd_sc_mcu7t5v0__fillcap_4
XFILLER_76_232 VDD VSS VDD VSS gf180mcu_fd_sc_mcu7t5v0__fillcap_4
XFILLER_77_766 VDD VSS VDD VSS gf180mcu_fd_sc_mcu7t5v0__fillcap_4
XFILLER_39_72 VDD VSS VDD VSS gf180mcu_fd_sc_mcu7t5v0__fillcap_64
XFILLER_36_107 VDD VSS VDD VSS gf180mcu_fd_sc_mcu7t5v0__fillcap_64
XFILLER_205_422 VDD VSS VDD VSS gf180mcu_fd_sc_mcu7t5v0__fillcap_32
XFILLER_217_282 VDD VSS VDD VSS gf180mcu_fd_sc_mcu7t5v0__fillcap_8
XFILLER_18_877 VDD VSS VDD VSS gf180mcu_fd_sc_mcu7t5v0__fillcap_8
XFILLER_232_241 VDD VSS VDD VSS gf180mcu_fd_sc_mcu7t5v0__fillcap_4
XFILLER_33_836 VDD VSS VDD VSS gf180mcu_fd_sc_mcu7t5v0__fillcap_4
XFILLER_45_696 VDD VSS VDD VSS gf180mcu_fd_sc_mcu7t5v0__fillcap_4
XFILLER_201_672 VDD VSS VDD VSS gf180mcu_fd_sc_mcu7t5v0__fillcap_16
X_2710_ _2961_/Q VSS VDD _2945_/Q _2953_/Q _2718_/S0 _2937_/Q _2742_/S1 _2710_/Z VDD
+ VSS gf180mcu_fd_sc_mcu7t5v0__mux4_1
XFILLER_186_885 VDD VSS VDD VSS gf180mcu_fd_sc_mcu7t5v0__fillcap_4
XFILLER_200_171 VDD VSS VDD VSS gf180mcu_fd_sc_mcu7t5v0__fillcap_4
X_2641_ wire46/Z VDD VSS _3304_/D _3262_/Q _3304_/Q VDD VSS gf180mcu_fd_sc_mcu7t5v0__mux2_2
XFILLER_126_451 VDD VSS VDD VSS gf180mcu_fd_sc_mcu7t5v0__fillcap_4
X_2572_ _2587_/S VDD VSS _3240_/D _3217_/Q _3240_/Q VDD VSS gf180mcu_fd_sc_mcu7t5v0__mux2_2
X_1523_ _3382_/Q VDD VSS _1529_/A2 wire76/I _1516_/Z VDD VSS gf180mcu_fd_sc_mcu7t5v0__aoi21_1
X_1454_ VDD VSS _1454_/I _1898_/A3 VDD VSS gf180mcu_fd_sc_mcu7t5v0__clkinv_1
XFILLER_256_801 VDD VSS VDD VSS gf180mcu_fd_sc_mcu7t5v0__fillcap_4
XFILLER_206_77 VDD VSS VDD VSS gf180mcu_fd_sc_mcu7t5v0__fillcap_16
X_1385_ VDD VSS _3362_/Q _2324_/A1 VDD VSS gf180mcu_fd_sc_mcu7t5v0__clkinv_1
X_3124_ _3124_/D _3124_/Q _3457_/RN VSS _3380_/CLK VDD VDD VSS gf180mcu_fd_sc_mcu7t5v0__dffrnq_1
XFILLER_222_10 VDD VSS VDD VSS gf180mcu_fd_sc_mcu7t5v0__fillcap_4
XFILLER_67_276 VDD VSS VDD VSS gf180mcu_fd_sc_mcu7t5v0__fillcap_4
XFILLER_110_885 VDD VSS VDD VSS gf180mcu_fd_sc_mcu7t5v0__fillcap_4
XFILLER_55_416 VDD VSS VDD VSS gf180mcu_fd_sc_mcu7t5v0__fillcap_4
XFILLER_209_772 VDD VSS VDD VSS gf180mcu_fd_sc_mcu7t5v0__fillcap_64
X_3055_ VDD _3055_/Q _3055_/CLK VSS _3055_/D VDD VSS gf180mcu_fd_sc_mcu7t5v0__dffq_1
XFILLER_224_731 VDD VSS VDD VSS gf180mcu_fd_sc_mcu7t5v0__fillcap_4
XFILLER_236_591 VDD VSS VDD VSS gf180mcu_fd_sc_mcu7t5v0__fillcap_4
X_2006_ _2009_/S VDD VSS _3049_/D _2015_/I0 _3049_/Q VDD VSS gf180mcu_fd_sc_mcu7t5v0__mux2_2
XFILLER_90_290 VDD VSS VDD VSS gf180mcu_fd_sc_mcu7t5v0__fillcap_16
XFILLER_23_346 VDD VSS VDD VSS gf180mcu_fd_sc_mcu7t5v0__fillcap_4
XFILLER_195_126 VDD VSS VDD VSS gf180mcu_fd_sc_mcu7t5v0__fillcap_8
XFILLER_177_874 VDD VSS VDD VSS gf180mcu_fd_sc_mcu7t5v0__fillcap_16
X_2908_ VDD _2908_/Q _2931_/CLK VSS _2908_/D VDD VSS gf180mcu_fd_sc_mcu7t5v0__dffq_1
XFILLER_137_738 VDD VSS VDD VSS gf180mcu_fd_sc_mcu7t5v0__fillcap_32
XFILLER_176_373 VDD VSS VDD VSS gf180mcu_fd_sc_mcu7t5v0__fillcap_8
X_2839_ VDD _2839_/Q _3369_/CLK VSS _2839_/D VDD VSS gf180mcu_fd_sc_mcu7t5v0__dffq_1
XFILLER_192_877 VDD VSS VDD VSS gf180mcu_fd_sc_mcu7t5v0__fillcap_8
XFILLER_132_443 VDD VSS VDD VSS gf180mcu_fd_sc_mcu7t5v0__fillcap_8
XFILLER_144_292 VDD VSS VDD VSS gf180mcu_fd_sc_mcu7t5v0__fillcap_4
XFILLER_263_72 VDD VSS VDD VSS gf180mcu_fd_sc_mcu7t5v0__fillcap_64
XFILLER_246_311 VDD VSS VDD VSS gf180mcu_fd_sc_mcu7t5v0__fillcap_4
XFILLER_258_171 VDD VSS VDD VSS gf180mcu_fd_sc_mcu7t5v0__fillcap_4
XFILLER_59_766 VDD VSS VDD VSS gf180mcu_fd_sc_mcu7t5v0__fillcap_4
XFILLER_76_37 VDD VSS VDD VSS gf180mcu_fd_sc_mcu7t5v0__fillcap_16
XFILLER_101_874 VDD VSS VDD VSS gf180mcu_fd_sc_mcu7t5v0__fillcap_16
XFILLER_18_107 VDD VSS VDD VSS gf180mcu_fd_sc_mcu7t5v0__fillcap_64
XFILLER_15_836 VDD VSS VDD VSS gf180mcu_fd_sc_mcu7t5v0__fillcap_4
XFILLER_27_696 VDD VSS VDD VSS gf180mcu_fd_sc_mcu7t5v0__fillcap_4
XFILLER_199_454 VDD VSS VDD VSS gf180mcu_fd_sc_mcu7t5v0__fillcap_16
XFILLER_155_2 VDD VSS VDD VSS gf180mcu_fd_sc_mcu7t5v0__fillcap_32
XFILLER_168_885 VDD VSS VDD VSS gf180mcu_fd_sc_mcu7t5v0__fillcap_4
XFILLER_195_693 VDD VSS VDD VSS gf180mcu_fd_sc_mcu7t5v0__fillcap_4
XFILLER_170_527 VDD VSS VDD VSS gf180mcu_fd_sc_mcu7t5v0__fillcap_64
XFILLER_182_387 VDD VSS VDD VSS gf180mcu_fd_sc_mcu7t5v0__fillcap_16
XFILLER_238_801 VDD VSS VDD VSS gf180mcu_fd_sc_mcu7t5v0__fillcap_4
XFILLER_150_273 VDD VSS VDD VSS gf180mcu_fd_sc_mcu7t5v0__fillcap_32
XFILLER_173_72 VDD VSS VDD VSS gf180mcu_fd_sc_mcu7t5v0__fillcap_8
XFILLER_110_115 VDD VSS VDD VSS gf180mcu_fd_sc_mcu7t5v0__fillcap_4
XFILLER_49_276 VDD VSS VDD VSS gf180mcu_fd_sc_mcu7t5v0__fillcap_4
XFILLER_37_416 VDD VSS VDD VSS gf180mcu_fd_sc_mcu7t5v0__fillcap_4
XFILLER_218_591 VDD VSS VDD VSS gf180mcu_fd_sc_mcu7t5v0__fillcap_4
XFILLER_159_874 VDD VSS VDD VSS gf180mcu_fd_sc_mcu7t5v0__fillcap_16
XFILLER_70_2 VDD VSS VDD VSS gf180mcu_fd_sc_mcu7t5v0__fillcap_32
XFILLER_186_693 VDD VSS VDD VSS gf180mcu_fd_sc_mcu7t5v0__fillcap_8
XFILLER_161_516 VDD VSS VDD VSS gf180mcu_fd_sc_mcu7t5v0__fillcap_4
XFILLER_174_877 VDD VSS VDD VSS gf180mcu_fd_sc_mcu7t5v0__fillcap_8
X_2624_ _2626_/S VDD VSS _3287_/D _3245_/Q _3287_/Q VDD VSS gf180mcu_fd_sc_mcu7t5v0__mux2_2
X_2555_ VDD _2555_/B _2553_/B _3226_/D _2555_/A1 VSS VDD VSS gf180mcu_fd_sc_mcu7t5v0__oai21_1
X_1506_ VDD VSS _1512_/A2 _3369_/Q _1500_/Z VDD VSS gf180mcu_fd_sc_mcu7t5v0__nor2_1
X_2486_ _2486_/B _2486_/C VDD VSS _2489_/S _2347_/B _2486_/A2 VDD VSS gf180mcu_fd_sc_mcu7t5v0__aoi211_1
X_1437_ VDD VSS _3343_/Q _2487_/A2 VDD VSS gf180mcu_fd_sc_mcu7t5v0__clkinv_1
XFILLER_228_311 VDD VSS VDD VSS gf180mcu_fd_sc_mcu7t5v0__fillcap_4
XFILLER_110_660 VDD VSS VDD VSS gf180mcu_fd_sc_mcu7t5v0__fillcap_4
X_3107_ _3107_/D _3107_/Q wire153/Z VSS _3109_/CLK VDD VDD VSS gf180mcu_fd_sc_mcu7t5v0__dffrnq_1
XFILLER_209_591 VDD VSS VDD VSS gf180mcu_fd_sc_mcu7t5v0__fillcap_16
X_3038_ VDD _3038_/Q _3039_/CLK VSS _3038_/D VDD VSS gf180mcu_fd_sc_mcu7t5v0__dffq_1
XFILLER_211_244 VDD VSS VDD VSS gf180mcu_fd_sc_mcu7t5v0__fillcap_8
XFILLER_192_641 VDD VSS VDD VSS gf180mcu_fd_sc_mcu7t5v0__fillcap_4
XFILLER_164_387 VDD VSS VDD VSS gf180mcu_fd_sc_mcu7t5v0__fillcap_4
XFILLER_105_476 VDD VSS VDD VSS gf180mcu_fd_sc_mcu7t5v0__fillcap_8
XFILLER_19_416 VDD VSS VDD VSS gf180mcu_fd_sc_mcu7t5v0__fillcap_4
XFILLER_262_667 VDD VSS VDD VSS gf180mcu_fd_sc_mcu7t5v0__fillcap_64
XFILLER_250_807 VDD VSS VDD VSS gf180mcu_fd_sc_mcu7t5v0__fillcap_64
XFILLER_202_255 VDD VSS VDD VSS gf180mcu_fd_sc_mcu7t5v0__fillcap_32
XFILLER_230_597 VDD VSS VDD VSS gf180mcu_fd_sc_mcu7t5v0__fillcap_64
XFILLER_174_107 VDD VSS VDD VSS gf180mcu_fd_sc_mcu7t5v0__fillcap_32
XFILLER_156_877 VDD VSS VDD VSS gf180mcu_fd_sc_mcu7t5v0__fillcap_8
Xclkbuf_leaf_4_clk_i _3289_/CLK VSS VDD clkload0/I VDD VSS gf180mcu_fd_sc_mcu7t5v0__clkbuf_2
XFILLER_116_708 VDD VSS VDD VSS gf180mcu_fd_sc_mcu7t5v0__fillcap_16
XFILLER_171_836 VDD VSS VDD VSS gf180mcu_fd_sc_mcu7t5v0__fillcap_4
XFILLER_183_696 VDD VSS VDD VSS gf180mcu_fd_sc_mcu7t5v0__fillcap_4
XFILLER_170_324 VDD VSS VDD VSS gf180mcu_fd_sc_mcu7t5v0__fillcap_16
XFILLER_124_730 VDD VSS VDD VSS gf180mcu_fd_sc_mcu7t5v0__fillcap_4
X_2340_ _2340_/A3 _2494_/C _2340_/B2 VDD VSS _3191_/D _2340_/A1 _2484_/A1 VDD VSS
+ gf180mcu_fd_sc_mcu7t5v0__oai32_1
XFILLER_111_413 VDD VSS VDD VSS gf180mcu_fd_sc_mcu7t5v0__fillcap_4
X_2271_ _2230_/Z _2365_/A2 VDD VSS _2478_/A1 _2262_/B _2336_/B VDD VSS gf180mcu_fd_sc_mcu7t5v0__nor4_1
XFILLER_93_842 VDD VSS VDD VSS gf180mcu_fd_sc_mcu7t5v0__fillcap_32
XFILLER_252_177 VDD VSS VDD VSS gf180mcu_fd_sc_mcu7t5v0__fillcap_64
XFILLER_240_317 VDD VSS VDD VSS gf180mcu_fd_sc_mcu7t5v0__fillcap_64
XFILLER_61_772 VDD VSS VDD VSS gf180mcu_fd_sc_mcu7t5v0__fillcap_64
X_1986_ _1991_/S VDD VSS _3031_/D _3031_/Q wire121/Z VDD VSS gf180mcu_fd_sc_mcu7t5v0__mux2_2
XFILLER_193_438 VDD VSS VDD VSS gf180mcu_fd_sc_mcu7t5v0__fillcap_4
XFILLER_134_527 VDD VSS VDD VSS gf180mcu_fd_sc_mcu7t5v0__fillcap_4
X_2607_ _2607_/B VDD VSS _3273_/D _2607_/A1 _2619_/S VDD VSS gf180mcu_fd_sc_mcu7t5v0__aoi21_1
X_2538_ _2539_/S VDD VSS _3219_/D wire100/Z _3219_/Q VDD VSS gf180mcu_fd_sc_mcu7t5v0__mux2_2
X_2469_ VDD _2469_/B _2472_/A2 _3204_/D _2469_/A1 VSS VDD VSS gf180mcu_fd_sc_mcu7t5v0__oai21_1
XFILLER_95_190 VDD VSS VDD VSS gf180mcu_fd_sc_mcu7t5v0__fillcap_16
XFILLER_244_667 VDD VSS VDD VSS gf180mcu_fd_sc_mcu7t5v0__fillcap_64
XFILLER_232_807 VDD VSS VDD VSS gf180mcu_fd_sc_mcu7t5v0__fillcap_64
XFILLER_83_352 VDD VSS VDD VSS gf180mcu_fd_sc_mcu7t5v0__fillcap_64
Xwire72 VSS wire72/Z wire72/I VDD VDD VSS gf180mcu_fd_sc_mcu7t5v0__buf_1
Xwire94 wire94/Z VSS VDD wire94/I VDD VSS gf180mcu_fd_sc_mcu7t5v0__clkbuf_2
XFILLER_51_282 VDD VSS VDD VSS gf180mcu_fd_sc_mcu7t5v0__fillcap_64
XFILLER_212_597 VDD VSS VDD VSS gf180mcu_fd_sc_mcu7t5v0__fillcap_8
XFILLER_200_737 VDD VSS VDD VSS gf180mcu_fd_sc_mcu7t5v0__fillcap_64
XFILLER_156_107 VDD VSS VDD VSS gf180mcu_fd_sc_mcu7t5v0__fillcap_16
XFILLER_138_877 VDD VSS VDD VSS gf180mcu_fd_sc_mcu7t5v0__fillcap_8
XFILLER_165_696 VDD VSS VDD VSS gf180mcu_fd_sc_mcu7t5v0__fillcap_4
XFILLER_153_836 VDD VSS VDD VSS gf180mcu_fd_sc_mcu7t5v0__fillcap_4
XFILLER_118_2 VDD VSS VDD VSS gf180mcu_fd_sc_mcu7t5v0__fillcap_8
XFILLER_164_195 VDD VSS VDD VSS gf180mcu_fd_sc_mcu7t5v0__fillcap_8
XFILLER_106_730 VDD VSS VDD VSS gf180mcu_fd_sc_mcu7t5v0__fillcap_4
XFILLER_266_247 VDD VSS VDD VSS gf180mcu_fd_sc_mcu7t5v0__fillcap_64
XFILLER_121_766 VDD VSS VDD VSS gf180mcu_fd_sc_mcu7t5v0__fillcap_4
XFILLER_75_842 VDD VSS VDD VSS gf180mcu_fd_sc_mcu7t5v0__fillcap_32
XFILLER_47_72 VDD VSS VDD VSS gf180mcu_fd_sc_mcu7t5v0__fillcap_64
XFILLER_219_196 VDD VSS VDD VSS gf180mcu_fd_sc_mcu7t5v0__fillcap_8
XFILLER_90_801 VDD VSS VDD VSS gf180mcu_fd_sc_mcu7t5v0__fillcap_4
XFILLER_234_177 VDD VSS VDD VSS gf180mcu_fd_sc_mcu7t5v0__fillcap_64
XFILLER_222_317 VDD VSS VDD VSS gf180mcu_fd_sc_mcu7t5v0__fillcap_8
XFILLER_43_772 VDD VSS VDD VSS gf180mcu_fd_sc_mcu7t5v0__fillcap_64
XFILLER_70_591 VDD VSS VDD VSS gf180mcu_fd_sc_mcu7t5v0__fillcap_4
X_1840_ _1842_/S VDD VSS _2906_/D wire130/Z _2906_/Q VDD VSS gf180mcu_fd_sc_mcu7t5v0__mux2_2
XFILLER_175_416 VDD VSS VDD VSS gf180mcu_fd_sc_mcu7t5v0__fillcap_4
X_1771_ _1777_/S VDD VSS _2846_/D _1863_/I0 _2846_/Q VDD VSS gf180mcu_fd_sc_mcu7t5v0__mux2_2
XFILLER_128_343 VDD VSS VDD VSS gf180mcu_fd_sc_mcu7t5v0__fillcap_16
XFILLER_155_151 VDD VSS VDD VSS gf180mcu_fd_sc_mcu7t5v0__fillcap_32
XFILLER_128_387 VDD VSS VDD VSS gf180mcu_fd_sc_mcu7t5v0__fillcap_16
XFILLER_116_527 VDD VSS VDD VSS gf180mcu_fd_sc_mcu7t5v0__fillcap_8
X_3441_ _3441_/D _3441_/Q wire161/I VSS _3441_/CLK VDD VDD VSS gf180mcu_fd_sc_mcu7t5v0__dffrnq_1
X_3372_ _3372_/D _3390_/D _3403_/RN VSS _3403_/CLK VDD VDD VSS gf180mcu_fd_sc_mcu7t5v0__dffrnq_1
XFILLER_143_368 VDD VSS VDD VSS gf180mcu_fd_sc_mcu7t5v0__fillcap_8
X_2323_ VDD VSS _2324_/B _3186_/Q _2324_/A2 VDD VSS gf180mcu_fd_sc_mcu7t5v0__nor2_1
XFILLER_33_2 VDD VSS VDD VSS gf180mcu_fd_sc_mcu7t5v0__fillcap_64
XFILLER_258_737 VDD VSS VDD VSS gf180mcu_fd_sc_mcu7t5v0__fillcap_64
XFILLER_214_22 VDD VSS VDD VSS gf180mcu_fd_sc_mcu7t5v0__fillcap_8
X_2254_ _2900_/Q VSS VDD _2884_/Q _2892_/Q _2427_/S0 _2876_/Q _2460_/S1 _2254_/Z VDD
+ VSS gf180mcu_fd_sc_mcu7t5v0__mux4_1
XFILLER_111_265 VDD VSS VDD VSS gf180mcu_fd_sc_mcu7t5v0__fillcap_4
X_2185_ _1532_/Z _2324_/A1 VDD VSS _2186_/B _3346_/Q _2186_/A1 VDD VSS gf180mcu_fd_sc_mcu7t5v0__aoi22_1
XFILLER_226_667 VDD VSS VDD VSS gf180mcu_fd_sc_mcu7t5v0__fillcap_64
XFILLER_214_807 VDD VSS VDD VSS gf180mcu_fd_sc_mcu7t5v0__fillcap_64
XFILLER_80_300 VDD VSS VDD VSS gf180mcu_fd_sc_mcu7t5v0__fillcap_8
XFILLER_65_352 VDD VSS VDD VSS gf180mcu_fd_sc_mcu7t5v0__fillcap_64
XFILLER_241_626 VDD VSS VDD VSS gf180mcu_fd_sc_mcu7t5v0__fillcap_4
XFILLER_253_486 VDD VSS VDD VSS gf180mcu_fd_sc_mcu7t5v0__fillcap_4
XFILLER_213_306 VDD VSS VDD VSS gf180mcu_fd_sc_mcu7t5v0__fillcap_4
XFILLER_21_422 VDD VSS VDD VSS gf180mcu_fd_sc_mcu7t5v0__fillcap_64
XFILLER_179_766 VDD VSS VDD VSS gf180mcu_fd_sc_mcu7t5v0__fillcap_4
XFILLER_194_725 VDD VSS VDD VSS gf180mcu_fd_sc_mcu7t5v0__fillcap_8
XFILLER_138_107 VDD VSS VDD VSS gf180mcu_fd_sc_mcu7t5v0__fillcap_64
XFILLER_33_282 VDD VSS VDD VSS gf180mcu_fd_sc_mcu7t5v0__fillcap_64
X_1969_ _1972_/S VDD VSS _3017_/D _2015_/I0 _3017_/Q VDD VSS gf180mcu_fd_sc_mcu7t5v0__mux2_2
XFILLER_147_696 VDD VSS VDD VSS gf180mcu_fd_sc_mcu7t5v0__fillcap_4
XFILLER_135_836 VDD VSS VDD VSS gf180mcu_fd_sc_mcu7t5v0__fillcap_4
XFILLER_122_519 VDD VSS VDD VSS gf180mcu_fd_sc_mcu7t5v0__fillcap_4
XFILLER_103_766 VDD VSS VDD VSS gf180mcu_fd_sc_mcu7t5v0__fillcap_4
XFILLER_248_247 VDD VSS VDD VSS gf180mcu_fd_sc_mcu7t5v0__fillcap_64
XFILLER_263_206 VDD VSS VDD VSS gf180mcu_fd_sc_mcu7t5v0__fillcap_4
XFILLER_57_842 VDD VSS VDD VSS gf180mcu_fd_sc_mcu7t5v0__fillcap_32
XFILLER_84_661 VDD VSS VDD VSS gf180mcu_fd_sc_mcu7t5v0__fillcap_4
XFILLER_72_801 VDD VSS VDD VSS gf180mcu_fd_sc_mcu7t5v0__fillcap_4
XFILLER_216_177 VDD VSS VDD VSS gf180mcu_fd_sc_mcu7t5v0__fillcap_64
XFILLER_204_317 VDD VSS VDD VSS gf180mcu_fd_sc_mcu7t5v0__fillcap_8
XFILLER_204_306 VDD VSS VDD VSS gf180mcu_fd_sc_mcu7t5v0__fillcap_8
XFILLER_231_136 VDD VSS VDD VSS gf180mcu_fd_sc_mcu7t5v0__fillcap_4
XFILLER_25_772 VDD VSS VDD VSS gf180mcu_fd_sc_mcu7t5v0__fillcap_64
XFILLER_235_2 VDD VSS VDD VSS gf180mcu_fd_sc_mcu7t5v0__fillcap_64
XFILLER_52_591 VDD VSS VDD VSS gf180mcu_fd_sc_mcu7t5v0__fillcap_4
XFILLER_40_731 VDD VSS VDD VSS gf180mcu_fd_sc_mcu7t5v0__fillcap_4
XFILLER_185_747 VDD VSS VDD VSS gf180mcu_fd_sc_mcu7t5v0__fillcap_16
XFILLER_3_142 VDD VSS VDD VSS gf180mcu_fd_sc_mcu7t5v0__fillcap_64
XFILLER_79_422 VDD VSS VDD VSS gf180mcu_fd_sc_mcu7t5v0__fillcap_64
XFILLER_165_84 VDD VSS VDD VSS gf180mcu_fd_sc_mcu7t5v0__fillcap_8
XFILLER_267_556 VDD VSS VDD VSS gf180mcu_fd_sc_mcu7t5v0__fillcap_4
XFILLER_181_72 VDD VSS VDD VSS gf180mcu_fd_sc_mcu7t5v0__fillcap_32
XFILLER_47_352 VDD VSS VDD VSS gf180mcu_fd_sc_mcu7t5v0__fillcap_64
XFILLER_208_667 VDD VSS VDD VSS gf180mcu_fd_sc_mcu7t5v0__fillcap_8
Xclkbuf_leaf_22_clk_i _3359_/CLK VSS VDD clkload4/I VDD VSS gf180mcu_fd_sc_mcu7t5v0__clkbuf_2
XFILLER_62_311 VDD VSS VDD VSS gf180mcu_fd_sc_mcu7t5v0__fillcap_4
XFILLER_235_486 VDD VSS VDD VSS gf180mcu_fd_sc_mcu7t5v0__fillcap_4
X_2941_ VDD _2941_/Q _2958_/CLK VSS _2941_/D VDD VSS gf180mcu_fd_sc_mcu7t5v0__dffq_1
Xclkbuf_leaf_37_clk_i _3415_/CLK VSS VDD clkload6/I VDD VSS gf180mcu_fd_sc_mcu7t5v0__clkbuf_2
XFILLER_15_282 VDD VSS VDD VSS gf180mcu_fd_sc_mcu7t5v0__fillcap_64
X_2872_ VDD _2872_/Q _2899_/CLK VSS _2872_/D VDD VSS gf180mcu_fd_sc_mcu7t5v0__dffq_1
XFILLER_30_241 VDD VSS VDD VSS gf180mcu_fd_sc_mcu7t5v0__fillcap_4
X_1823_ _1823_/S VDD VSS _2892_/D _1869_/I0 _2892_/Q VDD VSS gf180mcu_fd_sc_mcu7t5v0__mux2_2
X_1754_ _1758_/S VDD VSS _2832_/D _3122_/Q _2832_/Q VDD VSS gf180mcu_fd_sc_mcu7t5v0__mux2_2
XFILLER_129_696 VDD VSS VDD VSS gf180mcu_fd_sc_mcu7t5v0__fillcap_4
XFILLER_117_836 VDD VSS VDD VSS gf180mcu_fd_sc_mcu7t5v0__fillcap_4
XFILLER_171_430 VDD VSS VDD VSS gf180mcu_fd_sc_mcu7t5v0__fillcap_4
XFILLER_7_492 VDD VSS VDD VSS gf180mcu_fd_sc_mcu7t5v0__fillcap_64
X_3424_ _3424_/D _3445_/D wire161/I VSS _3435_/CLK VDD VDD VSS gf180mcu_fd_sc_mcu7t5v0__dffrnq_1
X_1685_ _1689_/C VDD VSS _2278_/A2 _2331_/B _2803_/Q VDD VSS gf180mcu_fd_sc_mcu7t5v0__nand3_1
XFILLER_98_731 VDD VSS VDD VSS gf180mcu_fd_sc_mcu7t5v0__fillcap_4
X_3355_ VSS _3362_/CLK VDD _3355_/D _3356_/D wire153/I VDD VSS gf180mcu_fd_sc_mcu7t5v0__dffsnq_1
X_3286_ _3286_/D _3286_/Q wire151/I VSS _3289_/CLK VDD VDD VSS gf180mcu_fd_sc_mcu7t5v0__dffrnq_1
X_2306_ _2306_/A3 _2306_/A4 VDD VSS _2307_/A2 _2306_/A1 _2306_/A2 VDD VSS gf180mcu_fd_sc_mcu7t5v0__nor4_1
XFILLER_245_206 VDD VSS VDD VSS gf180mcu_fd_sc_mcu7t5v0__fillcap_4
X_2237_ _1691_/B _2230_/Z _3171_/Q VDD VSS _2240_/B _2488_/A1 VDD VSS gf180mcu_fd_sc_mcu7t5v0__oai22_1
XFILLER_39_842 VDD VSS VDD VSS gf180mcu_fd_sc_mcu7t5v0__fillcap_32
XFILLER_241_42 VDD VSS VDD VSS gf180mcu_fd_sc_mcu7t5v0__fillcap_16
XFILLER_66_661 VDD VSS VDD VSS gf180mcu_fd_sc_mcu7t5v0__fillcap_4
XFILLER_54_801 VDD VSS VDD VSS gf180mcu_fd_sc_mcu7t5v0__fillcap_4
X_2168_ _3168_/Q _2168_/C VDD VSS _2169_/B _3159_/Q _2168_/A2 _2168_/B1 VDD VSS gf180mcu_fd_sc_mcu7t5v0__aoi221_1
X_2099_ VDD VSS _2100_/B _2125_/A2 _2113_/A3 VDD VSS gf180mcu_fd_sc_mcu7t5v0__nor2_1
XFILLER_213_158 VDD VSS VDD VSS gf180mcu_fd_sc_mcu7t5v0__fillcap_4
XFILLER_34_591 VDD VSS VDD VSS gf180mcu_fd_sc_mcu7t5v0__fillcap_4
XFILLER_22_731 VDD VSS VDD VSS gf180mcu_fd_sc_mcu7t5v0__fillcap_4
XFILLER_139_438 VDD VSS VDD VSS gf180mcu_fd_sc_mcu7t5v0__fillcap_4
XFILLER_166_279 VDD VSS VDD VSS gf180mcu_fd_sc_mcu7t5v0__fillcap_16
XFILLER_150_647 VDD VSS VDD VSS gf180mcu_fd_sc_mcu7t5v0__fillcap_4
XFILLER_122_349 VDD VSS VDD VSS gf180mcu_fd_sc_mcu7t5v0__fillcap_16
XFILLER_249_556 VDD VSS VDD VSS gf180mcu_fd_sc_mcu7t5v0__fillcap_4
XFILLER_185_2 VDD VSS VDD VSS gf180mcu_fd_sc_mcu7t5v0__fillcap_64
XFILLER_29_352 VDD VSS VDD VSS gf180mcu_fd_sc_mcu7t5v0__fillcap_64
XFILLER_44_311 VDD VSS VDD VSS gf180mcu_fd_sc_mcu7t5v0__fillcap_4
XFILLER_56_171 VDD VSS VDD VSS gf180mcu_fd_sc_mcu7t5v0__fillcap_4
XFILLER_9_702 VDD VSS VDD VSS gf180mcu_fd_sc_mcu7t5v0__fillcap_64
XFILLER_212_191 VDD VSS VDD VSS gf180mcu_fd_sc_mcu7t5v0__fillcap_32
XFILLER_12_241 VDD VSS VDD VSS gf180mcu_fd_sc_mcu7t5v0__fillcap_4
XFILLER_165_290 VDD VSS VDD VSS gf180mcu_fd_sc_mcu7t5v0__fillcap_4
XFILLER_181_772 VDD VSS VDD VSS gf180mcu_fd_sc_mcu7t5v0__fillcap_64
XFILLER_4_451 VDD VSS VDD VSS gf180mcu_fd_sc_mcu7t5v0__fillcap_4
X_1470_ VDD VSS _3412_/D _3408_/Q _1470_/A2 VDD VSS gf180mcu_fd_sc_mcu7t5v0__xnor2_1
XFILLER_113_327 VDD VSS VDD VSS gf180mcu_fd_sc_mcu7t5v0__fillcap_16
XFILLER_192_71 VDD VSS VDD VSS gf180mcu_fd_sc_mcu7t5v0__fillcap_4
X_3140_ _3140_/D _3140_/Q wire147/Z VSS _3182_/CLK VDD VDD VSS gf180mcu_fd_sc_mcu7t5v0__dffrnq_1
XFILLER_227_206 VDD VSS VDD VSS gf180mcu_fd_sc_mcu7t5v0__fillcap_4
X_3071_ _3071_/D _3071_/Q wire147/I VSS _3279_/CLK VDD VDD VSS gf180mcu_fd_sc_mcu7t5v0__dffrnq_1
XFILLER_94_255 VDD VSS VDD VSS gf180mcu_fd_sc_mcu7t5v0__fillcap_8
XFILLER_48_661 VDD VSS VDD VSS gf180mcu_fd_sc_mcu7t5v0__fillcap_4
XFILLER_36_801 VDD VSS VDD VSS gf180mcu_fd_sc_mcu7t5v0__fillcap_4
X_2022_ VDD VSS _2061_/A2 _3272_/Q _1540_/Z VDD VSS gf180mcu_fd_sc_mcu7t5v0__nor2_1
XFILLER_90_450 VDD VSS VDD VSS gf180mcu_fd_sc_mcu7t5v0__fillcap_4
XFILLER_16_591 VDD VSS VDD VSS gf180mcu_fd_sc_mcu7t5v0__fillcap_4
X_2924_ VDD _2924_/Q _2931_/CLK VSS _2924_/D VDD VSS gf180mcu_fd_sc_mcu7t5v0__dffq_1
XFILLER_210_139 VDD VSS VDD VSS gf180mcu_fd_sc_mcu7t5v0__fillcap_16
X_2855_ VDD _2855_/Q _3369_/CLK VSS _2855_/D VDD VSS gf180mcu_fd_sc_mcu7t5v0__dffq_1
XFILLER_148_235 VDD VSS VDD VSS gf180mcu_fd_sc_mcu7t5v0__fillcap_8
X_1806_ VDD VSS _1814_/S _1843_/A1 _1796_/Z VDD VSS gf180mcu_fd_sc_mcu7t5v0__nand2_1
XFILLER_163_227 VDD VSS VDD VSS gf180mcu_fd_sc_mcu7t5v0__fillcap_8
X_2786_ VDD VSS _2786_/I _3334_/D VDD VSS gf180mcu_fd_sc_mcu7t5v0__clkinv_1
X_1737_ _1738_/S VDD VSS _2819_/D _2819_/Q _1794_/I1 VDD VSS gf180mcu_fd_sc_mcu7t5v0__mux2_2
Xhold212 _3399_/D VSS _3404_/Q VDD VDD VSS gf180mcu_fd_sc_mcu7t5v0__dlyc_1
Xhold223 _3439_/D VSS _3444_/Q VDD VDD VSS gf180mcu_fd_sc_mcu7t5v0__dlyc_1
Xclkbuf_3_1__f_clk_i VDD VSS clkload0/I clkbuf_0_clk_i/Z VDD VSS gf180mcu_fd_sc_mcu7t5v0__clkbuf_16
XFILLER_117_677 VDD VSS VDD VSS gf180mcu_fd_sc_mcu7t5v0__fillcap_4
X_1668_ VDD VSS _2316_/C _2488_/A1 VDD VSS gf180mcu_fd_sc_mcu7t5v0__clkinv_1
XFILLER_171_282 VDD VSS VDD VSS gf180mcu_fd_sc_mcu7t5v0__fillcap_16
XFILLER_104_338 VDD VSS VDD VSS gf180mcu_fd_sc_mcu7t5v0__fillcap_16
X_3407_ _3407_/D _3407_/Q wire163/Z VSS _3409_/CLK VDD VDD VSS gf180mcu_fd_sc_mcu7t5v0__dffrnq_1
XFILLER_98_583 VDD VSS VDD VSS gf180mcu_fd_sc_mcu7t5v0__fillcap_8
X_3338_ _3338_/D _3338_/Q wire169/Z VSS _3454_/CLK VDD VDD VSS gf180mcu_fd_sc_mcu7t5v0__dffrnq_1
X_1599_ VDD VSS wire46/I _1599_/A1 _3450_/Q VDD VSS gf180mcu_fd_sc_mcu7t5v0__nand2_2
X_3269_ _3269_/D _3269_/Q wire147/I VSS _3320_/CLK VDD VDD VSS gf180mcu_fd_sc_mcu7t5v0__dffrnq_1
XFILLER_26_311 VDD VSS VDD VSS gf180mcu_fd_sc_mcu7t5v0__fillcap_4
XFILLER_38_171 VDD VSS VDD VSS gf180mcu_fd_sc_mcu7t5v0__fillcap_4
XFILLER_195_842 VDD VSS VDD VSS gf180mcu_fd_sc_mcu7t5v0__fillcap_32
XFILLER_167_577 VDD VSS VDD VSS gf180mcu_fd_sc_mcu7t5v0__fillcap_32
XFILLER_163_772 VDD VSS VDD VSS gf180mcu_fd_sc_mcu7t5v0__fillcap_64
XFILLER_190_591 VDD VSS VDD VSS gf180mcu_fd_sc_mcu7t5v0__fillcap_4
XFILLER_146_53 VDD VSS VDD VSS gf180mcu_fd_sc_mcu7t5v0__fillcap_4
XFILLER_100_2 VDD VSS VDD VSS gf180mcu_fd_sc_mcu7t5v0__fillcap_8
XFILLER_122_135 VDD VSS VDD VSS gf180mcu_fd_sc_mcu7t5v0__fillcap_4
XFILLER_123_658 VDD VSS VDD VSS gf180mcu_fd_sc_mcu7t5v0__fillcap_16
XFILLER_18_801 VDD VSS VDD VSS gf180mcu_fd_sc_mcu7t5v0__fillcap_4
XFILLER_92_737 VDD VSS VDD VSS gf180mcu_fd_sc_mcu7t5v0__fillcap_64
XFILLER_55_72 VDD VSS VDD VSS gf180mcu_fd_sc_mcu7t5v0__fillcap_64
XFILLER_60_667 VDD VSS VDD VSS gf180mcu_fd_sc_mcu7t5v0__fillcap_64
XFILLER_146_728 VDD VSS VDD VSS gf180mcu_fd_sc_mcu7t5v0__fillcap_4
XFILLER_185_352 VDD VSS VDD VSS gf180mcu_fd_sc_mcu7t5v0__fillcap_64
X_2640_ _2642_/S VDD VSS _3303_/D _3261_/Q _3303_/Q VDD VSS gf180mcu_fd_sc_mcu7t5v0__mux2_2
X_2571_ _2587_/S VDD VSS _3239_/D _3216_/Q _3239_/Q VDD VSS gf180mcu_fd_sc_mcu7t5v0__mux2_2
X_1522_ _1516_/Z VDD VSS _1522_/Z wire76/I _3382_/Q VDD VSS gf180mcu_fd_sc_mcu7t5v0__and3_1
XFILLER_153_282 VDD VSS VDD VSS gf180mcu_fd_sc_mcu7t5v0__fillcap_32
XFILLER_141_422 VDD VSS VDD VSS gf180mcu_fd_sc_mcu7t5v0__fillcap_16
X_1453_ VDD VSS _3174_/Q _2276_/B2 VDD VSS gf180mcu_fd_sc_mcu7t5v0__clkinv_1
XFILLER_206_45 VDD VSS VDD VSS gf180mcu_fd_sc_mcu7t5v0__fillcap_32
XFILLER_113_157 VDD VSS VDD VSS gf180mcu_fd_sc_mcu7t5v0__fillcap_8
X_1384_ VDD VSS _3383_/Q _2461_/A1 VDD VSS gf180mcu_fd_sc_mcu7t5v0__clkinv_1
X_3123_ _3123_/D _3123_/Q _3457_/RN VSS _3365_/CLK VDD VDD VSS gf180mcu_fd_sc_mcu7t5v0__dffrnq_1
XFILLER_95_553 VDD VSS VDD VSS gf180mcu_fd_sc_mcu7t5v0__fillcap_4
X_3054_ VDD _3054_/Q _3058_/CLK VSS _3054_/D VDD VSS gf180mcu_fd_sc_mcu7t5v0__dffq_1
XFILLER_82_247 VDD VSS VDD VSS gf180mcu_fd_sc_mcu7t5v0__fillcap_32
X_2005_ _2009_/S VDD VSS _3048_/D wire119/Z _3048_/Q VDD VSS gf180mcu_fd_sc_mcu7t5v0__mux2_2
XFILLER_251_562 VDD VSS VDD VSS gf180mcu_fd_sc_mcu7t5v0__fillcap_64
XFILLER_177_842 VDD VSS VDD VSS gf180mcu_fd_sc_mcu7t5v0__fillcap_32
X_2907_ VDD _2907_/Q _2931_/CLK VSS _2907_/D VDD VSS gf180mcu_fd_sc_mcu7t5v0__dffq_1
XFILLER_50_177 VDD VSS VDD VSS gf180mcu_fd_sc_mcu7t5v0__fillcap_64
XFILLER_192_801 VDD VSS VDD VSS gf180mcu_fd_sc_mcu7t5v0__fillcap_4
X_2838_ VDD _2838_/Q _2914_/CLK VSS _2838_/D VDD VSS gf180mcu_fd_sc_mcu7t5v0__dffq_1
XFILLER_145_772 VDD VSS VDD VSS gf180mcu_fd_sc_mcu7t5v0__fillcap_64
XFILLER_117_463 VDD VSS VDD VSS gf180mcu_fd_sc_mcu7t5v0__fillcap_8
X_2769_ wire20/Z _3078_/Q VDD VSS _2770_/A2 _3326_/Q _2739_/S VDD VSS gf180mcu_fd_sc_mcu7t5v0__aoi22_1
XFILLER_160_731 VDD VSS VDD VSS gf180mcu_fd_sc_mcu7t5v0__fillcap_4
XFILLER_101_842 VDD VSS VDD VSS gf180mcu_fd_sc_mcu7t5v0__fillcap_32
XFILLER_100_352 VDD VSS VDD VSS gf180mcu_fd_sc_mcu7t5v0__fillcap_32
XFILLER_86_597 VDD VSS VDD VSS gf180mcu_fd_sc_mcu7t5v0__fillcap_64
XFILLER_74_737 VDD VSS VDD VSS gf180mcu_fd_sc_mcu7t5v0__fillcap_64
XFILLER_73_203 VDD VSS VDD VSS gf180mcu_fd_sc_mcu7t5v0__fillcap_4
XFILLER_199_422 VDD VSS VDD VSS gf180mcu_fd_sc_mcu7t5v0__fillcap_32
XFILLER_30_807 VDD VSS VDD VSS gf180mcu_fd_sc_mcu7t5v0__fillcap_64
XFILLER_42_667 VDD VSS VDD VSS gf180mcu_fd_sc_mcu7t5v0__fillcap_64
XFILLER_167_352 VDD VSS VDD VSS gf180mcu_fd_sc_mcu7t5v0__fillcap_64
XFILLER_182_311 VDD VSS VDD VSS gf180mcu_fd_sc_mcu7t5v0__fillcap_4
XFILLER_182_366 VDD VSS VDD VSS gf180mcu_fd_sc_mcu7t5v0__fillcap_16
XFILLER_10_597 VDD VSS VDD VSS gf180mcu_fd_sc_mcu7t5v0__fillcap_64
XFILLER_123_422 VDD VSS VDD VSS gf180mcu_fd_sc_mcu7t5v0__fillcap_64
XFILLER_135_282 VDD VSS VDD VSS gf180mcu_fd_sc_mcu7t5v0__fillcap_32
XFILLER_96_317 VDD VSS VDD VSS gf180mcu_fd_sc_mcu7t5v0__fillcap_8
XFILLER_265_632 VDD VSS VDD VSS gf180mcu_fd_sc_mcu7t5v0__fillcap_64
XFILLER_64_247 VDD VSS VDD VSS gf180mcu_fd_sc_mcu7t5v0__fillcap_64
XFILLER_221_702 VDD VSS VDD VSS gf180mcu_fd_sc_mcu7t5v0__fillcap_64
XFILLER_233_562 VDD VSS VDD VSS gf180mcu_fd_sc_mcu7t5v0__fillcap_64
XFILLER_260_381 VDD VSS VDD VSS gf180mcu_fd_sc_mcu7t5v0__fillcap_4
XFILLER_159_842 VDD VSS VDD VSS gf180mcu_fd_sc_mcu7t5v0__fillcap_32
XFILLER_32_177 VDD VSS VDD VSS gf180mcu_fd_sc_mcu7t5v0__fillcap_64
XFILLER_20_317 VDD VSS VDD VSS gf180mcu_fd_sc_mcu7t5v0__fillcap_64
XFILLER_174_801 VDD VSS VDD VSS gf180mcu_fd_sc_mcu7t5v0__fillcap_4
XFILLER_118_205 VDD VSS VDD VSS gf180mcu_fd_sc_mcu7t5v0__fillcap_4
XFILLER_201_492 VDD VSS VDD VSS gf180mcu_fd_sc_mcu7t5v0__fillcap_16
X_2623_ _2626_/S VDD VSS _3286_/D wire99/I _3286_/Q VDD VSS gf180mcu_fd_sc_mcu7t5v0__mux2_2
X_2554_ VDD VSS _2555_/B _2567_/B _2554_/A2 VDD VSS gf180mcu_fd_sc_mcu7t5v0__nand2_1
XFILLER_127_772 VDD VSS VDD VSS gf180mcu_fd_sc_mcu7t5v0__fillcap_64
X_1505_ VDD VSS _3372_/D _3368_/Q _1505_/A2 VDD VSS gf180mcu_fd_sc_mcu7t5v0__xnor2_1
XFILLER_154_591 VDD VSS VDD VSS gf180mcu_fd_sc_mcu7t5v0__fillcap_4
XFILLER_88_807 VDD VSS VDD VSS gf180mcu_fd_sc_mcu7t5v0__fillcap_64
X_2485_ VDD VSS _2486_/A2 _2485_/A1 _2485_/A2 VDD VSS gf180mcu_fd_sc_mcu7t5v0__nand2_1
X_1436_ VDD VSS _3160_/Q _2214_/A1 VDD VSS gf180mcu_fd_sc_mcu7t5v0__clkinv_1
XFILLER_141_274 VDD VSS VDD VSS gf180mcu_fd_sc_mcu7t5v0__fillcap_4
XFILLER_87_339 VDD VSS VDD VSS gf180mcu_fd_sc_mcu7t5v0__fillcap_8
XFILLER_255_142 VDD VSS VDD VSS gf180mcu_fd_sc_mcu7t5v0__fillcap_64
X_3106_ _3106_/D _3106_/Q wire153/Z VSS _3109_/CLK VDD VDD VSS gf180mcu_fd_sc_mcu7t5v0__dffrnq_1
XFILLER_95_394 VDD VSS VDD VSS gf180mcu_fd_sc_mcu7t5v0__fillcap_16
XFILLER_56_737 VDD VSS VDD VSS gf180mcu_fd_sc_mcu7t5v0__fillcap_64
XFILLER_68_597 VDD VSS VDD VSS gf180mcu_fd_sc_mcu7t5v0__fillcap_64
XFILLER_83_556 VDD VSS VDD VSS gf180mcu_fd_sc_mcu7t5v0__fillcap_4
X_3037_ VDD _3037_/Q _3044_/CLK VSS _3037_/D VDD VSS gf180mcu_fd_sc_mcu7t5v0__dffq_1
XFILLER_252_871 VDD VSS VDD VSS gf180mcu_fd_sc_mcu7t5v0__fillcap_4
XFILLER_102_69 VDD VSS VDD VSS gf180mcu_fd_sc_mcu7t5v0__fillcap_16
XFILLER_211_212 VDD VSS VDD VSS gf180mcu_fd_sc_mcu7t5v0__fillcap_32
XFILLER_178_18 VDD VSS VDD VSS gf180mcu_fd_sc_mcu7t5v0__fillcap_8
XFILLER_12_807 VDD VSS VDD VSS gf180mcu_fd_sc_mcu7t5v0__fillcap_64
XFILLER_24_667 VDD VSS VDD VSS gf180mcu_fd_sc_mcu7t5v0__fillcap_64
XFILLER_51_486 VDD VSS VDD VSS gf180mcu_fd_sc_mcu7t5v0__fillcap_4
XFILLER_149_352 VDD VSS VDD VSS gf180mcu_fd_sc_mcu7t5v0__fillcap_16
XFILLER_78_317 VDD VSS VDD VSS gf180mcu_fd_sc_mcu7t5v0__fillcap_4
XFILLER_247_632 VDD VSS VDD VSS gf180mcu_fd_sc_mcu7t5v0__fillcap_64
XFILLER_259_492 VDD VSS VDD VSS gf180mcu_fd_sc_mcu7t5v0__fillcap_64
XFILLER_46_247 VDD VSS VDD VSS gf180mcu_fd_sc_mcu7t5v0__fillcap_64
XFILLER_36_30 VDD VSS VDD VSS gf180mcu_fd_sc_mcu7t5v0__fillcap_4
XFILLER_265_2 VDD VSS VDD VSS gf180mcu_fd_sc_mcu7t5v0__fillcap_64
XFILLER_61_206 VDD VSS VDD VSS gf180mcu_fd_sc_mcu7t5v0__fillcap_4
XFILLER_215_562 VDD VSS VDD VSS gf180mcu_fd_sc_mcu7t5v0__fillcap_64
XFILLER_230_521 VDD VSS VDD VSS gf180mcu_fd_sc_mcu7t5v0__fillcap_4
XFILLER_242_381 VDD VSS VDD VSS gf180mcu_fd_sc_mcu7t5v0__fillcap_4
XFILLER_202_234 VDD VSS VDD VSS gf180mcu_fd_sc_mcu7t5v0__fillcap_8
XFILLER_14_177 VDD VSS VDD VSS gf180mcu_fd_sc_mcu7t5v0__fillcap_64
XFILLER_168_661 VDD VSS VDD VSS gf180mcu_fd_sc_mcu7t5v0__fillcap_4
XFILLER_156_801 VDD VSS VDD VSS gf180mcu_fd_sc_mcu7t5v0__fillcap_4
XFILLER_6_387 VDD VSS VDD VSS gf180mcu_fd_sc_mcu7t5v0__fillcap_64
XFILLER_182_185 VDD VSS VDD VSS gf180mcu_fd_sc_mcu7t5v0__fillcap_4
XFILLER_109_772 VDD VSS VDD VSS gf180mcu_fd_sc_mcu7t5v0__fillcap_64
X_2270_ _2270_/S VDD VSS _3172_/D _3172_/Q _2270_/I1 VDD VSS gf180mcu_fd_sc_mcu7t5v0__mux2_2
XFILLER_237_142 VDD VSS VDD VSS gf180mcu_fd_sc_mcu7t5v0__fillcap_64
XFILLER_38_737 VDD VSS VDD VSS gf180mcu_fd_sc_mcu7t5v0__fillcap_64
XFILLER_252_101 VDD VSS VDD VSS gf180mcu_fd_sc_mcu7t5v0__fillcap_4
XFILLER_65_556 VDD VSS VDD VSS gf180mcu_fd_sc_mcu7t5v0__fillcap_4
XFILLER_234_871 VDD VSS VDD VSS gf180mcu_fd_sc_mcu7t5v0__fillcap_4
XFILLER_33_486 VDD VSS VDD VSS gf180mcu_fd_sc_mcu7t5v0__fillcap_4
XFILLER_21_626 VDD VSS VDD VSS gf180mcu_fd_sc_mcu7t5v0__fillcap_4
X_1985_ _1991_/S VDD VSS _3030_/D _3030_/Q wire123/Z VDD VSS gf180mcu_fd_sc_mcu7t5v0__mux2_2
XFILLER_146_311 VDD VSS VDD VSS gf180mcu_fd_sc_mcu7t5v0__fillcap_4
XFILLER_174_653 VDD VSS VDD VSS gf180mcu_fd_sc_mcu7t5v0__fillcap_8
X_2606_ VDD VSS _2607_/B _3233_/Q _2619_/S VDD VSS gf180mcu_fd_sc_mcu7t5v0__nor2_1
X_2537_ _2537_/S VDD VSS _3218_/D _3217_/Q _3218_/Q VDD VSS gf180mcu_fd_sc_mcu7t5v0__mux2_2
X_2468_ VDD VSS _2469_/B _3204_/Q _2472_/A2 VDD VSS gf180mcu_fd_sc_mcu7t5v0__nand2_1
XFILLER_229_632 VDD VSS VDD VSS gf180mcu_fd_sc_mcu7t5v0__fillcap_64
X_1419_ VDD VSS _3143_/Q _2182_/A1 VDD VSS gf180mcu_fd_sc_mcu7t5v0__clkinv_1
XFILLER_256_451 VDD VSS VDD VSS gf180mcu_fd_sc_mcu7t5v0__fillcap_4
X_2399_ _2927_/Q VSS VDD _2911_/Q _2919_/Q _2454_/S0 _2903_/Q _2454_/S1 _2399_/Z VDD
+ VSS gf180mcu_fd_sc_mcu7t5v0__mux4_1
XFILLER_28_247 VDD VSS VDD VSS gf180mcu_fd_sc_mcu7t5v0__fillcap_64
XFILLER_43_206 VDD VSS VDD VSS gf180mcu_fd_sc_mcu7t5v0__fillcap_4
XFILLER_224_381 VDD VSS VDD VSS gf180mcu_fd_sc_mcu7t5v0__fillcap_4
XFILLER_189_39 VDD VSS VDD VSS gf180mcu_fd_sc_mcu7t5v0__fillcap_16
Xwire84 wire84/Z VSS VDD wire84/I VDD VSS gf180mcu_fd_sc_mcu7t5v0__clkbuf_2
XFILLER_169_414 VDD VSS VDD VSS gf180mcu_fd_sc_mcu7t5v0__fillcap_4
Xwire95 VSS wire95/Z wire95/I VDD VDD VSS gf180mcu_fd_sc_mcu7t5v0__clkbuf_1
XFILLER_212_543 VDD VSS VDD VSS gf180mcu_fd_sc_mcu7t5v0__fillcap_4
XFILLER_240_885 VDD VSS VDD VSS gf180mcu_fd_sc_mcu7t5v0__fillcap_4
XFILLER_11_136 VDD VSS VDD VSS gf180mcu_fd_sc_mcu7t5v0__fillcap_4
XFILLER_138_10 VDD VSS VDD VSS gf180mcu_fd_sc_mcu7t5v0__fillcap_8
XFILLER_149_193 VDD VSS VDD VSS gf180mcu_fd_sc_mcu7t5v0__fillcap_16
XFILLER_125_539 VDD VSS VDD VSS gf180mcu_fd_sc_mcu7t5v0__fillcap_16
XFILLER_180_667 VDD VSS VDD VSS gf180mcu_fd_sc_mcu7t5v0__fillcap_8
XFILLER_3_346 VDD VSS VDD VSS gf180mcu_fd_sc_mcu7t5v0__fillcap_4
XFILLER_154_53 VDD VSS VDD VSS gf180mcu_fd_sc_mcu7t5v0__fillcap_4
XFILLER_105_274 VDD VSS VDD VSS gf180mcu_fd_sc_mcu7t5v0__fillcap_4
XFILLER_79_626 VDD VSS VDD VSS gf180mcu_fd_sc_mcu7t5v0__fillcap_4
XFILLER_133_594 VDD VSS VDD VSS gf180mcu_fd_sc_mcu7t5v0__fillcap_8
XFILLER_120_277 VDD VSS VDD VSS gf180mcu_fd_sc_mcu7t5v0__fillcap_32
XFILLER_234_101 VDD VSS VDD VSS gf180mcu_fd_sc_mcu7t5v0__fillcap_4
XFILLER_47_556 VDD VSS VDD VSS gf180mcu_fd_sc_mcu7t5v0__fillcap_4
XFILLER_216_871 VDD VSS VDD VSS gf180mcu_fd_sc_mcu7t5v0__fillcap_4
XFILLER_187_200 VDD VSS VDD VSS gf180mcu_fd_sc_mcu7t5v0__fillcap_4
XFILLER_231_874 VDD VSS VDD VSS gf180mcu_fd_sc_mcu7t5v0__fillcap_16
XFILLER_15_486 VDD VSS VDD VSS gf180mcu_fd_sc_mcu7t5v0__fillcap_4
XFILLER_63_72 VDD VSS VDD VSS gf180mcu_fd_sc_mcu7t5v0__fillcap_64
XFILLER_179_72 VDD VSS VDD VSS gf180mcu_fd_sc_mcu7t5v0__fillcap_32
X_1770_ _1777_/S VDD VSS _2845_/D _3119_/Q _2845_/Q VDD VSS gf180mcu_fd_sc_mcu7t5v0__mux2_2
X_3440_ _3440_/D _3440_/Q wire161/I VSS _3443_/CLK VDD VDD VSS gf180mcu_fd_sc_mcu7t5v0__dffrnq_1
XFILLER_7_696 VDD VSS VDD VSS gf180mcu_fd_sc_mcu7t5v0__fillcap_4
X_3371_ _3371_/D _3394_/D _3458_/RN VSS _3405_/CLK VDD VDD VSS gf180mcu_fd_sc_mcu7t5v0__dffrnq_1
XFILLER_170_166 VDD VSS VDD VSS gf180mcu_fd_sc_mcu7t5v0__fillcap_8
XFILLER_170_177 VDD VSS VDD VSS gf180mcu_fd_sc_mcu7t5v0__fillcap_8
X_2322_ VDD _2322_/B _2328_/A1 _3185_/D _2322_/A1 VSS VDD VSS gf180mcu_fd_sc_mcu7t5v0__oai21_1
XFILLER_69_136 VDD VSS VDD VSS gf180mcu_fd_sc_mcu7t5v0__fillcap_4
XFILLER_238_451 VDD VSS VDD VSS gf180mcu_fd_sc_mcu7t5v0__fillcap_4
X_2253_ VDD VSS _2256_/A2 _2459_/A1 _2252_/Z VDD VSS gf180mcu_fd_sc_mcu7t5v0__nand2_1
XFILLER_26_2 VDD VSS VDD VSS gf180mcu_fd_sc_mcu7t5v0__fillcap_32
X_2184_ _2184_/S VDD VSS _3145_/D _3182_/Q _3145_/Q VDD VSS gf180mcu_fd_sc_mcu7t5v0__mux2_2
XFILLER_225_134 VDD VSS VDD VSS gf180mcu_fd_sc_mcu7t5v0__fillcap_4
XFILLER_25_206 VDD VSS VDD VSS gf180mcu_fd_sc_mcu7t5v0__fillcap_4
XFILLER_206_381 VDD VSS VDD VSS gf180mcu_fd_sc_mcu7t5v0__fillcap_4
XFILLER_80_378 VDD VSS VDD VSS gf180mcu_fd_sc_mcu7t5v0__fillcap_4
XFILLER_222_885 VDD VSS VDD VSS gf180mcu_fd_sc_mcu7t5v0__fillcap_4
XFILLER_178_255 VDD VSS VDD VSS gf180mcu_fd_sc_mcu7t5v0__fillcap_4
XFILLER_194_737 VDD VSS VDD VSS gf180mcu_fd_sc_mcu7t5v0__fillcap_8
XFILLER_193_203 VDD VSS VDD VSS gf180mcu_fd_sc_mcu7t5v0__fillcap_4
X_1968_ _1972_/S VDD VSS _3016_/D wire119/Z _3016_/Q VDD VSS gf180mcu_fd_sc_mcu7t5v0__mux2_2
X_1899_ _2010_/A1 VDD VSS _1907_/S _3409_/Q _3410_/Q VDD VSS gf180mcu_fd_sc_mcu7t5v0__nand3_1
XFILLER_146_185 VDD VSS VDD VSS gf180mcu_fd_sc_mcu7t5v0__fillcap_4
XFILLER_162_667 VDD VSS VDD VSS gf180mcu_fd_sc_mcu7t5v0__fillcap_64
XFILLER_150_807 VDD VSS VDD VSS gf180mcu_fd_sc_mcu7t5v0__fillcap_64
XFILLER_108_68 VDD VSS VDD VSS gf180mcu_fd_sc_mcu7t5v0__fillcap_8
XFILLER_191_18 VDD VSS VDD VSS gf180mcu_fd_sc_mcu7t5v0__fillcap_8
XFILLER_102_288 VDD VSS VDD VSS gf180mcu_fd_sc_mcu7t5v0__fillcap_16
XFILLER_130_597 VDD VSS VDD VSS gf180mcu_fd_sc_mcu7t5v0__fillcap_16
XFILLER_29_556 VDD VSS VDD VSS gf180mcu_fd_sc_mcu7t5v0__fillcap_4
Xclkbuf_leaf_3_clk_i _3452_/CLK VSS VDD clkload0/I VDD VSS gf180mcu_fd_sc_mcu7t5v0__clkbuf_2
XFILLER_213_874 VDD VSS VDD VSS gf180mcu_fd_sc_mcu7t5v0__fillcap_16
XFILLER_185_715 VDD VSS VDD VSS gf180mcu_fd_sc_mcu7t5v0__fillcap_32
XFILLER_200_535 VDD VSS VDD VSS gf180mcu_fd_sc_mcu7t5v0__fillcap_4
XFILLER_184_225 VDD VSS VDD VSS gf180mcu_fd_sc_mcu7t5v0__fillcap_8
XFILLER_130_2 VDD VSS VDD VSS gf180mcu_fd_sc_mcu7t5v0__fillcap_16
XFILLER_228_2 VDD VSS VDD VSS gf180mcu_fd_sc_mcu7t5v0__fillcap_32
XFILLER_184_247 VDD VSS VDD VSS gf180mcu_fd_sc_mcu7t5v0__fillcap_4
XFILLER_153_689 VDD VSS VDD VSS gf180mcu_fd_sc_mcu7t5v0__fillcap_8
XFILLER_180_486 VDD VSS VDD VSS gf180mcu_fd_sc_mcu7t5v0__fillcap_32
XFILLER_152_177 VDD VSS VDD VSS gf180mcu_fd_sc_mcu7t5v0__fillcap_8
XFILLER_181_51 VDD VSS VDD VSS gf180mcu_fd_sc_mcu7t5v0__fillcap_16
XFILLER_121_586 VDD VSS VDD VSS gf180mcu_fd_sc_mcu7t5v0__fillcap_8
XFILLER_94_448 VDD VSS VDD VSS gf180mcu_fd_sc_mcu7t5v0__fillcap_4
XFILLER_250_457 VDD VSS VDD VSS gf180mcu_fd_sc_mcu7t5v0__fillcap_64
XFILLER_188_520 VDD VSS VDD VSS gf180mcu_fd_sc_mcu7t5v0__fillcap_4
X_2940_ VDD _2940_/Q _3365_/CLK VSS _2940_/D VDD VSS gf180mcu_fd_sc_mcu7t5v0__dffq_1
XFILLER_204_885 VDD VSS VDD VSS gf180mcu_fd_sc_mcu7t5v0__fillcap_4
X_2871_ VDD _2871_/Q _2899_/CLK VSS _2871_/D VDD VSS gf180mcu_fd_sc_mcu7t5v0__dffq_1
XFILLER_200_69 VDD VSS VDD VSS gf180mcu_fd_sc_mcu7t5v0__fillcap_16
X_1822_ _1823_/S VDD VSS _2891_/D wire128/Z _2891_/Q VDD VSS gf180mcu_fd_sc_mcu7t5v0__mux2_2
XFILLER_176_737 VDD VSS VDD VSS gf180mcu_fd_sc_mcu7t5v0__fillcap_64
XFILLER_191_718 VDD VSS VDD VSS gf180mcu_fd_sc_mcu7t5v0__fillcap_4
X_1753_ _1758_/S VDD VSS _2831_/D _3121_/Q _2831_/Q VDD VSS gf180mcu_fd_sc_mcu7t5v0__mux2_2
X_1684_ VDD VSS _2234_/B _2804_/Q _2260_/B VDD VSS gf180mcu_fd_sc_mcu7t5v0__nor2_1
XFILLER_144_667 VDD VSS VDD VSS gf180mcu_fd_sc_mcu7t5v0__fillcap_64
X_3423_ _3423_/D _3423_/Q wire163/Z VSS _3427_/CLK VDD VDD VSS gf180mcu_fd_sc_mcu7t5v0__dffrnq_1
XFILLER_132_807 VDD VSS VDD VSS gf180mcu_fd_sc_mcu7t5v0__fillcap_64
Xclkbuf_4_11_0_host_clk_i _2932_/CLK VSS VDD clkbuf_0_host_clk_i/Z VDD VSS gf180mcu_fd_sc_mcu7t5v0__clkbuf_2
XFILLER_225_66 VDD VSS VDD VSS gf180mcu_fd_sc_mcu7t5v0__fillcap_4
X_3354_ VSS _3357_/CLK VDD input2/Z _3355_/D wire153/I VDD VSS gf180mcu_fd_sc_mcu7t5v0__dffsnq_1
X_2305_ _2305_/A2 _3095_/Q _2305_/B2 VDD VSS _2306_/A4 _1424_/I VDD VSS gf180mcu_fd_sc_mcu7t5v0__oai22_1
X_3285_ _3285_/D wire89/I wire165/Z VSS _3462_/CLK VDD VDD VSS gf180mcu_fd_sc_mcu7t5v0__dffrnq_1
XFILLER_241_10 VDD VSS VDD VSS gf180mcu_fd_sc_mcu7t5v0__fillcap_32
X_2236_ VDD VSS _2247_/A1 _3171_/Q _2236_/A2 VDD VSS gf180mcu_fd_sc_mcu7t5v0__nand2_1
XFILLER_112_597 VDD VSS VDD VSS gf180mcu_fd_sc_mcu7t5v0__fillcap_32
XFILLER_100_737 VDD VSS VDD VSS gf180mcu_fd_sc_mcu7t5v0__fillcap_64
X_2167_ _2167_/B1 _2166_/Z VDD VSS _3135_/D _2167_/A1 _2168_/C VDD VSS gf180mcu_fd_sc_mcu7t5v0__aoi22_1
XFILLER_93_492 VDD VSS VDD VSS gf180mcu_fd_sc_mcu7t5v0__fillcap_64
XFILLER_81_632 VDD VSS VDD VSS gf180mcu_fd_sc_mcu7t5v0__fillcap_64
XFILLER_214_638 VDD VSS VDD VSS gf180mcu_fd_sc_mcu7t5v0__fillcap_16
X_2098_ _3107_/Q _2090_/Z VDD VSS _2113_/A3 _3108_/Q _3106_/Q VDD VSS gf180mcu_fd_sc_mcu7t5v0__nand4_1
XFILLER_198_317 VDD VSS VDD VSS gf180mcu_fd_sc_mcu7t5v0__fillcap_32
XFILLER_139_406 VDD VSS VDD VSS gf180mcu_fd_sc_mcu7t5v0__fillcap_8
XFILLER_210_877 VDD VSS VDD VSS gf180mcu_fd_sc_mcu7t5v0__fillcap_8
XFILLER_166_247 VDD VSS VDD VSS gf180mcu_fd_sc_mcu7t5v0__fillcap_32
XFILLER_135_612 VDD VSS VDD VSS gf180mcu_fd_sc_mcu7t5v0__fillcap_16
XFILLER_119_45 VDD VSS VDD VSS gf180mcu_fd_sc_mcu7t5v0__fillcap_16
XFILLER_107_314 VDD VSS VDD VSS gf180mcu_fd_sc_mcu7t5v0__fillcap_8
XFILLER_119_196 VDD VSS VDD VSS gf180mcu_fd_sc_mcu7t5v0__fillcap_4
XFILLER_79_38 VDD VSS VDD VSS gf180mcu_fd_sc_mcu7t5v0__fillcap_16
XFILLER_122_317 VDD VSS VDD VSS gf180mcu_fd_sc_mcu7t5v0__fillcap_32
XFILLER_135_88 VDD VSS VDD VSS gf180mcu_fd_sc_mcu7t5v0__fillcap_8
XFILLER_264_527 VDD VSS VDD VSS gf180mcu_fd_sc_mcu7t5v0__fillcap_64
XFILLER_178_2 VDD VSS VDD VSS gf180mcu_fd_sc_mcu7t5v0__fillcap_16
XFILLER_151_87 VDD VSS VDD VSS gf180mcu_fd_sc_mcu7t5v0__fillcap_8
XFILLER_71_142 VDD VSS VDD VSS gf180mcu_fd_sc_mcu7t5v0__fillcap_16
XFILLER_232_457 VDD VSS VDD VSS gf180mcu_fd_sc_mcu7t5v0__fillcap_64
XFILLER_158_737 VDD VSS VDD VSS gf180mcu_fd_sc_mcu7t5v0__fillcap_64
XFILLER_200_387 VDD VSS VDD VSS gf180mcu_fd_sc_mcu7t5v0__fillcap_64
XFILLER_138_450 VDD VSS VDD VSS gf180mcu_fd_sc_mcu7t5v0__fillcap_4
XFILLER_125_122 VDD VSS VDD VSS gf180mcu_fd_sc_mcu7t5v0__fillcap_8
XFILLER_114_807 VDD VSS VDD VSS gf180mcu_fd_sc_mcu7t5v0__fillcap_64
XFILLER_126_667 VDD VSS VDD VSS gf180mcu_fd_sc_mcu7t5v0__fillcap_4
XFILLER_140_136 VDD VSS VDD VSS gf180mcu_fd_sc_mcu7t5v0__fillcap_4
XFILLER_95_702 VDD VSS VDD VSS gf180mcu_fd_sc_mcu7t5v0__fillcap_64
X_3070_ _3070_/D _3070_/Q _3452_/RN VSS _3281_/CLK VDD VDD VSS gf180mcu_fd_sc_mcu7t5v0__dffrnq_1
X_2021_ VDD VSS _2203_/A2 _3455_/Q _3276_/Q VDD VSS gf180mcu_fd_sc_mcu7t5v0__nand2_1
XFILLER_63_632 VDD VSS VDD VSS gf180mcu_fd_sc_mcu7t5v0__fillcap_64
XFILLER_75_492 VDD VSS VDD VSS gf180mcu_fd_sc_mcu7t5v0__fillcap_64
XFILLER_251_766 VDD VSS VDD VSS gf180mcu_fd_sc_mcu7t5v0__fillcap_4
XFILLER_211_57 VDD VSS VDD VSS gf180mcu_fd_sc_mcu7t5v0__fillcap_8
XFILLER_210_107 VDD VSS VDD VSS gf180mcu_fd_sc_mcu7t5v0__fillcap_32
X_2923_ VDD _2923_/Q _2931_/CLK VSS _2923_/D VDD VSS gf180mcu_fd_sc_mcu7t5v0__dffq_1
XFILLER_31_562 VDD VSS VDD VSS gf180mcu_fd_sc_mcu7t5v0__fillcap_64
XFILLER_176_556 VDD VSS VDD VSS gf180mcu_fd_sc_mcu7t5v0__fillcap_8
X_2854_ VDD _2854_/Q _2914_/CLK VSS _2854_/D VDD VSS gf180mcu_fd_sc_mcu7t5v0__dffq_1
XFILLER_148_247 VDD VSS VDD VSS gf180mcu_fd_sc_mcu7t5v0__fillcap_64
X_1805_ _1805_/S VDD VSS _2876_/D _1869_/I0 _2876_/Q VDD VSS gf180mcu_fd_sc_mcu7t5v0__mux2_2
XFILLER_191_526 VDD VSS VDD VSS gf180mcu_fd_sc_mcu7t5v0__fillcap_16
X_2785_ wire20/Z _3086_/Q VDD VSS _2786_/I _3334_/Q _2739_/S VDD VSS gf180mcu_fd_sc_mcu7t5v0__aoi22_1
X_1736_ _1738_/S VDD VSS _2818_/D _2818_/Q _3124_/Q VDD VSS gf180mcu_fd_sc_mcu7t5v0__mux2_2
XFILLER_116_100 VDD VSS VDD VSS gf180mcu_fd_sc_mcu7t5v0__fillcap_4
Xhold224 _3385_/D VSS _3390_/Q VDD VDD VSS gf180mcu_fd_sc_mcu7t5v0__dlyc_1
Xhold213 _3452_/D VSS _3451_/Q VDD VDD VSS gf180mcu_fd_sc_mcu7t5v0__dlyc_1
XFILLER_144_486 VDD VSS VDD VSS gf180mcu_fd_sc_mcu7t5v0__fillcap_8
X_1667_ _2804_/Q VDD VSS _2316_/C _2341_/C _2803_/Q VDD VSS gf180mcu_fd_sc_mcu7t5v0__nand3_1
XFILLER_116_177 VDD VSS VDD VSS gf180mcu_fd_sc_mcu7t5v0__fillcap_8
X_3406_ _3406_/D _3406_/Q wire161/I VSS _3441_/CLK VDD VDD VSS gf180mcu_fd_sc_mcu7t5v0__dffrnq_1
X_1598_ VDD _1598_/B _1598_/A2 _3346_/D _1598_/A1 VSS VDD VSS gf180mcu_fd_sc_mcu7t5v0__oai21_1
XFILLER_98_551 VDD VSS VDD VSS gf180mcu_fd_sc_mcu7t5v0__fillcap_32
XFILLER_131_136 VDD VSS VDD VSS gf180mcu_fd_sc_mcu7t5v0__fillcap_4
X_3337_ _3337_/D _3337_/Q wire145/I VSS _3337_/CLK VDD VDD VSS gf180mcu_fd_sc_mcu7t5v0__dffrnq_1
XFILLER_258_387 VDD VSS VDD VSS gf180mcu_fd_sc_mcu7t5v0__fillcap_64
XFILLER_246_527 VDD VSS VDD VSS gf180mcu_fd_sc_mcu7t5v0__fillcap_64
XFILLER_140_692 VDD VSS VDD VSS gf180mcu_fd_sc_mcu7t5v0__fillcap_32
XFILLER_85_212 VDD VSS VDD VSS gf180mcu_fd_sc_mcu7t5v0__fillcap_64
XFILLER_100_567 VDD VSS VDD VSS gf180mcu_fd_sc_mcu7t5v0__fillcap_16
X_3268_ _3268_/D _3268_/Q wire145/I VSS _3452_/CLK VDD VDD VSS gf180mcu_fd_sc_mcu7t5v0__dffrnq_1
X_2219_ _2219_/S VDD VSS _3165_/D _3282_/Q _3165_/Q VDD VSS gf180mcu_fd_sc_mcu7t5v0__mux2_2
X_3199_ _3199_/D _3199_/Q wire151/Z VSS _3211_/CLK VDD VDD VSS gf180mcu_fd_sc_mcu7t5v0__dffrnq_1
XFILLER_214_457 VDD VSS VDD VSS gf180mcu_fd_sc_mcu7t5v0__fillcap_16
XFILLER_199_648 VDD VSS VDD VSS gf180mcu_fd_sc_mcu7t5v0__fillcap_8
XFILLER_53_142 VDD VSS VDD VSS gf180mcu_fd_sc_mcu7t5v0__fillcap_64
XFILLER_241_276 VDD VSS VDD VSS gf180mcu_fd_sc_mcu7t5v0__fillcap_4
XFILLER_186_309 VDD VSS VDD VSS gf180mcu_fd_sc_mcu7t5v0__fillcap_4
XFILLER_197_39 VDD VSS VDD VSS gf180mcu_fd_sc_mcu7t5v0__fillcap_8
XFILLER_50_871 VDD VSS VDD VSS gf180mcu_fd_sc_mcu7t5v0__fillcap_4
Xclkbuf_leaf_21_clk_i _3360_/CLK VSS VDD clkload4/I VDD VSS gf180mcu_fd_sc_mcu7t5v0__clkbuf_2
XFILLER_108_667 VDD VSS VDD VSS gf180mcu_fd_sc_mcu7t5v0__fillcap_8
XFILLER_1_422 VDD VSS VDD VSS gf180mcu_fd_sc_mcu7t5v0__fillcap_64
XFILLER_77_702 VDD VSS VDD VSS gf180mcu_fd_sc_mcu7t5v0__fillcap_64
XFILLER_265_836 VDD VSS VDD VSS gf180mcu_fd_sc_mcu7t5v0__fillcap_4
Xclkbuf_leaf_36_clk_i _3445_/CLK VSS VDD clkload6/I VDD VSS gf180mcu_fd_sc_mcu7t5v0__clkbuf_2
XFILLER_162_53 VDD VSS VDD VSS gf180mcu_fd_sc_mcu7t5v0__fillcap_4
XFILLER_57_492 VDD VSS VDD VSS gf180mcu_fd_sc_mcu7t5v0__fillcap_64
XFILLER_45_632 VDD VSS VDD VSS gf180mcu_fd_sc_mcu7t5v0__fillcap_64
XFILLER_233_766 VDD VSS VDD VSS gf180mcu_fd_sc_mcu7t5v0__fillcap_4
XFILLER_72_451 VDD VSS VDD VSS gf180mcu_fd_sc_mcu7t5v0__fillcap_4
XFILLER_189_158 VDD VSS VDD VSS gf180mcu_fd_sc_mcu7t5v0__fillcap_8
XFILLER_13_562 VDD VSS VDD VSS gf180mcu_fd_sc_mcu7t5v0__fillcap_64
XFILLER_71_72 VDD VSS VDD VSS gf180mcu_fd_sc_mcu7t5v0__fillcap_64
XFILLER_40_381 VDD VSS VDD VSS gf180mcu_fd_sc_mcu7t5v0__fillcap_4
XFILLER_201_696 VDD VSS VDD VSS gf180mcu_fd_sc_mcu7t5v0__fillcap_4
XFILLER_187_72 VDD VSS VDD VSS gf180mcu_fd_sc_mcu7t5v0__fillcap_16
XFILLER_145_228 VDD VSS VDD VSS gf180mcu_fd_sc_mcu7t5v0__fillcap_8
X_2570_ _2587_/S VDD VSS _3238_/D _3215_/Q _3238_/Q VDD VSS gf180mcu_fd_sc_mcu7t5v0__mux2_2
X_1521_ VDD VSS _3376_/D _3381_/Q _1521_/A2 VDD VSS gf180mcu_fd_sc_mcu7t5v0__xnor2_1
XFILLER_5_772 VDD VSS VDD VSS gf180mcu_fd_sc_mcu7t5v0__fillcap_64
X_1452_ VDD VSS _3360_/D _2228_/A1 VDD VSS gf180mcu_fd_sc_mcu7t5v0__clkinv_1
XFILLER_113_136 VDD VSS VDD VSS gf180mcu_fd_sc_mcu7t5v0__fillcap_4
X_3122_ _3122_/D _3122_/Q _3457_/RN VSS _3380_/CLK VDD VDD VSS gf180mcu_fd_sc_mcu7t5v0__dffrnq_1
X_1383_ VDD VSS _3370_/Q _1796_/A2 VDD VSS gf180mcu_fd_sc_mcu7t5v0__clkinv_1
XFILLER_67_212 VDD VSS VDD VSS gf180mcu_fd_sc_mcu7t5v0__fillcap_64
XFILLER_228_527 VDD VSS VDD VSS gf180mcu_fd_sc_mcu7t5v0__fillcap_64
XFILLER_255_346 VDD VSS VDD VSS gf180mcu_fd_sc_mcu7t5v0__fillcap_4
X_3053_ VDD _3053_/Q _3059_/CLK VSS _3053_/D VDD VSS gf180mcu_fd_sc_mcu7t5v0__dffq_1
X_2004_ _2009_/S VDD VSS _3047_/D wire121/Z _3047_/Q VDD VSS gf180mcu_fd_sc_mcu7t5v0__mux2_2
XFILLER_35_142 VDD VSS VDD VSS gf180mcu_fd_sc_mcu7t5v0__fillcap_64
XFILLER_223_276 VDD VSS VDD VSS gf180mcu_fd_sc_mcu7t5v0__fillcap_4
XFILLER_50_101 VDD VSS VDD VSS gf180mcu_fd_sc_mcu7t5v0__fillcap_4
X_2906_ VDD _2906_/Q _2914_/CLK VSS _2906_/D VDD VSS gf180mcu_fd_sc_mcu7t5v0__dffq_1
XFILLER_32_871 VDD VSS VDD VSS gf180mcu_fd_sc_mcu7t5v0__fillcap_4
XFILLER_149_578 VDD VSS VDD VSS gf180mcu_fd_sc_mcu7t5v0__fillcap_8
X_2837_ VDD _2837_/Q _2914_/CLK VSS _2837_/D VDD VSS gf180mcu_fd_sc_mcu7t5v0__dffq_1
X_2768_ VDD VSS _2768_/I _3325_/D VDD VSS gf180mcu_fd_sc_mcu7t5v0__clkinv_1
X_1719_ VDD VSS _1720_/C _1720_/A2 _1719_/A2 VDD VSS gf180mcu_fd_sc_mcu7t5v0__nor2_1
X_2699_ _2699_/B _2724_/C VDD VSS _2705_/A1 _2732_/C _2698_/Z VDD VSS gf180mcu_fd_sc_mcu7t5v0__oai211_1
XFILLER_105_604 VDD VSS VDD VSS gf180mcu_fd_sc_mcu7t5v0__fillcap_16
XFILLER_105_659 VDD VSS VDD VSS gf180mcu_fd_sc_mcu7t5v0__fillcap_8
XFILLER_59_702 VDD VSS VDD VSS gf180mcu_fd_sc_mcu7t5v0__fillcap_64
XFILLER_247_836 VDD VSS VDD VSS gf180mcu_fd_sc_mcu7t5v0__fillcap_4
XFILLER_259_696 VDD VSS VDD VSS gf180mcu_fd_sc_mcu7t5v0__fillcap_4
XFILLER_39_492 VDD VSS VDD VSS gf180mcu_fd_sc_mcu7t5v0__fillcap_64
XFILLER_27_632 VDD VSS VDD VSS gf180mcu_fd_sc_mcu7t5v0__fillcap_64
XFILLER_215_766 VDD VSS VDD VSS gf180mcu_fd_sc_mcu7t5v0__fillcap_4
XFILLER_54_451 VDD VSS VDD VSS gf180mcu_fd_sc_mcu7t5v0__fillcap_4
XFILLER_199_478 VDD VSS VDD VSS gf180mcu_fd_sc_mcu7t5v0__fillcap_4
XFILLER_10_521 VDD VSS VDD VSS gf180mcu_fd_sc_mcu7t5v0__fillcap_4
XFILLER_22_381 VDD VSS VDD VSS gf180mcu_fd_sc_mcu7t5v0__fillcap_4
XFILLER_210_2 VDD VSS VDD VSS gf180mcu_fd_sc_mcu7t5v0__fillcap_32
XFILLER_170_518 VDD VSS VDD VSS gf180mcu_fd_sc_mcu7t5v0__fillcap_4
XFILLER_2_731 VDD VSS VDD VSS gf180mcu_fd_sc_mcu7t5v0__fillcap_4
XFILLER_173_63 VDD VSS VDD VSS gf180mcu_fd_sc_mcu7t5v0__fillcap_4
XFILLER_49_212 VDD VSS VDD VSS gf180mcu_fd_sc_mcu7t5v0__fillcap_64
XFILLER_237_346 VDD VSS VDD VSS gf180mcu_fd_sc_mcu7t5v0__fillcap_4
XFILLER_17_142 VDD VSS VDD VSS gf180mcu_fd_sc_mcu7t5v0__fillcap_64
XFILLER_32_101 VDD VSS VDD VSS gf180mcu_fd_sc_mcu7t5v0__fillcap_4
XFILLER_177_106 VDD VSS VDD VSS gf180mcu_fd_sc_mcu7t5v0__fillcap_8
XFILLER_177_128 VDD VSS VDD VSS gf180mcu_fd_sc_mcu7t5v0__fillcap_4
XFILLER_14_871 VDD VSS VDD VSS gf180mcu_fd_sc_mcu7t5v0__fillcap_4
XFILLER_9_352 VDD VSS VDD VSS gf180mcu_fd_sc_mcu7t5v0__fillcap_64
XFILLER_173_345 VDD VSS VDD VSS gf180mcu_fd_sc_mcu7t5v0__fillcap_4
X_2622_ wire46/I VDD VSS _3285_/D _3243_/Q wire89/I VDD VSS gf180mcu_fd_sc_mcu7t5v0__mux2_2
XFILLER_56_2 VDD VSS VDD VSS gf180mcu_fd_sc_mcu7t5v0__fillcap_32
X_2553_ _2553_/B VDD VSS _3225_/D _2553_/A1 _2553_/A2 VDD VSS gf180mcu_fd_sc_mcu7t5v0__aoi21_1
X_1504_ VDD VSS _3367_/D _3367_/Q _1497_/I VDD VSS gf180mcu_fd_sc_mcu7t5v0__xor2_1
X_2484_ _2316_/C _2484_/B1 _1715_/B VDD VSS _2485_/A2 _2484_/A1 VDD VSS gf180mcu_fd_sc_mcu7t5v0__oai22_1
X_1435_ VDD VSS _3344_/Q _1551_/A1 VDD VSS gf180mcu_fd_sc_mcu7t5v0__clkinv_1
XFILLER_68_521 VDD VSS VDD VSS gf180mcu_fd_sc_mcu7t5v0__fillcap_4
XFILLER_102_629 VDD VSS VDD VSS gf180mcu_fd_sc_mcu7t5v0__fillcap_16
XFILLER_229_836 VDD VSS VDD VSS gf180mcu_fd_sc_mcu7t5v0__fillcap_4
XFILLER_233_66 VDD VSS VDD VSS gf180mcu_fd_sc_mcu7t5v0__fillcap_4
X_3105_ _3105_/D _3105_/Q wire153/Z VSS _3109_/CLK VDD VDD VSS gf180mcu_fd_sc_mcu7t5v0__dffrnq_1
XFILLER_96_885 VDD VSS VDD VSS gf180mcu_fd_sc_mcu7t5v0__fillcap_4
X_3036_ VDD _3036_/Q _3044_/CLK VSS _3036_/D VDD VSS gf180mcu_fd_sc_mcu7t5v0__dffq_1
XFILLER_36_451 VDD VSS VDD VSS gf180mcu_fd_sc_mcu7t5v0__fillcap_4
XFILLER_102_37 VDD VSS VDD VSS gf180mcu_fd_sc_mcu7t5v0__fillcap_32
XFILLER_168_139 VDD VSS VDD VSS gf180mcu_fd_sc_mcu7t5v0__fillcap_8
XFILLER_20_885 VDD VSS VDD VSS gf180mcu_fd_sc_mcu7t5v0__fillcap_4
XFILLER_191_142 VDD VSS VDD VSS gf180mcu_fd_sc_mcu7t5v0__fillcap_32
XFILLER_152_518 VDD VSS VDD VSS gf180mcu_fd_sc_mcu7t5v0__fillcap_4
XFILLER_191_186 VDD VSS VDD VSS gf180mcu_fd_sc_mcu7t5v0__fillcap_4
XFILLER_127_56 VDD VSS VDD VSS gf180mcu_fd_sc_mcu7t5v0__fillcap_8
XFILLER_160_584 VDD VSS VDD VSS gf180mcu_fd_sc_mcu7t5v0__fillcap_8
XFILLER_120_426 VDD VSS VDD VSS gf180mcu_fd_sc_mcu7t5v0__fillcap_8
XFILLER_219_324 VDD VSS VDD VSS gf180mcu_fd_sc_mcu7t5v0__fillcap_16
XFILLER_87_874 VDD VSS VDD VSS gf180mcu_fd_sc_mcu7t5v0__fillcap_16
XFILLER_219_368 VDD VSS VDD VSS gf180mcu_fd_sc_mcu7t5v0__fillcap_8
XFILLER_101_695 VDD VSS VDD VSS gf180mcu_fd_sc_mcu7t5v0__fillcap_4
XFILLER_258_2 VDD VSS VDD VSS gf180mcu_fd_sc_mcu7t5v0__fillcap_32
XFILLER_160_2 VDD VSS VDD VSS gf180mcu_fd_sc_mcu7t5v0__fillcap_32
XFILLER_14_101 VDD VSS VDD VSS gf180mcu_fd_sc_mcu7t5v0__fillcap_4
XFILLER_159_128 VDD VSS VDD VSS gf180mcu_fd_sc_mcu7t5v0__fillcap_8
XFILLER_187_437 VDD VSS VDD VSS gf180mcu_fd_sc_mcu7t5v0__fillcap_8
XFILLER_183_632 VDD VSS VDD VSS gf180mcu_fd_sc_mcu7t5v0__fillcap_32
XFILLER_195_492 VDD VSS VDD VSS gf180mcu_fd_sc_mcu7t5v0__fillcap_32
XFILLER_11_874 VDD VSS VDD VSS gf180mcu_fd_sc_mcu7t5v0__fillcap_16
XFILLER_6_311 VDD VSS VDD VSS gf180mcu_fd_sc_mcu7t5v0__fillcap_4
XFILLER_184_84 VDD VSS VDD VSS gf180mcu_fd_sc_mcu7t5v0__fillcap_16
XFILLER_78_885 VDD VSS VDD VSS gf180mcu_fd_sc_mcu7t5v0__fillcap_4
XFILLER_92_365 VDD VSS VDD VSS gf180mcu_fd_sc_mcu7t5v0__fillcap_4
XFILLER_18_451 VDD VSS VDD VSS gf180mcu_fd_sc_mcu7t5v0__fillcap_4
XFILLER_92_387 VDD VSS VDD VSS gf180mcu_fd_sc_mcu7t5v0__fillcap_32
XFILLER_80_527 VDD VSS VDD VSS gf180mcu_fd_sc_mcu7t5v0__fillcap_64
X_1984_ _1991_/S VDD VSS _3029_/D _3029_/Q _2011_/I0 VDD VSS gf180mcu_fd_sc_mcu7t5v0__mux2_2
XFILLER_173_142 VDD VSS VDD VSS gf180mcu_fd_sc_mcu7t5v0__fillcap_16
XFILLER_173_120 VDD VSS VDD VSS gf180mcu_fd_sc_mcu7t5v0__fillcap_16
X_2605_ _2619_/S VDD VSS _3272_/D _3232_/Q _3272_/Q VDD VSS gf180mcu_fd_sc_mcu7t5v0__mux2_2
XFILLER_170_871 VDD VSS VDD VSS gf180mcu_fd_sc_mcu7t5v0__fillcap_4
X_2536_ _2537_/S VDD VSS _3217_/D _3216_/Q _3217_/Q VDD VSS gf180mcu_fd_sc_mcu7t5v0__mux2_2
X_2467_ VDD _2467_/B _2467_/A2 _3203_/D _2467_/A1 VSS VDD VSS gf180mcu_fd_sc_mcu7t5v0__oai21_1
X_1418_ VDD VSS _3141_/Q _2179_/A1 VDD VSS gf180mcu_fd_sc_mcu7t5v0__clkinv_1
X_2398_ _2863_/Q VSS VDD _2847_/Q _2855_/Q wire78/Z _2839_/Q wire76/Z _2398_/Z VDD
+ VSS gf180mcu_fd_sc_mcu7t5v0__mux4_1
XFILLER_69_874 VDD VSS VDD VSS gf180mcu_fd_sc_mcu7t5v0__fillcap_16
XFILLER_96_682 VDD VSS VDD VSS gf180mcu_fd_sc_mcu7t5v0__fillcap_32
XFILLER_84_877 VDD VSS VDD VSS gf180mcu_fd_sc_mcu7t5v0__fillcap_8
XFILLER_73_18 VDD VSS VDD VSS gf180mcu_fd_sc_mcu7t5v0__fillcap_8
X_3019_ VDD _3019_/Q _3039_/CLK VSS _3019_/D VDD VSS gf180mcu_fd_sc_mcu7t5v0__dffq_1
Xwire96 VSS wire96/Z wire96/I VDD VDD VSS gf180mcu_fd_sc_mcu7t5v0__buf_1
Xwire85 VSS wire85/Z wire85/I VDD VDD VSS gf180mcu_fd_sc_mcu7t5v0__buf_1
XFILLER_149_161 VDD VSS VDD VSS gf180mcu_fd_sc_mcu7t5v0__fillcap_32
XFILLER_184_429 VDD VSS VDD VSS gf180mcu_fd_sc_mcu7t5v0__fillcap_16
XFILLER_165_632 VDD VSS VDD VSS gf180mcu_fd_sc_mcu7t5v0__fillcap_64
XFILLER_177_492 VDD VSS VDD VSS gf180mcu_fd_sc_mcu7t5v0__fillcap_32
XFILLER_164_120 VDD VSS VDD VSS gf180mcu_fd_sc_mcu7t5v0__fillcap_4
XFILLER_192_473 VDD VSS VDD VSS gf180mcu_fd_sc_mcu7t5v0__fillcap_8
XFILLER_125_507 VDD VSS VDD VSS gf180mcu_fd_sc_mcu7t5v0__fillcap_32
XFILLER_98_37 VDD VSS VDD VSS gf180mcu_fd_sc_mcu7t5v0__fillcap_8
XFILLER_133_562 VDD VSS VDD VSS gf180mcu_fd_sc_mcu7t5v0__fillcap_32
XFILLER_121_702 VDD VSS VDD VSS gf180mcu_fd_sc_mcu7t5v0__fillcap_64
XFILLER_120_201 VDD VSS VDD VSS gf180mcu_fd_sc_mcu7t5v0__fillcap_4
XFILLER_105_297 VDD VSS VDD VSS gf180mcu_fd_sc_mcu7t5v0__fillcap_8
XFILLER_74_310 VDD VSS VDD VSS gf180mcu_fd_sc_mcu7t5v0__fillcap_4
XFILLER_101_492 VDD VSS VDD VSS gf180mcu_fd_sc_mcu7t5v0__fillcap_16
XFILLER_86_170 VDD VSS VDD VSS gf180mcu_fd_sc_mcu7t5v0__fillcap_4
XFILLER_74_387 VDD VSS VDD VSS gf180mcu_fd_sc_mcu7t5v0__fillcap_64
XFILLER_62_527 VDD VSS VDD VSS gf180mcu_fd_sc_mcu7t5v0__fillcap_64
XFILLER_231_842 VDD VSS VDD VSS gf180mcu_fd_sc_mcu7t5v0__fillcap_32
XFILLER_203_555 VDD VSS VDD VSS gf180mcu_fd_sc_mcu7t5v0__fillcap_4
XFILLER_179_40 VDD VSS VDD VSS gf180mcu_fd_sc_mcu7t5v0__fillcap_16
XFILLER_30_457 VDD VSS VDD VSS gf180mcu_fd_sc_mcu7t5v0__fillcap_64
Xmax_length160 _3403_/RN wire161/Z VDD VSS VDD VSS gf180mcu_fd_sc_mcu7t5v0__buf_8
XFILLER_155_142 VDD VSS VDD VSS gf180mcu_fd_sc_mcu7t5v0__fillcap_4
XFILLER_170_101 VDD VSS VDD VSS gf180mcu_fd_sc_mcu7t5v0__fillcap_4
X_3370_ _3370_/D _3370_/Q _3458_/RN VSS _3370_/CLK VDD VDD VSS gf180mcu_fd_sc_mcu7t5v0__dffrnq_1
XFILLER_152_871 VDD VSS VDD VSS gf180mcu_fd_sc_mcu7t5v0__fillcap_4
X_2321_ VDD VSS _2322_/B _3185_/Q _2336_/B VDD VSS gf180mcu_fd_sc_mcu7t5v0__nand2_1
X_2252_ _2836_/Q VSS VDD _2820_/Q _2828_/Q wire78/I _2812_/Q wire76/Z _2252_/Z VDD
+ VSS gf180mcu_fd_sc_mcu7t5v0__mux4_1
XFILLER_84_107 VDD VSS VDD VSS gf180mcu_fd_sc_mcu7t5v0__fillcap_64
X_2183_ _2184_/S VDD VSS _3144_/D _3181_/Q _3144_/Q VDD VSS gf180mcu_fd_sc_mcu7t5v0__mux2_2
XFILLER_19_2 VDD VSS VDD VSS gf180mcu_fd_sc_mcu7t5v0__fillcap_64
XFILLER_77_192 VDD VSS VDD VSS gf180mcu_fd_sc_mcu7t5v0__fillcap_16
XFILLER_253_422 VDD VSS VDD VSS gf180mcu_fd_sc_mcu7t5v0__fillcap_64
XFILLER_265_282 VDD VSS VDD VSS gf180mcu_fd_sc_mcu7t5v0__fillcap_64
XFILLER_66_877 VDD VSS VDD VSS gf180mcu_fd_sc_mcu7t5v0__fillcap_8
XFILLER_81_836 VDD VSS VDD VSS gf180mcu_fd_sc_mcu7t5v0__fillcap_4
XFILLER_179_702 VDD VSS VDD VSS gf180mcu_fd_sc_mcu7t5v0__fillcap_64
XFILLER_221_352 VDD VSS VDD VSS gf180mcu_fd_sc_mcu7t5v0__fillcap_4
XFILLER_178_289 VDD VSS VDD VSS gf180mcu_fd_sc_mcu7t5v0__fillcap_16
X_1967_ _1972_/S VDD VSS _3015_/D wire121/Z _3015_/Q VDD VSS gf180mcu_fd_sc_mcu7t5v0__mux2_2
XFILLER_174_451 VDD VSS VDD VSS gf180mcu_fd_sc_mcu7t5v0__fillcap_4
XFILLER_174_473 VDD VSS VDD VSS gf180mcu_fd_sc_mcu7t5v0__fillcap_4
X_1898_ _1898_/A3 _3406_/Q VDD VSS _2010_/A1 _3408_/Q _3407_/Q VDD VSS gf180mcu_fd_sc_mcu7t5v0__nor4_1
XFILLER_162_657 VDD VSS VDD VSS gf180mcu_fd_sc_mcu7t5v0__fillcap_8
XFILLER_103_702 VDD VSS VDD VSS gf180mcu_fd_sc_mcu7t5v0__fillcap_64
X_2519_ _2525_/B1 _3318_/Q VDD VSS _2520_/A3 _3310_/Q _1640_/I VDD VSS gf180mcu_fd_sc_mcu7t5v0__aoi22_1
XFILLER_115_562 VDD VSS VDD VSS gf180mcu_fd_sc_mcu7t5v0__fillcap_16
XFILLER_142_381 VDD VSS VDD VSS gf180mcu_fd_sc_mcu7t5v0__fillcap_4
XFILLER_102_234 VDD VSS VDD VSS gf180mcu_fd_sc_mcu7t5v0__fillcap_8
XFILLER_88_435 VDD VSS VDD VSS gf180mcu_fd_sc_mcu7t5v0__fillcap_4
XFILLER_88_457 VDD VSS VDD VSS gf180mcu_fd_sc_mcu7t5v0__fillcap_16
XFILLER_75_118 VDD VSS VDD VSS gf180mcu_fd_sc_mcu7t5v0__fillcap_16
XFILLER_257_772 VDD VSS VDD VSS gf180mcu_fd_sc_mcu7t5v0__fillcap_64
XFILLER_56_387 VDD VSS VDD VSS gf180mcu_fd_sc_mcu7t5v0__fillcap_64
XFILLER_216_157 VDD VSS VDD VSS gf180mcu_fd_sc_mcu7t5v0__fillcap_16
XFILLER_140_23 VDD VSS VDD VSS gf180mcu_fd_sc_mcu7t5v0__fillcap_8
XFILLER_44_527 VDD VSS VDD VSS gf180mcu_fd_sc_mcu7t5v0__fillcap_64
XFILLER_71_346 VDD VSS VDD VSS gf180mcu_fd_sc_mcu7t5v0__fillcap_4
XFILLER_17_66 VDD VSS VDD VSS gf180mcu_fd_sc_mcu7t5v0__fillcap_4
XFILLER_213_842 VDD VSS VDD VSS gf180mcu_fd_sc_mcu7t5v0__fillcap_32
XFILLER_212_341 VDD VSS VDD VSS gf180mcu_fd_sc_mcu7t5v0__fillcap_4
XFILLER_240_661 VDD VSS VDD VSS gf180mcu_fd_sc_mcu7t5v0__fillcap_4
XFILLER_212_374 VDD VSS VDD VSS gf180mcu_fd_sc_mcu7t5v0__fillcap_8
XFILLER_138_621 VDD VSS VDD VSS gf180mcu_fd_sc_mcu7t5v0__fillcap_16
XFILLER_12_457 VDD VSS VDD VSS gf180mcu_fd_sc_mcu7t5v0__fillcap_64
XFILLER_184_259 VDD VSS VDD VSS gf180mcu_fd_sc_mcu7t5v0__fillcap_4
XFILLER_137_142 VDD VSS VDD VSS gf180mcu_fd_sc_mcu7t5v0__fillcap_8
XFILLER_180_421 VDD VSS VDD VSS gf180mcu_fd_sc_mcu7t5v0__fillcap_4
XFILLER_165_42 VDD VSS VDD VSS gf180mcu_fd_sc_mcu7t5v0__fillcap_16
XFILLER_4_667 VDD VSS VDD VSS gf180mcu_fd_sc_mcu7t5v0__fillcap_64
XFILLER_134_871 VDD VSS VDD VSS gf180mcu_fd_sc_mcu7t5v0__fillcap_4
XFILLER_66_107 VDD VSS VDD VSS gf180mcu_fd_sc_mcu7t5v0__fillcap_64
XFILLER_235_422 VDD VSS VDD VSS gf180mcu_fd_sc_mcu7t5v0__fillcap_64
XFILLER_247_282 VDD VSS VDD VSS gf180mcu_fd_sc_mcu7t5v0__fillcap_64
XFILLER_48_877 VDD VSS VDD VSS gf180mcu_fd_sc_mcu7t5v0__fillcap_8
XFILLER_262_241 VDD VSS VDD VSS gf180mcu_fd_sc_mcu7t5v0__fillcap_4
XFILLER_207_135 VDD VSS VDD VSS gf180mcu_fd_sc_mcu7t5v0__fillcap_4
XFILLER_63_836 VDD VSS VDD VSS gf180mcu_fd_sc_mcu7t5v0__fillcap_4
XFILLER_75_696 VDD VSS VDD VSS gf180mcu_fd_sc_mcu7t5v0__fillcap_4
XFILLER_203_330 VDD VSS VDD VSS gf180mcu_fd_sc_mcu7t5v0__fillcap_4
X_2870_ VDD _2870_/Q _2932_/CLK VSS _2870_/D VDD VSS gf180mcu_fd_sc_mcu7t5v0__dffq_1
XFILLER_200_37 VDD VSS VDD VSS gf180mcu_fd_sc_mcu7t5v0__fillcap_32
X_1821_ _1823_/S VDD VSS _2890_/D wire130/Z _2890_/Q VDD VSS gf180mcu_fd_sc_mcu7t5v0__mux2_2
XFILLER_230_171 VDD VSS VDD VSS gf180mcu_fd_sc_mcu7t5v0__fillcap_4
XFILLER_31_766 VDD VSS VDD VSS gf180mcu_fd_sc_mcu7t5v0__fillcap_4
XFILLER_129_610 VDD VSS VDD VSS gf180mcu_fd_sc_mcu7t5v0__fillcap_8
XFILLER_129_632 VDD VSS VDD VSS gf180mcu_fd_sc_mcu7t5v0__fillcap_16
X_1752_ _1758_/S VDD VSS _2830_/D _3120_/Q _2830_/Q VDD VSS gf180mcu_fd_sc_mcu7t5v0__mux2_2
XFILLER_156_451 VDD VSS VDD VSS gf180mcu_fd_sc_mcu7t5v0__fillcap_4
XFILLER_209_57 VDD VSS VDD VSS gf180mcu_fd_sc_mcu7t5v0__fillcap_8
X_1683_ _3195_/Q _2362_/A1 VDD VSS _1683_/Z _1704_/A3 _3363_/Q VDD VSS gf180mcu_fd_sc_mcu7t5v0__or4_1
X_3422_ _3422_/D wire59/I wire163/Z VSS _3427_/CLK VDD VDD VSS gf180mcu_fd_sc_mcu7t5v0__dffrnq_1
X_3353_ VSS _3360_/CLK VDD _3353_/D _3353_/Q wire153/Z VDD VSS gf180mcu_fd_sc_mcu7t5v0__dffsnq_1
XFILLER_140_885 VDD VSS VDD VSS gf180mcu_fd_sc_mcu7t5v0__fillcap_4
X_2304_ VDD _3101_/Q _3094_/Q _2306_/A3 _2304_/A1 VSS VDD VSS gf180mcu_fd_sc_mcu7t5v0__oai21_1
X_3284_ _3284_/D wire90/I wire165/Z VSS _3450_/CLK VDD VDD VSS gf180mcu_fd_sc_mcu7t5v0__dffrnq_1
XFILLER_85_416 VDD VSS VDD VSS gf180mcu_fd_sc_mcu7t5v0__fillcap_4
XFILLER_239_772 VDD VSS VDD VSS gf180mcu_fd_sc_mcu7t5v0__fillcap_64
X_2235_ VDD _2235_/B _2235_/A2 _2236_/A2 _2485_/A1 VSS VDD VSS gf180mcu_fd_sc_mcu7t5v0__oai21_1
XFILLER_254_731 VDD VSS VDD VSS gf180mcu_fd_sc_mcu7t5v0__fillcap_4
XFILLER_266_591 VDD VSS VDD VSS gf180mcu_fd_sc_mcu7t5v0__fillcap_4
X_2166_ VDD VSS _2166_/Z _2157_/Z _2166_/A2 VDD VSS gf180mcu_fd_sc_mcu7t5v0__and2_1
XFILLER_38_387 VDD VSS VDD VSS gf180mcu_fd_sc_mcu7t5v0__fillcap_64
XFILLER_241_66 VDD VSS VDD VSS gf180mcu_fd_sc_mcu7t5v0__fillcap_4
XFILLER_26_527 VDD VSS VDD VSS gf180mcu_fd_sc_mcu7t5v0__fillcap_64
X_2097_ _2092_/Z VDD VSS _2100_/A2 _3107_/Q _2074_/Z VDD VSS gf180mcu_fd_sc_mcu7t5v0__nand3_1
XFILLER_53_346 VDD VSS VDD VSS gf180mcu_fd_sc_mcu7t5v0__fillcap_4
XFILLER_210_801 VDD VSS VDD VSS gf180mcu_fd_sc_mcu7t5v0__fillcap_4
XFILLER_179_543 VDD VSS VDD VSS gf180mcu_fd_sc_mcu7t5v0__fillcap_8
XFILLER_110_37 VDD VSS VDD VSS gf180mcu_fd_sc_mcu7t5v0__fillcap_16
XFILLER_194_535 VDD VSS VDD VSS gf180mcu_fd_sc_mcu7t5v0__fillcap_4
X_2999_ VDD _2999_/Q _3006_/CLK VSS _2999_/D VDD VSS gf180mcu_fd_sc_mcu7t5v0__dffq_1
XFILLER_21_276 VDD VSS VDD VSS gf180mcu_fd_sc_mcu7t5v0__fillcap_4
XFILLER_119_131 VDD VSS VDD VSS gf180mcu_fd_sc_mcu7t5v0__fillcap_8
XFILLER_134_101 VDD VSS VDD VSS gf180mcu_fd_sc_mcu7t5v0__fillcap_4
XFILLER_1_626 VDD VSS VDD VSS gf180mcu_fd_sc_mcu7t5v0__fillcap_4
XFILLER_116_871 VDD VSS VDD VSS gf180mcu_fd_sc_mcu7t5v0__fillcap_4
XFILLER_89_766 VDD VSS VDD VSS gf180mcu_fd_sc_mcu7t5v0__fillcap_4
XFILLER_131_874 VDD VSS VDD VSS gf180mcu_fd_sc_mcu7t5v0__fillcap_16
XFILLER_48_107 VDD VSS VDD VSS gf180mcu_fd_sc_mcu7t5v0__fillcap_64
XFILLER_95_38 VDD VSS VDD VSS gf180mcu_fd_sc_mcu7t5v0__fillcap_32
XFILLER_28_10 VDD VSS VDD VSS gf180mcu_fd_sc_mcu7t5v0__fillcap_16
XFILLER_229_282 VDD VSS VDD VSS gf180mcu_fd_sc_mcu7t5v0__fillcap_64
XFILLER_217_422 VDD VSS VDD VSS gf180mcu_fd_sc_mcu7t5v0__fillcap_8
XFILLER_217_466 VDD VSS VDD VSS gf180mcu_fd_sc_mcu7t5v0__fillcap_16
XFILLER_244_241 VDD VSS VDD VSS gf180mcu_fd_sc_mcu7t5v0__fillcap_4
XFILLER_45_836 VDD VSS VDD VSS gf180mcu_fd_sc_mcu7t5v0__fillcap_4
XFILLER_57_696 VDD VSS VDD VSS gf180mcu_fd_sc_mcu7t5v0__fillcap_4
XFILLER_198_885 VDD VSS VDD VSS gf180mcu_fd_sc_mcu7t5v0__fillcap_4
XFILLER_13_766 VDD VSS VDD VSS gf180mcu_fd_sc_mcu7t5v0__fillcap_4
XFILLER_185_546 VDD VSS VDD VSS gf180mcu_fd_sc_mcu7t5v0__fillcap_8
XFILLER_8_247 VDD VSS VDD VSS gf180mcu_fd_sc_mcu7t5v0__fillcap_64
XFILLER_180_240 VDD VSS VDD VSS gf180mcu_fd_sc_mcu7t5v0__fillcap_4
XFILLER_69_72 VDD VSS VDD VSS gf180mcu_fd_sc_mcu7t5v0__fillcap_64
XFILLER_192_95 VDD VSS VDD VSS gf180mcu_fd_sc_mcu7t5v0__fillcap_8
XFILLER_67_416 VDD VSS VDD VSS gf180mcu_fd_sc_mcu7t5v0__fillcap_4
XFILLER_122_885 VDD VSS VDD VSS gf180mcu_fd_sc_mcu7t5v0__fillcap_4
XFILLER_236_731 VDD VSS VDD VSS gf180mcu_fd_sc_mcu7t5v0__fillcap_4
XFILLER_248_591 VDD VSS VDD VSS gf180mcu_fd_sc_mcu7t5v0__fillcap_4
X_2020_ _2020_/B VDD VSS _3061_/D _2020_/A1 _3455_/Q VDD VSS gf180mcu_fd_sc_mcu7t5v0__aoi21_1
XFILLER_94_279 VDD VSS VDD VSS gf180mcu_fd_sc_mcu7t5v0__fillcap_32
XFILLER_35_346 VDD VSS VDD VSS gf180mcu_fd_sc_mcu7t5v0__fillcap_4
XFILLER_189_874 VDD VSS VDD VSS gf180mcu_fd_sc_mcu7t5v0__fillcap_16
X_2922_ VDD _2922_/Q _2932_/CLK VSS _2922_/D VDD VSS gf180mcu_fd_sc_mcu7t5v0__dffq_1
X_2853_ VDD _2853_/Q _2914_/CLK VSS _2853_/D VDD VSS gf180mcu_fd_sc_mcu7t5v0__dffq_1
X_1804_ _1805_/S VDD VSS _2875_/D wire128/Z _2875_/Q VDD VSS gf180mcu_fd_sc_mcu7t5v0__mux2_2
X_2784_ VDD VSS _2784_/I _3333_/D VDD VSS gf180mcu_fd_sc_mcu7t5v0__clkinv_1
X_1735_ _1738_/S VDD VSS _2817_/D _2817_/Q wire132/Z VDD VSS gf180mcu_fd_sc_mcu7t5v0__mux2_2
XFILLER_156_281 VDD VSS VDD VSS gf180mcu_fd_sc_mcu7t5v0__fillcap_32
XFILLER_144_443 VDD VSS VDD VSS gf180mcu_fd_sc_mcu7t5v0__fillcap_8
Xhold225 _3429_/D VSS _3434_/Q VDD VDD VSS gf180mcu_fd_sc_mcu7t5v0__dlyc_1
Xhold214 _3447_/D VSS _3446_/Q VDD VDD VSS gf180mcu_fd_sc_mcu7t5v0__dlyc_1
Xclkbuf_leaf_2_clk_i _3451_/CLK VSS VDD clkload0/I VDD VSS gf180mcu_fd_sc_mcu7t5v0__clkbuf_2
X_1666_ VDD VSS _2485_/A1 _2262_/B _2480_/A3 VDD VSS gf180mcu_fd_sc_mcu7t5v0__nand2_1
X_3405_ _3405_/D _3405_/Q wire161/Z VSS _3405_/CLK VDD VDD VSS gf180mcu_fd_sc_mcu7t5v0__dffrnq_1
XFILLER_258_311 VDD VSS VDD VSS gf180mcu_fd_sc_mcu7t5v0__fillcap_4
X_1597_ _2187_/A2 _1597_/A4 VDD VSS _1598_/B _2470_/B _2171_/A1 VDD VSS gf180mcu_fd_sc_mcu7t5v0__and4_1
X_3336_ _3336_/D _3336_/Q _3336_/RN VSS _3336_/CLK VDD VDD VSS gf180mcu_fd_sc_mcu7t5v0__dffrnq_1
XFILLER_113_874 VDD VSS VDD VSS gf180mcu_fd_sc_mcu7t5v0__fillcap_16
X_3267_ _3267_/D _3267_/Q wire165/Z VSS clkload8/I VDD VDD VSS gf180mcu_fd_sc_mcu7t5v0__dffrnq_1
XFILLER_226_241 VDD VSS VDD VSS gf180mcu_fd_sc_mcu7t5v0__fillcap_4
X_2218_ _2219_/S VDD VSS _3164_/D wire94/I _3164_/Q VDD VSS gf180mcu_fd_sc_mcu7t5v0__mux2_2
X_3198_ _3198_/D _3198_/Q _3344_/RN VSS _3202_/CLK VDD VDD VSS gf180mcu_fd_sc_mcu7t5v0__dffrnq_1
XFILLER_39_696 VDD VSS VDD VSS gf180mcu_fd_sc_mcu7t5v0__fillcap_4
XFILLER_27_836 VDD VSS VDD VSS gf180mcu_fd_sc_mcu7t5v0__fillcap_4
XFILLER_199_605 VDD VSS VDD VSS gf180mcu_fd_sc_mcu7t5v0__fillcap_16
X_2149_ _3162_/Q _2149_/C VDD VSS _2152_/B1 _3153_/Q _2168_/A2 _2168_/B1 VDD VSS gf180mcu_fd_sc_mcu7t5v0__aoi221_1
XFILLER_81_18 VDD VSS VDD VSS gf180mcu_fd_sc_mcu7t5v0__fillcap_4
XFILLER_175_590 VDD VSS VDD VSS gf180mcu_fd_sc_mcu7t5v0__fillcap_4
XFILLER_194_387 VDD VSS VDD VSS gf180mcu_fd_sc_mcu7t5v0__fillcap_8
XFILLER_5_206 VDD VSS VDD VSS gf180mcu_fd_sc_mcu7t5v0__fillcap_4
XFILLER_107_134 VDD VSS VDD VSS gf180mcu_fd_sc_mcu7t5v0__fillcap_4
XFILLER_150_457 VDD VSS VDD VSS gf180mcu_fd_sc_mcu7t5v0__fillcap_8
XFILLER_146_99 VDD VSS VDD VSS gf180mcu_fd_sc_mcu7t5v0__fillcap_4
XFILLER_104_885 VDD VSS VDD VSS gf180mcu_fd_sc_mcu7t5v0__fillcap_4
XFILLER_103_395 VDD VSS VDD VSS gf180mcu_fd_sc_mcu7t5v0__fillcap_4
XFILLER_76_224 VDD VSS VDD VSS gf180mcu_fd_sc_mcu7t5v0__fillcap_8
XFILLER_49_416 VDD VSS VDD VSS gf180mcu_fd_sc_mcu7t5v0__fillcap_4
XFILLER_218_731 VDD VSS VDD VSS gf180mcu_fd_sc_mcu7t5v0__fillcap_4
XFILLER_17_346 VDD VSS VDD VSS gf180mcu_fd_sc_mcu7t5v0__fillcap_4
XFILLER_189_104 VDD VSS VDD VSS gf180mcu_fd_sc_mcu7t5v0__fillcap_16
XFILLER_220_417 VDD VSS VDD VSS gf180mcu_fd_sc_mcu7t5v0__fillcap_4
XFILLER_260_597 VDD VSS VDD VSS gf180mcu_fd_sc_mcu7t5v0__fillcap_64
XFILLER_186_877 VDD VSS VDD VSS gf180mcu_fd_sc_mcu7t5v0__fillcap_8
XFILLER_187_62 VDD VSS VDD VSS gf180mcu_fd_sc_mcu7t5v0__fillcap_8
XFILLER_9_556 VDD VSS VDD VSS gf180mcu_fd_sc_mcu7t5v0__fillcap_4
X_1520_ VDD VSS _3380_/D _1516_/Z _1521_/A2 VDD VSS gf180mcu_fd_sc_mcu7t5v0__nor2_1
XFILLER_153_273 VDD VSS VDD VSS gf180mcu_fd_sc_mcu7t5v0__fillcap_4
XFILLER_126_465 VDD VSS VDD VSS gf180mcu_fd_sc_mcu7t5v0__fillcap_4
XFILLER_114_605 VDD VSS VDD VSS gf180mcu_fd_sc_mcu7t5v0__fillcap_4
X_1451_ VDD VSS _3357_/D _2225_/A1 VDD VSS gf180mcu_fd_sc_mcu7t5v0__clkinv_1
X_1382_ VDD VSS _3410_/Q _1945_/A2 VDD VSS gf180mcu_fd_sc_mcu7t5v0__clkinv_1
X_3121_ _3121_/D _3121_/Q _3457_/RN VSS _3150_/CLK VDD VDD VSS gf180mcu_fd_sc_mcu7t5v0__dffrnq_1
XFILLER_110_877 VDD VSS VDD VSS gf180mcu_fd_sc_mcu7t5v0__fillcap_8
X_3052_ VDD _3052_/Q _3414_/CLK VSS _3052_/D VDD VSS gf180mcu_fd_sc_mcu7t5v0__dffq_1
X_2003_ _2009_/S VDD VSS _3046_/D wire123/Z _3046_/Q VDD VSS gf180mcu_fd_sc_mcu7t5v0__mux2_2
XFILLER_91_772 VDD VSS VDD VSS gf180mcu_fd_sc_mcu7t5v0__fillcap_64
XFILLER_149_524 VDD VSS VDD VSS gf180mcu_fd_sc_mcu7t5v0__fillcap_16
X_2905_ VDD _2905_/Q _2931_/CLK VSS _2905_/D VDD VSS gf180mcu_fd_sc_mcu7t5v0__dffq_1
X_2836_ VDD _2836_/Q _3457_/CLK VSS _2836_/D VDD VSS gf180mcu_fd_sc_mcu7t5v0__dffq_1
XFILLER_164_527 VDD VSS VDD VSS gf180mcu_fd_sc_mcu7t5v0__fillcap_32
XFILLER_191_368 VDD VSS VDD VSS gf180mcu_fd_sc_mcu7t5v0__fillcap_4
X_2767_ wire20/I _3077_/Q VDD VSS _2768_/I _3325_/Q _2749_/C VDD VSS gf180mcu_fd_sc_mcu7t5v0__aoi22_1
X_1718_ VDD VSS _1719_/A2 _2278_/A2 _1718_/A2 VDD VSS gf180mcu_fd_sc_mcu7t5v0__nand2_1
X_2698_ wire59/Z VDD VSS _2698_/Z _2696_/Z _2697_/Z VDD VSS gf180mcu_fd_sc_mcu7t5v0__mux2_2
X_1649_ _1649_/B1 _2565_/S VDD VSS _3450_/D _3227_/Q _1649_/A2 VDD VSS gf180mcu_fd_sc_mcu7t5v0__aoi22_1
XFILLER_132_457 VDD VSS VDD VSS gf180mcu_fd_sc_mcu7t5v0__fillcap_32
XFILLER_86_511 VDD VSS VDD VSS gf180mcu_fd_sc_mcu7t5v0__fillcap_8
XFILLER_113_693 VDD VSS VDD VSS gf180mcu_fd_sc_mcu7t5v0__fillcap_4
XFILLER_112_170 VDD VSS VDD VSS gf180mcu_fd_sc_mcu7t5v0__fillcap_4
X_3319_ _3319_/D _3319_/Q wire145/Z VSS _3320_/CLK VDD VDD VSS gf180mcu_fd_sc_mcu7t5v0__dffrnq_1
XFILLER_100_387 VDD VSS VDD VSS gf180mcu_fd_sc_mcu7t5v0__fillcap_64
XFILLER_262_807 VDD VSS VDD VSS gf180mcu_fd_sc_mcu7t5v0__fillcap_64
XFILLER_214_211 VDD VSS VDD VSS gf180mcu_fd_sc_mcu7t5v0__fillcap_32
XFILLER_81_282 VDD VSS VDD VSS gf180mcu_fd_sc_mcu7t5v0__fillcap_4
XFILLER_230_737 VDD VSS VDD VSS gf180mcu_fd_sc_mcu7t5v0__fillcap_64
XFILLER_242_597 VDD VSS VDD VSS gf180mcu_fd_sc_mcu7t5v0__fillcap_64
XFILLER_186_107 VDD VSS VDD VSS gf180mcu_fd_sc_mcu7t5v0__fillcap_4
XFILLER_25_66 VDD VSS VDD VSS gf180mcu_fd_sc_mcu7t5v0__fillcap_4
XFILLER_168_877 VDD VSS VDD VSS gf180mcu_fd_sc_mcu7t5v0__fillcap_8
XFILLER_183_836 VDD VSS VDD VSS gf180mcu_fd_sc_mcu7t5v0__fillcap_4
XFILLER_195_685 VDD VSS VDD VSS gf180mcu_fd_sc_mcu7t5v0__fillcap_8
XFILLER_203_2 VDD VSS VDD VSS gf180mcu_fd_sc_mcu7t5v0__fillcap_8
XFILLER_151_766 VDD VSS VDD VSS gf180mcu_fd_sc_mcu7t5v0__fillcap_4
XFILLER_110_107 VDD VSS VDD VSS gf180mcu_fd_sc_mcu7t5v0__fillcap_8
XFILLER_2_37 VDD VSS VDD VSS gf180mcu_fd_sc_mcu7t5v0__fillcap_64
XFILLER_264_177 VDD VSS VDD VSS gf180mcu_fd_sc_mcu7t5v0__fillcap_64
XFILLER_252_317 VDD VSS VDD VSS gf180mcu_fd_sc_mcu7t5v0__fillcap_64
XFILLER_218_583 VDD VSS VDD VSS gf180mcu_fd_sc_mcu7t5v0__fillcap_8
XFILLER_73_772 VDD VSS VDD VSS gf180mcu_fd_sc_mcu7t5v0__fillcap_64
XFILLER_220_247 VDD VSS VDD VSS gf180mcu_fd_sc_mcu7t5v0__fillcap_64
XFILLER_158_310 VDD VSS VDD VSS gf180mcu_fd_sc_mcu7t5v0__fillcap_4
XFILLER_146_527 VDD VSS VDD VSS gf180mcu_fd_sc_mcu7t5v0__fillcap_4
X_2621_ wire46/I VDD VSS _3284_/D _3242_/Q wire90/I VDD VSS gf180mcu_fd_sc_mcu7t5v0__mux2_2
XFILLER_161_508 VDD VSS VDD VSS gf180mcu_fd_sc_mcu7t5v0__fillcap_8
X_2552_ _2552_/B VDD VSS _2553_/B _2567_/B _2552_/A2 VDD VSS gf180mcu_fd_sc_mcu7t5v0__aoi21_1
X_1503_ VDD VSS _1505_/A2 _3367_/Q _1497_/I VDD VSS gf180mcu_fd_sc_mcu7t5v0__nor2_1
XFILLER_49_2 VDD VSS VDD VSS gf180mcu_fd_sc_mcu7t5v0__fillcap_64
X_2483_ _2483_/B VDD VSS _3209_/D _2483_/A1 _2482_/Z VDD VSS gf180mcu_fd_sc_mcu7t5v0__aoi21_1
XFILLER_114_457 VDD VSS VDD VSS gf180mcu_fd_sc_mcu7t5v0__fillcap_16
X_1434_ VDD VSS _3190_/Q _2339_/A1 VDD VSS gf180mcu_fd_sc_mcu7t5v0__clkinv_1
XFILLER_256_667 VDD VSS VDD VSS gf180mcu_fd_sc_mcu7t5v0__fillcap_64
XFILLER_244_807 VDD VSS VDD VSS gf180mcu_fd_sc_mcu7t5v0__fillcap_64
X_3104_ _3104_/D _3104_/Q wire153/Z VSS _3359_/CLK VDD VDD VSS gf180mcu_fd_sc_mcu7t5v0__dffrnq_1
XFILLER_95_352 VDD VSS VDD VSS gf180mcu_fd_sc_mcu7t5v0__fillcap_16
X_3035_ VDD _3035_/Q _3046_/CLK VSS _3035_/D VDD VSS gf180mcu_fd_sc_mcu7t5v0__dffq_1
XFILLER_51_422 VDD VSS VDD VSS gf180mcu_fd_sc_mcu7t5v0__fillcap_64
Xclkbuf_leaf_20_clk_i _3358_/CLK VSS VDD clkload3/I VDD VSS gf180mcu_fd_sc_mcu7t5v0__clkbuf_2
XFILLER_63_282 VDD VSS VDD VSS gf180mcu_fd_sc_mcu7t5v0__fillcap_64
XFILLER_212_737 VDD VSS VDD VSS gf180mcu_fd_sc_mcu7t5v0__fillcap_64
XFILLER_224_597 VDD VSS VDD VSS gf180mcu_fd_sc_mcu7t5v0__fillcap_64
XFILLER_168_107 VDD VSS VDD VSS gf180mcu_fd_sc_mcu7t5v0__fillcap_32
XFILLER_149_321 VDD VSS VDD VSS gf180mcu_fd_sc_mcu7t5v0__fillcap_16
Xclkbuf_leaf_35_clk_i _3394_/CLK VSS VDD clkload6/I VDD VSS gf180mcu_fd_sc_mcu7t5v0__clkbuf_2
XFILLER_137_527 VDD VSS VDD VSS gf180mcu_fd_sc_mcu7t5v0__fillcap_16
XFILLER_177_696 VDD VSS VDD VSS gf180mcu_fd_sc_mcu7t5v0__fillcap_4
XFILLER_165_836 VDD VSS VDD VSS gf180mcu_fd_sc_mcu7t5v0__fillcap_4
XFILLER_149_387 VDD VSS VDD VSS gf180mcu_fd_sc_mcu7t5v0__fillcap_32
X_2819_ VDD _2819_/Q _3457_/CLK VSS _2819_/D VDD VSS gf180mcu_fd_sc_mcu7t5v0__dffq_1
XFILLER_117_273 VDD VSS VDD VSS gf180mcu_fd_sc_mcu7t5v0__fillcap_4
XFILLER_160_552 VDD VSS VDD VSS gf180mcu_fd_sc_mcu7t5v0__fillcap_32
XFILLER_143_45 VDD VSS VDD VSS gf180mcu_fd_sc_mcu7t5v0__fillcap_16
XFILLER_87_842 VDD VSS VDD VSS gf180mcu_fd_sc_mcu7t5v0__fillcap_32
XFILLER_86_352 VDD VSS VDD VSS gf180mcu_fd_sc_mcu7t5v0__fillcap_32
XFILLER_246_177 VDD VSS VDD VSS gf180mcu_fd_sc_mcu7t5v0__fillcap_64
XFILLER_234_317 VDD VSS VDD VSS gf180mcu_fd_sc_mcu7t5v0__fillcap_64
XFILLER_100_162 VDD VSS VDD VSS gf180mcu_fd_sc_mcu7t5v0__fillcap_4
XFILLER_261_136 VDD VSS VDD VSS gf180mcu_fd_sc_mcu7t5v0__fillcap_4
XFILLER_55_772 VDD VSS VDD VSS gf180mcu_fd_sc_mcu7t5v0__fillcap_64
XFILLER_70_731 VDD VSS VDD VSS gf180mcu_fd_sc_mcu7t5v0__fillcap_4
XFILLER_153_2 VDD VSS VDD VSS gf180mcu_fd_sc_mcu7t5v0__fillcap_32
XFILLER_82_591 VDD VSS VDD VSS gf180mcu_fd_sc_mcu7t5v0__fillcap_4
XFILLER_202_247 VDD VSS VDD VSS gf180mcu_fd_sc_mcu7t5v0__fillcap_4
XFILLER_11_842 VDD VSS VDD VSS gf180mcu_fd_sc_mcu7t5v0__fillcap_32
XFILLER_168_86 VDD VSS VDD VSS gf180mcu_fd_sc_mcu7t5v0__fillcap_16
XFILLER_170_305 VDD VSS VDD VSS gf180mcu_fd_sc_mcu7t5v0__fillcap_4
XFILLER_111_438 VDD VSS VDD VSS gf180mcu_fd_sc_mcu7t5v0__fillcap_4
XFILLER_77_72 VDD VSS VDD VSS gf180mcu_fd_sc_mcu7t5v0__fillcap_32
XFILLER_238_667 VDD VSS VDD VSS gf180mcu_fd_sc_mcu7t5v0__fillcap_64
XFILLER_226_807 VDD VSS VDD VSS gf180mcu_fd_sc_mcu7t5v0__fillcap_64
XFILLER_77_352 VDD VSS VDD VSS gf180mcu_fd_sc_mcu7t5v0__fillcap_64
XFILLER_253_626 VDD VSS VDD VSS gf180mcu_fd_sc_mcu7t5v0__fillcap_4
XFILLER_265_486 VDD VSS VDD VSS gf180mcu_fd_sc_mcu7t5v0__fillcap_4
XFILLER_92_311 VDD VSS VDD VSS gf180mcu_fd_sc_mcu7t5v0__fillcap_4
XFILLER_33_422 VDD VSS VDD VSS gf180mcu_fd_sc_mcu7t5v0__fillcap_64
XFILLER_206_597 VDD VSS VDD VSS gf180mcu_fd_sc_mcu7t5v0__fillcap_64
XFILLER_178_416 VDD VSS VDD VSS gf180mcu_fd_sc_mcu7t5v0__fillcap_8
XFILLER_45_282 VDD VSS VDD VSS gf180mcu_fd_sc_mcu7t5v0__fillcap_64
XFILLER_60_241 VDD VSS VDD VSS gf180mcu_fd_sc_mcu7t5v0__fillcap_4
X_1983_ VDD VSS _1991_/S _1465_/Z _2010_/A2 VDD VSS gf180mcu_fd_sc_mcu7t5v0__and2_1
XFILLER_159_696 VDD VSS VDD VSS gf180mcu_fd_sc_mcu7t5v0__fillcap_4
XFILLER_147_836 VDD VSS VDD VSS gf180mcu_fd_sc_mcu7t5v0__fillcap_4
X_2604_ _2604_/B VDD VSS _3271_/D _2686_/A1 _2625_/S VDD VSS gf180mcu_fd_sc_mcu7t5v0__aoi21_1
XFILLER_115_766 VDD VSS VDD VSS gf180mcu_fd_sc_mcu7t5v0__fillcap_4
X_2535_ _2537_/S VDD VSS _3216_/D _3215_/Q _3216_/Q VDD VSS gf180mcu_fd_sc_mcu7t5v0__mux2_2
XFILLER_142_574 VDD VSS VDD VSS gf180mcu_fd_sc_mcu7t5v0__fillcap_16
X_2466_ VDD _2466_/B _1654_/Z _2467_/A2 _3202_/Q VSS VDD VSS gf180mcu_fd_sc_mcu7t5v0__oai21_1
XFILLER_102_427 VDD VSS VDD VSS gf180mcu_fd_sc_mcu7t5v0__fillcap_4
XFILLER_87_127 VDD VSS VDD VSS gf180mcu_fd_sc_mcu7t5v0__fillcap_4
X_1417_ VDD VSS _3140_/Q _2177_/A1 VDD VSS gf180mcu_fd_sc_mcu7t5v0__clkinv_1
XFILLER_69_842 VDD VSS VDD VSS gf180mcu_fd_sc_mcu7t5v0__fillcap_32
X_2397_ VDD VSS _2410_/B _3199_/Q _2467_/A1 VDD VSS gf180mcu_fd_sc_mcu7t5v0__nand2_1
XFILLER_84_801 VDD VSS VDD VSS gf180mcu_fd_sc_mcu7t5v0__fillcap_4
XFILLER_228_177 VDD VSS VDD VSS gf180mcu_fd_sc_mcu7t5v0__fillcap_64
XFILLER_243_136 VDD VSS VDD VSS gf180mcu_fd_sc_mcu7t5v0__fillcap_4
Xwire20 wire20/Z VSS VDD wire20/I VDD VSS gf180mcu_fd_sc_mcu7t5v0__clkbuf_3
XFILLER_37_772 VDD VSS VDD VSS gf180mcu_fd_sc_mcu7t5v0__fillcap_64
Xwire53 VSS wire53/Z wire53/I VDD VDD VSS gf180mcu_fd_sc_mcu7t5v0__clkbuf_1
X_3018_ VDD _3018_/Q _3023_/CLK VSS _3018_/D VDD VSS gf180mcu_fd_sc_mcu7t5v0__dffq_1
Xwire86 VSS wire86/Z wire86/I VDD VDD VSS gf180mcu_fd_sc_mcu7t5v0__clkbuf_1
XFILLER_64_591 VDD VSS VDD VSS gf180mcu_fd_sc_mcu7t5v0__fillcap_4
XFILLER_52_731 VDD VSS VDD VSS gf180mcu_fd_sc_mcu7t5v0__fillcap_4
Xwire97 VSS wire97/Z wire97/I VDD VDD VSS gf180mcu_fd_sc_mcu7t5v0__buf_1
XFILLER_196_279 VDD VSS VDD VSS gf180mcu_fd_sc_mcu7t5v0__fillcap_4
XFILLER_20_661 VDD VSS VDD VSS gf180mcu_fd_sc_mcu7t5v0__fillcap_4
XFILLER_137_346 VDD VSS VDD VSS gf180mcu_fd_sc_mcu7t5v0__fillcap_4
XFILLER_219_100 VDD VSS VDD VSS gf180mcu_fd_sc_mcu7t5v0__fillcap_4
XFILLER_59_352 VDD VSS VDD VSS gf180mcu_fd_sc_mcu7t5v0__fillcap_64
XFILLER_208_807 VDD VSS VDD VSS gf180mcu_fd_sc_mcu7t5v0__fillcap_64
XFILLER_235_626 VDD VSS VDD VSS gf180mcu_fd_sc_mcu7t5v0__fillcap_4
XFILLER_247_486 VDD VSS VDD VSS gf180mcu_fd_sc_mcu7t5v0__fillcap_4
XFILLER_15_422 VDD VSS VDD VSS gf180mcu_fd_sc_mcu7t5v0__fillcap_64
XFILLER_203_523 VDD VSS VDD VSS gf180mcu_fd_sc_mcu7t5v0__fillcap_32
XFILLER_27_282 VDD VSS VDD VSS gf180mcu_fd_sc_mcu7t5v0__fillcap_64
XFILLER_42_241 VDD VSS VDD VSS gf180mcu_fd_sc_mcu7t5v0__fillcap_4
XFILLER_129_836 VDD VSS VDD VSS gf180mcu_fd_sc_mcu7t5v0__fillcap_4
XFILLER_7_632 VDD VSS VDD VSS gf180mcu_fd_sc_mcu7t5v0__fillcap_64
Xmax_length150 _3344_/RN VSS VDD wire151/Z VDD VSS gf180mcu_fd_sc_mcu7t5v0__clkbuf_8
XFILLER_116_519 VDD VSS VDD VSS gf180mcu_fd_sc_mcu7t5v0__fillcap_4
XFILLER_10_171 VDD VSS VDD VSS gf180mcu_fd_sc_mcu7t5v0__fillcap_4
X_2320_ VDD _3184_/D _2320_/B _2320_/A1 _2324_/A2 VSS _2320_/A3 VDD VSS gf180mcu_fd_sc_mcu7t5v0__oai31_1
XFILLER_257_206 VDD VSS VDD VSS gf180mcu_fd_sc_mcu7t5v0__fillcap_4
X_2251_ _3382_/Q VDD VSS _2257_/A2 _2442_/S _2250_/Z VDD VSS gf180mcu_fd_sc_mcu7t5v0__aoi21_1
XFILLER_151_393 VDD VSS VDD VSS gf180mcu_fd_sc_mcu7t5v0__fillcap_8
XFILLER_2_381 VDD VSS VDD VSS gf180mcu_fd_sc_mcu7t5v0__fillcap_4
XFILLER_111_257 VDD VSS VDD VSS gf180mcu_fd_sc_mcu7t5v0__fillcap_8
XFILLER_78_661 VDD VSS VDD VSS gf180mcu_fd_sc_mcu7t5v0__fillcap_4
XFILLER_66_801 VDD VSS VDD VSS gf180mcu_fd_sc_mcu7t5v0__fillcap_4
X_2182_ VDD _2182_/B _3348_/D _3143_/D _2182_/A1 VSS VDD VSS gf180mcu_fd_sc_mcu7t5v0__oai21_1
XFILLER_19_772 VDD VSS VDD VSS gf180mcu_fd_sc_mcu7t5v0__fillcap_64
XFILLER_46_591 VDD VSS VDD VSS gf180mcu_fd_sc_mcu7t5v0__fillcap_4
XFILLER_34_731 VDD VSS VDD VSS gf180mcu_fd_sc_mcu7t5v0__fillcap_4
X_1966_ _1972_/S VDD VSS _3014_/D wire123/Z _3014_/Q VDD VSS gf180mcu_fd_sc_mcu7t5v0__mux2_2
XFILLER_239_66 VDD VSS VDD VSS gf180mcu_fd_sc_mcu7t5v0__fillcap_4
XFILLER_146_165 VDD VSS VDD VSS gf180mcu_fd_sc_mcu7t5v0__fillcap_8
X_1897_ _1897_/S VDD VSS _2956_/D _2956_/Q _3182_/Q VDD VSS gf180mcu_fd_sc_mcu7t5v0__mux2_2
X_2518_ _2524_/B1 _3334_/Q VDD VSS _2520_/A2 _3326_/Q _2554_/A2 VDD VSS gf180mcu_fd_sc_mcu7t5v0__aoi22_1
X_2449_ VDD VSS _2450_/A3 _2449_/A1 _3134_/Q VDD VSS gf180mcu_fd_sc_mcu7t5v0__nand2_1
XFILLER_130_588 VDD VSS VDD VSS gf180mcu_fd_sc_mcu7t5v0__fillcap_4
XFILLER_56_311 VDD VSS VDD VSS gf180mcu_fd_sc_mcu7t5v0__fillcap_4
XFILLER_68_171 VDD VSS VDD VSS gf180mcu_fd_sc_mcu7t5v0__fillcap_4
XFILLER_229_486 VDD VSS VDD VSS gf180mcu_fd_sc_mcu7t5v0__fillcap_4
XFILLER_83_174 VDD VSS VDD VSS gf180mcu_fd_sc_mcu7t5v0__fillcap_16
XFILLER_169_224 VDD VSS VDD VSS gf180mcu_fd_sc_mcu7t5v0__fillcap_16
XFILLER_24_241 VDD VSS VDD VSS gf180mcu_fd_sc_mcu7t5v0__fillcap_4
XFILLER_33_66 VDD VSS VDD VSS gf180mcu_fd_sc_mcu7t5v0__fillcap_4
XFILLER_149_66 VDD VSS VDD VSS gf180mcu_fd_sc_mcu7t5v0__fillcap_4
XFILLER_177_290 VDD VSS VDD VSS gf180mcu_fd_sc_mcu7t5v0__fillcap_16
XFILLER_193_772 VDD VSS VDD VSS gf180mcu_fd_sc_mcu7t5v0__fillcap_64
XFILLER_193_761 VDD VSS VDD VSS gf180mcu_fd_sc_mcu7t5v0__fillcap_8
XFILLER_138_688 VDD VSS VDD VSS gf180mcu_fd_sc_mcu7t5v0__fillcap_32
XFILLER_165_10 VDD VSS VDD VSS gf180mcu_fd_sc_mcu7t5v0__fillcap_32
XFILLER_116_2 VDD VSS VDD VSS gf180mcu_fd_sc_mcu7t5v0__fillcap_32
XFILLER_239_206 VDD VSS VDD VSS gf180mcu_fd_sc_mcu7t5v0__fillcap_4
XFILLER_48_801 VDD VSS VDD VSS gf180mcu_fd_sc_mcu7t5v0__fillcap_4
XFILLER_0_852 VDD VSS VDD VSS gf180mcu_fd_sc_mcu7t5v0__fillcap_32
XFILLER_114_80 VDD VSS VDD VSS gf180mcu_fd_sc_mcu7t5v0__fillcap_4
XFILLER_28_591 VDD VSS VDD VSS gf180mcu_fd_sc_mcu7t5v0__fillcap_4
XFILLER_16_731 VDD VSS VDD VSS gf180mcu_fd_sc_mcu7t5v0__fillcap_4
XFILLER_90_667 VDD VSS VDD VSS gf180mcu_fd_sc_mcu7t5v0__fillcap_64
X_1820_ _1823_/S VDD VSS _2889_/D wire131/Z _2889_/Q VDD VSS gf180mcu_fd_sc_mcu7t5v0__mux2_2
XFILLER_88_6 VDD VSS VDD VSS gf180mcu_fd_sc_mcu7t5v0__fillcap_16
X_1751_ _1758_/S VDD VSS _2829_/D _1788_/I1 _2829_/Q VDD VSS gf180mcu_fd_sc_mcu7t5v0__mux2_2
X_1682_ VDD VSS _2477_/A2 _2363_/A1 _2482_/A1 VDD VSS gf180mcu_fd_sc_mcu7t5v0__nor2_1
XFILLER_171_422 VDD VSS VDD VSS gf180mcu_fd_sc_mcu7t5v0__fillcap_8
XFILLER_183_282 VDD VSS VDD VSS gf180mcu_fd_sc_mcu7t5v0__fillcap_4
XFILLER_116_305 VDD VSS VDD VSS gf180mcu_fd_sc_mcu7t5v0__fillcap_8
XFILLER_129_688 VDD VSS VDD VSS gf180mcu_fd_sc_mcu7t5v0__fillcap_8
X_3421_ _3421_/D _3421_/Q wire163/Z VSS _3427_/CLK VDD VDD VSS gf180mcu_fd_sc_mcu7t5v0__dffrnq_1
X_3352_ VSS _3360_/CLK VDD _3352_/D _3353_/D wire153/Z VDD VSS gf180mcu_fd_sc_mcu7t5v0__dffsnq_1
X_2303_ VDD VSS _2306_/A2 _2303_/A1 _2303_/A2 VDD VSS gf180mcu_fd_sc_mcu7t5v0__nand2_1
XFILLER_31_2 VDD VSS VDD VSS gf180mcu_fd_sc_mcu7t5v0__fillcap_64
X_3283_ _3283_/D wire91/I _3336_/RN VSS clkload9/I VDD VDD VSS gf180mcu_fd_sc_mcu7t5v0__dffrnq_1
X_2234_ _2234_/B VDD VSS _2235_/B _2364_/A1 _2239_/C VDD VSS gf180mcu_fd_sc_mcu7t5v0__aoi21_1
XFILLER_38_311 VDD VSS VDD VSS gf180mcu_fd_sc_mcu7t5v0__fillcap_4
X_2165_ _2168_/B1 _3167_/Q VDD VSS _2166_/A2 _3158_/Q _2168_/A2 VDD VSS gf180mcu_fd_sc_mcu7t5v0__aoi22_1
XFILLER_213_106 VDD VSS VDD VSS gf180mcu_fd_sc_mcu7t5v0__fillcap_32
X_2096_ VDD _3107_/D _2096_/B _3107_/Q _2110_/A2 VSS _2096_/A3 VDD VSS gf180mcu_fd_sc_mcu7t5v0__oai31_1
XFILLER_0_70 VDD VSS VDD VSS gf180mcu_fd_sc_mcu7t5v0__fillcap_32
XFILLER_80_133 VDD VSS VDD VSS gf180mcu_fd_sc_mcu7t5v0__fillcap_4
XFILLER_179_500 VDD VSS VDD VSS gf180mcu_fd_sc_mcu7t5v0__fillcap_4
XFILLER_179_511 VDD VSS VDD VSS gf180mcu_fd_sc_mcu7t5v0__fillcap_32
XFILLER_222_651 VDD VSS VDD VSS gf180mcu_fd_sc_mcu7t5v0__fillcap_8
XFILLER_80_177 VDD VSS VDD VSS gf180mcu_fd_sc_mcu7t5v0__fillcap_4
XFILLER_194_503 VDD VSS VDD VSS gf180mcu_fd_sc_mcu7t5v0__fillcap_4
XFILLER_166_238 VDD VSS VDD VSS gf180mcu_fd_sc_mcu7t5v0__fillcap_4
X_2998_ VDD _2998_/Q _3006_/CLK VSS _2998_/D VDD VSS gf180mcu_fd_sc_mcu7t5v0__dffq_1
XFILLER_175_772 VDD VSS VDD VSS gf180mcu_fd_sc_mcu7t5v0__fillcap_64
X_1949_ _1954_/S VDD VSS _2999_/D _2999_/Q wire121/Z VDD VSS gf180mcu_fd_sc_mcu7t5v0__mux2_2
XFILLER_150_639 VDD VSS VDD VSS gf180mcu_fd_sc_mcu7t5v0__fillcap_8
XFILLER_143_680 VDD VSS VDD VSS gf180mcu_fd_sc_mcu7t5v0__fillcap_16
XFILLER_131_842 VDD VSS VDD VSS gf180mcu_fd_sc_mcu7t5v0__fillcap_32
XFILLER_0_104 VDD VSS VDD VSS gf180mcu_fd_sc_mcu7t5v0__fillcap_32
XFILLER_142_190 VDD VSS VDD VSS gf180mcu_fd_sc_mcu7t5v0__fillcap_32
XFILLER_103_555 VDD VSS VDD VSS gf180mcu_fd_sc_mcu7t5v0__fillcap_4
XFILLER_60_807 VDD VSS VDD VSS gf180mcu_fd_sc_mcu7t5v0__fillcap_64
XFILLER_72_667 VDD VSS VDD VSS gf180mcu_fd_sc_mcu7t5v0__fillcap_64
XFILLER_213_695 VDD VSS VDD VSS gf180mcu_fd_sc_mcu7t5v0__fillcap_4
XFILLER_185_514 VDD VSS VDD VSS gf180mcu_fd_sc_mcu7t5v0__fillcap_32
XFILLER_233_2 VDD VSS VDD VSS gf180mcu_fd_sc_mcu7t5v0__fillcap_64
XFILLER_197_352 VDD VSS VDD VSS gf180mcu_fd_sc_mcu7t5v0__fillcap_4
XFILLER_40_597 VDD VSS VDD VSS gf180mcu_fd_sc_mcu7t5v0__fillcap_64
XFILLER_176_53 VDD VSS VDD VSS gf180mcu_fd_sc_mcu7t5v0__fillcap_8
XFILLER_165_282 VDD VSS VDD VSS gf180mcu_fd_sc_mcu7t5v0__fillcap_8
XFILLER_153_422 VDD VSS VDD VSS gf180mcu_fd_sc_mcu7t5v0__fillcap_4
XFILLER_125_102 VDD VSS VDD VSS gf180mcu_fd_sc_mcu7t5v0__fillcap_4
XFILLER_121_352 VDD VSS VDD VSS gf180mcu_fd_sc_mcu7t5v0__fillcap_16
XFILLER_79_244 VDD VSS VDD VSS gf180mcu_fd_sc_mcu7t5v0__fillcap_16
XFILLER_0_682 VDD VSS VDD VSS gf180mcu_fd_sc_mcu7t5v0__fillcap_32
XFILLER_251_702 VDD VSS VDD VSS gf180mcu_fd_sc_mcu7t5v0__fillcap_64
XFILLER_263_562 VDD VSS VDD VSS gf180mcu_fd_sc_mcu7t5v0__fillcap_64
XFILLER_189_842 VDD VSS VDD VSS gf180mcu_fd_sc_mcu7t5v0__fillcap_32
X_2921_ VDD _2921_/Q _2932_/CLK VSS _2921_/D VDD VSS gf180mcu_fd_sc_mcu7t5v0__dffq_1
XFILLER_62_177 VDD VSS VDD VSS gf180mcu_fd_sc_mcu7t5v0__fillcap_64
XFILLER_50_317 VDD VSS VDD VSS gf180mcu_fd_sc_mcu7t5v0__fillcap_64
XFILLER_231_492 VDD VSS VDD VSS gf180mcu_fd_sc_mcu7t5v0__fillcap_64
XFILLER_203_183 VDD VSS VDD VSS gf180mcu_fd_sc_mcu7t5v0__fillcap_16
X_2852_ VDD _2852_/Q _2914_/CLK VSS _2852_/D VDD VSS gf180mcu_fd_sc_mcu7t5v0__dffq_1
X_1803_ _1805_/S VDD VSS _2874_/D wire130/Z _2874_/Q VDD VSS gf180mcu_fd_sc_mcu7t5v0__mux2_2
X_2783_ wire20/I _3085_/Q VDD VSS _2784_/I _3333_/Q _2749_/C VDD VSS gf180mcu_fd_sc_mcu7t5v0__aoi22_1
X_1734_ _1738_/S VDD VSS _2816_/D _2816_/Q _3122_/Q VDD VSS gf180mcu_fd_sc_mcu7t5v0__mux2_2
XFILLER_157_772 VDD VSS VDD VSS gf180mcu_fd_sc_mcu7t5v0__fillcap_64
XFILLER_172_731 VDD VSS VDD VSS gf180mcu_fd_sc_mcu7t5v0__fillcap_4
XFILLER_184_591 VDD VSS VDD VSS gf180mcu_fd_sc_mcu7t5v0__fillcap_4
Xhold226 _3400_/D VSS _3405_/Q VDD VDD VSS gf180mcu_fd_sc_mcu7t5v0__dlyc_1
Xhold215 _3427_/D VSS _3432_/Q VDD VDD VSS gf180mcu_fd_sc_mcu7t5v0__dlyc_1
X_3404_ _3404_/D _3404_/Q wire161/Z VSS _3405_/CLK VDD VDD VSS gf180mcu_fd_sc_mcu7t5v0__dffrnq_1
X_1665_ VDD VSS _2480_/A3 _2231_/A1 _1673_/A2 VDD VSS gf180mcu_fd_sc_mcu7t5v0__nand2_1
X_1596_ _2470_/B VDD VSS _1638_/A3 _3185_/Q _3347_/Q VDD VSS gf180mcu_fd_sc_mcu7t5v0__nand3_1
XFILLER_113_842 VDD VSS VDD VSS gf180mcu_fd_sc_mcu7t5v0__fillcap_32
X_3335_ _3335_/D _3335_/Q _3335_/RN VSS _3453_/CLK VDD VDD VSS gf180mcu_fd_sc_mcu7t5v0__dffrnq_1
XFILLER_98_597 VDD VSS VDD VSS gf180mcu_fd_sc_mcu7t5v0__fillcap_64
XFILLER_86_737 VDD VSS VDD VSS gf180mcu_fd_sc_mcu7t5v0__fillcap_64
X_3266_ _3266_/D _3266_/Q _3339_/RN VSS _3340_/CLK VDD VDD VSS gf180mcu_fd_sc_mcu7t5v0__dffrnq_1
X_2217_ _2221_/S VDD VSS _3163_/D wire95/I _3163_/Q VDD VSS gf180mcu_fd_sc_mcu7t5v0__mux2_2
X_3197_ _3197_/D _3197_/Q _3344_/RN VSS _3211_/CLK VDD VDD VSS gf180mcu_fd_sc_mcu7t5v0__dffrnq_1
X_2148_ _2161_/B1 _2148_/B2 VDD VSS _3129_/D _2148_/A1 _2168_/C VDD VSS gf180mcu_fd_sc_mcu7t5v0__aoi22_1
XFILLER_241_212 VDD VSS VDD VSS gf180mcu_fd_sc_mcu7t5v0__fillcap_64
X_2079_ _2074_/Z VDD VSS _2087_/A2 _3103_/Q _3102_/Q VDD VSS gf180mcu_fd_sc_mcu7t5v0__nand3_1
XFILLER_42_807 VDD VSS VDD VSS gf180mcu_fd_sc_mcu7t5v0__fillcap_64
XFILLER_54_667 VDD VSS VDD VSS gf180mcu_fd_sc_mcu7t5v0__fillcap_64
XFILLER_81_486 VDD VSS VDD VSS gf180mcu_fd_sc_mcu7t5v0__fillcap_4
XFILLER_194_300 VDD VSS VDD VSS gf180mcu_fd_sc_mcu7t5v0__fillcap_8
XFILLER_22_597 VDD VSS VDD VSS gf180mcu_fd_sc_mcu7t5v0__fillcap_64
XFILLER_10_737 VDD VSS VDD VSS gf180mcu_fd_sc_mcu7t5v0__fillcap_64
XFILLER_135_455 VDD VSS VDD VSS gf180mcu_fd_sc_mcu7t5v0__fillcap_4
XFILLER_147_282 VDD VSS VDD VSS gf180mcu_fd_sc_mcu7t5v0__fillcap_4
XFILLER_135_422 VDD VSS VDD VSS gf180mcu_fd_sc_mcu7t5v0__fillcap_4
XFILLER_122_127 VDD VSS VDD VSS gf180mcu_fd_sc_mcu7t5v0__fillcap_8
XFILLER_103_352 VDD VSS VDD VSS gf180mcu_fd_sc_mcu7t5v0__fillcap_16
XFILLER_76_247 VDD VSS VDD VSS gf180mcu_fd_sc_mcu7t5v0__fillcap_64
XFILLER_183_2 VDD VSS VDD VSS gf180mcu_fd_sc_mcu7t5v0__fillcap_32
XFILLER_91_206 VDD VSS VDD VSS gf180mcu_fd_sc_mcu7t5v0__fillcap_4
XFILLER_233_702 VDD VSS VDD VSS gf180mcu_fd_sc_mcu7t5v0__fillcap_64
XFILLER_245_562 VDD VSS VDD VSS gf180mcu_fd_sc_mcu7t5v0__fillcap_64
XFILLER_91_228 VDD VSS VDD VSS gf180mcu_fd_sc_mcu7t5v0__fillcap_4
XFILLER_260_521 VDD VSS VDD VSS gf180mcu_fd_sc_mcu7t5v0__fillcap_4
XFILLER_44_177 VDD VSS VDD VSS gf180mcu_fd_sc_mcu7t5v0__fillcap_64
XFILLER_32_317 VDD VSS VDD VSS gf180mcu_fd_sc_mcu7t5v0__fillcap_64
XFILLER_186_801 VDD VSS VDD VSS gf180mcu_fd_sc_mcu7t5v0__fillcap_4
XFILLER_198_683 VDD VSS VDD VSS gf180mcu_fd_sc_mcu7t5v0__fillcap_8
XFILLER_201_632 VDD VSS VDD VSS gf180mcu_fd_sc_mcu7t5v0__fillcap_16
XFILLER_213_492 VDD VSS VDD VSS gf180mcu_fd_sc_mcu7t5v0__fillcap_8
XFILLER_166_580 VDD VSS VDD VSS gf180mcu_fd_sc_mcu7t5v0__fillcap_8
XFILLER_139_772 VDD VSS VDD VSS gf180mcu_fd_sc_mcu7t5v0__fillcap_64
XFILLER_138_271 VDD VSS VDD VSS gf180mcu_fd_sc_mcu7t5v0__fillcap_4
XFILLER_154_731 VDD VSS VDD VSS gf180mcu_fd_sc_mcu7t5v0__fillcap_4
X_1450_ VDD VSS _3136_/Q _2169_/A1 VDD VSS gf180mcu_fd_sc_mcu7t5v0__clkinv_1
XFILLER_114_639 VDD VSS VDD VSS gf180mcu_fd_sc_mcu7t5v0__fillcap_16
XFILLER_122_661 VDD VSS VDD VSS gf180mcu_fd_sc_mcu7t5v0__fillcap_4
XFILLER_110_801 VDD VSS VDD VSS gf180mcu_fd_sc_mcu7t5v0__fillcap_4
XFILLER_267_142 VDD VSS VDD VSS gf180mcu_fd_sc_mcu7t5v0__fillcap_64
X_3120_ _3120_/D _3120_/Q wire147/Z VSS _3364_/CLK VDD VDD VSS gf180mcu_fd_sc_mcu7t5v0__dffrnq_1
XFILLER_68_737 VDD VSS VDD VSS gf180mcu_fd_sc_mcu7t5v0__fillcap_64
X_3051_ VDD _3051_/Q _3059_/CLK VSS _3051_/D VDD VSS gf180mcu_fd_sc_mcu7t5v0__dffq_1
XFILLER_264_871 VDD VSS VDD VSS gf180mcu_fd_sc_mcu7t5v0__fillcap_4
X_2002_ _2009_/S VDD VSS _3045_/D _2011_/I0 _3045_/Q VDD VSS gf180mcu_fd_sc_mcu7t5v0__mux2_2
XFILLER_223_212 VDD VSS VDD VSS gf180mcu_fd_sc_mcu7t5v0__fillcap_64
XFILLER_24_807 VDD VSS VDD VSS gf180mcu_fd_sc_mcu7t5v0__fillcap_64
XFILLER_36_667 VDD VSS VDD VSS gf180mcu_fd_sc_mcu7t5v0__fillcap_64
XFILLER_51_626 VDD VSS VDD VSS gf180mcu_fd_sc_mcu7t5v0__fillcap_4
XFILLER_63_486 VDD VSS VDD VSS gf180mcu_fd_sc_mcu7t5v0__fillcap_4
X_2904_ VDD _2904_/Q _2932_/CLK VSS _2904_/D VDD VSS gf180mcu_fd_sc_mcu7t5v0__dffq_1
X_2835_ VDD _2835_/Q _3457_/CLK VSS _2835_/D VDD VSS gf180mcu_fd_sc_mcu7t5v0__dffq_1
XFILLER_247_66 VDD VSS VDD VSS gf180mcu_fd_sc_mcu7t5v0__fillcap_4
XFILLER_129_282 VDD VSS VDD VSS gf180mcu_fd_sc_mcu7t5v0__fillcap_64
XFILLER_117_422 VDD VSS VDD VSS gf180mcu_fd_sc_mcu7t5v0__fillcap_8
X_2766_ VDD VSS _3324_/D _2796_/A1 _2766_/A2 VDD VSS gf180mcu_fd_sc_mcu7t5v0__nand2_1
X_1717_ _2239_/C _2490_/B VDD VSS _1718_/A2 _2332_/A3 _1717_/A2 VDD VSS gf180mcu_fd_sc_mcu7t5v0__aoi211_1
XFILLER_144_263 VDD VSS VDD VSS gf180mcu_fd_sc_mcu7t5v0__fillcap_4
X_2697_ _3024_/Q VSS VDD _3008_/Q _3016_/Q _2730_/S0 _3000_/Q wire60/I _2697_/Z VDD
+ VSS gf180mcu_fd_sc_mcu7t5v0__mux4_1
X_1648_ _2555_/A1 _2567_/B VDD VSS _2565_/S _3224_/Q _2553_/A1 VDD VSS gf180mcu_fd_sc_mcu7t5v0__nand4_1
XFILLER_259_632 VDD VSS VDD VSS gf180mcu_fd_sc_mcu7t5v0__fillcap_64
X_1579_ VDD VSS _2164_/S _2328_/B2 _2199_/A1 VDD VSS gf180mcu_fd_sc_mcu7t5v0__nor2_1
X_3318_ _3318_/D _3318_/Q wire163/I VSS clkload7/I VDD VDD VSS gf180mcu_fd_sc_mcu7t5v0__dffrnq_1
XFILLER_58_247 VDD VSS VDD VSS gf180mcu_fd_sc_mcu7t5v0__fillcap_64
XFILLER_112_193 VDD VSS VDD VSS gf180mcu_fd_sc_mcu7t5v0__fillcap_8
X_3249_ _3249_/D _3249_/Q _3339_/RN VSS _3316_/CLK VDD VDD VSS gf180mcu_fd_sc_mcu7t5v0__dffrnq_1
XFILLER_215_702 VDD VSS VDD VSS gf180mcu_fd_sc_mcu7t5v0__fillcap_64
XFILLER_227_562 VDD VSS VDD VSS gf180mcu_fd_sc_mcu7t5v0__fillcap_64
XFILLER_132_69 VDD VSS VDD VSS gf180mcu_fd_sc_mcu7t5v0__fillcap_16
XFILLER_242_521 VDD VSS VDD VSS gf180mcu_fd_sc_mcu7t5v0__fillcap_4
XFILLER_254_381 VDD VSS VDD VSS gf180mcu_fd_sc_mcu7t5v0__fillcap_4
XFILLER_26_177 VDD VSS VDD VSS gf180mcu_fd_sc_mcu7t5v0__fillcap_64
XFILLER_14_317 VDD VSS VDD VSS gf180mcu_fd_sc_mcu7t5v0__fillcap_64
XFILLER_168_801 VDD VSS VDD VSS gf180mcu_fd_sc_mcu7t5v0__fillcap_4
XFILLER_41_136 VDD VSS VDD VSS gf180mcu_fd_sc_mcu7t5v0__fillcap_4
XFILLER_186_119 VDD VSS VDD VSS gf180mcu_fd_sc_mcu7t5v0__fillcap_32
XFILLER_182_303 VDD VSS VDD VSS gf180mcu_fd_sc_mcu7t5v0__fillcap_8
XFILLER_6_527 VDD VSS VDD VSS gf180mcu_fd_sc_mcu7t5v0__fillcap_64
XFILLER_41_66 VDD VSS VDD VSS gf180mcu_fd_sc_mcu7t5v0__fillcap_4
XFILLER_157_66 VDD VSS VDD VSS gf180mcu_fd_sc_mcu7t5v0__fillcap_4
XFILLER_157_88 VDD VSS VDD VSS gf180mcu_fd_sc_mcu7t5v0__fillcap_8
XFILLER_9_2 VDD VSS VDD VSS gf180mcu_fd_sc_mcu7t5v0__fillcap_64
XFILLER_249_142 VDD VSS VDD VSS gf180mcu_fd_sc_mcu7t5v0__fillcap_64
XFILLER_1_276 VDD VSS VDD VSS gf180mcu_fd_sc_mcu7t5v0__fillcap_4
XFILLER_264_101 VDD VSS VDD VSS gf180mcu_fd_sc_mcu7t5v0__fillcap_4
XFILLER_77_556 VDD VSS VDD VSS gf180mcu_fd_sc_mcu7t5v0__fillcap_4
XFILLER_246_871 VDD VSS VDD VSS gf180mcu_fd_sc_mcu7t5v0__fillcap_4
XFILLER_205_212 VDD VSS VDD VSS gf180mcu_fd_sc_mcu7t5v0__fillcap_16
XFILLER_18_667 VDD VSS VDD VSS gf180mcu_fd_sc_mcu7t5v0__fillcap_64
XFILLER_261_874 VDD VSS VDD VSS gf180mcu_fd_sc_mcu7t5v0__fillcap_16
XFILLER_205_234 VDD VSS VDD VSS gf180mcu_fd_sc_mcu7t5v0__fillcap_16
XFILLER_33_626 VDD VSS VDD VSS gf180mcu_fd_sc_mcu7t5v0__fillcap_4
XFILLER_45_486 VDD VSS VDD VSS gf180mcu_fd_sc_mcu7t5v0__fillcap_4
Xclkbuf_leaf_1_clk_i _3329_/CLK VSS VDD clkload0/I VDD VSS gf180mcu_fd_sc_mcu7t5v0__clkbuf_2
XFILLER_146_539 VDD VSS VDD VSS gf180mcu_fd_sc_mcu7t5v0__fillcap_32
X_2620_ _2644_/S VDD VSS _3283_/D _3241_/Q wire91/I VDD VSS gf180mcu_fd_sc_mcu7t5v0__mux2_2
X_2551_ _3224_/Q VDD VSS _3224_/D _2567_/B _2552_/B VDD VSS gf180mcu_fd_sc_mcu7t5v0__mux2_2
X_1502_ VDD VSS _3368_/D _1500_/Z _1508_/A2 VDD VSS gf180mcu_fd_sc_mcu7t5v0__nor2_1
XFILLER_154_583 VDD VSS VDD VSS gf180mcu_fd_sc_mcu7t5v0__fillcap_8
XFILLER_217_36 VDD VSS VDD VSS gf180mcu_fd_sc_mcu7t5v0__fillcap_32
X_2482_ _2482_/A3 VDD VSS _2482_/Z _2482_/A1 _2482_/A2 VDD VSS gf180mcu_fd_sc_mcu7t5v0__or3_1
X_1433_ VDD VSS _3189_/Q _2338_/A1 VDD VSS gf180mcu_fd_sc_mcu7t5v0__clkinv_1
XFILLER_99_136 VDD VSS VDD VSS gf180mcu_fd_sc_mcu7t5v0__fillcap_4
X_3103_ _3103_/D _3103_/Q wire153/Z VSS _3109_/CLK VDD VDD VSS gf180mcu_fd_sc_mcu7t5v0__dffrnq_1
XFILLER_55_206 VDD VSS VDD VSS gf180mcu_fd_sc_mcu7t5v0__fillcap_4
X_3034_ VDD _3034_/Q _3058_/CLK VSS _3034_/D VDD VSS gf180mcu_fd_sc_mcu7t5v0__dffq_1
XFILLER_224_521 VDD VSS VDD VSS gf180mcu_fd_sc_mcu7t5v0__fillcap_4
XFILLER_236_381 VDD VSS VDD VSS gf180mcu_fd_sc_mcu7t5v0__fillcap_4
XFILLER_252_885 VDD VSS VDD VSS gf180mcu_fd_sc_mcu7t5v0__fillcap_4
XFILLER_23_136 VDD VSS VDD VSS gf180mcu_fd_sc_mcu7t5v0__fillcap_4
X_2818_ VDD _2818_/Q _3458_/CLK VSS _2818_/D VDD VSS gf180mcu_fd_sc_mcu7t5v0__dffq_1
XFILLER_180_807 VDD VSS VDD VSS gf180mcu_fd_sc_mcu7t5v0__fillcap_64
XFILLER_118_731 VDD VSS VDD VSS gf180mcu_fd_sc_mcu7t5v0__fillcap_4
XFILLER_192_667 VDD VSS VDD VSS gf180mcu_fd_sc_mcu7t5v0__fillcap_64
X_2749_ _2749_/B _2749_/C VDD VSS _2750_/B _3070_/Q _2749_/A2 VDD VSS gf180mcu_fd_sc_mcu7t5v0__aoi211_1
XFILLER_160_597 VDD VSS VDD VSS gf180mcu_fd_sc_mcu7t5v0__fillcap_64
XFILLER_246_101 VDD VSS VDD VSS gf180mcu_fd_sc_mcu7t5v0__fillcap_4
XFILLER_59_556 VDD VSS VDD VSS gf180mcu_fd_sc_mcu7t5v0__fillcap_4
XFILLER_228_871 VDD VSS VDD VSS gf180mcu_fd_sc_mcu7t5v0__fillcap_4
XFILLER_36_22 VDD VSS VDD VSS gf180mcu_fd_sc_mcu7t5v0__fillcap_8
XFILLER_243_874 VDD VSS VDD VSS gf180mcu_fd_sc_mcu7t5v0__fillcap_16
XFILLER_27_486 VDD VSS VDD VSS gf180mcu_fd_sc_mcu7t5v0__fillcap_4
XFILLER_15_626 VDD VSS VDD VSS gf180mcu_fd_sc_mcu7t5v0__fillcap_4
XFILLER_203_749 VDD VSS VDD VSS gf180mcu_fd_sc_mcu7t5v0__fillcap_16
XFILLER_146_2 VDD VSS VDD VSS gf180mcu_fd_sc_mcu7t5v0__fillcap_32
XFILLER_182_100 VDD VSS VDD VSS gf180mcu_fd_sc_mcu7t5v0__fillcap_4
XFILLER_167_152 VDD VSS VDD VSS gf180mcu_fd_sc_mcu7t5v0__fillcap_8
XFILLER_7_836 VDD VSS VDD VSS gf180mcu_fd_sc_mcu7t5v0__fillcap_4
XFILLER_182_177 VDD VSS VDD VSS gf180mcu_fd_sc_mcu7t5v0__fillcap_8
XFILLER_108_285 VDD VSS VDD VSS gf180mcu_fd_sc_mcu7t5v0__fillcap_16
XFILLER_151_553 VDD VSS VDD VSS gf180mcu_fd_sc_mcu7t5v0__fillcap_4
XFILLER_37_206 VDD VSS VDD VSS gf180mcu_fd_sc_mcu7t5v0__fillcap_4
XFILLER_218_381 VDD VSS VDD VSS gf180mcu_fd_sc_mcu7t5v0__fillcap_4
XFILLER_93_72 VDD VSS VDD VSS gf180mcu_fd_sc_mcu7t5v0__fillcap_16
XFILLER_234_885 VDD VSS VDD VSS gf180mcu_fd_sc_mcu7t5v0__fillcap_4
X_1982_ VDD VSS _2010_/A2 _3409_/Q _3410_/Q VDD VSS gf180mcu_fd_sc_mcu7t5v0__nor2_1
XFILLER_146_303 VDD VSS VDD VSS gf180mcu_fd_sc_mcu7t5v0__fillcap_8
XFILLER_186_494 VDD VSS VDD VSS gf180mcu_fd_sc_mcu7t5v0__fillcap_4
XFILLER_174_667 VDD VSS VDD VSS gf180mcu_fd_sc_mcu7t5v0__fillcap_64
XFILLER_162_807 VDD VSS VDD VSS gf180mcu_fd_sc_mcu7t5v0__fillcap_64
XFILLER_173_166 VDD VSS VDD VSS gf180mcu_fd_sc_mcu7t5v0__fillcap_4
XFILLER_61_2 VDD VSS VDD VSS gf180mcu_fd_sc_mcu7t5v0__fillcap_64
X_2603_ VDD VSS _2604_/B _3231_/Q _2625_/S VDD VSS gf180mcu_fd_sc_mcu7t5v0__nor2_1
X_2534_ _2537_/S VDD VSS _3215_/D _3214_/Q _3215_/Q VDD VSS gf180mcu_fd_sc_mcu7t5v0__mux2_2
XFILLER_127_583 VDD VSS VDD VSS gf180mcu_fd_sc_mcu7t5v0__fillcap_16
XFILLER_142_542 VDD VSS VDD VSS gf180mcu_fd_sc_mcu7t5v0__fillcap_32
X_2465_ VDD VSS _2466_/B _1654_/Z _2465_/A2 VDD VSS gf180mcu_fd_sc_mcu7t5v0__nand2_1
XFILLER_130_737 VDD VSS VDD VSS gf180mcu_fd_sc_mcu7t5v0__fillcap_64
X_2396_ VDD _2396_/B _2396_/A2 _3198_/D _2467_/A1 VSS VDD VSS gf180mcu_fd_sc_mcu7t5v0__oai21_1
X_1416_ VDD VSS _3139_/Q _2175_/A1 VDD VSS gf180mcu_fd_sc_mcu7t5v0__clkinv_1
XFILLER_228_101 VDD VSS VDD VSS gf180mcu_fd_sc_mcu7t5v0__fillcap_4
XFILLER_110_472 VDD VSS VDD VSS gf180mcu_fd_sc_mcu7t5v0__fillcap_4
Xwire10 wire10/Z VSS VDD wire10/I VDD VSS gf180mcu_fd_sc_mcu7t5v0__clkbuf_2
Xwire21 VSS wire21/Z wire21/I VDD VDD VSS gf180mcu_fd_sc_mcu7t5v0__clkbuf_1
X_3017_ VDD _3017_/Q _3044_/CLK VSS _3017_/D VDD VSS gf180mcu_fd_sc_mcu7t5v0__dffq_1
XFILLER_225_874 VDD VSS VDD VSS gf180mcu_fd_sc_mcu7t5v0__fillcap_16
Xwire76 VSS wire76/Z wire76/I VDD VDD VSS gf180mcu_fd_sc_mcu7t5v0__buf_3
XFILLER_197_715 VDD VSS VDD VSS gf180mcu_fd_sc_mcu7t5v0__fillcap_8
Xwire87 VSS wire87/Z wire87/I VDD VDD VSS gf180mcu_fd_sc_mcu7t5v0__clkbuf_1
Xwire98 VSS wire98/Z wire98/I VDD VDD VSS gf180mcu_fd_sc_mcu7t5v0__clkbuf_1
XFILLER_240_877 VDD VSS VDD VSS gf180mcu_fd_sc_mcu7t5v0__fillcap_8
XFILLER_196_247 VDD VSS VDD VSS gf180mcu_fd_sc_mcu7t5v0__fillcap_32
XFILLER_220_590 VDD VSS VDD VSS gf180mcu_fd_sc_mcu7t5v0__fillcap_4
XFILLER_164_177 VDD VSS VDD VSS gf180mcu_fd_sc_mcu7t5v0__fillcap_4
XFILLER_120_247 VDD VSS VDD VSS gf180mcu_fd_sc_mcu7t5v0__fillcap_16
XFILLER_19_206 VDD VSS VDD VSS gf180mcu_fd_sc_mcu7t5v0__fillcap_4
XFILLER_262_457 VDD VSS VDD VSS gf180mcu_fd_sc_mcu7t5v0__fillcap_64
XFILLER_263_2 VDD VSS VDD VSS gf180mcu_fd_sc_mcu7t5v0__fillcap_64
XFILLER_216_885 VDD VSS VDD VSS gf180mcu_fd_sc_mcu7t5v0__fillcap_4
XFILLER_188_737 VDD VSS VDD VSS gf180mcu_fd_sc_mcu7t5v0__fillcap_64
XFILLER_215_384 VDD VSS VDD VSS gf180mcu_fd_sc_mcu7t5v0__fillcap_32
XFILLER_179_64 VDD VSS VDD VSS gf180mcu_fd_sc_mcu7t5v0__fillcap_4
XFILLER_230_387 VDD VSS VDD VSS gf180mcu_fd_sc_mcu7t5v0__fillcap_64
XFILLER_168_450 VDD VSS VDD VSS gf180mcu_fd_sc_mcu7t5v0__fillcap_4
XFILLER_8_37 VDD VSS VDD VSS gf180mcu_fd_sc_mcu7t5v0__fillcap_64
XFILLER_168_483 VDD VSS VDD VSS gf180mcu_fd_sc_mcu7t5v0__fillcap_16
XFILLER_156_667 VDD VSS VDD VSS gf180mcu_fd_sc_mcu7t5v0__fillcap_64
XFILLER_144_807 VDD VSS VDD VSS gf180mcu_fd_sc_mcu7t5v0__fillcap_64
XFILLER_195_63 VDD VSS VDD VSS gf180mcu_fd_sc_mcu7t5v0__fillcap_4
Xmax_length162 wire161/I wire163/Z VDD VSS VDD VSS gf180mcu_fd_sc_mcu7t5v0__buf_12
XFILLER_183_486 VDD VSS VDD VSS gf180mcu_fd_sc_mcu7t5v0__fillcap_4
XFILLER_195_96 VDD VSS VDD VSS gf180mcu_fd_sc_mcu7t5v0__fillcap_16
XFILLER_155_199 VDD VSS VDD VSS gf180mcu_fd_sc_mcu7t5v0__fillcap_8
X_2250_ _2932_/Q VSS VDD _2916_/Q _2924_/Q _2454_/S0 _2908_/Q _2454_/S1 _2250_/Z VDD
+ VSS gf180mcu_fd_sc_mcu7t5v0__mux4_1
XFILLER_124_597 VDD VSS VDD VSS gf180mcu_fd_sc_mcu7t5v0__fillcap_4
XFILLER_112_737 VDD VSS VDD VSS gf180mcu_fd_sc_mcu7t5v0__fillcap_64
XFILLER_214_37 VDD VSS VDD VSS gf180mcu_fd_sc_mcu7t5v0__fillcap_32
Xclkbuf_leaf_34_clk_i _3395_/CLK VSS VDD clkload6/I VDD VSS gf180mcu_fd_sc_mcu7t5v0__clkbuf_2
X_2181_ VDD VSS _2182_/B _2287_/I0 _3348_/D VDD VSS gf180mcu_fd_sc_mcu7t5v0__nand2_1
XFILLER_93_610 VDD VSS VDD VSS gf180mcu_fd_sc_mcu7t5v0__fillcap_16
XFILLER_225_126 VDD VSS VDD VSS gf180mcu_fd_sc_mcu7t5v0__fillcap_8
XFILLER_207_874 VDD VSS VDD VSS gf180mcu_fd_sc_mcu7t5v0__fillcap_16
XFILLER_240_107 VDD VSS VDD VSS gf180mcu_fd_sc_mcu7t5v0__fillcap_64
Xclkbuf_4_2_0_host_clk_i _3458_/CLK VSS VDD clkbuf_0_host_clk_i/Z VDD VSS gf180mcu_fd_sc_mcu7t5v0__clkbuf_2
Xclkbuf_leaf_49_clk_i _3055_/CLK VSS VDD clkload1/I VDD VSS gf180mcu_fd_sc_mcu7t5v0__clkbuf_2
XFILLER_61_562 VDD VSS VDD VSS gf180mcu_fd_sc_mcu7t5v0__fillcap_64
XFILLER_222_877 VDD VSS VDD VSS gf180mcu_fd_sc_mcu7t5v0__fillcap_8
XFILLER_178_247 VDD VSS VDD VSS gf180mcu_fd_sc_mcu7t5v0__fillcap_8
XFILLER_178_269 VDD VSS VDD VSS gf180mcu_fd_sc_mcu7t5v0__fillcap_4
X_1965_ _1972_/S VDD VSS _3013_/D _2011_/I0 _3013_/Q VDD VSS gf180mcu_fd_sc_mcu7t5v0__mux2_2
XFILLER_147_623 VDD VSS VDD VSS gf180mcu_fd_sc_mcu7t5v0__fillcap_4
XFILLER_146_133 VDD VSS VDD VSS gf180mcu_fd_sc_mcu7t5v0__fillcap_32
X_1896_ _1897_/S VDD VSS _2955_/D _2955_/Q _3181_/Q VDD VSS gf180mcu_fd_sc_mcu7t5v0__mux2_2
XFILLER_146_177 VDD VSS VDD VSS gf180mcu_fd_sc_mcu7t5v0__fillcap_8
XFILLER_161_158 VDD VSS VDD VSS gf180mcu_fd_sc_mcu7t5v0__fillcap_4
XFILLER_161_136 VDD VSS VDD VSS gf180mcu_fd_sc_mcu7t5v0__fillcap_4
XFILLER_255_66 VDD VSS VDD VSS gf180mcu_fd_sc_mcu7t5v0__fillcap_4
Xclkbuf_3_4__f_clk_i VDD VSS clkload3/I clkbuf_0_clk_i/Z VDD VSS gf180mcu_fd_sc_mcu7t5v0__clkbuf_16
XFILLER_0_308 VDD VSS VDD VSS gf180mcu_fd_sc_mcu7t5v0__fillcap_32
X_2517_ VSS VDD _3335_/Q _2517_/C1 _3327_/Q _2554_/A2 _1640_/I _3311_/Q _2521_/A2
+ VDD VSS gf180mcu_fd_sc_mcu7t5v0__aoi222_1
X_2448_ _2448_/B _2448_/C VDD VSS _2450_/A2 _3382_/Q _2442_/Z VDD VSS gf180mcu_fd_sc_mcu7t5v0__oai211_1
XFILLER_102_225 VDD VSS VDD VSS gf180mcu_fd_sc_mcu7t5v0__fillcap_4
XFILLER_102_247 VDD VSS VDD VSS gf180mcu_fd_sc_mcu7t5v0__fillcap_4
X_2379_ _2379_/A3 VDD VSS _2380_/B _1654_/Z _2379_/A2 VDD VSS gf180mcu_fd_sc_mcu7t5v0__nand3_1
XFILLER_83_142 VDD VSS VDD VSS gf180mcu_fd_sc_mcu7t5v0__fillcap_32
XFILLER_244_457 VDD VSS VDD VSS gf180mcu_fd_sc_mcu7t5v0__fillcap_64
XFILLER_80_871 VDD VSS VDD VSS gf180mcu_fd_sc_mcu7t5v0__fillcap_4
XFILLER_197_545 VDD VSS VDD VSS gf180mcu_fd_sc_mcu7t5v0__fillcap_8
XFILLER_200_527 VDD VSS VDD VSS gf180mcu_fd_sc_mcu7t5v0__fillcap_8
XFILLER_212_387 VDD VSS VDD VSS gf180mcu_fd_sc_mcu7t5v0__fillcap_8
XFILLER_138_645 VDD VSS VDD VSS gf180mcu_fd_sc_mcu7t5v0__fillcap_4
XFILLER_137_122 VDD VSS VDD VSS gf180mcu_fd_sc_mcu7t5v0__fillcap_16
XFILLER_126_807 VDD VSS VDD VSS gf180mcu_fd_sc_mcu7t5v0__fillcap_64
XFILLER_192_283 VDD VSS VDD VSS gf180mcu_fd_sc_mcu7t5v0__fillcap_8
XFILLER_180_434 VDD VSS VDD VSS gf180mcu_fd_sc_mcu7t5v0__fillcap_8
XFILLER_109_2 VDD VSS VDD VSS gf180mcu_fd_sc_mcu7t5v0__fillcap_16
XFILLER_106_597 VDD VSS VDD VSS gf180mcu_fd_sc_mcu7t5v0__fillcap_64
XFILLER_121_556 VDD VSS VDD VSS gf180mcu_fd_sc_mcu7t5v0__fillcap_4
XFILLER_0_886 VDD VSS VDD VSS gf180mcu_fd_sc_mcu7t5v0__fillcap_4
XFILLER_87_481 VDD VSS VDD VSS gf180mcu_fd_sc_mcu7t5v0__fillcap_8
XFILLER_87_492 VDD VSS VDD VSS gf180mcu_fd_sc_mcu7t5v0__fillcap_8
XFILLER_75_632 VDD VSS VDD VSS gf180mcu_fd_sc_mcu7t5v0__fillcap_64
XFILLER_263_766 VDD VSS VDD VSS gf180mcu_fd_sc_mcu7t5v0__fillcap_4
XFILLER_222_107 VDD VSS VDD VSS gf180mcu_fd_sc_mcu7t5v0__fillcap_64
XFILLER_74_63 VDD VSS VDD VSS gf180mcu_fd_sc_mcu7t5v0__fillcap_8
XFILLER_43_562 VDD VSS VDD VSS gf180mcu_fd_sc_mcu7t5v0__fillcap_64
XFILLER_31_702 VDD VSS VDD VSS gf180mcu_fd_sc_mcu7t5v0__fillcap_64
XFILLER_204_877 VDD VSS VDD VSS gf180mcu_fd_sc_mcu7t5v0__fillcap_8
XFILLER_70_381 VDD VSS VDD VSS gf180mcu_fd_sc_mcu7t5v0__fillcap_4
XFILLER_231_696 VDD VSS VDD VSS gf180mcu_fd_sc_mcu7t5v0__fillcap_4
XFILLER_175_206 VDD VSS VDD VSS gf180mcu_fd_sc_mcu7t5v0__fillcap_4
X_1750_ _1861_/A1 VDD VSS _1758_/S _3369_/Q _3370_/Q VDD VSS gf180mcu_fd_sc_mcu7t5v0__nand3_1
XFILLER_11_492 VDD VSS VDD VSS gf180mcu_fd_sc_mcu7t5v0__fillcap_64
X_1681_ VDD VSS _2482_/A1 _3363_/D _2341_/A2 VDD VSS gf180mcu_fd_sc_mcu7t5v0__nand2_1
XFILLER_128_177 VDD VSS VDD VSS gf180mcu_fd_sc_mcu7t5v0__fillcap_4
X_3420_ _3420_/D _3420_/Q wire163/Z VSS _3461_/CLK VDD VDD VSS gf180mcu_fd_sc_mcu7t5v0__dffrnq_1
X_3351_ VSS _3360_/CLK VDD input3/Z _3352_/D wire153/Z VDD VSS gf180mcu_fd_sc_mcu7t5v0__dffsnq_1
XFILLER_258_527 VDD VSS VDD VSS gf180mcu_fd_sc_mcu7t5v0__fillcap_64
X_2302_ VDD _2302_/B _2302_/A2 _2306_/A1 _3199_/Q VSS VDD VSS gf180mcu_fd_sc_mcu7t5v0__oai21_1
XFILLER_225_58 VDD VSS VDD VSS gf180mcu_fd_sc_mcu7t5v0__fillcap_8
X_3282_ _3282_/D _3282_/Q _3452_/RN VSS _3451_/CLK VDD VDD VSS gf180mcu_fd_sc_mcu7t5v0__dffrnq_1
X_2233_ VDD VSS _2233_/Z _2485_/A1 _2235_/A2 VDD VSS gf180mcu_fd_sc_mcu7t5v0__or2_1
XFILLER_24_2 VDD VSS VDD VSS gf180mcu_fd_sc_mcu7t5v0__fillcap_32
X_2164_ _2164_/S VDD VSS _3134_/D _3134_/Q _2164_/I1 VDD VSS gf180mcu_fd_sc_mcu7t5v0__mux2_2
XFILLER_226_457 VDD VSS VDD VSS gf180mcu_fd_sc_mcu7t5v0__fillcap_64
XFILLER_65_142 VDD VSS VDD VSS gf180mcu_fd_sc_mcu7t5v0__fillcap_64
XFILLER_214_619 VDD VSS VDD VSS gf180mcu_fd_sc_mcu7t5v0__fillcap_4
XFILLER_241_416 VDD VSS VDD VSS gf180mcu_fd_sc_mcu7t5v0__fillcap_4
XFILLER_253_276 VDD VSS VDD VSS gf180mcu_fd_sc_mcu7t5v0__fillcap_4
X_2095_ _2120_/B _3107_/Q VDD VSS _2096_/B _2125_/A2 _2096_/A3 VDD VSS gf180mcu_fd_sc_mcu7t5v0__oai211_1
XFILLER_80_112 VDD VSS VDD VSS gf180mcu_fd_sc_mcu7t5v0__fillcap_4
XFILLER_207_693 VDD VSS VDD VSS gf180mcu_fd_sc_mcu7t5v0__fillcap_4
XFILLER_62_871 VDD VSS VDD VSS gf180mcu_fd_sc_mcu7t5v0__fillcap_4
XFILLER_21_212 VDD VSS VDD VSS gf180mcu_fd_sc_mcu7t5v0__fillcap_64
X_2997_ VDD _2997_/Q _3005_/CLK VSS _2997_/D VDD VSS gf180mcu_fd_sc_mcu7t5v0__dffq_1
X_1948_ _1954_/S VDD VSS _2998_/D _2998_/Q wire123/Z VDD VSS gf180mcu_fd_sc_mcu7t5v0__mux2_2
XFILLER_108_807 VDD VSS VDD VSS gf180mcu_fd_sc_mcu7t5v0__fillcap_64
XFILLER_147_486 VDD VSS VDD VSS gf180mcu_fd_sc_mcu7t5v0__fillcap_4
XFILLER_119_188 VDD VSS VDD VSS gf180mcu_fd_sc_mcu7t5v0__fillcap_8
X_1879_ _1889_/A3 VDD VSS wire36/I _3407_/Q _1879_/A2 VDD VSS gf180mcu_fd_sc_mcu7t5v0__nor3_1
XFILLER_89_702 VDD VSS VDD VSS gf180mcu_fd_sc_mcu7t5v0__fillcap_64
XFILLER_88_201 VDD VSS VDD VSS gf180mcu_fd_sc_mcu7t5v0__fillcap_4
XFILLER_0_138 VDD VSS VDD VSS gf180mcu_fd_sc_mcu7t5v0__fillcap_32
XFILLER_69_492 VDD VSS VDD VSS gf180mcu_fd_sc_mcu7t5v0__fillcap_64
XFILLER_57_632 VDD VSS VDD VSS gf180mcu_fd_sc_mcu7t5v0__fillcap_64
XFILLER_245_766 VDD VSS VDD VSS gf180mcu_fd_sc_mcu7t5v0__fillcap_4
XFILLER_84_451 VDD VSS VDD VSS gf180mcu_fd_sc_mcu7t5v0__fillcap_4
XFILLER_13_702 VDD VSS VDD VSS gf180mcu_fd_sc_mcu7t5v0__fillcap_64
XFILLER_40_521 VDD VSS VDD VSS gf180mcu_fd_sc_mcu7t5v0__fillcap_4
XFILLER_25_562 VDD VSS VDD VSS gf180mcu_fd_sc_mcu7t5v0__fillcap_64
XFILLER_201_836 VDD VSS VDD VSS gf180mcu_fd_sc_mcu7t5v0__fillcap_4
XFILLER_52_381 VDD VSS VDD VSS gf180mcu_fd_sc_mcu7t5v0__fillcap_4
XFILLER_138_486 VDD VSS VDD VSS gf180mcu_fd_sc_mcu7t5v0__fillcap_16
XFILLER_126_626 VDD VSS VDD VSS gf180mcu_fd_sc_mcu7t5v0__fillcap_16
XFILLER_192_31 VDD VSS VDD VSS gf180mcu_fd_sc_mcu7t5v0__fillcap_4
XFILLER_140_128 VDD VSS VDD VSS gf180mcu_fd_sc_mcu7t5v0__fillcap_8
XFILLER_79_212 VDD VSS VDD VSS gf180mcu_fd_sc_mcu7t5v0__fillcap_32
XFILLER_192_53 VDD VSS VDD VSS gf180mcu_fd_sc_mcu7t5v0__fillcap_8
XFILLER_267_346 VDD VSS VDD VSS gf180mcu_fd_sc_mcu7t5v0__fillcap_4
XFILLER_208_446 VDD VSS VDD VSS gf180mcu_fd_sc_mcu7t5v0__fillcap_8
XFILLER_208_457 VDD VSS VDD VSS gf180mcu_fd_sc_mcu7t5v0__fillcap_64
XFILLER_47_142 VDD VSS VDD VSS gf180mcu_fd_sc_mcu7t5v0__fillcap_64
XFILLER_235_276 VDD VSS VDD VSS gf180mcu_fd_sc_mcu7t5v0__fillcap_4
XFILLER_62_101 VDD VSS VDD VSS gf180mcu_fd_sc_mcu7t5v0__fillcap_4
X_2920_ VDD _2920_/Q _2932_/CLK VSS _2920_/D VDD VSS gf180mcu_fd_sc_mcu7t5v0__dffq_1
XFILLER_204_652 VDD VSS VDD VSS gf180mcu_fd_sc_mcu7t5v0__fillcap_4
XFILLER_44_871 VDD VSS VDD VSS gf180mcu_fd_sc_mcu7t5v0__fillcap_4
X_2851_ VDD _2851_/Q _2867_/CLK VSS _2851_/D VDD VSS gf180mcu_fd_sc_mcu7t5v0__dffq_1
X_1802_ _1805_/S VDD VSS _2873_/D wire131/Z _2873_/Q VDD VSS gf180mcu_fd_sc_mcu7t5v0__mux2_2
X_2782_ VDD VSS _2782_/I _3332_/D VDD VSS gf180mcu_fd_sc_mcu7t5v0__clkinv_1
X_1733_ _1738_/S VDD VSS _2815_/D _2815_/Q _3121_/Q VDD VSS gf180mcu_fd_sc_mcu7t5v0__mux2_2
XFILLER_117_626 VDD VSS VDD VSS gf180mcu_fd_sc_mcu7t5v0__fillcap_4
Xhold216 _3426_/D VSS _3431_/Q VDD VDD VSS gf180mcu_fd_sc_mcu7t5v0__dlyc_1
XFILLER_171_220 VDD VSS VDD VSS gf180mcu_fd_sc_mcu7t5v0__fillcap_4
XFILLER_7_282 VDD VSS VDD VSS gf180mcu_fd_sc_mcu7t5v0__fillcap_64
X_3403_ _3403_/D _3403_/Q _3403_/RN VSS _3403_/CLK VDD VDD VSS gf180mcu_fd_sc_mcu7t5v0__dffrnq_1
Xhold227 _3457_/D VSS _3456_/Q VDD VDD VSS gf180mcu_fd_sc_mcu7t5v0__dlyc_1
X_1664_ VDD VSS _1664_/Z _2231_/A1 _1673_/A2 VDD VSS gf180mcu_fd_sc_mcu7t5v0__and2_1
XFILLER_171_242 VDD VSS VDD VSS gf180mcu_fd_sc_mcu7t5v0__fillcap_4
XFILLER_116_169 VDD VSS VDD VSS gf180mcu_fd_sc_mcu7t5v0__fillcap_4
X_1595_ VDD VSS _1597_/A4 _3347_/Q _1595_/A2 VDD VSS gf180mcu_fd_sc_mcu7t5v0__nand2_1
XFILLER_98_510 VDD VSS VDD VSS gf180mcu_fd_sc_mcu7t5v0__fillcap_4
XFILLER_259_836 VDD VSS VDD VSS gf180mcu_fd_sc_mcu7t5v0__fillcap_4
X_3334_ _3334_/D _3334_/Q wire169/Z VSS _3340_/CLK VDD VDD VSS gf180mcu_fd_sc_mcu7t5v0__dffrnq_1
X_3265_ _3265_/D _3265_/Q _3339_/RN VSS _3307_/CLK VDD VDD VSS gf180mcu_fd_sc_mcu7t5v0__dffrnq_1
X_2216_ _2219_/S VDD VSS _3162_/D wire96/I _3162_/Q VDD VSS gf180mcu_fd_sc_mcu7t5v0__mux2_2
XFILLER_39_632 VDD VSS VDD VSS gf180mcu_fd_sc_mcu7t5v0__fillcap_64
X_3196_ _3196_/D _3196_/Q _3344_/RN VSS _3212_/CLK VDD VDD VSS gf180mcu_fd_sc_mcu7t5v0__dffrnq_1
XFILLER_66_451 VDD VSS VDD VSS gf180mcu_fd_sc_mcu7t5v0__fillcap_4
XFILLER_227_766 VDD VSS VDD VSS gf180mcu_fd_sc_mcu7t5v0__fillcap_4
X_2147_ _3161_/Q _2149_/C VDD VSS _2148_/B2 _3152_/Q _2168_/A2 _2168_/B1 VDD VSS gf180mcu_fd_sc_mcu7t5v0__aoi221_1
X_2078_ _2078_/B VDD VSS _3102_/D _3102_/Q _2074_/Z VDD VSS gf180mcu_fd_sc_mcu7t5v0__aoi21_1
XFILLER_198_117 VDD VSS VDD VSS gf180mcu_fd_sc_mcu7t5v0__fillcap_8
XFILLER_139_206 VDD VSS VDD VSS gf180mcu_fd_sc_mcu7t5v0__fillcap_4
XFILLER_22_521 VDD VSS VDD VSS gf180mcu_fd_sc_mcu7t5v0__fillcap_4
XFILLER_34_381 VDD VSS VDD VSS gf180mcu_fd_sc_mcu7t5v0__fillcap_4
XFILLER_50_885 VDD VSS VDD VSS gf180mcu_fd_sc_mcu7t5v0__fillcap_4
XFILLER_147_272 VDD VSS VDD VSS gf180mcu_fd_sc_mcu7t5v0__fillcap_8
XFILLER_162_231 VDD VSS VDD VSS gf180mcu_fd_sc_mcu7t5v0__fillcap_8
XFILLER_107_169 VDD VSS VDD VSS gf180mcu_fd_sc_mcu7t5v0__fillcap_32
XFILLER_107_158 VDD VSS VDD VSS gf180mcu_fd_sc_mcu7t5v0__fillcap_4
XFILLER_115_191 VDD VSS VDD VSS gf180mcu_fd_sc_mcu7t5v0__fillcap_16
XFILLER_249_346 VDD VSS VDD VSS gf180mcu_fd_sc_mcu7t5v0__fillcap_4
XFILLER_39_66 VDD VSS VDD VSS gf180mcu_fd_sc_mcu7t5v0__fillcap_4
XFILLER_162_78 VDD VSS VDD VSS gf180mcu_fd_sc_mcu7t5v0__fillcap_16
XFILLER_29_142 VDD VSS VDD VSS gf180mcu_fd_sc_mcu7t5v0__fillcap_64
XFILLER_176_2 VDD VSS VDD VSS gf180mcu_fd_sc_mcu7t5v0__fillcap_16
XFILLER_44_101 VDD VSS VDD VSS gf180mcu_fd_sc_mcu7t5v0__fillcap_4
XFILLER_217_276 VDD VSS VDD VSS gf180mcu_fd_sc_mcu7t5v0__fillcap_4
XFILLER_205_416 VDD VSS VDD VSS gf180mcu_fd_sc_mcu7t5v0__fillcap_4
XFILLER_26_871 VDD VSS VDD VSS gf180mcu_fd_sc_mcu7t5v0__fillcap_4
XFILLER_111_60 VDD VSS VDD VSS gf180mcu_fd_sc_mcu7t5v0__fillcap_8
XFILLER_158_515 VDD VSS VDD VSS gf180mcu_fd_sc_mcu7t5v0__fillcap_8
XFILLER_41_874 VDD VSS VDD VSS gf180mcu_fd_sc_mcu7t5v0__fillcap_16
XFILLER_201_688 VDD VSS VDD VSS gf180mcu_fd_sc_mcu7t5v0__fillcap_8
XFILLER_181_562 VDD VSS VDD VSS gf180mcu_fd_sc_mcu7t5v0__fillcap_32
XFILLER_4_241 VDD VSS VDD VSS gf180mcu_fd_sc_mcu7t5v0__fillcap_4
XFILLER_121_150 VDD VSS VDD VSS gf180mcu_fd_sc_mcu7t5v0__fillcap_4
X_3050_ VDD _3050_/Q _3058_/CLK VSS _3050_/D VDD VSS gf180mcu_fd_sc_mcu7t5v0__dffq_1
XFILLER_48_451 VDD VSS VDD VSS gf180mcu_fd_sc_mcu7t5v0__fillcap_4
X_2001_ VDD VSS _2009_/S _2001_/A1 _2010_/A2 VDD VSS gf180mcu_fd_sc_mcu7t5v0__nand2_1
XFILLER_209_766 VDD VSS VDD VSS gf180mcu_fd_sc_mcu7t5v0__fillcap_4
XFILLER_90_240 VDD VSS VDD VSS gf180mcu_fd_sc_mcu7t5v0__fillcap_4
XFILLER_189_640 VDD VSS VDD VSS gf180mcu_fd_sc_mcu7t5v0__fillcap_4
XFILLER_16_381 VDD VSS VDD VSS gf180mcu_fd_sc_mcu7t5v0__fillcap_4
X_2903_ VDD _2903_/Q _2932_/CLK VSS _2903_/D VDD VSS gf180mcu_fd_sc_mcu7t5v0__dffq_1
XFILLER_32_885 VDD VSS VDD VSS gf180mcu_fd_sc_mcu7t5v0__fillcap_4
XFILLER_91_2 VDD VSS VDD VSS gf180mcu_fd_sc_mcu7t5v0__fillcap_16
X_2834_ VDD _2834_/Q _3435_/CLK VSS _2834_/D VDD VSS gf180mcu_fd_sc_mcu7t5v0__dffq_1
X_2765_ wire20/Z _3076_/Q VDD VSS _2766_/A2 _3324_/Q _2749_/C VDD VSS gf180mcu_fd_sc_mcu7t5v0__aoi22_1
XFILLER_8_591 VDD VSS VDD VSS gf180mcu_fd_sc_mcu7t5v0__fillcap_4
X_1716_ VDD _1716_/B _1716_/A2 _1717_/A2 _2232_/A1 VSS VDD VSS gf180mcu_fd_sc_mcu7t5v0__oai21_1
X_2696_ _3056_/Q VSS VDD _3040_/Q _3048_/Q _2722_/S0 _3032_/Q wire60/Z _2696_/Z VDD
+ VSS gf180mcu_fd_sc_mcu7t5v0__mux4_1
X_1647_ VDD VSS _2553_/A2 _3224_/Q _2567_/B VDD VSS gf180mcu_fd_sc_mcu7t5v0__nand2_1
XFILLER_99_874 VDD VSS VDD VSS gf180mcu_fd_sc_mcu7t5v0__fillcap_16
XFILLER_219_508 VDD VSS VDD VSS gf180mcu_fd_sc_mcu7t5v0__fillcap_4
XFILLER_263_66 VDD VSS VDD VSS gf180mcu_fd_sc_mcu7t5v0__fillcap_4
X_1578_ _2470_/B _3349_/Q VDD VSS _2197_/A1 _3147_/Q _2191_/A3 VDD VSS gf180mcu_fd_sc_mcu7t5v0__oai211_1
X_3317_ _3317_/D _3317_/Q wire165/Z VSS clkload8/I VDD VDD VSS gf180mcu_fd_sc_mcu7t5v0__dffrnq_1
X_3248_ _3248_/D _3248_/Q _3452_/RN VSS _3451_/CLK VDD VDD VSS gf180mcu_fd_sc_mcu7t5v0__dffrnq_1
X_3179_ VDD _3179_/Q _3179_/CLK VSS _3179_/D VDD VSS gf180mcu_fd_sc_mcu7t5v0__dffq_1
XFILLER_26_101 VDD VSS VDD VSS gf180mcu_fd_sc_mcu7t5v0__fillcap_4
XFILLER_132_37 VDD VSS VDD VSS gf180mcu_fd_sc_mcu7t5v0__fillcap_32
XFILLER_81_295 VDD VSS VDD VSS gf180mcu_fd_sc_mcu7t5v0__fillcap_32
XFILLER_195_632 VDD VSS VDD VSS gf180mcu_fd_sc_mcu7t5v0__fillcap_16
XFILLER_179_172 VDD VSS VDD VSS gf180mcu_fd_sc_mcu7t5v0__fillcap_4
XFILLER_148_6 VDD VSS VDD VSS gf180mcu_fd_sc_mcu7t5v0__fillcap_16
XFILLER_23_874 VDD VSS VDD VSS gf180mcu_fd_sc_mcu7t5v0__fillcap_16
XFILLER_163_562 VDD VSS VDD VSS gf180mcu_fd_sc_mcu7t5v0__fillcap_8
XFILLER_151_702 VDD VSS VDD VSS gf180mcu_fd_sc_mcu7t5v0__fillcap_64
XFILLER_173_55 VDD VSS VDD VSS gf180mcu_fd_sc_mcu7t5v0__fillcap_8
XFILLER_131_492 VDD VSS VDD VSS gf180mcu_fd_sc_mcu7t5v0__fillcap_64
XFILLER_103_172 VDD VSS VDD VSS gf180mcu_fd_sc_mcu7t5v0__fillcap_32
XFILLER_92_527 VDD VSS VDD VSS gf180mcu_fd_sc_mcu7t5v0__fillcap_64
XFILLER_205_202 VDD VSS VDD VSS gf180mcu_fd_sc_mcu7t5v0__fillcap_8
XFILLER_261_842 VDD VSS VDD VSS gf180mcu_fd_sc_mcu7t5v0__fillcap_32
XFILLER_198_30 VDD VSS VDD VSS gf180mcu_fd_sc_mcu7t5v0__fillcap_4
Xclkbuf_4_7_0_host_clk_i _3435_/CLK VSS VDD clkbuf_0_host_clk_i/Z VDD VSS gf180mcu_fd_sc_mcu7t5v0__clkbuf_2
XFILLER_198_74 VDD VSS VDD VSS gf180mcu_fd_sc_mcu7t5v0__fillcap_16
XFILLER_60_457 VDD VSS VDD VSS gf180mcu_fd_sc_mcu7t5v0__fillcap_64
XFILLER_14_885 VDD VSS VDD VSS gf180mcu_fd_sc_mcu7t5v0__fillcap_4
XFILLER_82_96 VDD VSS VDD VSS gf180mcu_fd_sc_mcu7t5v0__fillcap_8
XFILLER_185_142 VDD VSS VDD VSS gf180mcu_fd_sc_mcu7t5v0__fillcap_16
XFILLER_185_175 VDD VSS VDD VSS gf180mcu_fd_sc_mcu7t5v0__fillcap_8
XFILLER_139_581 VDD VSS VDD VSS gf180mcu_fd_sc_mcu7t5v0__fillcap_32
XFILLER_63_6 VDD VSS VDD VSS gf180mcu_fd_sc_mcu7t5v0__fillcap_64
XFILLER_182_871 VDD VSS VDD VSS gf180mcu_fd_sc_mcu7t5v0__fillcap_4
X_2550_ VDD VSS _2552_/B _2550_/A1 _2550_/A2 VDD VSS gf180mcu_fd_sc_mcu7t5v0__nand2_1
X_1501_ _3368_/Q VDD VSS _1508_/A2 _3367_/Q _1497_/I VDD VSS gf180mcu_fd_sc_mcu7t5v0__aoi21_1
XFILLER_142_724 VDD VSS VDD VSS gf180mcu_fd_sc_mcu7t5v0__fillcap_8
XFILLER_141_212 VDD VSS VDD VSS gf180mcu_fd_sc_mcu7t5v0__fillcap_16
X_2481_ VDD _2481_/B _2481_/A2 _3208_/D _2483_/B VSS VDD VSS gf180mcu_fd_sc_mcu7t5v0__oai21_1
XFILLER_114_448 VDD VSS VDD VSS gf180mcu_fd_sc_mcu7t5v0__fillcap_4
X_1432_ VDD VSS _3226_/Q _2555_/A1 VDD VSS gf180mcu_fd_sc_mcu7t5v0__clkinv_1
X_3102_ _3102_/D _3102_/Q wire153/Z VSS _3359_/CLK VDD VDD VSS gf180mcu_fd_sc_mcu7t5v0__dffrnq_1
XFILLER_95_376 VDD VSS VDD VSS gf180mcu_fd_sc_mcu7t5v0__fillcap_4
XFILLER_96_877 VDD VSS VDD VSS gf180mcu_fd_sc_mcu7t5v0__fillcap_8
XFILLER_209_552 VDD VSS VDD VSS gf180mcu_fd_sc_mcu7t5v0__fillcap_8
X_3033_ VDD _3033_/Q _3059_/CLK VSS _3033_/D VDD VSS gf180mcu_fd_sc_mcu7t5v0__dffq_1
XFILLER_251_352 VDD VSS VDD VSS gf180mcu_fd_sc_mcu7t5v0__fillcap_64
XFILLER_177_632 VDD VSS VDD VSS gf180mcu_fd_sc_mcu7t5v0__fillcap_64
XFILLER_189_492 VDD VSS VDD VSS gf180mcu_fd_sc_mcu7t5v0__fillcap_32
XFILLER_204_290 VDD VSS VDD VSS gf180mcu_fd_sc_mcu7t5v0__fillcap_16
XFILLER_149_345 VDD VSS VDD VSS gf180mcu_fd_sc_mcu7t5v0__fillcap_4
XFILLER_20_877 VDD VSS VDD VSS gf180mcu_fd_sc_mcu7t5v0__fillcap_8
X_2817_ VDD _2817_/Q _3458_/CLK VSS _2817_/D VDD VSS gf180mcu_fd_sc_mcu7t5v0__dffq_1
XFILLER_176_186 VDD VSS VDD VSS gf180mcu_fd_sc_mcu7t5v0__fillcap_8
XFILLER_164_337 VDD VSS VDD VSS gf180mcu_fd_sc_mcu7t5v0__fillcap_4
XFILLER_145_562 VDD VSS VDD VSS gf180mcu_fd_sc_mcu7t5v0__fillcap_8
X_2748_ _2752_/A1 _2202_/Z _2748_/B2 VDD VSS _2749_/B _3277_/Q _2020_/B VDD VSS gf180mcu_fd_sc_mcu7t5v0__oai32_1
XFILLER_160_521 VDD VSS VDD VSS gf180mcu_fd_sc_mcu7t5v0__fillcap_4
XFILLER_132_201 VDD VSS VDD VSS gf180mcu_fd_sc_mcu7t5v0__fillcap_4
X_2679_ VDD VSS _3311_/D _2679_/A1 _2679_/A2 VDD VSS gf180mcu_fd_sc_mcu7t5v0__nand2_1
XFILLER_86_310 VDD VSS VDD VSS gf180mcu_fd_sc_mcu7t5v0__fillcap_4
XFILLER_86_387 VDD VSS VDD VSS gf180mcu_fd_sc_mcu7t5v0__fillcap_64
XFILLER_74_527 VDD VSS VDD VSS gf180mcu_fd_sc_mcu7t5v0__fillcap_64
XFILLER_243_842 VDD VSS VDD VSS gf180mcu_fd_sc_mcu7t5v0__fillcap_32
XFILLER_203_717 VDD VSS VDD VSS gf180mcu_fd_sc_mcu7t5v0__fillcap_32
XFILLER_42_457 VDD VSS VDD VSS gf180mcu_fd_sc_mcu7t5v0__fillcap_64
XFILLER_211_772 VDD VSS VDD VSS gf180mcu_fd_sc_mcu7t5v0__fillcap_64
XFILLER_195_473 VDD VSS VDD VSS gf180mcu_fd_sc_mcu7t5v0__fillcap_4
XFILLER_167_142 VDD VSS VDD VSS gf180mcu_fd_sc_mcu7t5v0__fillcap_4
XFILLER_10_387 VDD VSS VDD VSS gf180mcu_fd_sc_mcu7t5v0__fillcap_64
XFILLER_136_573 VDD VSS VDD VSS gf180mcu_fd_sc_mcu7t5v0__fillcap_4
XFILLER_164_871 VDD VSS VDD VSS gf180mcu_fd_sc_mcu7t5v0__fillcap_4
XFILLER_123_256 VDD VSS VDD VSS gf180mcu_fd_sc_mcu7t5v0__fillcap_16
XFILLER_96_107 VDD VSS VDD VSS gf180mcu_fd_sc_mcu7t5v0__fillcap_32
XFILLER_2_597 VDD VSS VDD VSS gf180mcu_fd_sc_mcu7t5v0__fillcap_64
XFILLER_265_422 VDD VSS VDD VSS gf180mcu_fd_sc_mcu7t5v0__fillcap_64
XFILLER_78_877 VDD VSS VDD VSS gf180mcu_fd_sc_mcu7t5v0__fillcap_8
XFILLER_93_836 VDD VSS VDD VSS gf180mcu_fd_sc_mcu7t5v0__fillcap_4
XFILLER_133_80 VDD VSS VDD VSS gf180mcu_fd_sc_mcu7t5v0__fillcap_4
XFILLER_233_352 VDD VSS VDD VSS gf180mcu_fd_sc_mcu7t5v0__fillcap_64
XFILLER_260_171 VDD VSS VDD VSS gf180mcu_fd_sc_mcu7t5v0__fillcap_4
XFILLER_61_766 VDD VSS VDD VSS gf180mcu_fd_sc_mcu7t5v0__fillcap_4
XFILLER_159_632 VDD VSS VDD VSS gf180mcu_fd_sc_mcu7t5v0__fillcap_64
X_1981_ _1981_/S VDD VSS _3028_/D wire113/Z _3028_/Q VDD VSS gf180mcu_fd_sc_mcu7t5v0__mux2_2
XFILLER_20_107 VDD VSS VDD VSS gf180mcu_fd_sc_mcu7t5v0__fillcap_64
XFILLER_201_282 VDD VSS VDD VSS gf180mcu_fd_sc_mcu7t5v0__fillcap_16
X_2602_ _2625_/S VDD VSS _3270_/D _3230_/Q _3270_/Q VDD VSS gf180mcu_fd_sc_mcu7t5v0__mux2_2
XFILLER_173_178 VDD VSS VDD VSS gf180mcu_fd_sc_mcu7t5v0__fillcap_32
XFILLER_127_562 VDD VSS VDD VSS gf180mcu_fd_sc_mcu7t5v0__fillcap_8
XFILLER_115_702 VDD VSS VDD VSS gf180mcu_fd_sc_mcu7t5v0__fillcap_64
XFILLER_54_2 VDD VSS VDD VSS gf180mcu_fd_sc_mcu7t5v0__fillcap_32
X_2533_ _2537_/S VDD VSS _3214_/D _3452_/Q _3214_/Q VDD VSS gf180mcu_fd_sc_mcu7t5v0__mux2_2
XFILLER_142_521 VDD VSS VDD VSS gf180mcu_fd_sc_mcu7t5v0__fillcap_4
XFILLER_170_885 VDD VSS VDD VSS gf180mcu_fd_sc_mcu7t5v0__fillcap_4
X_2464_ _2464_/B1 _2464_/B2 VDD VSS _2465_/A2 _3206_/Q _3135_/Q VDD VSS gf180mcu_fd_sc_mcu7t5v0__aoi22_1
X_2395_ VDD _2395_/B _1654_/Z _2396_/A2 _3197_/Q VSS VDD VSS gf180mcu_fd_sc_mcu7t5v0__oai21_1
X_1415_ VDD VSS _3138_/Q _2173_/A1 VDD VSS gf180mcu_fd_sc_mcu7t5v0__clkinv_1
XFILLER_68_387 VDD VSS VDD VSS gf180mcu_fd_sc_mcu7t5v0__fillcap_64
XFILLER_56_527 VDD VSS VDD VSS gf180mcu_fd_sc_mcu7t5v0__fillcap_64
XFILLER_225_842 VDD VSS VDD VSS gf180mcu_fd_sc_mcu7t5v0__fillcap_32
X_3016_ VDD _3016_/Q _3046_/CLK VSS _3016_/D VDD VSS gf180mcu_fd_sc_mcu7t5v0__dffq_1
XFILLER_240_801 VDD VSS VDD VSS gf180mcu_fd_sc_mcu7t5v0__fillcap_4
XFILLER_252_661 VDD VSS VDD VSS gf180mcu_fd_sc_mcu7t5v0__fillcap_4
Xwire55 VSS wire55/Z wire55/I VDD VDD VSS gf180mcu_fd_sc_mcu7t5v0__buf_1
XFILLER_24_457 VDD VSS VDD VSS gf180mcu_fd_sc_mcu7t5v0__fillcap_64
Xwire99 VSS wire99/Z wire99/I VDD VDD VSS gf180mcu_fd_sc_mcu7t5v0__clkbuf_1
Xwire88 VSS wire88/Z wire88/I VDD VDD VSS gf180mcu_fd_sc_mcu7t5v0__clkbuf_1
XFILLER_51_276 VDD VSS VDD VSS gf180mcu_fd_sc_mcu7t5v0__fillcap_4
XFILLER_177_451 VDD VSS VDD VSS gf180mcu_fd_sc_mcu7t5v0__fillcap_8
XFILLER_149_142 VDD VSS VDD VSS gf180mcu_fd_sc_mcu7t5v0__fillcap_4
XFILLER_177_484 VDD VSS VDD VSS gf180mcu_fd_sc_mcu7t5v0__fillcap_4
XFILLER_4_807 VDD VSS VDD VSS gf180mcu_fd_sc_mcu7t5v0__fillcap_64
XFILLER_146_871 VDD VSS VDD VSS gf180mcu_fd_sc_mcu7t5v0__fillcap_4
XFILLER_105_212 VDD VSS VDD VSS gf180mcu_fd_sc_mcu7t5v0__fillcap_4
Xclkbuf_leaf_0_clk_i _3321_/CLK VSS VDD clkload0/I VDD VSS gf180mcu_fd_sc_mcu7t5v0__clkbuf_2
XFILLER_161_874 VDD VSS VDD VSS gf180mcu_fd_sc_mcu7t5v0__fillcap_16
XFILLER_247_422 VDD VSS VDD VSS gf180mcu_fd_sc_mcu7t5v0__fillcap_64
XFILLER_259_282 VDD VSS VDD VSS gf180mcu_fd_sc_mcu7t5v0__fillcap_64
XFILLER_75_836 VDD VSS VDD VSS gf180mcu_fd_sc_mcu7t5v0__fillcap_4
XFILLER_87_696 VDD VSS VDD VSS gf180mcu_fd_sc_mcu7t5v0__fillcap_4
XFILLER_47_66 VDD VSS VDD VSS gf180mcu_fd_sc_mcu7t5v0__fillcap_4
XFILLER_215_330 VDD VSS VDD VSS gf180mcu_fd_sc_mcu7t5v0__fillcap_16
XFILLER_74_368 VDD VSS VDD VSS gf180mcu_fd_sc_mcu7t5v0__fillcap_16
XFILLER_256_2 VDD VSS VDD VSS gf180mcu_fd_sc_mcu7t5v0__fillcap_32
XFILLER_103_72 VDD VSS VDD VSS gf180mcu_fd_sc_mcu7t5v0__fillcap_32
XFILLER_230_311 VDD VSS VDD VSS gf180mcu_fd_sc_mcu7t5v0__fillcap_4
XFILLER_242_171 VDD VSS VDD VSS gf180mcu_fd_sc_mcu7t5v0__fillcap_4
XFILLER_43_766 VDD VSS VDD VSS gf180mcu_fd_sc_mcu7t5v0__fillcap_4
XFILLER_187_259 VDD VSS VDD VSS gf180mcu_fd_sc_mcu7t5v0__fillcap_4
Xmax_length141 VSS wire140/I _2803_/Q VDD VDD VSS gf180mcu_fd_sc_mcu7t5v0__clkbuf_1
XFILLER_128_359 VDD VSS VDD VSS gf180mcu_fd_sc_mcu7t5v0__fillcap_8
XFILLER_11_696 VDD VSS VDD VSS gf180mcu_fd_sc_mcu7t5v0__fillcap_4
Xmax_length152 _3359_/RN wire153/Z VDD VSS VDD VSS gf180mcu_fd_sc_mcu7t5v0__buf_8
XFILLER_6_177 VDD VSS VDD VSS gf180mcu_fd_sc_mcu7t5v0__fillcap_64
XFILLER_136_381 VDD VSS VDD VSS gf180mcu_fd_sc_mcu7t5v0__fillcap_4
XFILLER_124_543 VDD VSS VDD VSS gf180mcu_fd_sc_mcu7t5v0__fillcap_4
XFILLER_124_521 VDD VSS VDD VSS gf180mcu_fd_sc_mcu7t5v0__fillcap_4
XFILLER_152_885 VDD VSS VDD VSS gf180mcu_fd_sc_mcu7t5v0__fillcap_4
XFILLER_112_727 VDD VSS VDD VSS gf180mcu_fd_sc_mcu7t5v0__fillcap_8
XFILLER_88_95 VDD VSS VDD VSS gf180mcu_fd_sc_mcu7t5v0__fillcap_8
XFILLER_266_731 VDD VSS VDD VSS gf180mcu_fd_sc_mcu7t5v0__fillcap_4
X_2180_ _2184_/S VDD VSS _3142_/D _3179_/Q _3142_/Q VDD VSS gf180mcu_fd_sc_mcu7t5v0__mux2_2
XFILLER_38_527 VDD VSS VDD VSS gf180mcu_fd_sc_mcu7t5v0__fillcap_64
XFILLER_65_346 VDD VSS VDD VSS gf180mcu_fd_sc_mcu7t5v0__fillcap_4
XFILLER_207_842 VDD VSS VDD VSS gf180mcu_fd_sc_mcu7t5v0__fillcap_32
XFILLER_93_677 VDD VSS VDD VSS gf180mcu_fd_sc_mcu7t5v0__fillcap_16
XFILLER_222_801 VDD VSS VDD VSS gf180mcu_fd_sc_mcu7t5v0__fillcap_4
XFILLER_234_661 VDD VSS VDD VSS gf180mcu_fd_sc_mcu7t5v0__fillcap_4
XFILLER_230_37 VDD VSS VDD VSS gf180mcu_fd_sc_mcu7t5v0__fillcap_64
XFILLER_21_416 VDD VSS VDD VSS gf180mcu_fd_sc_mcu7t5v0__fillcap_4
XFILLER_33_276 VDD VSS VDD VSS gf180mcu_fd_sc_mcu7t5v0__fillcap_4
X_1964_ VDD VSS _1972_/S _2001_/A1 _1945_/Z VDD VSS gf180mcu_fd_sc_mcu7t5v0__nand2_1
XFILLER_202_591 VDD VSS VDD VSS gf180mcu_fd_sc_mcu7t5v0__fillcap_4
XFILLER_119_315 VDD VSS VDD VSS gf180mcu_fd_sc_mcu7t5v0__fillcap_32
X_1895_ _1895_/S VDD VSS _2954_/D _2954_/Q _2287_/I0 VDD VSS gf180mcu_fd_sc_mcu7t5v0__mux2_2
XFILLER_162_605 VDD VSS VDD VSS gf180mcu_fd_sc_mcu7t5v0__fillcap_4
XFILLER_128_871 VDD VSS VDD VSS gf180mcu_fd_sc_mcu7t5v0__fillcap_4
XFILLER_143_874 VDD VSS VDD VSS gf180mcu_fd_sc_mcu7t5v0__fillcap_16
X_2516_ _3221_/Q VDD VSS _2521_/A1 _3319_/Q _2525_/B1 VDD VSS gf180mcu_fd_sc_mcu7t5v0__aoi21_1
X_2447_ _2447_/A3 VDD VSS _2448_/B _3382_/Q _2447_/A2 VDD VSS gf180mcu_fd_sc_mcu7t5v0__nand3_1
XFILLER_130_535 VDD VSS VDD VSS gf180mcu_fd_sc_mcu7t5v0__fillcap_4
XFILLER_229_422 VDD VSS VDD VSS gf180mcu_fd_sc_mcu7t5v0__fillcap_64
XFILLER_256_241 VDD VSS VDD VSS gf180mcu_fd_sc_mcu7t5v0__fillcap_4
X_2378_ VDD VSS _2379_/A3 _2484_/A1 _3129_/Q VDD VSS gf180mcu_fd_sc_mcu7t5v0__nand2_1
XFILLER_57_836 VDD VSS VDD VSS gf180mcu_fd_sc_mcu7t5v0__fillcap_4
XFILLER_69_696 VDD VSS VDD VSS gf180mcu_fd_sc_mcu7t5v0__fillcap_4
XFILLER_83_132 VDD VSS VDD VSS gf180mcu_fd_sc_mcu7t5v0__fillcap_8
XFILLER_140_37 VDD VSS VDD VSS gf180mcu_fd_sc_mcu7t5v0__fillcap_16
XFILLER_212_311 VDD VSS VDD VSS gf180mcu_fd_sc_mcu7t5v0__fillcap_4
XFILLER_224_171 VDD VSS VDD VSS gf180mcu_fd_sc_mcu7t5v0__fillcap_4
XFILLER_25_766 VDD VSS VDD VSS gf180mcu_fd_sc_mcu7t5v0__fillcap_4
XFILLER_212_333 VDD VSS VDD VSS gf180mcu_fd_sc_mcu7t5v0__fillcap_8
XFILLER_197_579 VDD VSS VDD VSS gf180mcu_fd_sc_mcu7t5v0__fillcap_8
XFILLER_165_454 VDD VSS VDD VSS gf180mcu_fd_sc_mcu7t5v0__fillcap_4
XFILLER_134_885 VDD VSS VDD VSS gf180mcu_fd_sc_mcu7t5v0__fillcap_4
XFILLER_79_416 VDD VSS VDD VSS gf180mcu_fd_sc_mcu7t5v0__fillcap_4
XFILLER_3_136 VDD VSS VDD VSS gf180mcu_fd_sc_mcu7t5v0__fillcap_4
XFILLER_160_170 VDD VSS VDD VSS gf180mcu_fd_sc_mcu7t5v0__fillcap_4
XFILLER_133_384 VDD VSS VDD VSS gf180mcu_fd_sc_mcu7t5v0__fillcap_16
XFILLER_248_731 VDD VSS VDD VSS gf180mcu_fd_sc_mcu7t5v0__fillcap_4
XFILLER_47_346 VDD VSS VDD VSS gf180mcu_fd_sc_mcu7t5v0__fillcap_4
XFILLER_204_801 VDD VSS VDD VSS gf180mcu_fd_sc_mcu7t5v0__fillcap_4
XFILLER_216_661 VDD VSS VDD VSS gf180mcu_fd_sc_mcu7t5v0__fillcap_4
XFILLER_74_86 VDD VSS VDD VSS gf180mcu_fd_sc_mcu7t5v0__fillcap_4
XFILLER_200_18 VDD VSS VDD VSS gf180mcu_fd_sc_mcu7t5v0__fillcap_16
XFILLER_15_276 VDD VSS VDD VSS gf180mcu_fd_sc_mcu7t5v0__fillcap_4
XFILLER_128_101 VDD VSS VDD VSS gf180mcu_fd_sc_mcu7t5v0__fillcap_4
XFILLER_128_123 VDD VSS VDD VSS gf180mcu_fd_sc_mcu7t5v0__fillcap_4
X_1680_ _2359_/A1 VDD VSS _2363_/A1 _3194_/Q _2363_/B2 VDD VSS gf180mcu_fd_sc_mcu7t5v0__nand3_1
XFILLER_7_486 VDD VSS VDD VSS gf180mcu_fd_sc_mcu7t5v0__fillcap_4
XFILLER_99_72 VDD VSS VDD VSS gf180mcu_fd_sc_mcu7t5v0__fillcap_16
XFILLER_171_468 VDD VSS VDD VSS gf180mcu_fd_sc_mcu7t5v0__fillcap_16
X_3350_ VSS _3365_/CLK VDD _3350_/D wire84/I _3457_/RN VDD VSS gf180mcu_fd_sc_mcu7t5v0__dffsnq_1
XFILLER_125_874 VDD VSS VDD VSS gf180mcu_fd_sc_mcu7t5v0__fillcap_16
X_2301_ _3199_/Q _2301_/C VDD VSS _2307_/A1 _2305_/B2 _3095_/Q _2302_/A2 VDD VSS gf180mcu_fd_sc_mcu7t5v0__aoi221_1
XFILLER_140_877 VDD VSS VDD VSS gf180mcu_fd_sc_mcu7t5v0__fillcap_8
X_3281_ _3281_/D wire94/I _3452_/RN VSS _3281_/CLK VDD VDD VSS gf180mcu_fd_sc_mcu7t5v0__dffrnq_1
XFILLER_238_241 VDD VSS VDD VSS gf180mcu_fd_sc_mcu7t5v0__fillcap_4
X_2232_ _2232_/B VDD VSS _2235_/A2 _2232_/A1 _1716_/B VDD VSS gf180mcu_fd_sc_mcu7t5v0__aoi21_1
XFILLER_39_836 VDD VSS VDD VSS gf180mcu_fd_sc_mcu7t5v0__fillcap_4
XFILLER_112_579 VDD VSS VDD VSS gf180mcu_fd_sc_mcu7t5v0__fillcap_16
X_2163_ VDD VSS _2164_/I1 _2163_/A1 _2163_/A2 VDD VSS gf180mcu_fd_sc_mcu7t5v0__nand2_1
XFILLER_17_2 VDD VSS VDD VSS gf180mcu_fd_sc_mcu7t5v0__fillcap_64
XFILLER_241_58 VDD VSS VDD VSS gf180mcu_fd_sc_mcu7t5v0__fillcap_8
XFILLER_93_463 VDD VSS VDD VSS gf180mcu_fd_sc_mcu7t5v0__fillcap_16
X_2094_ _2094_/B _2115_/C VDD VSS _3106_/D _2074_/Z _2092_/Z VDD VSS gf180mcu_fd_sc_mcu7t5v0__aoi211_1
XFILLER_206_193 VDD VSS VDD VSS gf180mcu_fd_sc_mcu7t5v0__fillcap_8
XFILLER_194_527 VDD VSS VDD VSS gf180mcu_fd_sc_mcu7t5v0__fillcap_8
X_2996_ VDD _2996_/Q _3005_/CLK VSS _2996_/D VDD VSS gf180mcu_fd_sc_mcu7t5v0__dffq_1
X_1947_ _1954_/S VDD VSS _2997_/D _2997_/Q _2011_/I0 VDD VSS gf180mcu_fd_sc_mcu7t5v0__mux2_2
XFILLER_162_413 VDD VSS VDD VSS gf180mcu_fd_sc_mcu7t5v0__fillcap_8
XFILLER_119_156 VDD VSS VDD VSS gf180mcu_fd_sc_mcu7t5v0__fillcap_32
X_1878_ VDD VSS _1992_/A1 _3407_/Q _1879_/A2 VDD VSS gf180mcu_fd_sc_mcu7t5v0__nor2_1
XFILLER_174_295 VDD VSS VDD VSS gf180mcu_fd_sc_mcu7t5v0__fillcap_8
XFILLER_162_457 VDD VSS VDD VSS gf180mcu_fd_sc_mcu7t5v0__fillcap_64
XFILLER_116_885 VDD VSS VDD VSS gf180mcu_fd_sc_mcu7t5v0__fillcap_4
XFILLER_130_387 VDD VSS VDD VSS gf180mcu_fd_sc_mcu7t5v0__fillcap_8
XFILLER_29_346 VDD VSS VDD VSS gf180mcu_fd_sc_mcu7t5v0__fillcap_4
XFILLER_260_737 VDD VSS VDD VSS gf180mcu_fd_sc_mcu7t5v0__fillcap_64
XFILLER_198_800 VDD VSS VDD VSS gf180mcu_fd_sc_mcu7t5v0__fillcap_4
XFILLER_198_877 VDD VSS VDD VSS gf180mcu_fd_sc_mcu7t5v0__fillcap_8
XFILLER_197_387 VDD VSS VDD VSS gf180mcu_fd_sc_mcu7t5v0__fillcap_8
XFILLER_178_590 VDD VSS VDD VSS gf180mcu_fd_sc_mcu7t5v0__fillcap_4
Xclkbuf_leaf_33_clk_i _3392_/CLK VSS VDD clkload6/I VDD VSS gf180mcu_fd_sc_mcu7t5v0__clkbuf_2
XFILLER_138_465 VDD VSS VDD VSS gf180mcu_fd_sc_mcu7t5v0__fillcap_4
XFILLER_219_2 VDD VSS VDD VSS gf180mcu_fd_sc_mcu7t5v0__fillcap_16
XFILLER_121_2 VDD VSS VDD VSS gf180mcu_fd_sc_mcu7t5v0__fillcap_16
XFILLER_180_232 VDD VSS VDD VSS gf180mcu_fd_sc_mcu7t5v0__fillcap_8
XFILLER_134_660 VDD VSS VDD VSS gf180mcu_fd_sc_mcu7t5v0__fillcap_4
XFILLER_125_148 VDD VSS VDD VSS gf180mcu_fd_sc_mcu7t5v0__fillcap_32
XFILLER_107_874 VDD VSS VDD VSS gf180mcu_fd_sc_mcu7t5v0__fillcap_16
XFILLER_140_107 VDD VSS VDD VSS gf180mcu_fd_sc_mcu7t5v0__fillcap_4
XFILLER_192_10 VDD VSS VDD VSS gf180mcu_fd_sc_mcu7t5v0__fillcap_4
Xclkbuf_leaf_48_clk_i _3058_/CLK VSS VDD clkload1/I VDD VSS gf180mcu_fd_sc_mcu7t5v0__clkbuf_2
XFILLER_122_877 VDD VSS VDD VSS gf180mcu_fd_sc_mcu7t5v0__fillcap_8
XFILLER_79_268 VDD VSS VDD VSS gf180mcu_fd_sc_mcu7t5v0__fillcap_4
XFILLER_208_414 VDD VSS VDD VSS gf180mcu_fd_sc_mcu7t5v0__fillcap_32
XFILLER_250_247 VDD VSS VDD VSS gf180mcu_fd_sc_mcu7t5v0__fillcap_64
X_2850_ VDD _2850_/Q _2867_/CLK VSS _2850_/D VDD VSS gf180mcu_fd_sc_mcu7t5v0__dffq_1
X_1801_ _1805_/S VDD VSS _2872_/D wire133/Z _2872_/Q VDD VSS gf180mcu_fd_sc_mcu7t5v0__mux2_2
XFILLER_188_387 VDD VSS VDD VSS gf180mcu_fd_sc_mcu7t5v0__fillcap_4
X_2781_ wire20/Z _3084_/Q VDD VSS _2782_/I _3332_/Q _2739_/S VDD VSS gf180mcu_fd_sc_mcu7t5v0__aoi22_1
X_1732_ _1738_/S VDD VSS _2814_/D _2814_/Q _3120_/Q VDD VSS gf180mcu_fd_sc_mcu7t5v0__mux2_2
Xhold217 _3387_/D VSS _3392_/Q VDD VDD VSS gf180mcu_fd_sc_mcu7t5v0__dlyc_1
X_1663_ VDD VSS _1673_/A2 _3193_/Q _1677_/A2 VDD VSS gf180mcu_fd_sc_mcu7t5v0__nor2_1
Xwire170 wire170/Z VSS VDD input1/Z VDD VSS gf180mcu_fd_sc_mcu7t5v0__clkbuf_2
Xhold228 _3398_/D VSS _3403_/Q VDD VDD VSS gf180mcu_fd_sc_mcu7t5v0__dlyc_1
X_3402_ _3402_/D _3402_/Q _3403_/RN VSS _3403_/CLK VDD VDD VSS gf180mcu_fd_sc_mcu7t5v0__dffrnq_1
X_1594_ _3346_/Q _2470_/B VDD VSS _2187_/A2 _2320_/A1 _1583_/B VDD VSS gf180mcu_fd_sc_mcu7t5v0__oai211_1
XFILLER_124_170 VDD VSS VDD VSS gf180mcu_fd_sc_mcu7t5v0__fillcap_4
X_3333_ _3333_/D _3333_/Q wire165/Z VSS clkload9/I VDD VDD VSS gf180mcu_fd_sc_mcu7t5v0__dffrnq_1
XFILLER_100_527 VDD VSS VDD VSS gf180mcu_fd_sc_mcu7t5v0__fillcap_8
X_3264_ _3264_/D _3264_/Q _3335_/RN VSS _3446_/CLK VDD VDD VSS gf180mcu_fd_sc_mcu7t5v0__dffrnq_1
X_2215_ _2219_/S VDD VSS _3161_/D wire97/I _3161_/Q VDD VSS gf180mcu_fd_sc_mcu7t5v0__mux2_2
XFILLER_112_387 VDD VSS VDD VSS gf180mcu_fd_sc_mcu7t5v0__fillcap_8
X_3195_ _3195_/D _3195_/Q _3359_/RN VSS _3363_/CLK VDD VDD VSS gf180mcu_fd_sc_mcu7t5v0__dffrnq_1
XFILLER_81_422 VDD VSS VDD VSS gf180mcu_fd_sc_mcu7t5v0__fillcap_64
X_2146_ _2146_/A3 VDD VSS _2168_/B1 _2177_/A1 _3141_/Q VDD VSS gf180mcu_fd_sc_mcu7t5v0__nor3_1
XFILLER_93_282 VDD VSS VDD VSS gf180mcu_fd_sc_mcu7t5v0__fillcap_16
XFILLER_242_737 VDD VSS VDD VSS gf180mcu_fd_sc_mcu7t5v0__fillcap_64
XFILLER_254_597 VDD VSS VDD VSS gf180mcu_fd_sc_mcu7t5v0__fillcap_64
X_2077_ VDD VSS _2078_/B _3102_/Q _2075_/Z VDD VSS gf180mcu_fd_sc_mcu7t5v0__nor2_1
XFILLER_201_72 VDD VSS VDD VSS gf180mcu_fd_sc_mcu7t5v0__fillcap_16
XFILLER_195_836 VDD VSS VDD VSS gf180mcu_fd_sc_mcu7t5v0__fillcap_4
XFILLER_14_37 VDD VSS VDD VSS gf180mcu_fd_sc_mcu7t5v0__fillcap_64
XFILLER_210_667 VDD VSS VDD VSS gf180mcu_fd_sc_mcu7t5v0__fillcap_64
X_2979_ VDD _2979_/Q _3181_/CLK VSS _2979_/D VDD VSS gf180mcu_fd_sc_mcu7t5v0__dffq_1
XFILLER_163_766 VDD VSS VDD VSS gf180mcu_fd_sc_mcu7t5v0__fillcap_4
XFILLER_122_107 VDD VSS VDD VSS gf180mcu_fd_sc_mcu7t5v0__fillcap_4
XFILLER_103_332 VDD VSS VDD VSS gf180mcu_fd_sc_mcu7t5v0__fillcap_16
XFILLER_89_577 VDD VSS VDD VSS gf180mcu_fd_sc_mcu7t5v0__fillcap_32
XFILLER_104_877 VDD VSS VDD VSS gf180mcu_fd_sc_mcu7t5v0__fillcap_8
XFILLER_264_317 VDD VSS VDD VSS gf180mcu_fd_sc_mcu7t5v0__fillcap_64
XFILLER_103_387 VDD VSS VDD VSS gf180mcu_fd_sc_mcu7t5v0__fillcap_8
XFILLER_131_696 VDD VSS VDD VSS gf180mcu_fd_sc_mcu7t5v0__fillcap_4
XFILLER_85_772 VDD VSS VDD VSS gf180mcu_fd_sc_mcu7t5v0__fillcap_64
XFILLER_169_2 VDD VSS VDD VSS gf180mcu_fd_sc_mcu7t5v0__fillcap_32
XFILLER_55_66 VDD VSS VDD VSS gf180mcu_fd_sc_mcu7t5v0__fillcap_4
XFILLER_232_247 VDD VSS VDD VSS gf180mcu_fd_sc_mcu7t5v0__fillcap_64
XFILLER_220_409 VDD VSS VDD VSS gf180mcu_fd_sc_mcu7t5v0__fillcap_8
XFILLER_41_842 VDD VSS VDD VSS gf180mcu_fd_sc_mcu7t5v0__fillcap_32
XFILLER_158_527 VDD VSS VDD VSS gf180mcu_fd_sc_mcu7t5v0__fillcap_64
XFILLER_185_313 VDD VSS VDD VSS gf180mcu_fd_sc_mcu7t5v0__fillcap_16
XFILLER_201_656 VDD VSS VDD VSS gf180mcu_fd_sc_mcu7t5v0__fillcap_4
XFILLER_185_346 VDD VSS VDD VSS gf180mcu_fd_sc_mcu7t5v0__fillcap_4
XFILLER_200_177 VDD VSS VDD VSS gf180mcu_fd_sc_mcu7t5v0__fillcap_32
XFILLER_126_457 VDD VSS VDD VSS gf180mcu_fd_sc_mcu7t5v0__fillcap_8
XFILLER_141_416 VDD VSS VDD VSS gf180mcu_fd_sc_mcu7t5v0__fillcap_4
XFILLER_256_807 VDD VSS VDD VSS gf180mcu_fd_sc_mcu7t5v0__fillcap_64
XFILLER_208_200 VDD VSS VDD VSS gf180mcu_fd_sc_mcu7t5v0__fillcap_8
X_2000_ _2000_/S VDD VSS _3044_/D wire113/Z _3044_/Q VDD VSS gf180mcu_fd_sc_mcu7t5v0__mux2_2
XFILLER_63_422 VDD VSS VDD VSS gf180mcu_fd_sc_mcu7t5v0__fillcap_64
XFILLER_75_282 VDD VSS VDD VSS gf180mcu_fd_sc_mcu7t5v0__fillcap_8
XFILLER_224_737 VDD VSS VDD VSS gf180mcu_fd_sc_mcu7t5v0__fillcap_64
XFILLER_236_597 VDD VSS VDD VSS gf180mcu_fd_sc_mcu7t5v0__fillcap_64
XFILLER_251_556 VDD VSS VDD VSS gf180mcu_fd_sc_mcu7t5v0__fillcap_4
X_2902_ VDD _2902_/Q _2931_/CLK VSS _2902_/D VDD VSS gf180mcu_fd_sc_mcu7t5v0__dffq_1
XFILLER_177_836 VDD VSS VDD VSS gf180mcu_fd_sc_mcu7t5v0__fillcap_4
XFILLER_31_352 VDD VSS VDD VSS gf180mcu_fd_sc_mcu7t5v0__fillcap_64
X_2833_ VDD _2833_/Q _3405_/CLK VSS _2833_/D VDD VSS gf180mcu_fd_sc_mcu7t5v0__dffq_1
XFILLER_176_357 VDD VSS VDD VSS gf180mcu_fd_sc_mcu7t5v0__fillcap_16
XFILLER_84_2 VDD VSS VDD VSS gf180mcu_fd_sc_mcu7t5v0__fillcap_8
X_2764_ VDD VSS _2764_/I _3323_/D VDD VSS gf180mcu_fd_sc_mcu7t5v0__clkinv_1
X_1715_ _1715_/B VDD VSS _2332_/A3 _3362_/D _1700_/Z VDD VSS gf180mcu_fd_sc_mcu7t5v0__aoi21_1
XFILLER_145_766 VDD VSS VDD VSS gf180mcu_fd_sc_mcu7t5v0__fillcap_4
X_2695_ _2695_/B _2732_/C VDD VSS _2699_/B _2735_/S _2695_/A2 VDD VSS gf180mcu_fd_sc_mcu7t5v0__oai211_1
XFILLER_132_427 VDD VSS VDD VSS gf180mcu_fd_sc_mcu7t5v0__fillcap_16
XFILLER_104_107 VDD VSS VDD VSS gf180mcu_fd_sc_mcu7t5v0__fillcap_4
X_1646_ VDD VSS _1649_/B1 _3227_/Q _2567_/B VDD VSS gf180mcu_fd_sc_mcu7t5v0__nand2_1
X_1577_ _2142_/A1 VDD VSS _2191_/A3 _3146_/Q _3148_/Q VDD VSS gf180mcu_fd_sc_mcu7t5v0__nand3_1
XFILLER_99_842 VDD VSS VDD VSS gf180mcu_fd_sc_mcu7t5v0__fillcap_32
X_3316_ _3316_/D _3316_/Q _3336_/RN VSS _3316_/CLK VDD VDD VSS gf180mcu_fd_sc_mcu7t5v0__dffrnq_1
XFILLER_258_177 VDD VSS VDD VSS gf180mcu_fd_sc_mcu7t5v0__fillcap_64
XFILLER_246_317 VDD VSS VDD VSS gf180mcu_fd_sc_mcu7t5v0__fillcap_64
XFILLER_101_836 VDD VSS VDD VSS gf180mcu_fd_sc_mcu7t5v0__fillcap_4
X_3247_ _3247_/D _3247_/Q _3452_/RN VSS _3289_/CLK VDD VDD VSS gf180mcu_fd_sc_mcu7t5v0__dffrnq_1
X_3178_ VDD _3178_/Q _3179_/CLK VSS _3178_/D VDD VSS gf180mcu_fd_sc_mcu7t5v0__dffq_1
XFILLER_67_772 VDD VSS VDD VSS gf180mcu_fd_sc_mcu7t5v0__fillcap_64
XFILLER_199_416 VDD VSS VDD VSS gf180mcu_fd_sc_mcu7t5v0__fillcap_4
X_2129_ _2128_/Z VDD VSS _2205_/A4 _2614_/A1 _2203_/A2 VDD VSS gf180mcu_fd_sc_mcu7t5v0__nor3_1
XFILLER_82_731 VDD VSS VDD VSS gf180mcu_fd_sc_mcu7t5v0__fillcap_4
XFILLER_214_247 VDD VSS VDD VSS gf180mcu_fd_sc_mcu7t5v0__fillcap_64
XFILLER_212_60 VDD VSS VDD VSS gf180mcu_fd_sc_mcu7t5v0__fillcap_16
XFILLER_23_842 VDD VSS VDD VSS gf180mcu_fd_sc_mcu7t5v0__fillcap_32
XFILLER_50_661 VDD VSS VDD VSS gf180mcu_fd_sc_mcu7t5v0__fillcap_4
XFILLER_167_346 VDD VSS VDD VSS gf180mcu_fd_sc_mcu7t5v0__fillcap_4
XFILLER_194_143 VDD VSS VDD VSS gf180mcu_fd_sc_mcu7t5v0__fillcap_32
XFILLER_194_187 VDD VSS VDD VSS gf180mcu_fd_sc_mcu7t5v0__fillcap_32
XFILLER_182_349 VDD VSS VDD VSS gf180mcu_fd_sc_mcu7t5v0__fillcap_8
XFILLER_135_254 VDD VSS VDD VSS gf180mcu_fd_sc_mcu7t5v0__fillcap_16
XFILLER_108_457 VDD VSS VDD VSS gf180mcu_fd_sc_mcu7t5v0__fillcap_64
XFILLER_1_212 VDD VSS VDD VSS gf180mcu_fd_sc_mcu7t5v0__fillcap_64
XFILLER_238_807 VDD VSS VDD VSS gf180mcu_fd_sc_mcu7t5v0__fillcap_64
XFILLER_89_352 VDD VSS VDD VSS gf180mcu_fd_sc_mcu7t5v0__fillcap_8
XFILLER_265_626 VDD VSS VDD VSS gf180mcu_fd_sc_mcu7t5v0__fillcap_4
XFILLER_218_520 VDD VSS VDD VSS gf180mcu_fd_sc_mcu7t5v0__fillcap_4
XFILLER_45_422 VDD VSS VDD VSS gf180mcu_fd_sc_mcu7t5v0__fillcap_64
XFILLER_206_737 VDD VSS VDD VSS gf180mcu_fd_sc_mcu7t5v0__fillcap_64
XFILLER_218_597 VDD VSS VDD VSS gf180mcu_fd_sc_mcu7t5v0__fillcap_8
XFILLER_57_282 VDD VSS VDD VSS gf180mcu_fd_sc_mcu7t5v0__fillcap_64
XFILLER_233_556 VDD VSS VDD VSS gf180mcu_fd_sc_mcu7t5v0__fillcap_4
XFILLER_82_75 VDD VSS VDD VSS gf180mcu_fd_sc_mcu7t5v0__fillcap_4
XFILLER_159_836 VDD VSS VDD VSS gf180mcu_fd_sc_mcu7t5v0__fillcap_4
XFILLER_158_302 VDD VSS VDD VSS gf180mcu_fd_sc_mcu7t5v0__fillcap_8
XFILLER_13_352 VDD VSS VDD VSS gf180mcu_fd_sc_mcu7t5v0__fillcap_64
XFILLER_40_171 VDD VSS VDD VSS gf180mcu_fd_sc_mcu7t5v0__fillcap_4
XFILLER_201_486 VDD VSS VDD VSS gf180mcu_fd_sc_mcu7t5v0__fillcap_4
XFILLER_127_766 VDD VSS VDD VSS gf180mcu_fd_sc_mcu7t5v0__fillcap_4
XFILLER_114_416 VDD VSS VDD VSS gf180mcu_fd_sc_mcu7t5v0__fillcap_32
X_1500_ _1494_/Z _1500_/A4 VDD VSS _1500_/Z _3368_/Q _3367_/Q VDD VSS gf180mcu_fd_sc_mcu7t5v0__and4_1
X_2480_ VDD _2481_/A2 _3208_/Q _3209_/Q _1715_/B VSS _2480_/A3 VDD VSS gf180mcu_fd_sc_mcu7t5v0__oai31_1
XFILLER_5_562 VDD VSS VDD VSS gf180mcu_fd_sc_mcu7t5v0__fillcap_64
XFILLER_126_298 VDD VSS VDD VSS gf180mcu_fd_sc_mcu7t5v0__fillcap_8
X_1431_ VDD VSS _3225_/Q _2553_/A1 VDD VSS gf180mcu_fd_sc_mcu7t5v0__clkinv_1
XFILLER_96_801 VDD VSS VDD VSS gf180mcu_fd_sc_mcu7t5v0__fillcap_4
XFILLER_228_317 VDD VSS VDD VSS gf180mcu_fd_sc_mcu7t5v0__fillcap_64
X_3101_ _3101_/D _3101_/Q wire163/I VSS _3341_/CLK VDD VDD VSS gf180mcu_fd_sc_mcu7t5v0__dffrnq_1
XFILLER_255_136 VDD VSS VDD VSS gf180mcu_fd_sc_mcu7t5v0__fillcap_4
XFILLER_49_772 VDD VSS VDD VSS gf180mcu_fd_sc_mcu7t5v0__fillcap_64
X_3032_ VDD _3032_/Q _3058_/CLK VSS _3032_/D VDD VSS gf180mcu_fd_sc_mcu7t5v0__dffq_1
XFILLER_76_591 VDD VSS VDD VSS gf180mcu_fd_sc_mcu7t5v0__fillcap_4
XFILLER_64_731 VDD VSS VDD VSS gf180mcu_fd_sc_mcu7t5v0__fillcap_4
XFILLER_211_206 VDD VSS VDD VSS gf180mcu_fd_sc_mcu7t5v0__fillcap_4
XFILLER_20_801 VDD VSS VDD VSS gf180mcu_fd_sc_mcu7t5v0__fillcap_4
XFILLER_32_661 VDD VSS VDD VSS gf180mcu_fd_sc_mcu7t5v0__fillcap_4
X_2816_ VDD _2816_/Q _3434_/CLK VSS _2816_/D VDD VSS gf180mcu_fd_sc_mcu7t5v0__dffq_1
XFILLER_149_368 VDD VSS VDD VSS gf180mcu_fd_sc_mcu7t5v0__fillcap_8
XFILLER_192_625 VDD VSS VDD VSS gf180mcu_fd_sc_mcu7t5v0__fillcap_16
XFILLER_191_113 VDD VSS VDD VSS gf180mcu_fd_sc_mcu7t5v0__fillcap_16
X_2747_ _2749_/C VDD VSS _3317_/D _2747_/I0 _3317_/Q VDD VSS gf180mcu_fd_sc_mcu7t5v0__mux2_2
X_2678_ VDD VSS _2679_/A2 _2724_/C _2677_/Z VDD VSS gf180mcu_fd_sc_mcu7t5v0__nand2_1
XFILLER_117_265 VDD VSS VDD VSS gf180mcu_fd_sc_mcu7t5v0__fillcap_8
XFILLER_117_287 VDD VSS VDD VSS gf180mcu_fd_sc_mcu7t5v0__fillcap_4
XFILLER_133_736 VDD VSS VDD VSS gf180mcu_fd_sc_mcu7t5v0__fillcap_32
X_1629_ _3110_/Q VDD VSS _2113_/A2 _3112_/Q _3111_/Q VDD VSS gf180mcu_fd_sc_mcu7t5v0__nand3_1
XFILLER_247_626 VDD VSS VDD VSS gf180mcu_fd_sc_mcu7t5v0__fillcap_4
XFILLER_259_486 VDD VSS VDD VSS gf180mcu_fd_sc_mcu7t5v0__fillcap_4
XFILLER_98_193 VDD VSS VDD VSS gf180mcu_fd_sc_mcu7t5v0__fillcap_4
XFILLER_27_422 VDD VSS VDD VSS gf180mcu_fd_sc_mcu7t5v0__fillcap_64
XFILLER_39_282 VDD VSS VDD VSS gf180mcu_fd_sc_mcu7t5v0__fillcap_64
XFILLER_215_556 VDD VSS VDD VSS gf180mcu_fd_sc_mcu7t5v0__fillcap_4
XFILLER_54_241 VDD VSS VDD VSS gf180mcu_fd_sc_mcu7t5v0__fillcap_4
XFILLER_195_430 VDD VSS VDD VSS gf180mcu_fd_sc_mcu7t5v0__fillcap_4
XFILLER_168_45 VDD VSS VDD VSS gf180mcu_fd_sc_mcu7t5v0__fillcap_4
XFILLER_128_519 VDD VSS VDD VSS gf180mcu_fd_sc_mcu7t5v0__fillcap_4
XFILLER_10_311 VDD VSS VDD VSS gf180mcu_fd_sc_mcu7t5v0__fillcap_4
XFILLER_22_171 VDD VSS VDD VSS gf180mcu_fd_sc_mcu7t5v0__fillcap_4
XFILLER_183_625 VDD VSS VDD VSS gf180mcu_fd_sc_mcu7t5v0__fillcap_4
XFILLER_109_766 VDD VSS VDD VSS gf180mcu_fd_sc_mcu7t5v0__fillcap_4
XFILLER_136_585 VDD VSS VDD VSS gf180mcu_fd_sc_mcu7t5v0__fillcap_8
XFILLER_191_680 VDD VSS VDD VSS gf180mcu_fd_sc_mcu7t5v0__fillcap_16
XFILLER_124_714 VDD VSS VDD VSS gf180mcu_fd_sc_mcu7t5v0__fillcap_16
XFILLER_123_235 VDD VSS VDD VSS gf180mcu_fd_sc_mcu7t5v0__fillcap_4
XFILLER_2_521 VDD VSS VDD VSS gf180mcu_fd_sc_mcu7t5v0__fillcap_4
XFILLER_78_801 VDD VSS VDD VSS gf180mcu_fd_sc_mcu7t5v0__fillcap_4
XFILLER_89_193 VDD VSS VDD VSS gf180mcu_fd_sc_mcu7t5v0__fillcap_8
XFILLER_237_136 VDD VSS VDD VSS gf180mcu_fd_sc_mcu7t5v0__fillcap_4
XFILLER_58_591 VDD VSS VDD VSS gf180mcu_fd_sc_mcu7t5v0__fillcap_4
XFILLER_46_731 VDD VSS VDD VSS gf180mcu_fd_sc_mcu7t5v0__fillcap_4
XFILLER_93_63 VDD VSS VDD VSS gf180mcu_fd_sc_mcu7t5v0__fillcap_4
X_1980_ _1981_/S VDD VSS _3027_/D wire114/Z _3027_/Q VDD VSS gf180mcu_fd_sc_mcu7t5v0__mux2_2
XFILLER_186_430 VDD VSS VDD VSS gf180mcu_fd_sc_mcu7t5v0__fillcap_16
XFILLER_14_661 VDD VSS VDD VSS gf180mcu_fd_sc_mcu7t5v0__fillcap_4
XFILLER_201_261 VDD VSS VDD VSS gf180mcu_fd_sc_mcu7t5v0__fillcap_16
XFILLER_9_142 VDD VSS VDD VSS gf180mcu_fd_sc_mcu7t5v0__fillcap_64
XFILLER_228_37 VDD VSS VDD VSS gf180mcu_fd_sc_mcu7t5v0__fillcap_64
XFILLER_139_390 VDD VSS VDD VSS gf180mcu_fd_sc_mcu7t5v0__fillcap_16
X_2601_ _2625_/S VDD VSS _3269_/D _3229_/Q _3269_/Q VDD VSS gf180mcu_fd_sc_mcu7t5v0__mux2_2
XFILLER_6_871 VDD VSS VDD VSS gf180mcu_fd_sc_mcu7t5v0__fillcap_4
X_2532_ VDD _2532_/B _2532_/A2 _3213_/D _2532_/A1 VSS VDD VSS gf180mcu_fd_sc_mcu7t5v0__oai21_1
XFILLER_114_235 VDD VSS VDD VSS gf180mcu_fd_sc_mcu7t5v0__fillcap_8
X_2463_ _3210_/Q _3206_/Q VDD VSS _2464_/B2 _2463_/A1 _2463_/A2 VDD VSS gf180mcu_fd_sc_mcu7t5v0__aoi211_1
XFILLER_102_419 VDD VSS VDD VSS gf180mcu_fd_sc_mcu7t5v0__fillcap_8
XFILLER_47_2 VDD VSS VDD VSS gf180mcu_fd_sc_mcu7t5v0__fillcap_64
X_1414_ VDD VSS _3118_/Q _2076_/A1 VDD VSS gf180mcu_fd_sc_mcu7t5v0__clkinv_1
X_2394_ VDD VSS _2395_/B _1654_/Z _2394_/A2 VDD VSS gf180mcu_fd_sc_mcu7t5v0__nand2_1
XFILLER_68_311 VDD VSS VDD VSS gf180mcu_fd_sc_mcu7t5v0__fillcap_4
XFILLER_96_620 VDD VSS VDD VSS gf180mcu_fd_sc_mcu7t5v0__fillcap_4
XFILLER_229_626 VDD VSS VDD VSS gf180mcu_fd_sc_mcu7t5v0__fillcap_4
XFILLER_3_72 VDD VSS VDD VSS gf180mcu_fd_sc_mcu7t5v0__fillcap_64
X_3015_ VDD _3015_/Q _3022_/CLK VSS _3015_/D VDD VSS gf180mcu_fd_sc_mcu7t5v0__dffq_1
Xwire12 wire12/Z wire12/I VDD VSS VDD VSS gf180mcu_fd_sc_mcu7t5v0__buf_4
XFILLER_36_241 VDD VSS VDD VSS gf180mcu_fd_sc_mcu7t5v0__fillcap_4
Xwire78 VSS wire78/Z wire78/I VDD VDD VSS gf180mcu_fd_sc_mcu7t5v0__buf_3
Xwire89 wire89/Z VSS VDD wire89/I VDD VSS gf180mcu_fd_sc_mcu7t5v0__clkbuf_2
XFILLER_177_430 VDD VSS VDD VSS gf180mcu_fd_sc_mcu7t5v0__fillcap_4
XFILLER_22_37 VDD VSS VDD VSS gf180mcu_fd_sc_mcu7t5v0__fillcap_64
XFILLER_138_37 VDD VSS VDD VSS gf180mcu_fd_sc_mcu7t5v0__fillcap_32
XFILLER_180_628 VDD VSS VDD VSS gf180mcu_fd_sc_mcu7t5v0__fillcap_32
XFILLER_164_168 VDD VSS VDD VSS gf180mcu_fd_sc_mcu7t5v0__fillcap_4
XFILLER_161_842 VDD VSS VDD VSS gf180mcu_fd_sc_mcu7t5v0__fillcap_32
XFILLER_120_216 VDD VSS VDD VSS gf180mcu_fd_sc_mcu7t5v0__fillcap_8
XFILLER_74_336 VDD VSS VDD VSS gf180mcu_fd_sc_mcu7t5v0__fillcap_32
XFILLER_28_731 VDD VSS VDD VSS gf180mcu_fd_sc_mcu7t5v0__fillcap_4
XFILLER_90_807 VDD VSS VDD VSS gf180mcu_fd_sc_mcu7t5v0__fillcap_64
XFILLER_86_185 VDD VSS VDD VSS gf180mcu_fd_sc_mcu7t5v0__fillcap_4
XFILLER_151_2 VDD VSS VDD VSS gf180mcu_fd_sc_mcu7t5v0__fillcap_16
XFILLER_249_2 VDD VSS VDD VSS gf180mcu_fd_sc_mcu7t5v0__fillcap_64
XFILLER_70_597 VDD VSS VDD VSS gf180mcu_fd_sc_mcu7t5v0__fillcap_64
XFILLER_183_422 VDD VSS VDD VSS gf180mcu_fd_sc_mcu7t5v0__fillcap_64
XFILLER_195_282 VDD VSS VDD VSS gf180mcu_fd_sc_mcu7t5v0__fillcap_32
XFILLER_6_101 VDD VSS VDD VSS gf180mcu_fd_sc_mcu7t5v0__fillcap_4
XFILLER_155_135 VDD VSS VDD VSS gf180mcu_fd_sc_mcu7t5v0__fillcap_4
Xmax_length120 VSS wire119/I _3178_/Q VDD VDD VSS gf180mcu_fd_sc_mcu7t5v0__buf_2
XFILLER_195_76 VDD VSS VDD VSS gf180mcu_fd_sc_mcu7t5v0__fillcap_8
XFILLER_143_308 VDD VSS VDD VSS gf180mcu_fd_sc_mcu7t5v0__fillcap_32
Xmax_length164 wire163/I wire165/Z VDD VSS VDD VSS gf180mcu_fd_sc_mcu7t5v0__buf_4
XFILLER_109_552 VDD VSS VDD VSS gf180mcu_fd_sc_mcu7t5v0__fillcap_8
XFILLER_88_30 VDD VSS VDD VSS gf180mcu_fd_sc_mcu7t5v0__fillcap_4
XFILLER_151_330 VDD VSS VDD VSS gf180mcu_fd_sc_mcu7t5v0__fillcap_4
XFILLER_151_352 VDD VSS VDD VSS gf180mcu_fd_sc_mcu7t5v0__fillcap_8
XFILLER_3_874 VDD VSS VDD VSS gf180mcu_fd_sc_mcu7t5v0__fillcap_16
XFILLER_97_439 VDD VSS VDD VSS gf180mcu_fd_sc_mcu7t5v0__fillcap_32
XFILLER_18_241 VDD VSS VDD VSS gf180mcu_fd_sc_mcu7t5v0__fillcap_4
XFILLER_92_177 VDD VSS VDD VSS gf180mcu_fd_sc_mcu7t5v0__fillcap_64
XFILLER_261_492 VDD VSS VDD VSS gf180mcu_fd_sc_mcu7t5v0__fillcap_64
XFILLER_187_772 VDD VSS VDD VSS gf180mcu_fd_sc_mcu7t5v0__fillcap_64
X_1963_ _1963_/S VDD VSS _3012_/D wire113/Z _3012_/Q VDD VSS gf180mcu_fd_sc_mcu7t5v0__mux2_2
X_1894_ _1895_/S VDD VSS _2953_/D _2953_/Q _3179_/Q VDD VSS gf180mcu_fd_sc_mcu7t5v0__mux2_2
XFILLER_186_293 VDD VSS VDD VSS gf180mcu_fd_sc_mcu7t5v0__fillcap_16
XFILLER_143_842 VDD VSS VDD VSS gf180mcu_fd_sc_mcu7t5v0__fillcap_32
X_2515_ _2515_/A3 VDD VSS _2515_/Z _2546_/B _2515_/A2 VDD VSS gf180mcu_fd_sc_mcu7t5v0__and3_1
X_2446_ VDD VSS _2447_/A3 _2461_/A1 _2445_/Z VDD VSS gf180mcu_fd_sc_mcu7t5v0__nand2_1
XFILLER_130_514 VDD VSS VDD VSS gf180mcu_fd_sc_mcu7t5v0__fillcap_8
X_2377_ _2377_/B _2448_/C VDD VSS _2379_/A2 _3382_/Q _2371_/Z VDD VSS gf180mcu_fd_sc_mcu7t5v0__oai211_1
XFILLER_111_772 VDD VSS VDD VSS gf180mcu_fd_sc_mcu7t5v0__fillcap_64
XFILLER_72_807 VDD VSS VDD VSS gf180mcu_fd_sc_mcu7t5v0__fillcap_64
XFILLER_84_667 VDD VSS VDD VSS gf180mcu_fd_sc_mcu7t5v0__fillcap_64
XFILLER_40_737 VDD VSS VDD VSS gf180mcu_fd_sc_mcu7t5v0__fillcap_64
XFILLER_52_597 VDD VSS VDD VSS gf180mcu_fd_sc_mcu7t5v0__fillcap_64
XFILLER_165_422 VDD VSS VDD VSS gf180mcu_fd_sc_mcu7t5v0__fillcap_32
XFILLER_192_241 VDD VSS VDD VSS gf180mcu_fd_sc_mcu7t5v0__fillcap_4
XFILLER_146_680 VDD VSS VDD VSS gf180mcu_fd_sc_mcu7t5v0__fillcap_32
XFILLER_152_127 VDD VSS VDD VSS gf180mcu_fd_sc_mcu7t5v0__fillcap_8
XFILLER_106_511 VDD VSS VDD VSS gf180mcu_fd_sc_mcu7t5v0__fillcap_8
XFILLER_133_352 VDD VSS VDD VSS gf180mcu_fd_sc_mcu7t5v0__fillcap_32
XFILLER_263_702 VDD VSS VDD VSS gf180mcu_fd_sc_mcu7t5v0__fillcap_64
XFILLER_101_282 VDD VSS VDD VSS gf180mcu_fd_sc_mcu7t5v0__fillcap_32
XFILLER_114_72 VDD VSS VDD VSS gf180mcu_fd_sc_mcu7t5v0__fillcap_8
XFILLER_62_317 VDD VSS VDD VSS gf180mcu_fd_sc_mcu7t5v0__fillcap_64
XFILLER_231_632 VDD VSS VDD VSS gf180mcu_fd_sc_mcu7t5v0__fillcap_64
XFILLER_243_492 VDD VSS VDD VSS gf180mcu_fd_sc_mcu7t5v0__fillcap_64
XFILLER_169_772 VDD VSS VDD VSS gf180mcu_fd_sc_mcu7t5v0__fillcap_64
XFILLER_30_247 VDD VSS VDD VSS gf180mcu_fd_sc_mcu7t5v0__fillcap_64
XFILLER_171_414 VDD VSS VDD VSS gf180mcu_fd_sc_mcu7t5v0__fillcap_4
XFILLER_183_274 VDD VSS VDD VSS gf180mcu_fd_sc_mcu7t5v0__fillcap_4
XFILLER_137_691 VDD VSS VDD VSS gf180mcu_fd_sc_mcu7t5v0__fillcap_8
XFILLER_125_842 VDD VSS VDD VSS gf180mcu_fd_sc_mcu7t5v0__fillcap_32
XFILLER_152_661 VDD VSS VDD VSS gf180mcu_fd_sc_mcu7t5v0__fillcap_4
XFILLER_140_801 VDD VSS VDD VSS gf180mcu_fd_sc_mcu7t5v0__fillcap_4
X_3280_ _3280_/D wire95/I wire145/Z VSS _3288_/CLK VDD VDD VSS gf180mcu_fd_sc_mcu7t5v0__dffrnq_1
X_2300_ VDD VSS _2301_/C wire110/Z _3096_/Q VDD VSS gf180mcu_fd_sc_mcu7t5v0__xor2_1
XFILLER_98_737 VDD VSS VDD VSS gf180mcu_fd_sc_mcu7t5v0__fillcap_64
X_2231_ VDD VSS _2232_/B _2231_/A1 _2357_/A2 VDD VSS gf180mcu_fd_sc_mcu7t5v0__nand2_1
XFILLER_112_547 VDD VSS VDD VSS gf180mcu_fd_sc_mcu7t5v0__fillcap_32
X_2162_ _2168_/B1 _3166_/Q VDD VSS _2163_/A2 _3157_/Q _2168_/A2 VDD VSS gf180mcu_fd_sc_mcu7t5v0__aoi22_1
XFILLER_253_212 VDD VSS VDD VSS gf180mcu_fd_sc_mcu7t5v0__fillcap_64
X_2093_ VDD VSS _2096_/A3 _3106_/Q _2090_/Z VDD VSS gf180mcu_fd_sc_mcu7t5v0__nand2_1
XFILLER_54_807 VDD VSS VDD VSS gf180mcu_fd_sc_mcu7t5v0__fillcap_64
XFILLER_66_667 VDD VSS VDD VSS gf180mcu_fd_sc_mcu7t5v0__fillcap_64
XFILLER_81_626 VDD VSS VDD VSS gf180mcu_fd_sc_mcu7t5v0__fillcap_4
XFILLER_80_125 VDD VSS VDD VSS gf180mcu_fd_sc_mcu7t5v0__fillcap_8
XFILLER_221_142 VDD VSS VDD VSS gf180mcu_fd_sc_mcu7t5v0__fillcap_64
XFILLER_34_597 VDD VSS VDD VSS gf180mcu_fd_sc_mcu7t5v0__fillcap_64
XFILLER_22_737 VDD VSS VDD VSS gf180mcu_fd_sc_mcu7t5v0__fillcap_64
XFILLER_159_260 VDD VSS VDD VSS gf180mcu_fd_sc_mcu7t5v0__fillcap_16
X_2995_ VDD _2995_/Q _3012_/CLK VSS _2995_/D VDD VSS gf180mcu_fd_sc_mcu7t5v0__dffq_1
XFILLER_147_422 VDD VSS VDD VSS gf180mcu_fd_sc_mcu7t5v0__fillcap_64
XFILLER_159_282 VDD VSS VDD VSS gf180mcu_fd_sc_mcu7t5v0__fillcap_64
X_1946_ VDD VSS _1954_/S _1465_/Z _1945_/Z VDD VSS gf180mcu_fd_sc_mcu7t5v0__and2_1
X_1877_ _1877_/S VDD VSS _2940_/D _2940_/Q _3182_/Q VDD VSS gf180mcu_fd_sc_mcu7t5v0__mux2_2
XFILLER_128_691 VDD VSS VDD VSS gf180mcu_fd_sc_mcu7t5v0__fillcap_32
XFILLER_115_352 VDD VSS VDD VSS gf180mcu_fd_sc_mcu7t5v0__fillcap_64
XFILLER_88_247 VDD VSS VDD VSS gf180mcu_fd_sc_mcu7t5v0__fillcap_8
X_2429_ _2833_/Q VSS VDD _2817_/Q _2825_/Q wire78/I _2809_/Q wire76/Z _2429_/Z VDD
+ VSS gf180mcu_fd_sc_mcu7t5v0__mux4_1
XFILLER_245_702 VDD VSS VDD VSS gf180mcu_fd_sc_mcu7t5v0__fillcap_64
XFILLER_257_562 VDD VSS VDD VSS gf180mcu_fd_sc_mcu7t5v0__fillcap_64
XFILLER_56_177 VDD VSS VDD VSS gf180mcu_fd_sc_mcu7t5v0__fillcap_64
XFILLER_44_317 VDD VSS VDD VSS gf180mcu_fd_sc_mcu7t5v0__fillcap_64
XFILLER_71_136 VDD VSS VDD VSS gf180mcu_fd_sc_mcu7t5v0__fillcap_4
XFILLER_225_492 VDD VSS VDD VSS gf180mcu_fd_sc_mcu7t5v0__fillcap_64
XFILLER_240_451 VDD VSS VDD VSS gf180mcu_fd_sc_mcu7t5v0__fillcap_4
XFILLER_12_247 VDD VSS VDD VSS gf180mcu_fd_sc_mcu7t5v0__fillcap_64
XFILLER_166_731 VDD VSS VDD VSS gf180mcu_fd_sc_mcu7t5v0__fillcap_4
XFILLER_4_457 VDD VSS VDD VSS gf180mcu_fd_sc_mcu7t5v0__fillcap_64
XFILLER_107_842 VDD VSS VDD VSS gf180mcu_fd_sc_mcu7t5v0__fillcap_32
XFILLER_122_801 VDD VSS VDD VSS gf180mcu_fd_sc_mcu7t5v0__fillcap_4
XFILLER_109_72 VDD VSS VDD VSS gf180mcu_fd_sc_mcu7t5v0__fillcap_16
XFILLER_235_212 VDD VSS VDD VSS gf180mcu_fd_sc_mcu7t5v0__fillcap_64
XFILLER_87_291 VDD VSS VDD VSS gf180mcu_fd_sc_mcu7t5v0__fillcap_16
XFILLER_36_807 VDD VSS VDD VSS gf180mcu_fd_sc_mcu7t5v0__fillcap_64
XFILLER_48_667 VDD VSS VDD VSS gf180mcu_fd_sc_mcu7t5v0__fillcap_64
XFILLER_63_626 VDD VSS VDD VSS gf180mcu_fd_sc_mcu7t5v0__fillcap_4
XFILLER_75_486 VDD VSS VDD VSS gf180mcu_fd_sc_mcu7t5v0__fillcap_4
XFILLER_90_434 VDD VSS VDD VSS gf180mcu_fd_sc_mcu7t5v0__fillcap_16
XFILLER_203_142 VDD VSS VDD VSS gf180mcu_fd_sc_mcu7t5v0__fillcap_16
XFILLER_16_597 VDD VSS VDD VSS gf180mcu_fd_sc_mcu7t5v0__fillcap_64
X_1800_ _1805_/S VDD VSS _2871_/D _1864_/I0 _2871_/Q VDD VSS gf180mcu_fd_sc_mcu7t5v0__mux2_2
XFILLER_148_219 VDD VSS VDD VSS gf180mcu_fd_sc_mcu7t5v0__fillcap_16
XFILLER_31_556 VDD VSS VDD VSS gf180mcu_fd_sc_mcu7t5v0__fillcap_4
XFILLER_86_6 VDD VSS VDD VSS gf180mcu_fd_sc_mcu7t5v0__fillcap_16
X_2780_ VDD VSS _3331_/D _2796_/A1 _2780_/A2 VDD VSS gf180mcu_fd_sc_mcu7t5v0__nand2_1
X_1731_ _1738_/S VDD VSS _2813_/D _2813_/Q _1788_/I1 VDD VSS gf180mcu_fd_sc_mcu7t5v0__mux2_2
XFILLER_200_871 VDD VSS VDD VSS gf180mcu_fd_sc_mcu7t5v0__fillcap_4
XFILLER_156_241 VDD VSS VDD VSS gf180mcu_fd_sc_mcu7t5v0__fillcap_4
X_1662_ _3194_/Q _2363_/B2 VDD VSS _2231_/A1 _3363_/D _2341_/A2 VDD VSS gf180mcu_fd_sc_mcu7t5v0__nor4_1
Xhold207 input1/I VSS rst_ni VDD VDD VSS gf180mcu_fd_sc_mcu7t5v0__dlyc_1
Xhold218 _3386_/D VSS _3391_/Q VDD VDD VSS gf180mcu_fd_sc_mcu7t5v0__dlyc_1
X_3401_ _3401_/D _3401_/Q wire161/Z VSS _3403_/CLK VDD VDD VSS gf180mcu_fd_sc_mcu7t5v0__dffrnq_1
Xhold229 _3397_/D VSS _3402_/Q VDD VDD VSS gf180mcu_fd_sc_mcu7t5v0__dlyc_1
XFILLER_236_37 VDD VSS VDD VSS gf180mcu_fd_sc_mcu7t5v0__fillcap_64
X_1593_ VDD VSS _2171_/A1 _2164_/S _1593_/A2 VDD VSS gf180mcu_fd_sc_mcu7t5v0__nand2_1
X_3332_ _3332_/D _3332_/Q wire165/I VSS _3332_/CLK VDD VDD VSS gf180mcu_fd_sc_mcu7t5v0__dffrnq_1
X_3263_ _3263_/D _3263_/Q _3452_/RN VSS _3451_/CLK VDD VDD VSS gf180mcu_fd_sc_mcu7t5v0__dffrnq_1
XFILLER_227_702 VDD VSS VDD VSS gf180mcu_fd_sc_mcu7t5v0__fillcap_64
XFILLER_239_562 VDD VSS VDD VSS gf180mcu_fd_sc_mcu7t5v0__fillcap_64
X_2214_ VDD VSS _3160_/D _2214_/A1 _1546_/B VDD VSS gf180mcu_fd_sc_mcu7t5v0__nand2_1
X_3194_ _3194_/D _3194_/Q _3359_/RN VSS _3212_/CLK VDD VDD VSS gf180mcu_fd_sc_mcu7t5v0__dffrnq_1
XFILLER_254_521 VDD VSS VDD VSS gf180mcu_fd_sc_mcu7t5v0__fillcap_4
XFILLER_266_381 VDD VSS VDD VSS gf180mcu_fd_sc_mcu7t5v0__fillcap_4
X_2145_ _2146_/A3 VDD VSS _2168_/A2 _3140_/Q _3141_/Q VDD VSS gf180mcu_fd_sc_mcu7t5v0__nor3_1
XFILLER_38_177 VDD VSS VDD VSS gf180mcu_fd_sc_mcu7t5v0__fillcap_64
XFILLER_26_317 VDD VSS VDD VSS gf180mcu_fd_sc_mcu7t5v0__fillcap_64
X_2076_ VDD VSS _2110_/A2 _2076_/A1 _2076_/A2 VDD VSS gf180mcu_fd_sc_mcu7t5v0__nand2_1
XFILLER_53_136 VDD VSS VDD VSS gf180mcu_fd_sc_mcu7t5v0__fillcap_4
XFILLER_121_18 VDD VSS VDD VSS gf180mcu_fd_sc_mcu7t5v0__fillcap_8
XFILLER_207_492 VDD VSS VDD VSS gf180mcu_fd_sc_mcu7t5v0__fillcap_64
XFILLER_210_613 VDD VSS VDD VSS gf180mcu_fd_sc_mcu7t5v0__fillcap_4
XFILLER_210_646 VDD VSS VDD VSS gf180mcu_fd_sc_mcu7t5v0__fillcap_16
XFILLER_179_399 VDD VSS VDD VSS gf180mcu_fd_sc_mcu7t5v0__fillcap_16
XFILLER_194_347 VDD VSS VDD VSS gf180mcu_fd_sc_mcu7t5v0__fillcap_16
XFILLER_194_325 VDD VSS VDD VSS gf180mcu_fd_sc_mcu7t5v0__fillcap_4
X_2978_ VDD _2978_/Q _3307_/CLK VSS _2978_/D VDD VSS gf180mcu_fd_sc_mcu7t5v0__dffq_1
X_1929_ _1933_/S VDD VSS _2982_/D wire123/Z _2982_/Q VDD VSS gf180mcu_fd_sc_mcu7t5v0__mux2_2
XFILLER_162_200 VDD VSS VDD VSS gf180mcu_fd_sc_mcu7t5v0__fillcap_4
XFILLER_30_37 VDD VSS VDD VSS gf180mcu_fd_sc_mcu7t5v0__fillcap_64
XFILLER_146_37 VDD VSS VDD VSS gf180mcu_fd_sc_mcu7t5v0__fillcap_16
XFILLER_190_597 VDD VSS VDD VSS gf180mcu_fd_sc_mcu7t5v0__fillcap_8
XFILLER_104_801 VDD VSS VDD VSS gf180mcu_fd_sc_mcu7t5v0__fillcap_4
XFILLER_1_416 VDD VSS VDD VSS gf180mcu_fd_sc_mcu7t5v0__fillcap_4
XFILLER_258_871 VDD VSS VDD VSS gf180mcu_fd_sc_mcu7t5v0__fillcap_4
XFILLER_190_6 VDD VSS VDD VSS gf180mcu_fd_sc_mcu7t5v0__fillcap_16
XFILLER_217_212 VDD VSS VDD VSS gf180mcu_fd_sc_mcu7t5v0__fillcap_64
XFILLER_18_807 VDD VSS VDD VSS gf180mcu_fd_sc_mcu7t5v0__fillcap_64
XFILLER_45_626 VDD VSS VDD VSS gf180mcu_fd_sc_mcu7t5v0__fillcap_4
XFILLER_57_486 VDD VSS VDD VSS gf180mcu_fd_sc_mcu7t5v0__fillcap_4
XFILLER_231_2 VDD VSS VDD VSS gf180mcu_fd_sc_mcu7t5v0__fillcap_64
XFILLER_13_556 VDD VSS VDD VSS gf180mcu_fd_sc_mcu7t5v0__fillcap_4
XFILLER_187_88 VDD VSS VDD VSS gf180mcu_fd_sc_mcu7t5v0__fillcap_4
XFILLER_153_244 VDD VSS VDD VSS gf180mcu_fd_sc_mcu7t5v0__fillcap_4
XFILLER_5_766 VDD VSS VDD VSS gf180mcu_fd_sc_mcu7t5v0__fillcap_4
XFILLER_106_171 VDD VSS VDD VSS gf180mcu_fd_sc_mcu7t5v0__fillcap_4
XFILLER_67_206 VDD VSS VDD VSS gf180mcu_fd_sc_mcu7t5v0__fillcap_4
XFILLER_209_702 VDD VSS VDD VSS gf180mcu_fd_sc_mcu7t5v0__fillcap_64
XFILLER_96_85 VDD VSS VDD VSS gf180mcu_fd_sc_mcu7t5v0__fillcap_4
XFILLER_236_521 VDD VSS VDD VSS gf180mcu_fd_sc_mcu7t5v0__fillcap_4
XFILLER_248_381 VDD VSS VDD VSS gf180mcu_fd_sc_mcu7t5v0__fillcap_4
XFILLER_264_885 VDD VSS VDD VSS gf180mcu_fd_sc_mcu7t5v0__fillcap_4
XFILLER_208_289 VDD VSS VDD VSS gf180mcu_fd_sc_mcu7t5v0__fillcap_16
XFILLER_35_136 VDD VSS VDD VSS gf180mcu_fd_sc_mcu7t5v0__fillcap_4
XFILLER_204_451 VDD VSS VDD VSS gf180mcu_fd_sc_mcu7t5v0__fillcap_4
X_2901_ VDD _2901_/Q _2931_/CLK VSS _2901_/D VDD VSS gf180mcu_fd_sc_mcu7t5v0__dffq_1
XFILLER_189_686 VDD VSS VDD VSS gf180mcu_fd_sc_mcu7t5v0__fillcap_4
XFILLER_188_152 VDD VSS VDD VSS gf180mcu_fd_sc_mcu7t5v0__fillcap_16
X_2832_ VDD _2832_/Q _3435_/CLK VSS _2832_/D VDD VSS gf180mcu_fd_sc_mcu7t5v0__dffq_1
XFILLER_176_325 VDD VSS VDD VSS gf180mcu_fd_sc_mcu7t5v0__fillcap_32
XFILLER_192_807 VDD VSS VDD VSS gf180mcu_fd_sc_mcu7t5v0__fillcap_64
X_2763_ wire20/Z _3075_/Q VDD VSS _2764_/I _3323_/Q _2739_/S VDD VSS gf180mcu_fd_sc_mcu7t5v0__aoi22_1
X_1714_ _3343_/Q _2316_/C VDD VSS _2490_/B _2484_/A1 _3137_/Q _1714_/B1 VDD VSS gf180mcu_fd_sc_mcu7t5v0__aoi221_1
XFILLER_184_380 VDD VSS VDD VSS gf180mcu_fd_sc_mcu7t5v0__fillcap_4
X_2694_ VDD VSS _2694_/I _2695_/A2 VDD VSS gf180mcu_fd_sc_mcu7t5v0__clkinv_1
XFILLER_117_447 VDD VSS VDD VSS gf180mcu_fd_sc_mcu7t5v0__fillcap_16
XFILLER_160_737 VDD VSS VDD VSS gf180mcu_fd_sc_mcu7t5v0__fillcap_64
X_1645_ VDD VSS _2567_/B _2549_/A1 _2539_/S VDD VSS gf180mcu_fd_sc_mcu7t5v0__nor2_1
XFILLER_258_101 VDD VSS VDD VSS gf180mcu_fd_sc_mcu7t5v0__fillcap_4
X_1576_ VDD VSS _2143_/B _2186_/A2 _2186_/A3 VDD VSS gf180mcu_fd_sc_mcu7t5v0__nor2_1
X_3315_ _3315_/D _3315_/Q _3336_/RN VSS clkload9/I VDD VDD VSS gf180mcu_fd_sc_mcu7t5v0__dffrnq_1
XFILLER_113_664 VDD VSS VDD VSS gf180mcu_fd_sc_mcu7t5v0__fillcap_4
X_3246_ _3246_/D wire98/I wire145/Z VSS _3288_/CLK VDD VDD VSS gf180mcu_fd_sc_mcu7t5v0__dffrnq_1
XFILLER_255_874 VDD VSS VDD VSS gf180mcu_fd_sc_mcu7t5v0__fillcap_16
Xclkbuf_leaf_32_clk_i _3380_/CLK VSS VDD clkload6/I VDD VSS gf180mcu_fd_sc_mcu7t5v0__clkbuf_2
X_3177_ VDD _3177_/Q _3179_/CLK VSS _3177_/D VDD VSS gf180mcu_fd_sc_mcu7t5v0__dffq_1
XFILLER_39_486 VDD VSS VDD VSS gf180mcu_fd_sc_mcu7t5v0__fillcap_4
XFILLER_27_626 VDD VSS VDD VSS gf180mcu_fd_sc_mcu7t5v0__fillcap_4
X_2128_ _3275_/Q _3272_/Q VDD VSS _2128_/Z _2607_/A1 _3274_/Q VDD VSS gf180mcu_fd_sc_mcu7t5v0__or4_1
XFILLER_81_264 VDD VSS VDD VSS gf180mcu_fd_sc_mcu7t5v0__fillcap_8
X_2059_ _2059_/S VDD VSS _3092_/D _3308_/Q _3092_/Q VDD VSS gf180mcu_fd_sc_mcu7t5v0__mux2_2
Xclkbuf_leaf_47_clk_i _3046_/CLK VSS VDD clkload1/I VDD VSS gf180mcu_fd_sc_mcu7t5v0__clkbuf_2
XFILLER_182_317 VDD VSS VDD VSS gf180mcu_fd_sc_mcu7t5v0__fillcap_32
XFILLER_108_403 VDD VSS VDD VSS gf180mcu_fd_sc_mcu7t5v0__fillcap_8
XFILLER_150_247 VDD VSS VDD VSS gf180mcu_fd_sc_mcu7t5v0__fillcap_16
XFILLER_49_206 VDD VSS VDD VSS gf180mcu_fd_sc_mcu7t5v0__fillcap_4
XFILLER_218_543 VDD VSS VDD VSS gf180mcu_fd_sc_mcu7t5v0__fillcap_8
XFILLER_246_885 VDD VSS VDD VSS gf180mcu_fd_sc_mcu7t5v0__fillcap_4
XFILLER_72_231 VDD VSS VDD VSS gf180mcu_fd_sc_mcu7t5v0__fillcap_8
XFILLER_17_136 VDD VSS VDD VSS gf180mcu_fd_sc_mcu7t5v0__fillcap_4
XFILLER_260_387 VDD VSS VDD VSS gf180mcu_fd_sc_mcu7t5v0__fillcap_64
XFILLER_198_98 VDD VSS VDD VSS gf180mcu_fd_sc_mcu7t5v0__fillcap_4
XFILLER_174_807 VDD VSS VDD VSS gf180mcu_fd_sc_mcu7t5v0__fillcap_64
XFILLER_9_346 VDD VSS VDD VSS gf180mcu_fd_sc_mcu7t5v0__fillcap_4
XFILLER_185_199 VDD VSS VDD VSS gf180mcu_fd_sc_mcu7t5v0__fillcap_8
XFILLER_147_80 VDD VSS VDD VSS gf180mcu_fd_sc_mcu7t5v0__fillcap_4
XFILLER_154_597 VDD VSS VDD VSS gf180mcu_fd_sc_mcu7t5v0__fillcap_16
XFILLER_142_737 VDD VSS VDD VSS gf180mcu_fd_sc_mcu7t5v0__fillcap_64
XFILLER_141_236 VDD VSS VDD VSS gf180mcu_fd_sc_mcu7t5v0__fillcap_4
XFILLER_99_128 VDD VSS VDD VSS gf180mcu_fd_sc_mcu7t5v0__fillcap_8
X_1430_ VDD VSS _3222_/Q _2529_/C VDD VSS gf180mcu_fd_sc_mcu7t5v0__clkinv_1
XFILLER_268_410 VDD VSS VDD VSS gf180mcu_fd_sc_mcu7t5v0__fillcap_32
X_3100_ _3100_/D _3100_/Q wire145/Z VSS _3179_/CLK VDD VDD VSS gf180mcu_fd_sc_mcu7t5v0__dffrnq_1
XFILLER_95_345 VDD VSS VDD VSS gf180mcu_fd_sc_mcu7t5v0__fillcap_4
XFILLER_110_667 VDD VSS VDD VSS gf180mcu_fd_sc_mcu7t5v0__fillcap_8
X_3031_ VDD _3031_/Q _3055_/CLK VSS _3031_/D VDD VSS gf180mcu_fd_sc_mcu7t5v0__dffq_1
XFILLER_237_874 VDD VSS VDD VSS gf180mcu_fd_sc_mcu7t5v0__fillcap_16
XFILLER_224_513 VDD VSS VDD VSS gf180mcu_fd_sc_mcu7t5v0__fillcap_8
XFILLER_91_562 VDD VSS VDD VSS gf180mcu_fd_sc_mcu7t5v0__fillcap_64
XFILLER_252_877 VDD VSS VDD VSS gf180mcu_fd_sc_mcu7t5v0__fillcap_8
X_2815_ VDD _2815_/Q _3458_/CLK VSS _2815_/D VDD VSS gf180mcu_fd_sc_mcu7t5v0__dffq_1
XFILLER_191_103 VDD VSS VDD VSS gf180mcu_fd_sc_mcu7t5v0__fillcap_4
X_2746_ VDD VSS _2746_/I _2747_/I0 VDD VSS gf180mcu_fd_sc_mcu7t5v0__clkinv_1
X_2677_ _2676_/Z VSS VDD _2673_/Z _2675_/Z _2735_/S _2674_/Z _2732_/C _2677_/Z VDD
+ VSS gf180mcu_fd_sc_mcu7t5v0__mux4_1
X_1628_ _1627_/Z VDD VSS _3406_/D _1628_/A1 _1628_/A2 VDD VSS gf180mcu_fd_sc_mcu7t5v0__nor3_1
XFILLER_117_299 VDD VSS VDD VSS gf180mcu_fd_sc_mcu7t5v0__fillcap_4
XFILLER_207_72 VDD VSS VDD VSS gf180mcu_fd_sc_mcu7t5v0__fillcap_4
XFILLER_132_247 VDD VSS VDD VSS gf180mcu_fd_sc_mcu7t5v0__fillcap_16
X_1559_ VDD VSS _1560_/A2 _3145_/Q _1566_/A4 VDD VSS gf180mcu_fd_sc_mcu7t5v0__nand2_1
XFILLER_223_60 VDD VSS VDD VSS gf180mcu_fd_sc_mcu7t5v0__fillcap_4
X_3229_ _3229_/D _3229_/Q wire147/I VSS _3320_/CLK VDD VDD VSS gf180mcu_fd_sc_mcu7t5v0__dffrnq_1
XFILLER_228_885 VDD VSS VDD VSS gf180mcu_fd_sc_mcu7t5v0__fillcap_4
XFILLER_242_387 VDD VSS VDD VSS gf180mcu_fd_sc_mcu7t5v0__fillcap_64
XFILLER_230_527 VDD VSS VDD VSS gf180mcu_fd_sc_mcu7t5v0__fillcap_64
XFILLER_202_218 VDD VSS VDD VSS gf180mcu_fd_sc_mcu7t5v0__fillcap_16
XFILLER_156_807 VDD VSS VDD VSS gf180mcu_fd_sc_mcu7t5v0__fillcap_64
XFILLER_210_295 VDD VSS VDD VSS gf180mcu_fd_sc_mcu7t5v0__fillcap_4
XFILLER_167_199 VDD VSS VDD VSS gf180mcu_fd_sc_mcu7t5v0__fillcap_8
XFILLER_182_147 VDD VSS VDD VSS gf180mcu_fd_sc_mcu7t5v0__fillcap_16
XFILLER_136_597 VDD VSS VDD VSS gf180mcu_fd_sc_mcu7t5v0__fillcap_8
XFILLER_124_737 VDD VSS VDD VSS gf180mcu_fd_sc_mcu7t5v0__fillcap_64
XFILLER_7_2 VDD VSS VDD VSS gf180mcu_fd_sc_mcu7t5v0__fillcap_64
XFILLER_117_72 VDD VSS VDD VSS gf180mcu_fd_sc_mcu7t5v0__fillcap_8
XFILLER_219_874 VDD VSS VDD VSS gf180mcu_fd_sc_mcu7t5v0__fillcap_16
XFILLER_252_107 VDD VSS VDD VSS gf180mcu_fd_sc_mcu7t5v0__fillcap_64
XFILLER_61_702 VDD VSS VDD VSS gf180mcu_fd_sc_mcu7t5v0__fillcap_64
XFILLER_73_562 VDD VSS VDD VSS gf180mcu_fd_sc_mcu7t5v0__fillcap_64
XFILLER_234_877 VDD VSS VDD VSS gf180mcu_fd_sc_mcu7t5v0__fillcap_8
XFILLER_261_696 VDD VSS VDD VSS gf180mcu_fd_sc_mcu7t5v0__fillcap_4
XFILLER_214_590 VDD VSS VDD VSS gf180mcu_fd_sc_mcu7t5v0__fillcap_4
XFILLER_158_122 VDD VSS VDD VSS gf180mcu_fd_sc_mcu7t5v0__fillcap_16
XFILLER_41_492 VDD VSS VDD VSS gf180mcu_fd_sc_mcu7t5v0__fillcap_64
XFILLER_174_637 VDD VSS VDD VSS gf180mcu_fd_sc_mcu7t5v0__fillcap_16
XFILLER_158_177 VDD VSS VDD VSS gf180mcu_fd_sc_mcu7t5v0__fillcap_16
XFILLER_146_317 VDD VSS VDD VSS gf180mcu_fd_sc_mcu7t5v0__fillcap_4
XFILLER_173_136 VDD VSS VDD VSS gf180mcu_fd_sc_mcu7t5v0__fillcap_4
X_2600_ _2626_/S VDD VSS _3268_/D _3228_/Q _3268_/Q VDD VSS gf180mcu_fd_sc_mcu7t5v0__mux2_2
XFILLER_173_158 VDD VSS VDD VSS gf180mcu_fd_sc_mcu7t5v0__fillcap_8
X_2531_ VDD _2532_/A2 _2531_/B _3222_/Q _2508_/Z VSS _2515_/Z VDD VSS gf180mcu_fd_sc_mcu7t5v0__oai31_1
X_2462_ _2462_/A3 VDD VSS _2464_/B1 _3382_/Q _2462_/A2 VDD VSS gf180mcu_fd_sc_mcu7t5v0__nand3_1
XFILLER_244_37 VDD VSS VDD VSS gf180mcu_fd_sc_mcu7t5v0__fillcap_64
XFILLER_114_247 VDD VSS VDD VSS gf180mcu_fd_sc_mcu7t5v0__fillcap_8
XFILLER_268_240 VDD VSS VDD VSS gf180mcu_fd_sc_mcu7t5v0__fillcap_32
X_1413_ VDD VSS _3109_/Q _2113_/A1 VDD VSS gf180mcu_fd_sc_mcu7t5v0__clkinv_1
X_2393_ _2393_/B1 _2393_/B2 VDD VSS _2394_/A2 _3206_/Q _3130_/Q VDD VSS gf180mcu_fd_sc_mcu7t5v0__aoi22_1
XFILLER_256_457 VDD VSS VDD VSS gf180mcu_fd_sc_mcu7t5v0__fillcap_64
XFILLER_95_142 VDD VSS VDD VSS gf180mcu_fd_sc_mcu7t5v0__fillcap_16
X_3014_ VDD _3014_/Q _3022_/CLK VSS _3014_/D VDD VSS gf180mcu_fd_sc_mcu7t5v0__dffq_1
Xwire24 VSS wire24/Z wire24/I VDD VDD VSS gf180mcu_fd_sc_mcu7t5v0__buf_2
XFILLER_92_871 VDD VSS VDD VSS gf180mcu_fd_sc_mcu7t5v0__fillcap_4
XFILLER_224_365 VDD VSS VDD VSS gf180mcu_fd_sc_mcu7t5v0__fillcap_16
Xwire46 wire46/Z wire46/I VDD VSS VDD VSS gf180mcu_fd_sc_mcu7t5v0__buf_4
XFILLER_51_212 VDD VSS VDD VSS gf180mcu_fd_sc_mcu7t5v0__fillcap_64
XFILLER_212_527 VDD VSS VDD VSS gf180mcu_fd_sc_mcu7t5v0__fillcap_16
XFILLER_224_387 VDD VSS VDD VSS gf180mcu_fd_sc_mcu7t5v0__fillcap_16
XFILLER_138_807 VDD VSS VDD VSS gf180mcu_fd_sc_mcu7t5v0__fillcap_64
XFILLER_220_582 VDD VSS VDD VSS gf180mcu_fd_sc_mcu7t5v0__fillcap_8
X_2729_ VDD VSS _2729_/I _2732_/A2 VDD VSS gf180mcu_fd_sc_mcu7t5v0__clkinv_1
XFILLER_118_597 VDD VSS VDD VSS gf180mcu_fd_sc_mcu7t5v0__fillcap_32
XFILLER_106_737 VDD VSS VDD VSS gf180mcu_fd_sc_mcu7t5v0__fillcap_64
XFILLER_154_37 VDD VSS VDD VSS gf180mcu_fd_sc_mcu7t5v0__fillcap_16
XFILLER_99_492 VDD VSS VDD VSS gf180mcu_fd_sc_mcu7t5v0__fillcap_16
XFILLER_87_632 VDD VSS VDD VSS gf180mcu_fd_sc_mcu7t5v0__fillcap_64
XFILLER_219_148 VDD VSS VDD VSS gf180mcu_fd_sc_mcu7t5v0__fillcap_32
XFILLER_234_107 VDD VSS VDD VSS gf180mcu_fd_sc_mcu7t5v0__fillcap_64
XFILLER_101_486 VDD VSS VDD VSS gf180mcu_fd_sc_mcu7t5v0__fillcap_4
XFILLER_55_562 VDD VSS VDD VSS gf180mcu_fd_sc_mcu7t5v0__fillcap_64
XFILLER_43_702 VDD VSS VDD VSS gf180mcu_fd_sc_mcu7t5v0__fillcap_64
XFILLER_216_877 VDD VSS VDD VSS gf180mcu_fd_sc_mcu7t5v0__fillcap_8
XFILLER_82_381 VDD VSS VDD VSS gf180mcu_fd_sc_mcu7t5v0__fillcap_4
XFILLER_70_521 VDD VSS VDD VSS gf180mcu_fd_sc_mcu7t5v0__fillcap_4
XFILLER_243_696 VDD VSS VDD VSS gf180mcu_fd_sc_mcu7t5v0__fillcap_4
XFILLER_231_836 VDD VSS VDD VSS gf180mcu_fd_sc_mcu7t5v0__fillcap_4
XFILLER_179_56 VDD VSS VDD VSS gf180mcu_fd_sc_mcu7t5v0__fillcap_8
XFILLER_144_2 VDD VSS VDD VSS gf180mcu_fd_sc_mcu7t5v0__fillcap_32
XFILLER_23_492 VDD VSS VDD VSS gf180mcu_fd_sc_mcu7t5v0__fillcap_64
XFILLER_11_632 VDD VSS VDD VSS gf180mcu_fd_sc_mcu7t5v0__fillcap_64
XFILLER_128_317 VDD VSS VDD VSS gf180mcu_fd_sc_mcu7t5v0__fillcap_16
XFILLER_195_55 VDD VSS VDD VSS gf180mcu_fd_sc_mcu7t5v0__fillcap_8
Xmax_length154 wire153/I wire151/I VDD VSS VDD VSS gf180mcu_fd_sc_mcu7t5v0__buf_8
Xmax_length143 VSS _2655_/B2 _2331_/B VDD VDD VSS gf180mcu_fd_sc_mcu7t5v0__clkbuf_1
XFILLER_3_842 VDD VSS VDD VSS gf180mcu_fd_sc_mcu7t5v0__fillcap_32
XFILLER_88_64 VDD VSS VDD VSS gf180mcu_fd_sc_mcu7t5v0__fillcap_4
XFILLER_128_93 VDD VSS VDD VSS gf180mcu_fd_sc_mcu7t5v0__fillcap_8
XFILLER_111_217 VDD VSS VDD VSS gf180mcu_fd_sc_mcu7t5v0__fillcap_4
XFILLER_238_457 VDD VSS VDD VSS gf180mcu_fd_sc_mcu7t5v0__fillcap_64
XFILLER_77_142 VDD VSS VDD VSS gf180mcu_fd_sc_mcu7t5v0__fillcap_16
XFILLER_253_416 VDD VSS VDD VSS gf180mcu_fd_sc_mcu7t5v0__fillcap_4
XFILLER_265_276 VDD VSS VDD VSS gf180mcu_fd_sc_mcu7t5v0__fillcap_4
XFILLER_92_123 VDD VSS VDD VSS gf180mcu_fd_sc_mcu7t5v0__fillcap_4
XFILLER_33_212 VDD VSS VDD VSS gf180mcu_fd_sc_mcu7t5v0__fillcap_64
XFILLER_74_871 VDD VSS VDD VSS gf180mcu_fd_sc_mcu7t5v0__fillcap_4
XFILLER_206_387 VDD VSS VDD VSS gf180mcu_fd_sc_mcu7t5v0__fillcap_64
XFILLER_178_228 VDD VSS VDD VSS gf180mcu_fd_sc_mcu7t5v0__fillcap_16
X_1962_ _1963_/S VDD VSS _3011_/D wire114/Z _3011_/Q VDD VSS gf180mcu_fd_sc_mcu7t5v0__mux2_2
X_1893_ _1895_/S VDD VSS _2952_/D _2952_/Q _3178_/Q VDD VSS gf180mcu_fd_sc_mcu7t5v0__mux2_2
X_2514_ _2514_/A3 VDD VSS _2515_/A3 _2546_/A1 _2514_/A2 VDD VSS gf180mcu_fd_sc_mcu7t5v0__nand3_1
XFILLER_115_556 VDD VSS VDD VSS gf180mcu_fd_sc_mcu7t5v0__fillcap_4
X_2445_ _2898_/Q VSS VDD _2882_/Q _2890_/Q _2460_/S0 _2874_/Q _3381_/Q _2445_/Z VDD
+ VSS gf180mcu_fd_sc_mcu7t5v0__mux4_1
XFILLER_69_632 VDD VSS VDD VSS gf180mcu_fd_sc_mcu7t5v0__fillcap_64
XFILLER_257_766 VDD VSS VDD VSS gf180mcu_fd_sc_mcu7t5v0__fillcap_4
X_2376_ _2376_/A3 VDD VSS _2377_/B _3382_/Q _2376_/A2 VDD VSS gf180mcu_fd_sc_mcu7t5v0__nand3_1
XFILLER_216_107 VDD VSS VDD VSS gf180mcu_fd_sc_mcu7t5v0__fillcap_16
XFILLER_37_562 VDD VSS VDD VSS gf180mcu_fd_sc_mcu7t5v0__fillcap_64
XFILLER_25_702 VDD VSS VDD VSS gf180mcu_fd_sc_mcu7t5v0__fillcap_64
XFILLER_225_696 VDD VSS VDD VSS gf180mcu_fd_sc_mcu7t5v0__fillcap_4
XFILLER_213_836 VDD VSS VDD VSS gf180mcu_fd_sc_mcu7t5v0__fillcap_4
XFILLER_52_521 VDD VSS VDD VSS gf180mcu_fd_sc_mcu7t5v0__fillcap_4
XFILLER_64_381 VDD VSS VDD VSS gf180mcu_fd_sc_mcu7t5v0__fillcap_4
XFILLER_80_885 VDD VSS VDD VSS gf180mcu_fd_sc_mcu7t5v0__fillcap_4
XFILLER_220_94 VDD VSS VDD VSS gf180mcu_fd_sc_mcu7t5v0__fillcap_8
XFILLER_184_209 VDD VSS VDD VSS gf180mcu_fd_sc_mcu7t5v0__fillcap_16
XFILLER_20_451 VDD VSS VDD VSS gf180mcu_fd_sc_mcu7t5v0__fillcap_4
XFILLER_138_637 VDD VSS VDD VSS gf180mcu_fd_sc_mcu7t5v0__fillcap_8
XFILLER_59_142 VDD VSS VDD VSS gf180mcu_fd_sc_mcu7t5v0__fillcap_64
XFILLER_235_416 VDD VSS VDD VSS gf180mcu_fd_sc_mcu7t5v0__fillcap_4
XFILLER_74_123 VDD VSS VDD VSS gf180mcu_fd_sc_mcu7t5v0__fillcap_8
XFILLER_247_276 VDD VSS VDD VSS gf180mcu_fd_sc_mcu7t5v0__fillcap_4
XFILLER_261_2 VDD VSS VDD VSS gf180mcu_fd_sc_mcu7t5v0__fillcap_64
XFILLER_56_871 VDD VSS VDD VSS gf180mcu_fd_sc_mcu7t5v0__fillcap_4
XFILLER_188_504 VDD VSS VDD VSS gf180mcu_fd_sc_mcu7t5v0__fillcap_16
XFILLER_15_212 VDD VSS VDD VSS gf180mcu_fd_sc_mcu7t5v0__fillcap_64
XFILLER_71_874 VDD VSS VDD VSS gf180mcu_fd_sc_mcu7t5v0__fillcap_16
XFILLER_90_10 VDD VSS VDD VSS gf180mcu_fd_sc_mcu7t5v0__fillcap_4
XFILLER_7_422 VDD VSS VDD VSS gf180mcu_fd_sc_mcu7t5v0__fillcap_64
XFILLER_209_18 VDD VSS VDD VSS gf180mcu_fd_sc_mcu7t5v0__fillcap_4
XFILLER_129_648 VDD VSS VDD VSS gf180mcu_fd_sc_mcu7t5v0__fillcap_4
XFILLER_90_98 VDD VSS VDD VSS gf180mcu_fd_sc_mcu7t5v0__fillcap_4
XFILLER_144_629 VDD VSS VDD VSS gf180mcu_fd_sc_mcu7t5v0__fillcap_32
XFILLER_128_169 VDD VSS VDD VSS gf180mcu_fd_sc_mcu7t5v0__fillcap_4
XFILLER_112_515 VDD VSS VDD VSS gf180mcu_fd_sc_mcu7t5v0__fillcap_8
XFILLER_97_204 VDD VSS VDD VSS gf180mcu_fd_sc_mcu7t5v0__fillcap_4
X_2230_ VDD VSS _2230_/Z _2231_/A1 _2357_/A2 VDD VSS gf180mcu_fd_sc_mcu7t5v0__and2_1
XFILLER_2_171 VDD VSS VDD VSS gf180mcu_fd_sc_mcu7t5v0__fillcap_4
XFILLER_78_451 VDD VSS VDD VSS gf180mcu_fd_sc_mcu7t5v0__fillcap_4
XFILLER_239_766 VDD VSS VDD VSS gf180mcu_fd_sc_mcu7t5v0__fillcap_4
X_2161_ _2161_/B1 _2161_/B2 VDD VSS _3133_/D _2161_/A1 _2168_/C VDD VSS gf180mcu_fd_sc_mcu7t5v0__aoi22_1
X_2092_ VDD VSS _2092_/Z _3106_/Q _2090_/Z VDD VSS gf180mcu_fd_sc_mcu7t5v0__and2_1
XFILLER_19_562 VDD VSS VDD VSS gf180mcu_fd_sc_mcu7t5v0__fillcap_64
XFILLER_207_685 VDD VSS VDD VSS gf180mcu_fd_sc_mcu7t5v0__fillcap_8
XFILLER_34_521 VDD VSS VDD VSS gf180mcu_fd_sc_mcu7t5v0__fillcap_4
XFILLER_46_381 VDD VSS VDD VSS gf180mcu_fd_sc_mcu7t5v0__fillcap_4
XFILLER_221_132 VDD VSS VDD VSS gf180mcu_fd_sc_mcu7t5v0__fillcap_4
XFILLER_62_885 VDD VSS VDD VSS gf180mcu_fd_sc_mcu7t5v0__fillcap_4
X_2994_ VDD _2994_/Q _2994_/CLK VSS _2994_/D VDD VSS gf180mcu_fd_sc_mcu7t5v0__dffq_1
X_1945_ VDD VSS _1945_/Z _3409_/Q _1945_/A2 VDD VSS gf180mcu_fd_sc_mcu7t5v0__and2_1
XFILLER_9_72 VDD VSS VDD VSS gf180mcu_fd_sc_mcu7t5v0__fillcap_64
XFILLER_174_220 VDD VSS VDD VSS gf180mcu_fd_sc_mcu7t5v0__fillcap_16
X_1876_ _1877_/S VDD VSS _2939_/D _2939_/Q _3181_/Q VDD VSS gf180mcu_fd_sc_mcu7t5v0__mux2_2
XFILLER_162_437 VDD VSS VDD VSS gf180mcu_fd_sc_mcu7t5v0__fillcap_16
XFILLER_143_640 VDD VSS VDD VSS gf180mcu_fd_sc_mcu7t5v0__fillcap_4
X_2428_ _2442_/S VDD VSS _2428_/Z _2426_/Z _2427_/Z VDD VSS gf180mcu_fd_sc_mcu7t5v0__mux2_2
XFILLER_215_72 VDD VSS VDD VSS gf180mcu_fd_sc_mcu7t5v0__fillcap_8
X_2359_ _3194_/Q VDD VSS _2360_/B _2359_/A1 _2362_/A2 VDD VSS gf180mcu_fd_sc_mcu7t5v0__aoi21_1
XFILLER_28_26 VDD VSS VDD VSS gf180mcu_fd_sc_mcu7t5v0__fillcap_8
XFILLER_28_37 VDD VSS VDD VSS gf180mcu_fd_sc_mcu7t5v0__fillcap_64
XFILLER_56_101 VDD VSS VDD VSS gf180mcu_fd_sc_mcu7t5v0__fillcap_4
XFILLER_229_276 VDD VSS VDD VSS gf180mcu_fd_sc_mcu7t5v0__fillcap_4
XFILLER_217_416 VDD VSS VDD VSS gf180mcu_fd_sc_mcu7t5v0__fillcap_4
XFILLER_38_871 VDD VSS VDD VSS gf180mcu_fd_sc_mcu7t5v0__fillcap_4
XFILLER_53_874 VDD VSS VDD VSS gf180mcu_fd_sc_mcu7t5v0__fillcap_16
XFILLER_200_305 VDD VSS VDD VSS gf180mcu_fd_sc_mcu7t5v0__fillcap_8
XFILLER_100_31 VDD VSS VDD VSS gf180mcu_fd_sc_mcu7t5v0__fillcap_4
XFILLER_138_434 VDD VSS VDD VSS gf180mcu_fd_sc_mcu7t5v0__fillcap_16
XFILLER_193_562 VDD VSS VDD VSS gf180mcu_fd_sc_mcu7t5v0__fillcap_32
XFILLER_192_23 VDD VSS VDD VSS gf180mcu_fd_sc_mcu7t5v0__fillcap_8
XFILLER_69_66 VDD VSS VDD VSS gf180mcu_fd_sc_mcu7t5v0__fillcap_4
XFILLER_161_492 VDD VSS VDD VSS gf180mcu_fd_sc_mcu7t5v0__fillcap_16
XFILLER_125_94 VDD VSS VDD VSS gf180mcu_fd_sc_mcu7t5v0__fillcap_8
XFILLER_125_72 VDD VSS VDD VSS gf180mcu_fd_sc_mcu7t5v0__fillcap_4
XFILLER_16_521 VDD VSS VDD VSS gf180mcu_fd_sc_mcu7t5v0__fillcap_4
XFILLER_28_381 VDD VSS VDD VSS gf180mcu_fd_sc_mcu7t5v0__fillcap_4
XFILLER_204_644 VDD VSS VDD VSS gf180mcu_fd_sc_mcu7t5v0__fillcap_8
XFILLER_44_885 VDD VSS VDD VSS gf180mcu_fd_sc_mcu7t5v0__fillcap_4
XFILLER_70_170 VDD VSS VDD VSS gf180mcu_fd_sc_mcu7t5v0__fillcap_4
XFILLER_8_731 VDD VSS VDD VSS gf180mcu_fd_sc_mcu7t5v0__fillcap_4
X_1730_ _1843_/A1 VDD VSS _1738_/S _3369_/Q _3370_/Q VDD VSS gf180mcu_fd_sc_mcu7t5v0__and3_1
Xhold208 _3425_/D VSS _3430_/Q VDD VDD VSS gf180mcu_fd_sc_mcu7t5v0__dlyc_1
Xwire161 wire161/Z wire161/I VDD VSS VDD VSS gf180mcu_fd_sc_mcu7t5v0__buf_4
X_1661_ VDD VSS _2364_/A1 _1704_/A3 _3363_/Q VDD VSS gf180mcu_fd_sc_mcu7t5v0__nand2_1
XFILLER_171_212 VDD VSS VDD VSS gf180mcu_fd_sc_mcu7t5v0__fillcap_8
X_3400_ _3400_/D _3400_/Q wire161/Z VSS _3405_/CLK VDD VDD VSS gf180mcu_fd_sc_mcu7t5v0__dffrnq_1
Xhold219 _3388_/D VSS _3393_/Q VDD VDD VSS gf180mcu_fd_sc_mcu7t5v0__dlyc_1
XFILLER_125_640 VDD VSS VDD VSS gf180mcu_fd_sc_mcu7t5v0__fillcap_4
X_1592_ VDD VSS _1598_/A2 _3348_/Q _1589_/B VDD VSS gf180mcu_fd_sc_mcu7t5v0__nand2_1
X_3331_ _3331_/D _3331_/Q _3339_/RN VSS _3339_/CLK VDD VDD VSS gf180mcu_fd_sc_mcu7t5v0__dffrnq_1
X_3262_ _3262_/D _3262_/Q _3339_/RN VSS _3339_/CLK VDD VDD VSS gf180mcu_fd_sc_mcu7t5v0__dffrnq_1
XFILLER_252_37 VDD VSS VDD VSS gf180mcu_fd_sc_mcu7t5v0__fillcap_64
X_3193_ _3193_/D _3193_/Q _3359_/RN VSS _3363_/CLK VDD VDD VSS gf180mcu_fd_sc_mcu7t5v0__dffrnq_1
X_2213_ _2222_/S VDD VSS _3159_/D _3293_/Q _3159_/Q VDD VSS gf180mcu_fd_sc_mcu7t5v0__mux2_2
XFILLER_94_730 VDD VSS VDD VSS gf180mcu_fd_sc_mcu7t5v0__fillcap_4
XFILLER_22_2 VDD VSS VDD VSS gf180mcu_fd_sc_mcu7t5v0__fillcap_32
XFILLER_38_101 VDD VSS VDD VSS gf180mcu_fd_sc_mcu7t5v0__fillcap_4
X_2144_ VDD _2164_/S _2186_/A3 _2149_/C _2175_/A1 VSS VDD VSS gf180mcu_fd_sc_mcu7t5v0__oai21_1
X_2075_ VDD VSS _2075_/Z _2076_/A1 _2076_/A2 VDD VSS gf180mcu_fd_sc_mcu7t5v0__and2_1
Xload_slew80 _2454_/S0 _2427_/S0 VDD VSS VDD VSS gf180mcu_fd_sc_mcu7t5v0__buf_4
XFILLER_35_874 VDD VSS VDD VSS gf180mcu_fd_sc_mcu7t5v0__fillcap_16
XFILLER_50_877 VDD VSS VDD VSS gf180mcu_fd_sc_mcu7t5v0__fillcap_8
X_2977_ VDD _2977_/Q _3005_/CLK VSS _2977_/D VDD VSS gf180mcu_fd_sc_mcu7t5v0__dffq_1
XFILLER_175_562 VDD VSS VDD VSS gf180mcu_fd_sc_mcu7t5v0__fillcap_4
XFILLER_163_702 VDD VSS VDD VSS gf180mcu_fd_sc_mcu7t5v0__fillcap_64
X_1928_ _1933_/S VDD VSS _2981_/D _2011_/I0 _2981_/Q VDD VSS gf180mcu_fd_sc_mcu7t5v0__mux2_2
XFILLER_190_510 VDD VSS VDD VSS gf180mcu_fd_sc_mcu7t5v0__fillcap_8
X_1859_ _1860_/S VDD VSS _2923_/D wire128/Z _2923_/Q VDD VSS gf180mcu_fd_sc_mcu7t5v0__mux2_2
XFILLER_135_415 VDD VSS VDD VSS gf180mcu_fd_sc_mcu7t5v0__fillcap_4
XFILLER_143_492 VDD VSS VDD VSS gf180mcu_fd_sc_mcu7t5v0__fillcap_8
XFILLER_131_632 VDD VSS VDD VSS gf180mcu_fd_sc_mcu7t5v0__fillcap_16
XFILLER_130_153 VDD VSS VDD VSS gf180mcu_fd_sc_mcu7t5v0__fillcap_4
XFILLER_162_37 VDD VSS VDD VSS gf180mcu_fd_sc_mcu7t5v0__fillcap_16
XFILLER_72_457 VDD VSS VDD VSS gf180mcu_fd_sc_mcu7t5v0__fillcap_64
XFILLER_241_772 VDD VSS VDD VSS gf180mcu_fd_sc_mcu7t5v0__fillcap_64
XFILLER_26_885 VDD VSS VDD VSS gf180mcu_fd_sc_mcu7t5v0__fillcap_4
XFILLER_139_710 VDD VSS VDD VSS gf180mcu_fd_sc_mcu7t5v0__fillcap_4
XFILLER_197_164 VDD VSS VDD VSS gf180mcu_fd_sc_mcu7t5v0__fillcap_4
XFILLER_197_175 VDD VSS VDD VSS gf180mcu_fd_sc_mcu7t5v0__fillcap_32
XFILLER_197_142 VDD VSS VDD VSS gf180mcu_fd_sc_mcu7t5v0__fillcap_4
XFILLER_40_387 VDD VSS VDD VSS gf180mcu_fd_sc_mcu7t5v0__fillcap_64
XFILLER_194_871 VDD VSS VDD VSS gf180mcu_fd_sc_mcu7t5v0__fillcap_4
XFILLER_139_765 VDD VSS VDD VSS gf180mcu_fd_sc_mcu7t5v0__fillcap_4
XFILLER_153_212 VDD VSS VDD VSS gf180mcu_fd_sc_mcu7t5v0__fillcap_32
XFILLER_153_256 VDD VSS VDD VSS gf180mcu_fd_sc_mcu7t5v0__fillcap_8
XFILLER_268_614 VDD VSS VDD VSS gf180mcu_fd_sc_mcu7t5v0__fillcap_32
XFILLER_136_93 VDD VSS VDD VSS gf180mcu_fd_sc_mcu7t5v0__fillcap_8
XFILLER_121_142 VDD VSS VDD VSS gf180mcu_fd_sc_mcu7t5v0__fillcap_8
XFILLER_263_352 VDD VSS VDD VSS gf180mcu_fd_sc_mcu7t5v0__fillcap_64
XFILLER_17_874 VDD VSS VDD VSS gf180mcu_fd_sc_mcu7t5v0__fillcap_16
XFILLER_91_766 VDD VSS VDD VSS gf180mcu_fd_sc_mcu7t5v0__fillcap_4
X_2900_ VDD _2900_/Q _2900_/CLK VSS _2900_/D VDD VSS gf180mcu_fd_sc_mcu7t5v0__dffq_1
XFILLER_189_632 VDD VSS VDD VSS gf180mcu_fd_sc_mcu7t5v0__fillcap_8
XFILLER_188_120 VDD VSS VDD VSS gf180mcu_fd_sc_mcu7t5v0__fillcap_32
XFILLER_50_107 VDD VSS VDD VSS gf180mcu_fd_sc_mcu7t5v0__fillcap_64
XFILLER_231_282 VDD VSS VDD VSS gf180mcu_fd_sc_mcu7t5v0__fillcap_64
XFILLER_32_877 VDD VSS VDD VSS gf180mcu_fd_sc_mcu7t5v0__fillcap_8
X_2831_ VDD _2831_/Q _3405_/CLK VSS _2831_/D VDD VSS gf180mcu_fd_sc_mcu7t5v0__dffq_1
XFILLER_157_562 VDD VSS VDD VSS gf180mcu_fd_sc_mcu7t5v0__fillcap_64
XFILLER_145_702 VDD VSS VDD VSS gf180mcu_fd_sc_mcu7t5v0__fillcap_64
XFILLER_129_220 VDD VSS VDD VSS gf180mcu_fd_sc_mcu7t5v0__fillcap_4
XFILLER_129_231 VDD VSS VDD VSS gf180mcu_fd_sc_mcu7t5v0__fillcap_32
X_2762_ VDD VSS _2762_/I _3322_/D VDD VSS gf180mcu_fd_sc_mcu7t5v0__clkinv_1
X_1713_ VDD VSS _1714_/B1 _2340_/A1 _2484_/A1 VDD VSS gf180mcu_fd_sc_mcu7t5v0__nor2_1
XFILLER_144_234 VDD VSS VDD VSS gf180mcu_fd_sc_mcu7t5v0__fillcap_8
X_2693_ _2992_/Q VSS VDD _2976_/Q _2984_/Q _2740_/S0 _2968_/Q _2740_/S1 _2694_/I VDD
+ VSS gf180mcu_fd_sc_mcu7t5v0__mux4_1
X_1644_ VDD VSS _2539_/S _2549_/A2 _2547_/A3 VDD VSS gf180mcu_fd_sc_mcu7t5v0__nand2_1
X_1575_ _2470_/B VDD VSS _1582_/C _2328_/B2 _3349_/Q VDD VSS gf180mcu_fd_sc_mcu7t5v0__nand3_1
XFILLER_113_632 VDD VSS VDD VSS gf180mcu_fd_sc_mcu7t5v0__fillcap_32
X_3314_ _3314_/D wire85/I wire163/I VSS _3462_/CLK VDD VDD VSS gf180mcu_fd_sc_mcu7t5v0__dffrnq_1
X_3245_ _3245_/D _3245_/Q wire151/I VSS _3289_/CLK VDD VDD VSS gf180mcu_fd_sc_mcu7t5v0__dffrnq_1
XFILLER_98_387 VDD VSS VDD VSS gf180mcu_fd_sc_mcu7t5v0__fillcap_4
XFILLER_86_527 VDD VSS VDD VSS gf180mcu_fd_sc_mcu7t5v0__fillcap_64
XFILLER_255_842 VDD VSS VDD VSS gf180mcu_fd_sc_mcu7t5v0__fillcap_32
X_3176_ VDD _3176_/Q _3179_/CLK VSS _3176_/D VDD VSS gf180mcu_fd_sc_mcu7t5v0__dffq_1
X_2127_ VDD VSS _2127_/I _3118_/D VDD VSS gf180mcu_fd_sc_mcu7t5v0__clkinv_1
X_2058_ _2058_/S VDD VSS _3091_/D _3307_/Q _3091_/Q VDD VSS gf180mcu_fd_sc_mcu7t5v0__mux2_2
XFILLER_54_457 VDD VSS VDD VSS gf180mcu_fd_sc_mcu7t5v0__fillcap_64
XFILLER_223_772 VDD VSS VDD VSS gf180mcu_fd_sc_mcu7t5v0__fillcap_64
XFILLER_179_164 VDD VSS VDD VSS gf180mcu_fd_sc_mcu7t5v0__fillcap_8
XFILLER_210_444 VDD VSS VDD VSS gf180mcu_fd_sc_mcu7t5v0__fillcap_8
XFILLER_250_591 VDD VSS VDD VSS gf180mcu_fd_sc_mcu7t5v0__fillcap_4
XFILLER_22_387 VDD VSS VDD VSS gf180mcu_fd_sc_mcu7t5v0__fillcap_64
XFILLER_10_527 VDD VSS VDD VSS gf180mcu_fd_sc_mcu7t5v0__fillcap_64
XFILLER_176_871 VDD VSS VDD VSS gf180mcu_fd_sc_mcu7t5v0__fillcap_4
XFILLER_135_212 VDD VSS VDD VSS gf180mcu_fd_sc_mcu7t5v0__fillcap_8
XFILLER_191_874 VDD VSS VDD VSS gf180mcu_fd_sc_mcu7t5v0__fillcap_16
XFILLER_190_362 VDD VSS VDD VSS gf180mcu_fd_sc_mcu7t5v0__fillcap_4
XFILLER_2_737 VDD VSS VDD VSS gf180mcu_fd_sc_mcu7t5v0__fillcap_64
XFILLER_100_871 VDD VSS VDD VSS gf180mcu_fd_sc_mcu7t5v0__fillcap_4
XFILLER_245_352 VDD VSS VDD VSS gf180mcu_fd_sc_mcu7t5v0__fillcap_64
XFILLER_260_311 VDD VSS VDD VSS gf180mcu_fd_sc_mcu7t5v0__fillcap_4
XFILLER_73_766 VDD VSS VDD VSS gf180mcu_fd_sc_mcu7t5v0__fillcap_4
XFILLER_198_22 VDD VSS VDD VSS gf180mcu_fd_sc_mcu7t5v0__fillcap_8
XFILLER_32_107 VDD VSS VDD VSS gf180mcu_fd_sc_mcu7t5v0__fillcap_64
XFILLER_122_84 VDD VSS VDD VSS gf180mcu_fd_sc_mcu7t5v0__fillcap_16
XFILLER_198_451 VDD VSS VDD VSS gf180mcu_fd_sc_mcu7t5v0__fillcap_4
XFILLER_201_411 VDD VSS VDD VSS gf180mcu_fd_sc_mcu7t5v0__fillcap_8
XFILLER_213_282 VDD VSS VDD VSS gf180mcu_fd_sc_mcu7t5v0__fillcap_16
XFILLER_14_877 VDD VSS VDD VSS gf180mcu_fd_sc_mcu7t5v0__fillcap_8
XFILLER_201_466 VDD VSS VDD VSS gf180mcu_fd_sc_mcu7t5v0__fillcap_4
XFILLER_139_540 VDD VSS VDD VSS gf180mcu_fd_sc_mcu7t5v0__fillcap_8
XFILLER_41_696 VDD VSS VDD VSS gf180mcu_fd_sc_mcu7t5v0__fillcap_4
XFILLER_173_329 VDD VSS VDD VSS gf180mcu_fd_sc_mcu7t5v0__fillcap_16
XFILLER_127_702 VDD VSS VDD VSS gf180mcu_fd_sc_mcu7t5v0__fillcap_64
XFILLER_154_521 VDD VSS VDD VSS gf180mcu_fd_sc_mcu7t5v0__fillcap_4
XFILLER_166_381 VDD VSS VDD VSS gf180mcu_fd_sc_mcu7t5v0__fillcap_4
XFILLER_182_885 VDD VSS VDD VSS gf180mcu_fd_sc_mcu7t5v0__fillcap_4
XFILLER_107_492 VDD VSS VDD VSS gf180mcu_fd_sc_mcu7t5v0__fillcap_32
XFILLER_268_444 VDD VSS VDD VSS gf180mcu_fd_sc_mcu7t5v0__fillcap_32
XFILLER_122_473 VDD VSS VDD VSS gf180mcu_fd_sc_mcu7t5v0__fillcap_8
XFILLER_68_527 VDD VSS VDD VSS gf180mcu_fd_sc_mcu7t5v0__fillcap_64
XFILLER_237_842 VDD VSS VDD VSS gf180mcu_fd_sc_mcu7t5v0__fillcap_32
XFILLER_95_368 VDD VSS VDD VSS gf180mcu_fd_sc_mcu7t5v0__fillcap_8
X_3030_ VDD _3030_/Q _3055_/CLK VSS _3030_/D VDD VSS gf180mcu_fd_sc_mcu7t5v0__dffq_1
XFILLER_252_801 VDD VSS VDD VSS gf180mcu_fd_sc_mcu7t5v0__fillcap_4
XFILLER_264_661 VDD VSS VDD VSS gf180mcu_fd_sc_mcu7t5v0__fillcap_4
XFILLER_36_457 VDD VSS VDD VSS gf180mcu_fd_sc_mcu7t5v0__fillcap_64
XFILLER_63_276 VDD VSS VDD VSS gf180mcu_fd_sc_mcu7t5v0__fillcap_4
XFILLER_51_416 VDD VSS VDD VSS gf180mcu_fd_sc_mcu7t5v0__fillcap_4
XFILLER_205_772 VDD VSS VDD VSS gf180mcu_fd_sc_mcu7t5v0__fillcap_64
XFILLER_220_731 VDD VSS VDD VSS gf180mcu_fd_sc_mcu7t5v0__fillcap_4
XFILLER_232_591 VDD VSS VDD VSS gf180mcu_fd_sc_mcu7t5v0__fillcap_4
XFILLER_177_624 VDD VSS VDD VSS gf180mcu_fd_sc_mcu7t5v0__fillcap_4
XFILLER_189_484 VDD VSS VDD VSS gf180mcu_fd_sc_mcu7t5v0__fillcap_4
XFILLER_149_337 VDD VSS VDD VSS gf180mcu_fd_sc_mcu7t5v0__fillcap_8
X_2814_ VDD _2814_/Q _3457_/CLK VSS _2814_/D VDD VSS gf180mcu_fd_sc_mcu7t5v0__dffq_1
XFILLER_176_134 VDD VSS VDD VSS gf180mcu_fd_sc_mcu7t5v0__fillcap_4
XFILLER_158_871 VDD VSS VDD VSS gf180mcu_fd_sc_mcu7t5v0__fillcap_4
XFILLER_164_329 VDD VSS VDD VSS gf180mcu_fd_sc_mcu7t5v0__fillcap_8
X_2745_ _2744_/Z _2745_/B2 VDD VSS _2746_/I _3069_/Q _2749_/A2 VDD VSS gf180mcu_fd_sc_mcu7t5v0__aoi22_1
XFILLER_173_874 VDD VSS VDD VSS gf180mcu_fd_sc_mcu7t5v0__fillcap_16
XFILLER_172_351 VDD VSS VDD VSS gf180mcu_fd_sc_mcu7t5v0__fillcap_8
X_2676_ _3054_/Q VSS VDD _3038_/Q _3046_/Q _2722_/S0 _3030_/Q wire60/Z _2676_/Z VDD
+ VSS gf180mcu_fd_sc_mcu7t5v0__mux4_1
X_1627_ VDD VSS _1627_/Z _3437_/Q _3413_/D VDD VSS gf180mcu_fd_sc_mcu7t5v0__xor2_1
XFILLER_259_422 VDD VSS VDD VSS gf180mcu_fd_sc_mcu7t5v0__fillcap_64
XFILLER_207_51 VDD VSS VDD VSS gf180mcu_fd_sc_mcu7t5v0__fillcap_16
Xclkbuf_3_7__f_clk_i VDD VSS clkload6/I clkbuf_0_clk_i/Z VDD VSS gf180mcu_fd_sc_mcu7t5v0__clkbuf_16
X_1558_ _3144_/Q VDD VSS _1566_/A4 _3143_/Q _3142_/Q VDD VSS gf180mcu_fd_sc_mcu7t5v0__nor3_1
XFILLER_113_484 VDD VSS VDD VSS gf180mcu_fd_sc_mcu7t5v0__fillcap_4
XFILLER_87_836 VDD VSS VDD VSS gf180mcu_fd_sc_mcu7t5v0__fillcap_4
XFILLER_99_696 VDD VSS VDD VSS gf180mcu_fd_sc_mcu7t5v0__fillcap_4
X_1489_ VDD VSS _1493_/A2 _3423_/Q _1484_/Z VDD VSS gf180mcu_fd_sc_mcu7t5v0__nor2_1
XFILLER_101_679 VDD VSS VDD VSS gf180mcu_fd_sc_mcu7t5v0__fillcap_16
X_3228_ _3228_/D _3228_/Q wire145/I VSS _3452_/CLK VDD VDD VSS gf180mcu_fd_sc_mcu7t5v0__dffrnq_1
X_3159_ _3159_/D _3159_/Q wire147/Z VSS _3159_/CLK VDD VDD VSS gf180mcu_fd_sc_mcu7t5v0__dffrnq_1
XFILLER_227_352 VDD VSS VDD VSS gf180mcu_fd_sc_mcu7t5v0__fillcap_64
XFILLER_36_37 VDD VSS VDD VSS gf180mcu_fd_sc_mcu7t5v0__fillcap_64
XFILLER_242_311 VDD VSS VDD VSS gf180mcu_fd_sc_mcu7t5v0__fillcap_4
XFILLER_254_171 VDD VSS VDD VSS gf180mcu_fd_sc_mcu7t5v0__fillcap_4
XFILLER_55_766 VDD VSS VDD VSS gf180mcu_fd_sc_mcu7t5v0__fillcap_4
XFILLER_14_107 VDD VSS VDD VSS gf180mcu_fd_sc_mcu7t5v0__fillcap_64
XFILLER_195_465 VDD VSS VDD VSS gf180mcu_fd_sc_mcu7t5v0__fillcap_8
XFILLER_210_241 VDD VSS VDD VSS gf180mcu_fd_sc_mcu7t5v0__fillcap_4
XFILLER_167_123 VDD VSS VDD VSS gf180mcu_fd_sc_mcu7t5v0__fillcap_16
XFILLER_11_836 VDD VSS VDD VSS gf180mcu_fd_sc_mcu7t5v0__fillcap_4
XFILLER_23_696 VDD VSS VDD VSS gf180mcu_fd_sc_mcu7t5v0__fillcap_4
XFILLER_182_115 VDD VSS VDD VSS gf180mcu_fd_sc_mcu7t5v0__fillcap_32
XFILLER_167_167 VDD VSS VDD VSS gf180mcu_fd_sc_mcu7t5v0__fillcap_32
XFILLER_109_702 VDD VSS VDD VSS gf180mcu_fd_sc_mcu7t5v0__fillcap_64
XFILLER_6_317 VDD VSS VDD VSS gf180mcu_fd_sc_mcu7t5v0__fillcap_64
XFILLER_148_381 VDD VSS VDD VSS gf180mcu_fd_sc_mcu7t5v0__fillcap_4
XFILLER_164_885 VDD VSS VDD VSS gf180mcu_fd_sc_mcu7t5v0__fillcap_4
XFILLER_77_346 VDD VSS VDD VSS gf180mcu_fd_sc_mcu7t5v0__fillcap_4
XFILLER_219_842 VDD VSS VDD VSS gf180mcu_fd_sc_mcu7t5v0__fillcap_32
XFILLER_234_801 VDD VSS VDD VSS gf180mcu_fd_sc_mcu7t5v0__fillcap_4
XFILLER_246_661 VDD VSS VDD VSS gf180mcu_fd_sc_mcu7t5v0__fillcap_4
XFILLER_92_349 VDD VSS VDD VSS gf180mcu_fd_sc_mcu7t5v0__fillcap_16
XFILLER_133_72 VDD VSS VDD VSS gf180mcu_fd_sc_mcu7t5v0__fillcap_8
XFILLER_18_457 VDD VSS VDD VSS gf180mcu_fd_sc_mcu7t5v0__fillcap_64
XFILLER_45_276 VDD VSS VDD VSS gf180mcu_fd_sc_mcu7t5v0__fillcap_4
XFILLER_33_416 VDD VSS VDD VSS gf180mcu_fd_sc_mcu7t5v0__fillcap_4
XFILLER_202_731 VDD VSS VDD VSS gf180mcu_fd_sc_mcu7t5v0__fillcap_4
XFILLER_174_605 VDD VSS VDD VSS gf180mcu_fd_sc_mcu7t5v0__fillcap_32
XFILLER_127_521 VDD VSS VDD VSS gf180mcu_fd_sc_mcu7t5v0__fillcap_8
XFILLER_155_874 VDD VSS VDD VSS gf180mcu_fd_sc_mcu7t5v0__fillcap_16
Xclkbuf_leaf_31_clk_i _3365_/CLK VSS VDD clkload5/I VDD VSS gf180mcu_fd_sc_mcu7t5v0__clkbuf_2
XFILLER_127_554 VDD VSS VDD VSS gf180mcu_fd_sc_mcu7t5v0__fillcap_4
X_2530_ _2530_/A3 VDD VSS _2531_/B _3448_/D _3227_/Q VDD VSS gf180mcu_fd_sc_mcu7t5v0__nor3_1
X_2461_ VDD VSS _2462_/A3 _2461_/A1 _2460_/Z VDD VSS gf180mcu_fd_sc_mcu7t5v0__nand2_1
XFILLER_170_877 VDD VSS VDD VSS gf180mcu_fd_sc_mcu7t5v0__fillcap_8
X_1412_ VDD VSS _3108_/Q _2100_/A1 VDD VSS gf180mcu_fd_sc_mcu7t5v0__clkinv_1
X_2392_ _3210_/Q _3206_/Q VDD VSS _2393_/B2 _2392_/A1 _2392_/A2 VDD VSS gf180mcu_fd_sc_mcu7t5v0__aoi211_1
XFILLER_69_836 VDD VSS VDD VSS gf180mcu_fd_sc_mcu7t5v0__fillcap_4
Xclkbuf_leaf_46_clk_i _3059_/CLK VSS VDD clkload1/I VDD VSS gf180mcu_fd_sc_mcu7t5v0__clkbuf_2
XFILLER_268_274 VDD VSS VDD VSS gf180mcu_fd_sc_mcu7t5v0__fillcap_32
XFILLER_209_352 VDD VSS VDD VSS gf180mcu_fd_sc_mcu7t5v0__fillcap_8
XFILLER_260_37 VDD VSS VDD VSS gf180mcu_fd_sc_mcu7t5v0__fillcap_64
X_3013_ VDD _3013_/Q _3021_/CLK VSS _3013_/D VDD VSS gf180mcu_fd_sc_mcu7t5v0__dffq_1
Xwire36 VSS wire36/Z wire36/I VDD VDD VSS gf180mcu_fd_sc_mcu7t5v0__buf_2
XFILLER_224_311 VDD VSS VDD VSS gf180mcu_fd_sc_mcu7t5v0__fillcap_4
XFILLER_236_171 VDD VSS VDD VSS gf180mcu_fd_sc_mcu7t5v0__fillcap_4
XFILLER_37_766 VDD VSS VDD VSS gf180mcu_fd_sc_mcu7t5v0__fillcap_4
XFILLER_212_517 VDD VSS VDD VSS gf180mcu_fd_sc_mcu7t5v0__fillcap_8
XFILLER_177_476 VDD VSS VDD VSS gf180mcu_fd_sc_mcu7t5v0__fillcap_8
XFILLER_192_446 VDD VSS VDD VSS gf180mcu_fd_sc_mcu7t5v0__fillcap_8
XFILLER_192_457 VDD VSS VDD VSS gf180mcu_fd_sc_mcu7t5v0__fillcap_16
XFILLER_146_885 VDD VSS VDD VSS gf180mcu_fd_sc_mcu7t5v0__fillcap_4
X_2728_ _3027_/Q VSS VDD _3011_/Q _3019_/Q _2730_/S0 _3003_/Q wire60/I _2729_/I VDD
+ VSS gf180mcu_fd_sc_mcu7t5v0__mux4_1
X_2659_ _3053_/Q VSS VDD _3037_/Q _3045_/Q _2730_/S0 _3029_/Q wire60/I _2659_/Z VDD
+ VSS gf180mcu_fd_sc_mcu7t5v0__mux4_1
XFILLER_160_398 VDD VSS VDD VSS gf180mcu_fd_sc_mcu7t5v0__fillcap_4
XFILLER_59_346 VDD VSS VDD VSS gf180mcu_fd_sc_mcu7t5v0__fillcap_4
XFILLER_216_801 VDD VSS VDD VSS gf180mcu_fd_sc_mcu7t5v0__fillcap_4
XFILLER_228_661 VDD VSS VDD VSS gf180mcu_fd_sc_mcu7t5v0__fillcap_4
XFILLER_170_37 VDD VSS VDD VSS gf180mcu_fd_sc_mcu7t5v0__fillcap_64
XFILLER_15_416 VDD VSS VDD VSS gf180mcu_fd_sc_mcu7t5v0__fillcap_4
XFILLER_27_276 VDD VSS VDD VSS gf180mcu_fd_sc_mcu7t5v0__fillcap_4
XFILLER_137_2 VDD VSS VDD VSS gf180mcu_fd_sc_mcu7t5v0__fillcap_32
XFILLER_7_626 VDD VSS VDD VSS gf180mcu_fd_sc_mcu7t5v0__fillcap_4
XFILLER_109_532 VDD VSS VDD VSS gf180mcu_fd_sc_mcu7t5v0__fillcap_4
XFILLER_137_874 VDD VSS VDD VSS gf180mcu_fd_sc_mcu7t5v0__fillcap_16
XFILLER_170_107 VDD VSS VDD VSS gf180mcu_fd_sc_mcu7t5v0__fillcap_32
Xmax_length144 _2331_/B VSS VDD _2802_/Q VDD VSS gf180mcu_fd_sc_mcu7t5v0__clkbuf_3
Xmax_length155 wire151/I _3452_/RN VDD VSS VDD VSS gf180mcu_fd_sc_mcu7t5v0__buf_8
Xmax_length166 _3336_/RN _3339_/RN VDD VSS VDD VSS gf180mcu_fd_sc_mcu7t5v0__buf_8
XFILLER_136_373 VDD VSS VDD VSS gf180mcu_fd_sc_mcu7t5v0__fillcap_8
XFILLER_152_877 VDD VSS VDD VSS gf180mcu_fd_sc_mcu7t5v0__fillcap_8
XFILLER_163_192 VDD VSS VDD VSS gf180mcu_fd_sc_mcu7t5v0__fillcap_8
XFILLER_111_229 VDD VSS VDD VSS gf180mcu_fd_sc_mcu7t5v0__fillcap_8
XFILLER_144_71 VDD VSS VDD VSS gf180mcu_fd_sc_mcu7t5v0__fillcap_32
XFILLER_19_766 VDD VSS VDD VSS gf180mcu_fd_sc_mcu7t5v0__fillcap_4
XFILLER_80_308 VDD VSS VDD VSS gf180mcu_fd_sc_mcu7t5v0__fillcap_4
X_1961_ _1963_/S VDD VSS _3010_/D wire116/Z _3010_/Q VDD VSS gf180mcu_fd_sc_mcu7t5v0__mux2_2
X_1892_ _1897_/S VDD VSS _2951_/D _2951_/Q wire122/Z VDD VSS gf180mcu_fd_sc_mcu7t5v0__mux2_2
XFILLER_174_457 VDD VSS VDD VSS gf180mcu_fd_sc_mcu7t5v0__fillcap_16
XFILLER_127_384 VDD VSS VDD VSS gf180mcu_fd_sc_mcu7t5v0__fillcap_16
XFILLER_128_885 VDD VSS VDD VSS gf180mcu_fd_sc_mcu7t5v0__fillcap_4
XFILLER_52_2 VDD VSS VDD VSS gf180mcu_fd_sc_mcu7t5v0__fillcap_32
X_2513_ _2513_/A3 VDD VSS _2515_/A2 _3221_/Q _2513_/A2 VDD VSS gf180mcu_fd_sc_mcu7t5v0__nand3_1
X_2444_ VDD VSS _2447_/A2 _2459_/A1 _2443_/Z VDD VSS gf180mcu_fd_sc_mcu7t5v0__nand2_1
XFILLER_88_419 VDD VSS VDD VSS gf180mcu_fd_sc_mcu7t5v0__fillcap_16
XFILLER_130_527 VDD VSS VDD VSS gf180mcu_fd_sc_mcu7t5v0__fillcap_8
X_2375_ VDD VSS _2376_/A3 _2461_/A1 _2374_/Z VDD VSS gf180mcu_fd_sc_mcu7t5v0__nand2_1
XFILLER_197_516 VDD VSS VDD VSS gf180mcu_fd_sc_mcu7t5v0__fillcap_4
XFILLER_240_667 VDD VSS VDD VSS gf180mcu_fd_sc_mcu7t5v0__fillcap_64
XFILLER_138_605 VDD VSS VDD VSS gf180mcu_fd_sc_mcu7t5v0__fillcap_4
XFILLER_193_722 VDD VSS VDD VSS gf180mcu_fd_sc_mcu7t5v0__fillcap_4
XFILLER_165_402 VDD VSS VDD VSS gf180mcu_fd_sc_mcu7t5v0__fillcap_16
XFILLER_180_405 VDD VSS VDD VSS gf180mcu_fd_sc_mcu7t5v0__fillcap_16
XFILLER_119_874 VDD VSS VDD VSS gf180mcu_fd_sc_mcu7t5v0__fillcap_16
XFILLER_152_107 VDD VSS VDD VSS gf180mcu_fd_sc_mcu7t5v0__fillcap_4
XFILLER_134_877 VDD VSS VDD VSS gf180mcu_fd_sc_mcu7t5v0__fillcap_8
XFILLER_160_162 VDD VSS VDD VSS gf180mcu_fd_sc_mcu7t5v0__fillcap_8
XFILLER_161_696 VDD VSS VDD VSS gf180mcu_fd_sc_mcu7t5v0__fillcap_4
XFILLER_114_30 VDD VSS VDD VSS gf180mcu_fd_sc_mcu7t5v0__fillcap_4
XFILLER_207_119 VDD VSS VDD VSS gf180mcu_fd_sc_mcu7t5v0__fillcap_16
XFILLER_262_247 VDD VSS VDD VSS gf180mcu_fd_sc_mcu7t5v0__fillcap_64
XFILLER_254_2 VDD VSS VDD VSS gf180mcu_fd_sc_mcu7t5v0__fillcap_32
XFILLER_71_842 VDD VSS VDD VSS gf180mcu_fd_sc_mcu7t5v0__fillcap_32
XFILLER_230_177 VDD VSS VDD VSS gf180mcu_fd_sc_mcu7t5v0__fillcap_64
XFILLER_168_295 VDD VSS VDD VSS gf180mcu_fd_sc_mcu7t5v0__fillcap_16
XFILLER_156_457 VDD VSS VDD VSS gf180mcu_fd_sc_mcu7t5v0__fillcap_64
XFILLER_136_192 VDD VSS VDD VSS gf180mcu_fd_sc_mcu7t5v0__fillcap_32
XFILLER_124_387 VDD VSS VDD VSS gf180mcu_fd_sc_mcu7t5v0__fillcap_16
XFILLER_112_527 VDD VSS VDD VSS gf180mcu_fd_sc_mcu7t5v0__fillcap_4
X_2160_ _3165_/Q _2168_/C VDD VSS _2161_/B2 _3156_/Q _2168_/A2 _2168_/B1 VDD VSS gf180mcu_fd_sc_mcu7t5v0__aoi221_1
XFILLER_93_411 VDD VSS VDD VSS gf180mcu_fd_sc_mcu7t5v0__fillcap_8
XFILLER_93_422 VDD VSS VDD VSS gf180mcu_fd_sc_mcu7t5v0__fillcap_16
XFILLER_254_737 VDD VSS VDD VSS gf180mcu_fd_sc_mcu7t5v0__fillcap_64
XFILLER_266_597 VDD VSS VDD VSS gf180mcu_fd_sc_mcu7t5v0__fillcap_64
X_2091_ _3106_/Q VDD VSS _2094_/B _2074_/Z _2090_/Z VDD VSS gf180mcu_fd_sc_mcu7t5v0__aoi21_1
XFILLER_222_612 VDD VSS VDD VSS gf180mcu_fd_sc_mcu7t5v0__fillcap_8
XFILLER_221_111 VDD VSS VDD VSS gf180mcu_fd_sc_mcu7t5v0__fillcap_4
XFILLER_61_352 VDD VSS VDD VSS gf180mcu_fd_sc_mcu7t5v0__fillcap_64
XFILLER_222_667 VDD VSS VDD VSS gf180mcu_fd_sc_mcu7t5v0__fillcap_64
XFILLER_210_807 VDD VSS VDD VSS gf180mcu_fd_sc_mcu7t5v0__fillcap_64
X_2993_ VDD _2993_/Q _3021_/CLK VSS _2993_/D VDD VSS gf180mcu_fd_sc_mcu7t5v0__dffq_1
X_1944_ _1944_/S VDD VSS _2996_/D wire113/Z _2996_/Q VDD VSS gf180mcu_fd_sc_mcu7t5v0__mux2_2
X_1875_ _1877_/S VDD VSS _2938_/D _2938_/Q _2287_/I0 VDD VSS gf180mcu_fd_sc_mcu7t5v0__mux2_2
XFILLER_175_766 VDD VSS VDD VSS gf180mcu_fd_sc_mcu7t5v0__fillcap_4
XFILLER_190_769 VDD VSS VDD VSS gf180mcu_fd_sc_mcu7t5v0__fillcap_32
XFILLER_116_877 VDD VSS VDD VSS gf180mcu_fd_sc_mcu7t5v0__fillcap_8
XFILLER_143_696 VDD VSS VDD VSS gf180mcu_fd_sc_mcu7t5v0__fillcap_4
X_2427_ _2929_/Q VSS VDD _2913_/Q _2921_/Q _2427_/S0 _2905_/Q _2460_/S1 _2427_/Z VDD
+ VSS gf180mcu_fd_sc_mcu7t5v0__mux4_1
XFILLER_131_836 VDD VSS VDD VSS gf180mcu_fd_sc_mcu7t5v0__fillcap_4
XFILLER_97_772 VDD VSS VDD VSS gf180mcu_fd_sc_mcu7t5v0__fillcap_64
X_2358_ _2358_/A3 VDD VSS _2360_/A2 _2362_/A1 _2494_/C VDD VSS gf180mcu_fd_sc_mcu7t5v0__nand3_1
XFILLER_111_582 VDD VSS VDD VSS gf180mcu_fd_sc_mcu7t5v0__fillcap_32
X_2289_ _2289_/S VDD VSS _3182_/D _3182_/Q _3202_/Q VDD VSS gf180mcu_fd_sc_mcu7t5v0__mux2_2
XFILLER_244_247 VDD VSS VDD VSS gf180mcu_fd_sc_mcu7t5v0__fillcap_64
XFILLER_231_72 VDD VSS VDD VSS gf180mcu_fd_sc_mcu7t5v0__fillcap_64
XFILLER_53_842 VDD VSS VDD VSS gf180mcu_fd_sc_mcu7t5v0__fillcap_32
XFILLER_80_661 VDD VSS VDD VSS gf180mcu_fd_sc_mcu7t5v0__fillcap_4
XFILLER_44_37 VDD VSS VDD VSS gf180mcu_fd_sc_mcu7t5v0__fillcap_64
XFILLER_100_10 VDD VSS VDD VSS gf180mcu_fd_sc_mcu7t5v0__fillcap_4
XFILLER_200_317 VDD VSS VDD VSS gf180mcu_fd_sc_mcu7t5v0__fillcap_64
XFILLER_226_6 VDD VSS VDD VSS gf180mcu_fd_sc_mcu7t5v0__fillcap_16
XFILLER_21_772 VDD VSS VDD VSS gf180mcu_fd_sc_mcu7t5v0__fillcap_64
XFILLER_138_457 VDD VSS VDD VSS gf180mcu_fd_sc_mcu7t5v0__fillcap_8
XFILLER_181_736 VDD VSS VDD VSS gf180mcu_fd_sc_mcu7t5v0__fillcap_32
XFILLER_134_652 VDD VSS VDD VSS gf180mcu_fd_sc_mcu7t5v0__fillcap_8
XFILLER_106_365 VDD VSS VDD VSS gf180mcu_fd_sc_mcu7t5v0__fillcap_4
XFILLER_268_818 VDD VSS VDD VSS gf180mcu_fd_sc_mcu7t5v0__fillcap_32
XFILLER_161_471 VDD VSS VDD VSS gf180mcu_fd_sc_mcu7t5v0__fillcap_16
XFILLER_106_387 VDD VSS VDD VSS gf180mcu_fd_sc_mcu7t5v0__fillcap_16
XFILLER_133_173 VDD VSS VDD VSS gf180mcu_fd_sc_mcu7t5v0__fillcap_8
XFILLER_121_346 VDD VSS VDD VSS gf180mcu_fd_sc_mcu7t5v0__fillcap_4
XFILLER_75_422 VDD VSS VDD VSS gf180mcu_fd_sc_mcu7t5v0__fillcap_64
XFILLER_236_737 VDD VSS VDD VSS gf180mcu_fd_sc_mcu7t5v0__fillcap_64
XFILLER_248_597 VDD VSS VDD VSS gf180mcu_fd_sc_mcu7t5v0__fillcap_64
XFILLER_263_556 VDD VSS VDD VSS gf180mcu_fd_sc_mcu7t5v0__fillcap_4
XFILLER_189_836 VDD VSS VDD VSS gf180mcu_fd_sc_mcu7t5v0__fillcap_4
XFILLER_43_352 VDD VSS VDD VSS gf180mcu_fd_sc_mcu7t5v0__fillcap_64
XFILLER_231_486 VDD VSS VDD VSS gf180mcu_fd_sc_mcu7t5v0__fillcap_4
XFILLER_203_166 VDD VSS VDD VSS gf180mcu_fd_sc_mcu7t5v0__fillcap_4
XFILLER_203_199 VDD VSS VDD VSS gf180mcu_fd_sc_mcu7t5v0__fillcap_4
XFILLER_157_766 VDD VSS VDD VSS gf180mcu_fd_sc_mcu7t5v0__fillcap_4
Xwire140 VSS wire140/Z wire140/I VDD VDD VSS gf180mcu_fd_sc_mcu7t5v0__clkbuf_1
XFILLER_11_282 VDD VSS VDD VSS gf180mcu_fd_sc_mcu7t5v0__fillcap_64
X_1660_ VDD VSS _1715_/B _2803_/Q _2337_/A1 VDD VSS gf180mcu_fd_sc_mcu7t5v0__nand2_1
Xwire151 wire151/Z VSS VDD wire151/I VDD VSS gf180mcu_fd_sc_mcu7t5v0__clkbuf_8
Xhold209 _3440_/D VSS _3445_/Q VDD VDD VSS gf180mcu_fd_sc_mcu7t5v0__dlyc_1
X_1591_ _1591_/A2 _1591_/B1 _1591_/B2 VDD VSS _3347_/D _1595_/A2 VDD VSS gf180mcu_fd_sc_mcu7t5v0__oai22_1
X_3330_ _3330_/D _3330_/Q wire169/Z VSS _3448_/CLK VDD VDD VSS gf180mcu_fd_sc_mcu7t5v0__dffrnq_1
XFILLER_258_317 VDD VSS VDD VSS gf180mcu_fd_sc_mcu7t5v0__fillcap_64
XFILLER_124_162 VDD VSS VDD VSS gf180mcu_fd_sc_mcu7t5v0__fillcap_8
XFILLER_124_184 VDD VSS VDD VSS gf180mcu_fd_sc_mcu7t5v0__fillcap_16
XFILLER_113_836 VDD VSS VDD VSS gf180mcu_fd_sc_mcu7t5v0__fillcap_4
XFILLER_3_492 VDD VSS VDD VSS gf180mcu_fd_sc_mcu7t5v0__fillcap_64
X_3261_ _3261_/D _3261_/Q _3335_/RN VSS _3453_/CLK VDD VDD VSS gf180mcu_fd_sc_mcu7t5v0__dffrnq_1
X_3192_ _3192_/D _3192_/Q _3359_/RN VSS _3192_/CLK VDD VDD VSS gf180mcu_fd_sc_mcu7t5v0__dffrnq_1
X_2212_ _2222_/S VDD VSS _3158_/D wire86/Z _3158_/Q VDD VSS gf180mcu_fd_sc_mcu7t5v0__mux2_2
XFILLER_79_772 VDD VSS VDD VSS gf180mcu_fd_sc_mcu7t5v0__fillcap_64
X_2143_ VDD _2143_/B _2143_/A2 _2161_/B1 _3146_/Q VSS VDD VSS gf180mcu_fd_sc_mcu7t5v0__oai21_1
XFILLER_15_2 VDD VSS VDD VSS gf180mcu_fd_sc_mcu7t5v0__fillcap_64
XFILLER_226_247 VDD VSS VDD VSS gf180mcu_fd_sc_mcu7t5v0__fillcap_64
XFILLER_93_263 VDD VSS VDD VSS gf180mcu_fd_sc_mcu7t5v0__fillcap_16
XFILLER_241_206 VDD VSS VDD VSS gf180mcu_fd_sc_mcu7t5v0__fillcap_4
X_2074_ _2274_/C VDD VSS _2074_/Z _3118_/Q _2076_/A2 VDD VSS gf180mcu_fd_sc_mcu7t5v0__or3_1
XFILLER_35_842 VDD VSS VDD VSS gf180mcu_fd_sc_mcu7t5v0__fillcap_32
Xload_slew81 _2427_/S0 _2460_/S0 VDD VSS VDD VSS gf180mcu_fd_sc_mcu7t5v0__buf_4
XFILLER_62_661 VDD VSS VDD VSS gf180mcu_fd_sc_mcu7t5v0__fillcap_4
XFILLER_50_801 VDD VSS VDD VSS gf180mcu_fd_sc_mcu7t5v0__fillcap_4
Xload_slew70 VSS _2730_/S0 _3420_/Q VDD VDD VSS gf180mcu_fd_sc_mcu7t5v0__buf_3
XFILLER_179_346 VDD VSS VDD VSS gf180mcu_fd_sc_mcu7t5v0__fillcap_4
X_2976_ VDD _2976_/Q clkload8/I VSS _2976_/D VDD VSS gf180mcu_fd_sc_mcu7t5v0__dffq_1
XFILLER_30_591 VDD VSS VDD VSS gf180mcu_fd_sc_mcu7t5v0__fillcap_4
X_1927_ VDD VSS _1935_/S _2001_/A1 _1936_/A2 VDD VSS gf180mcu_fd_sc_mcu7t5v0__nand2_1
XFILLER_175_574 VDD VSS VDD VSS gf180mcu_fd_sc_mcu7t5v0__fillcap_16
X_1858_ _1860_/S VDD VSS _2922_/D wire130/Z _2922_/Q VDD VSS gf180mcu_fd_sc_mcu7t5v0__mux2_2
XFILLER_108_619 VDD VSS VDD VSS gf180mcu_fd_sc_mcu7t5v0__fillcap_4
XFILLER_107_118 VDD VSS VDD VSS gf180mcu_fd_sc_mcu7t5v0__fillcap_16
X_1789_ _1795_/S VDD VSS _2862_/D _2862_/Q _3120_/Q VDD VSS gf180mcu_fd_sc_mcu7t5v0__mux2_2
X_3459_ _3459_/D _3459_/Q wire163/I VSS _3461_/CLK VDD VDD VSS gf180mcu_fd_sc_mcu7t5v0__dffrnq_1
XFILLER_103_368 VDD VSS VDD VSS gf180mcu_fd_sc_mcu7t5v0__fillcap_4
XFILLER_131_688 VDD VSS VDD VSS gf180mcu_fd_sc_mcu7t5v0__fillcap_8
XFILLER_57_422 VDD VSS VDD VSS gf180mcu_fd_sc_mcu7t5v0__fillcap_64
XFILLER_218_737 VDD VSS VDD VSS gf180mcu_fd_sc_mcu7t5v0__fillcap_64
XFILLER_69_282 VDD VSS VDD VSS gf180mcu_fd_sc_mcu7t5v0__fillcap_64
XFILLER_97_591 VDD VSS VDD VSS gf180mcu_fd_sc_mcu7t5v0__fillcap_32
XFILLER_245_556 VDD VSS VDD VSS gf180mcu_fd_sc_mcu7t5v0__fillcap_4
XFILLER_25_352 VDD VSS VDD VSS gf180mcu_fd_sc_mcu7t5v0__fillcap_64
XFILLER_197_132 VDD VSS VDD VSS gf180mcu_fd_sc_mcu7t5v0__fillcap_8
XFILLER_40_311 VDD VSS VDD VSS gf180mcu_fd_sc_mcu7t5v0__fillcap_4
XFILLER_52_171 VDD VSS VDD VSS gf180mcu_fd_sc_mcu7t5v0__fillcap_4
XFILLER_201_648 VDD VSS VDD VSS gf180mcu_fd_sc_mcu7t5v0__fillcap_8
XFILLER_187_46 VDD VSS VDD VSS gf180mcu_fd_sc_mcu7t5v0__fillcap_16
XFILLER_185_338 VDD VSS VDD VSS gf180mcu_fd_sc_mcu7t5v0__fillcap_8
XFILLER_5_702 VDD VSS VDD VSS gf180mcu_fd_sc_mcu7t5v0__fillcap_64
XFILLER_107_696 VDD VSS VDD VSS gf180mcu_fd_sc_mcu7t5v0__fillcap_4
XFILLER_268_648 VDD VSS VDD VSS gf180mcu_fd_sc_mcu7t5v0__fillcap_32
XFILLER_161_290 VDD VSS VDD VSS gf180mcu_fd_sc_mcu7t5v0__fillcap_8
XFILLER_267_136 VDD VSS VDD VSS gf180mcu_fd_sc_mcu7t5v0__fillcap_4
XFILLER_76_731 VDD VSS VDD VSS gf180mcu_fd_sc_mcu7t5v0__fillcap_4
XFILLER_208_247 VDD VSS VDD VSS gf180mcu_fd_sc_mcu7t5v0__fillcap_8
XFILLER_223_206 VDD VSS VDD VSS gf180mcu_fd_sc_mcu7t5v0__fillcap_4
Xclkbuf_4_12_0_host_clk_i _3370_/CLK VSS VDD clkbuf_0_host_clk_i/Z VDD VSS gf180mcu_fd_sc_mcu7t5v0__clkbuf_2
XFILLER_17_842 VDD VSS VDD VSS gf180mcu_fd_sc_mcu7t5v0__fillcap_32
XFILLER_44_661 VDD VSS VDD VSS gf180mcu_fd_sc_mcu7t5v0__fillcap_4
XFILLER_32_801 VDD VSS VDD VSS gf180mcu_fd_sc_mcu7t5v0__fillcap_4
X_2830_ VDD _2830_/Q _3458_/CLK VSS _2830_/D VDD VSS gf180mcu_fd_sc_mcu7t5v0__dffq_1
XFILLER_12_591 VDD VSS VDD VSS gf180mcu_fd_sc_mcu7t5v0__fillcap_4
X_2761_ wire19/Z _3074_/Q VDD VSS _2762_/I _3322_/Q wire37/Z VDD VSS gf180mcu_fd_sc_mcu7t5v0__aoi22_1
X_1712_ _2274_/C _1712_/C VDD VSS _2803_/D _1712_/A1 _1720_/A2 VDD VSS gf180mcu_fd_sc_mcu7t5v0__aoi211_1
XFILLER_117_416 VDD VSS VDD VSS gf180mcu_fd_sc_mcu7t5v0__fillcap_4
X_2692_ VDD VSS _2695_/B _2735_/S _2691_/Z VDD VSS gf180mcu_fd_sc_mcu7t5v0__nand2_1
XFILLER_129_276 VDD VSS VDD VSS gf180mcu_fd_sc_mcu7t5v0__fillcap_4
X_1643_ VDD VSS _2547_/A3 _1643_/A1 _3448_/Q VDD VSS gf180mcu_fd_sc_mcu7t5v0__nor2_1
XFILLER_172_577 VDD VSS VDD VSS gf180mcu_fd_sc_mcu7t5v0__fillcap_16
X_1574_ VDD VSS _2199_/A1 _3349_/Q _2470_/B VDD VSS gf180mcu_fd_sc_mcu7t5v0__nand2_1
XFILLER_259_626 VDD VSS VDD VSS gf180mcu_fd_sc_mcu7t5v0__fillcap_4
X_3313_ _3313_/D _3313_/Q wire165/Z VSS _3463_/CLK VDD VDD VSS gf180mcu_fd_sc_mcu7t5v0__dffrnq_1
XFILLER_113_677 VDD VSS VDD VSS gf180mcu_fd_sc_mcu7t5v0__fillcap_16
X_3244_ _3244_/D wire99/I _3452_/RN VSS _3452_/CLK VDD VDD VSS gf180mcu_fd_sc_mcu7t5v0__dffrnq_1
XFILLER_39_422 VDD VSS VDD VSS gf180mcu_fd_sc_mcu7t5v0__fillcap_64
XFILLER_227_556 VDD VSS VDD VSS gf180mcu_fd_sc_mcu7t5v0__fillcap_4
X_3175_ VDD _3175_/Q _3185_/CLK VSS _3175_/D VDD VSS gf180mcu_fd_sc_mcu7t5v0__dffq_1
XFILLER_66_241 VDD VSS VDD VSS gf180mcu_fd_sc_mcu7t5v0__fillcap_4
X_2126_ _2483_/B VDD VSS _2127_/I _3118_/Q _2347_/B VDD VSS gf180mcu_fd_sc_mcu7t5v0__aoi21_1
X_2057_ _2059_/S VDD VSS _3090_/D _3306_/Q _3090_/Q VDD VSS gf180mcu_fd_sc_mcu7t5v0__mux2_2
XFILLER_22_311 VDD VSS VDD VSS gf180mcu_fd_sc_mcu7t5v0__fillcap_4
XFILLER_34_171 VDD VSS VDD VSS gf180mcu_fd_sc_mcu7t5v0__fillcap_4
XFILLER_179_198 VDD VSS VDD VSS gf180mcu_fd_sc_mcu7t5v0__fillcap_8
X_2959_ VDD _2959_/Q _2963_/CLK VSS _2959_/D VDD VSS gf180mcu_fd_sc_mcu7t5v0__dffq_1
XFILLER_191_842 VDD VSS VDD VSS gf180mcu_fd_sc_mcu7t5v0__fillcap_32
XFILLER_249_136 VDD VSS VDD VSS gf180mcu_fd_sc_mcu7t5v0__fillcap_4
XFILLER_104_699 VDD VSS VDD VSS gf180mcu_fd_sc_mcu7t5v0__fillcap_32
XFILLER_58_731 VDD VSS VDD VSS gf180mcu_fd_sc_mcu7t5v0__fillcap_4
XFILLER_167_2 VDD VSS VDD VSS gf180mcu_fd_sc_mcu7t5v0__fillcap_32
XFILLER_122_52 VDD VSS VDD VSS gf180mcu_fd_sc_mcu7t5v0__fillcap_32
XFILLER_26_661 VDD VSS VDD VSS gf180mcu_fd_sc_mcu7t5v0__fillcap_4
XFILLER_14_801 VDD VSS VDD VSS gf180mcu_fd_sc_mcu7t5v0__fillcap_4
XFILLER_82_45 VDD VSS VDD VSS gf180mcu_fd_sc_mcu7t5v0__fillcap_4
XFILLER_72_299 VDD VSS VDD VSS gf180mcu_fd_sc_mcu7t5v0__fillcap_16
XFILLER_15_72 VDD VSS VDD VSS gf180mcu_fd_sc_mcu7t5v0__fillcap_64
XFILLER_201_478 VDD VSS VDD VSS gf180mcu_fd_sc_mcu7t5v0__fillcap_8
XFILLER_181_352 VDD VSS VDD VSS gf180mcu_fd_sc_mcu7t5v0__fillcap_4
XFILLER_141_205 VDD VSS VDD VSS gf180mcu_fd_sc_mcu7t5v0__fillcap_4
XFILLER_268_478 VDD VSS VDD VSS gf180mcu_fd_sc_mcu7t5v0__fillcap_32
XFILLER_48_241 VDD VSS VDD VSS gf180mcu_fd_sc_mcu7t5v0__fillcap_4
XFILLER_16_171 VDD VSS VDD VSS gf180mcu_fd_sc_mcu7t5v0__fillcap_4
X_2813_ VDD _2813_/Q _3370_/CLK VSS _2813_/D VDD VSS gf180mcu_fd_sc_mcu7t5v0__dffq_1
XFILLER_258_37 VDD VSS VDD VSS gf180mcu_fd_sc_mcu7t5v0__fillcap_64
XFILLER_145_500 VDD VSS VDD VSS gf180mcu_fd_sc_mcu7t5v0__fillcap_4
XFILLER_157_360 VDD VSS VDD VSS gf180mcu_fd_sc_mcu7t5v0__fillcap_8
X_2744_ _2743_/Z VSS VDD _2740_/Z _2742_/Z _2735_/S _2741_/Z _2744_/S1 _2744_/Z VDD
+ VSS gf180mcu_fd_sc_mcu7t5v0__mux4_1
XFILLER_173_842 VDD VSS VDD VSS gf180mcu_fd_sc_mcu7t5v0__fillcap_32
XFILLER_185_691 VDD VSS VDD VSS gf180mcu_fd_sc_mcu7t5v0__fillcap_8
XFILLER_8_381 VDD VSS VDD VSS gf180mcu_fd_sc_mcu7t5v0__fillcap_4
X_2675_ _3022_/Q VSS VDD _3006_/Q _3014_/Q _2730_/S0 _2998_/Q wire60/I _2675_/Z VDD
+ VSS gf180mcu_fd_sc_mcu7t5v0__mux4_1
X_1626_ _1626_/A3 VDD VSS _1628_/A2 _1622_/Z _1626_/A2 VDD VSS gf180mcu_fd_sc_mcu7t5v0__nand3_1
X_1557_ VDD VSS _1569_/A4 _3143_/Q _3144_/Q VDD VSS gf180mcu_fd_sc_mcu7t5v0__nor2_1
XFILLER_141_772 VDD VSS VDD VSS gf180mcu_fd_sc_mcu7t5v0__fillcap_64
XFILLER_98_152 VDD VSS VDD VSS gf180mcu_fd_sc_mcu7t5v0__fillcap_4
X_1488_ VDD VSS _1492_/A2 _3423_/Q _1484_/Z VDD VSS gf180mcu_fd_sc_mcu7t5v0__nand2_1
XFILLER_140_293 VDD VSS VDD VSS gf180mcu_fd_sc_mcu7t5v0__fillcap_8
XFILLER_101_647 VDD VSS VDD VSS gf180mcu_fd_sc_mcu7t5v0__fillcap_32
XFILLER_100_146 VDD VSS VDD VSS gf180mcu_fd_sc_mcu7t5v0__fillcap_16
X_3227_ _3227_/D _3227_/Q _3455_/RN VSS _3274_/CLK VDD VDD VSS gf180mcu_fd_sc_mcu7t5v0__dffrnq_1
X_3158_ _3158_/D _3158_/Q wire147/I VSS _3159_/CLK VDD VDD VSS gf180mcu_fd_sc_mcu7t5v0__dffrnq_1
X_2109_ _2109_/A3 VDD VSS _2110_/B _3111_/Q _2120_/B VDD VSS gf180mcu_fd_sc_mcu7t5v0__nand3_1
XFILLER_215_548 VDD VSS VDD VSS gf180mcu_fd_sc_mcu7t5v0__fillcap_8
XFILLER_82_597 VDD VSS VDD VSS gf180mcu_fd_sc_mcu7t5v0__fillcap_64
XFILLER_70_737 VDD VSS VDD VSS gf180mcu_fd_sc_mcu7t5v0__fillcap_64
X_3089_ _3089_/D _3089_/Q _3335_/RN VSS _3329_/CLK VDD VDD VSS gf180mcu_fd_sc_mcu7t5v0__dffrnq_1
XFILLER_195_422 VDD VSS VDD VSS gf180mcu_fd_sc_mcu7t5v0__fillcap_8
XFILLER_52_37 VDD VSS VDD VSS gf180mcu_fd_sc_mcu7t5v0__fillcap_64
XFILLER_168_37 VDD VSS VDD VSS gf180mcu_fd_sc_mcu7t5v0__fillcap_8
XFILLER_108_213 VDD VSS VDD VSS gf180mcu_fd_sc_mcu7t5v0__fillcap_32
XFILLER_163_352 VDD VSS VDD VSS gf180mcu_fd_sc_mcu7t5v0__fillcap_32
XFILLER_77_314 VDD VSS VDD VSS gf180mcu_fd_sc_mcu7t5v0__fillcap_16
XFILLER_117_96 VDD VSS VDD VSS gf180mcu_fd_sc_mcu7t5v0__fillcap_4
XFILLER_131_282 VDD VSS VDD VSS gf180mcu_fd_sc_mcu7t5v0__fillcap_4
XFILLER_131_293 VDD VSS VDD VSS gf180mcu_fd_sc_mcu7t5v0__fillcap_8
XFILLER_92_317 VDD VSS VDD VSS gf180mcu_fd_sc_mcu7t5v0__fillcap_32
XFILLER_261_632 VDD VSS VDD VSS gf180mcu_fd_sc_mcu7t5v0__fillcap_64
XFILLER_93_55 VDD VSS VDD VSS gf180mcu_fd_sc_mcu7t5v0__fillcap_8
XFILLER_93_88 VDD VSS VDD VSS gf180mcu_fd_sc_mcu7t5v0__fillcap_4
XFILLER_199_772 VDD VSS VDD VSS gf180mcu_fd_sc_mcu7t5v0__fillcap_64
XFILLER_60_247 VDD VSS VDD VSS gf180mcu_fd_sc_mcu7t5v0__fillcap_64
XFILLER_155_842 VDD VSS VDD VSS gf180mcu_fd_sc_mcu7t5v0__fillcap_32
XFILLER_170_801 VDD VSS VDD VSS gf180mcu_fd_sc_mcu7t5v0__fillcap_4
X_2460_ _2899_/Q VSS VDD _2883_/Q _2891_/Q _2460_/S0 _2875_/Q _2460_/S1 _2460_/Z VDD
+ VSS gf180mcu_fd_sc_mcu7t5v0__mux4_1
XFILLER_6_885 VDD VSS VDD VSS gf180mcu_fd_sc_mcu7t5v0__fillcap_4
X_1411_ VDD VSS _3114_/Q _2121_/A1 VDD VSS gf180mcu_fd_sc_mcu7t5v0__clkinv_1
X_2391_ _3382_/Q VDD VSS _2392_/A2 _2459_/A1 _2390_/Z VDD VSS gf180mcu_fd_sc_mcu7t5v0__aoi21_1
XFILLER_96_612 VDD VSS VDD VSS gf180mcu_fd_sc_mcu7t5v0__fillcap_8
XFILLER_123_772 VDD VSS VDD VSS gf180mcu_fd_sc_mcu7t5v0__fillcap_64
XFILLER_150_580 VDD VSS VDD VSS gf180mcu_fd_sc_mcu7t5v0__fillcap_8
XFILLER_96_656 VDD VSS VDD VSS gf180mcu_fd_sc_mcu7t5v0__fillcap_8
XFILLER_95_122 VDD VSS VDD VSS gf180mcu_fd_sc_mcu7t5v0__fillcap_8
XFILLER_84_807 VDD VSS VDD VSS gf180mcu_fd_sc_mcu7t5v0__fillcap_64
X_3012_ VDD _3012_/Q _3012_/CLK VSS _3012_/D VDD VSS gf180mcu_fd_sc_mcu7t5v0__dffq_1
XFILLER_209_331 VDD VSS VDD VSS gf180mcu_fd_sc_mcu7t5v0__fillcap_16
XFILLER_190_90 VDD VSS VDD VSS gf180mcu_fd_sc_mcu7t5v0__fillcap_8
Xwire37 VSS wire37/Z wire37/I VDD VDD VSS gf180mcu_fd_sc_mcu7t5v0__buf_2
Xwire59 wire59/Z VSS VDD wire59/I VDD VSS gf180mcu_fd_sc_mcu7t5v0__clkbuf_3
XFILLER_251_142 VDD VSS VDD VSS gf180mcu_fd_sc_mcu7t5v0__fillcap_64
XFILLER_64_597 VDD VSS VDD VSS gf180mcu_fd_sc_mcu7t5v0__fillcap_64
XFILLER_52_737 VDD VSS VDD VSS gf180mcu_fd_sc_mcu7t5v0__fillcap_64
XFILLER_177_422 VDD VSS VDD VSS gf180mcu_fd_sc_mcu7t5v0__fillcap_8
XFILLER_189_282 VDD VSS VDD VSS gf180mcu_fd_sc_mcu7t5v0__fillcap_4
XFILLER_192_414 VDD VSS VDD VSS gf180mcu_fd_sc_mcu7t5v0__fillcap_32
XFILLER_20_667 VDD VSS VDD VSS gf180mcu_fd_sc_mcu7t5v0__fillcap_64
X_2727_ _2727_/A3 VDD VSS _3315_/D _2727_/A1 _2727_/A2 VDD VSS gf180mcu_fd_sc_mcu7t5v0__nand3_1
XFILLER_160_311 VDD VSS VDD VSS gf180mcu_fd_sc_mcu7t5v0__fillcap_4
XFILLER_118_577 VDD VSS VDD VSS gf180mcu_fd_sc_mcu7t5v0__fillcap_16
XFILLER_105_205 VDD VSS VDD VSS gf180mcu_fd_sc_mcu7t5v0__fillcap_4
X_2658_ _3021_/Q VSS VDD _3005_/Q _3013_/Q _2743_/S0 _2997_/Q _2743_/S1 _2658_/Z VDD
+ VSS gf180mcu_fd_sc_mcu7t5v0__mux4_1
X_1609_ VDD VSS _1609_/Z _3397_/Q _3373_/D VDD VSS gf180mcu_fd_sc_mcu7t5v0__xor2_1
X_2589_ wire12/Z VDD VSS _3257_/D _3249_/Q _3257_/Q VDD VSS gf180mcu_fd_sc_mcu7t5v0__mux2_2
XFILLER_101_422 VDD VSS VDD VSS gf180mcu_fd_sc_mcu7t5v0__fillcap_64
XFILLER_113_271 VDD VSS VDD VSS gf180mcu_fd_sc_mcu7t5v0__fillcap_8
XFILLER_74_317 VDD VSS VDD VSS gf180mcu_fd_sc_mcu7t5v0__fillcap_4
XFILLER_86_177 VDD VSS VDD VSS gf180mcu_fd_sc_mcu7t5v0__fillcap_8
XFILLER_243_632 VDD VSS VDD VSS gf180mcu_fd_sc_mcu7t5v0__fillcap_64
XFILLER_255_492 VDD VSS VDD VSS gf180mcu_fd_sc_mcu7t5v0__fillcap_64
XFILLER_103_54 VDD VSS VDD VSS gf180mcu_fd_sc_mcu7t5v0__fillcap_4
XFILLER_187_219 VDD VSS VDD VSS gf180mcu_fd_sc_mcu7t5v0__fillcap_32
XFILLER_42_247 VDD VSS VDD VSS gf180mcu_fd_sc_mcu7t5v0__fillcap_64
XFILLER_195_252 VDD VSS VDD VSS gf180mcu_fd_sc_mcu7t5v0__fillcap_16
XFILLER_137_842 VDD VSS VDD VSS gf180mcu_fd_sc_mcu7t5v0__fillcap_32
XFILLER_10_177 VDD VSS VDD VSS gf180mcu_fd_sc_mcu7t5v0__fillcap_64
Xmax_length134 VSS wire133/I _3122_/Q VDD VDD VSS gf180mcu_fd_sc_mcu7t5v0__buf_2
XFILLER_164_650 VDD VSS VDD VSS gf180mcu_fd_sc_mcu7t5v0__fillcap_8
XFILLER_152_801 VDD VSS VDD VSS gf180mcu_fd_sc_mcu7t5v0__fillcap_4
Xmax_length167 _3339_/RN wire165/I VDD VSS VDD VSS gf180mcu_fd_sc_mcu7t5v0__buf_8
Xmax_length156 _3452_/RN _3335_/RN VDD VSS VDD VSS gf180mcu_fd_sc_mcu7t5v0__buf_8
XFILLER_88_22 VDD VSS VDD VSS gf180mcu_fd_sc_mcu7t5v0__fillcap_8
XFILLER_151_377 VDD VSS VDD VSS gf180mcu_fd_sc_mcu7t5v0__fillcap_16
XFILLER_105_772 VDD VSS VDD VSS gf180mcu_fd_sc_mcu7t5v0__fillcap_64
XFILLER_2_387 VDD VSS VDD VSS gf180mcu_fd_sc_mcu7t5v0__fillcap_64
XFILLER_132_591 VDD VSS VDD VSS gf180mcu_fd_sc_mcu7t5v0__fillcap_4
XFILLER_120_731 VDD VSS VDD VSS gf180mcu_fd_sc_mcu7t5v0__fillcap_4
XFILLER_265_212 VDD VSS VDD VSS gf180mcu_fd_sc_mcu7t5v0__fillcap_64
XFILLER_66_807 VDD VSS VDD VSS gf180mcu_fd_sc_mcu7t5v0__fillcap_64
XFILLER_78_667 VDD VSS VDD VSS gf180mcu_fd_sc_mcu7t5v0__fillcap_64
XFILLER_93_626 VDD VSS VDD VSS gf180mcu_fd_sc_mcu7t5v0__fillcap_4
XFILLER_219_695 VDD VSS VDD VSS gf180mcu_fd_sc_mcu7t5v0__fillcap_4
XFILLER_233_142 VDD VSS VDD VSS gf180mcu_fd_sc_mcu7t5v0__fillcap_64
XFILLER_46_597 VDD VSS VDD VSS gf180mcu_fd_sc_mcu7t5v0__fillcap_64
XFILLER_34_737 VDD VSS VDD VSS gf180mcu_fd_sc_mcu7t5v0__fillcap_64
XFILLER_61_556 VDD VSS VDD VSS gf180mcu_fd_sc_mcu7t5v0__fillcap_4
XFILLER_159_422 VDD VSS VDD VSS gf180mcu_fd_sc_mcu7t5v0__fillcap_8
X_1960_ _1963_/S VDD VSS _3009_/D _2015_/I0 _3009_/Q VDD VSS gf180mcu_fd_sc_mcu7t5v0__mux2_2
XFILLER_230_871 VDD VSS VDD VSS gf180mcu_fd_sc_mcu7t5v0__fillcap_4
X_1891_ _1891_/S VDD VSS _2950_/D _2950_/Q wire123/I VDD VSS gf180mcu_fd_sc_mcu7t5v0__mux2_2
XFILLER_127_352 VDD VSS VDD VSS gf180mcu_fd_sc_mcu7t5v0__fillcap_32
X_2512_ _2517_/C1 _3341_/Q VDD VSS _2514_/A3 _3333_/Q _2554_/A2 VDD VSS gf180mcu_fd_sc_mcu7t5v0__aoi22_1
XFILLER_154_171 VDD VSS VDD VSS gf180mcu_fd_sc_mcu7t5v0__fillcap_4
X_2443_ _2834_/Q VSS VDD _2818_/Q _2826_/Q _1519_/B _2810_/Q wire76/I _2443_/Z VDD
+ VSS gf180mcu_fd_sc_mcu7t5v0__mux4_1
XFILLER_45_2 VDD VSS VDD VSS gf180mcu_fd_sc_mcu7t5v0__fillcap_64
XFILLER_257_702 VDD VSS VDD VSS gf180mcu_fd_sc_mcu7t5v0__fillcap_64
X_2374_ _2893_/Q VSS VDD _2877_/Q _2885_/Q _2427_/S0 _2869_/Q _2460_/S1 _2374_/Z VDD
+ VSS gf180mcu_fd_sc_mcu7t5v0__mux4_1
XFILLER_110_230 VDD VSS VDD VSS gf180mcu_fd_sc_mcu7t5v0__fillcap_8
XFILLER_68_177 VDD VSS VDD VSS gf180mcu_fd_sc_mcu7t5v0__fillcap_64
XFILLER_96_497 VDD VSS VDD VSS gf180mcu_fd_sc_mcu7t5v0__fillcap_4
XFILLER_56_317 VDD VSS VDD VSS gf180mcu_fd_sc_mcu7t5v0__fillcap_64
XFILLER_209_161 VDD VSS VDD VSS gf180mcu_fd_sc_mcu7t5v0__fillcap_8
XFILLER_225_632 VDD VSS VDD VSS gf180mcu_fd_sc_mcu7t5v0__fillcap_64
XFILLER_237_492 VDD VSS VDD VSS gf180mcu_fd_sc_mcu7t5v0__fillcap_64
XFILLER_252_451 VDD VSS VDD VSS gf180mcu_fd_sc_mcu7t5v0__fillcap_4
XFILLER_24_247 VDD VSS VDD VSS gf180mcu_fd_sc_mcu7t5v0__fillcap_64
XFILLER_178_731 VDD VSS VDD VSS gf180mcu_fd_sc_mcu7t5v0__fillcap_4
XFILLER_229_72 VDD VSS VDD VSS gf180mcu_fd_sc_mcu7t5v0__fillcap_64
XFILLER_119_842 VDD VSS VDD VSS gf180mcu_fd_sc_mcu7t5v0__fillcap_32
XFILLER_134_801 VDD VSS VDD VSS gf180mcu_fd_sc_mcu7t5v0__fillcap_4
XFILLER_160_185 VDD VSS VDD VSS gf180mcu_fd_sc_mcu7t5v0__fillcap_4
XFILLER_114_591 VDD VSS VDD VSS gf180mcu_fd_sc_mcu7t5v0__fillcap_4
XFILLER_247_212 VDD VSS VDD VSS gf180mcu_fd_sc_mcu7t5v0__fillcap_64
XFILLER_48_807 VDD VSS VDD VSS gf180mcu_fd_sc_mcu7t5v0__fillcap_64
XFILLER_75_626 VDD VSS VDD VSS gf180mcu_fd_sc_mcu7t5v0__fillcap_4
XFILLER_114_53 VDD VSS VDD VSS gf180mcu_fd_sc_mcu7t5v0__fillcap_8
Xclkbuf_leaf_30_clk_i _3364_/CLK VSS VDD clkload5/I VDD VSS gf180mcu_fd_sc_mcu7t5v0__clkbuf_2
XFILLER_215_142 VDD VSS VDD VSS gf180mcu_fd_sc_mcu7t5v0__fillcap_64
XFILLER_215_131 VDD VSS VDD VSS gf180mcu_fd_sc_mcu7t5v0__fillcap_8
XFILLER_28_597 VDD VSS VDD VSS gf180mcu_fd_sc_mcu7t5v0__fillcap_64
XFILLER_16_737 VDD VSS VDD VSS gf180mcu_fd_sc_mcu7t5v0__fillcap_64
XFILLER_230_101 VDD VSS VDD VSS gf180mcu_fd_sc_mcu7t5v0__fillcap_4
XFILLER_43_556 VDD VSS VDD VSS gf180mcu_fd_sc_mcu7t5v0__fillcap_4
XFILLER_247_2 VDD VSS VDD VSS gf180mcu_fd_sc_mcu7t5v0__fillcap_64
XFILLER_90_45 VDD VSS VDD VSS gf180mcu_fd_sc_mcu7t5v0__fillcap_4
XFILLER_212_871 VDD VSS VDD VSS gf180mcu_fd_sc_mcu7t5v0__fillcap_4
Xclkbuf_leaf_45_clk_i _3443_/CLK VSS VDD clkload2/I VDD VSS gf180mcu_fd_sc_mcu7t5v0__clkbuf_2
XFILLER_196_583 VDD VSS VDD VSS gf180mcu_fd_sc_mcu7t5v0__fillcap_4
XFILLER_23_72 VDD VSS VDD VSS gf180mcu_fd_sc_mcu7t5v0__fillcap_64
XFILLER_139_72 VDD VSS VDD VSS gf180mcu_fd_sc_mcu7t5v0__fillcap_32
XFILLER_11_486 VDD VSS VDD VSS gf180mcu_fd_sc_mcu7t5v0__fillcap_4
XFILLER_109_352 VDD VSS VDD VSS gf180mcu_fd_sc_mcu7t5v0__fillcap_64
XFILLER_239_702 VDD VSS VDD VSS gf180mcu_fd_sc_mcu7t5v0__fillcap_64
XFILLER_3_696 VDD VSS VDD VSS gf180mcu_fd_sc_mcu7t5v0__fillcap_4
XFILLER_266_521 VDD VSS VDD VSS gf180mcu_fd_sc_mcu7t5v0__fillcap_4
XFILLER_38_317 VDD VSS VDD VSS gf180mcu_fd_sc_mcu7t5v0__fillcap_64
X_2090_ _3105_/Q _3104_/Q VDD VSS _2090_/Z _3103_/Q _3102_/Q VDD VSS gf180mcu_fd_sc_mcu7t5v0__and4_1
XFILLER_65_136 VDD VSS VDD VSS gf180mcu_fd_sc_mcu7t5v0__fillcap_4
XFILLER_219_492 VDD VSS VDD VSS gf180mcu_fd_sc_mcu7t5v0__fillcap_16
XFILLER_207_632 VDD VSS VDD VSS gf180mcu_fd_sc_mcu7t5v0__fillcap_16
XFILLER_234_451 VDD VSS VDD VSS gf180mcu_fd_sc_mcu7t5v0__fillcap_4
X_2992_ VDD _2992_/Q _3006_/CLK VSS _2992_/D VDD VSS gf180mcu_fd_sc_mcu7t5v0__dffq_1
XFILLER_21_206 VDD VSS VDD VSS gf180mcu_fd_sc_mcu7t5v0__fillcap_4
X_1943_ _1944_/S VDD VSS _2995_/D wire114/I _2995_/Q VDD VSS gf180mcu_fd_sc_mcu7t5v0__mux2_2
X_1874_ _1877_/S VDD VSS _2937_/D _2937_/Q _3179_/Q VDD VSS gf180mcu_fd_sc_mcu7t5v0__mux2_2
XFILLER_266_37 VDD VSS VDD VSS gf180mcu_fd_sc_mcu7t5v0__fillcap_64
XFILLER_190_737 VDD VSS VDD VSS gf180mcu_fd_sc_mcu7t5v0__fillcap_4
XFILLER_116_801 VDD VSS VDD VSS gf180mcu_fd_sc_mcu7t5v0__fillcap_4
X_2426_ _2865_/Q VSS VDD _2849_/Q _2857_/Q _2454_/S0 _2841_/Q _2454_/S1 _2426_/Z VDD
+ VSS gf180mcu_fd_sc_mcu7t5v0__mux4_1
XFILLER_88_239 VDD VSS VDD VSS gf180mcu_fd_sc_mcu7t5v0__fillcap_4
XFILLER_229_212 VDD VSS VDD VSS gf180mcu_fd_sc_mcu7t5v0__fillcap_64
X_2357_ _2345_/I _2360_/A1 _2357_/B2 VDD VSS _3193_/D _2359_/A1 _2357_/A2 VDD VSS
+ gf180mcu_fd_sc_mcu7t5v0__oai32_1
XFILLER_57_626 VDD VSS VDD VSS gf180mcu_fd_sc_mcu7t5v0__fillcap_4
XFILLER_69_486 VDD VSS VDD VSS gf180mcu_fd_sc_mcu7t5v0__fillcap_4
XFILLER_151_18 VDD VSS VDD VSS gf180mcu_fd_sc_mcu7t5v0__fillcap_8
X_2288_ _2288_/S VDD VSS _3181_/D _3181_/Q _3201_/Q VDD VSS gf180mcu_fd_sc_mcu7t5v0__mux2_2
XFILLER_213_624 VDD VSS VDD VSS gf180mcu_fd_sc_mcu7t5v0__fillcap_4
XFILLER_25_556 VDD VSS VDD VSS gf180mcu_fd_sc_mcu7t5v0__fillcap_4
XFILLER_213_679 VDD VSS VDD VSS gf180mcu_fd_sc_mcu7t5v0__fillcap_16
XFILLER_60_37 VDD VSS VDD VSS gf180mcu_fd_sc_mcu7t5v0__fillcap_64
XFILLER_176_37 VDD VSS VDD VSS gf180mcu_fd_sc_mcu7t5v0__fillcap_16
XFILLER_180_203 VDD VSS VDD VSS gf180mcu_fd_sc_mcu7t5v0__fillcap_4
XFILLER_180_247 VDD VSS VDD VSS gf180mcu_fd_sc_mcu7t5v0__fillcap_64
XFILLER_106_311 VDD VSS VDD VSS gf180mcu_fd_sc_mcu7t5v0__fillcap_4
XFILLER_248_521 VDD VSS VDD VSS gf180mcu_fd_sc_mcu7t5v0__fillcap_4
XFILLER_47_136 VDD VSS VDD VSS gf180mcu_fd_sc_mcu7t5v0__fillcap_4
XFILLER_200_885 VDD VSS VDD VSS gf180mcu_fd_sc_mcu7t5v0__fillcap_4
Xwire130 VSS wire130/Z _3124_/Q VDD VDD VSS gf180mcu_fd_sc_mcu7t5v0__buf_2
XFILLER_172_737 VDD VSS VDD VSS gf180mcu_fd_sc_mcu7t5v0__fillcap_64
Xwire163 wire163/Z VSS VDD wire163/I VDD VSS gf180mcu_fd_sc_mcu7t5v0__clkbuf_8
X_1590_ VDD VSS _1591_/B1 _1598_/A1 _1590_/A2 VDD VSS gf180mcu_fd_sc_mcu7t5v0__nor2_1
XFILLER_7_276 VDD VSS VDD VSS gf180mcu_fd_sc_mcu7t5v0__fillcap_4
XFILLER_124_141 VDD VSS VDD VSS gf180mcu_fd_sc_mcu7t5v0__fillcap_16
X_3260_ _3260_/D _3260_/Q wire165/I VSS _3446_/CLK VDD VDD VSS gf180mcu_fd_sc_mcu7t5v0__dffrnq_1
X_2211_ _2221_/S VDD VSS _3157_/D wire87/Z _3157_/Q VDD VSS gf180mcu_fd_sc_mcu7t5v0__mux2_2
X_3191_ _3191_/D _3191_/Q _3344_/RN VSS _3212_/CLK VDD VDD VSS gf180mcu_fd_sc_mcu7t5v0__dffrnq_1
XFILLER_39_626 VDD VSS VDD VSS gf180mcu_fd_sc_mcu7t5v0__fillcap_4
XFILLER_267_874 VDD VSS VDD VSS gf180mcu_fd_sc_mcu7t5v0__fillcap_16
X_2142_ VDD VSS _2143_/A2 _2142_/A1 _2142_/A2 VDD VSS gf180mcu_fd_sc_mcu7t5v0__nand2_1
X_2073_ _2274_/C VDD VSS _2125_/A2 _3118_/Q _2076_/A2 VDD VSS gf180mcu_fd_sc_mcu7t5v0__nor3_1
Xload_slew71 VSS _2743_/S0 _3420_/Q VDD VDD VSS gf180mcu_fd_sc_mcu7t5v0__buf_3
XFILLER_201_54 VDD VSS VDD VSS gf180mcu_fd_sc_mcu7t5v0__fillcap_16
X_2975_ VDD _2975_/Q _2994_/CLK VSS _2975_/D VDD VSS gf180mcu_fd_sc_mcu7t5v0__dffq_1
XFILLER_194_317 VDD VSS VDD VSS gf180mcu_fd_sc_mcu7t5v0__fillcap_8
X_1926_ _1926_/S VDD VSS _2980_/D wire113/Z _2980_/Q VDD VSS gf180mcu_fd_sc_mcu7t5v0__mux2_2
X_1857_ _1860_/S VDD VSS _2921_/D wire131/Z _2921_/Q VDD VSS gf180mcu_fd_sc_mcu7t5v0__mux2_2
X_1788_ _1795_/S VDD VSS _2861_/D _2861_/Q _1788_/I1 VDD VSS gf180mcu_fd_sc_mcu7t5v0__mux2_2
XFILLER_103_314 VDD VSS VDD VSS gf180mcu_fd_sc_mcu7t5v0__fillcap_8
X_3458_ _3458_/D _3458_/Q _3458_/RN VSS _3458_/CLK VDD VDD VSS gf180mcu_fd_sc_mcu7t5v0__dffrnq_1
XFILLER_130_122 VDD VSS VDD VSS gf180mcu_fd_sc_mcu7t5v0__fillcap_8
X_3389_ _3389_/D _3389_/Q wire161/Z VSS _3394_/CLK VDD VDD VSS gf180mcu_fd_sc_mcu7t5v0__dffrnq_1
X_2409_ VDD _2409_/B _1654_/Z _2410_/A2 wire110/Z VSS VDD VSS gf180mcu_fd_sc_mcu7t5v0__oai21_1
XFILLER_130_177 VDD VSS VDD VSS gf180mcu_fd_sc_mcu7t5v0__fillcap_32
XFILLER_258_885 VDD VSS VDD VSS gf180mcu_fd_sc_mcu7t5v0__fillcap_4
XFILLER_29_136 VDD VSS VDD VSS gf180mcu_fd_sc_mcu7t5v0__fillcap_4
XFILLER_260_527 VDD VSS VDD VSS gf180mcu_fd_sc_mcu7t5v0__fillcap_64
XFILLER_198_667 VDD VSS VDD VSS gf180mcu_fd_sc_mcu7t5v0__fillcap_16
XFILLER_201_616 VDD VSS VDD VSS gf180mcu_fd_sc_mcu7t5v0__fillcap_4
XFILLER_186_807 VDD VSS VDD VSS gf180mcu_fd_sc_mcu7t5v0__fillcap_64
XFILLER_111_87 VDD VSS VDD VSS gf180mcu_fd_sc_mcu7t5v0__fillcap_16
XFILLER_200_115 VDD VSS VDD VSS gf180mcu_fd_sc_mcu7t5v0__fillcap_4
XFILLER_153_203 VDD VSS VDD VSS gf180mcu_fd_sc_mcu7t5v0__fillcap_4
XFILLER_138_255 VDD VSS VDD VSS gf180mcu_fd_sc_mcu7t5v0__fillcap_16
XFILLER_166_597 VDD VSS VDD VSS gf180mcu_fd_sc_mcu7t5v0__fillcap_8
XFILLER_154_737 VDD VSS VDD VSS gf180mcu_fd_sc_mcu7t5v0__fillcap_64
XFILLER_107_620 VDD VSS VDD VSS gf180mcu_fd_sc_mcu7t5v0__fillcap_8
XFILLER_112_2 VDD VSS VDD VSS gf180mcu_fd_sc_mcu7t5v0__fillcap_16
XFILLER_110_807 VDD VSS VDD VSS gf180mcu_fd_sc_mcu7t5v0__fillcap_64
XFILLER_122_667 VDD VSS VDD VSS gf180mcu_fd_sc_mcu7t5v0__fillcap_64
XFILLER_249_874 VDD VSS VDD VSS gf180mcu_fd_sc_mcu7t5v0__fillcap_16
XFILLER_102_380 VDD VSS VDD VSS gf180mcu_fd_sc_mcu7t5v0__fillcap_4
XFILLER_91_702 VDD VSS VDD VSS gf180mcu_fd_sc_mcu7t5v0__fillcap_64
XFILLER_264_877 VDD VSS VDD VSS gf180mcu_fd_sc_mcu7t5v0__fillcap_8
XFILLER_189_678 VDD VSS VDD VSS gf180mcu_fd_sc_mcu7t5v0__fillcap_8
XFILLER_71_492 VDD VSS VDD VSS gf180mcu_fd_sc_mcu7t5v0__fillcap_64
XFILLER_188_177 VDD VSS VDD VSS gf180mcu_fd_sc_mcu7t5v0__fillcap_32
X_2760_ VDD VSS _3321_/D _2760_/A1 _2760_/A2 VDD VSS gf180mcu_fd_sc_mcu7t5v0__nand2_1
X_2691_ _2960_/Q VSS VDD _2944_/Q _2952_/Q _2718_/S0 _2936_/Q _2742_/S1 _2691_/Z VDD
+ VSS gf180mcu_fd_sc_mcu7t5v0__mux4_1
X_1711_ _1720_/A2 _1711_/A4 VDD VSS _1712_/C _2330_/A2 _2239_/C VDD VSS gf180mcu_fd_sc_mcu7t5v0__nor4_1
XFILLER_191_309 VDD VSS VDD VSS gf180mcu_fd_sc_mcu7t5v0__fillcap_32
XFILLER_184_372 VDD VSS VDD VSS gf180mcu_fd_sc_mcu7t5v0__fillcap_8
X_1642_ VDD VSS _2549_/A2 _3454_/D _3454_/Q VDD VSS gf180mcu_fd_sc_mcu7t5v0__nor2_1
XFILLER_144_247 VDD VSS VDD VSS gf180mcu_fd_sc_mcu7t5v0__fillcap_16
X_1573_ _1591_/B2 VDD VSS _1582_/B _1573_/A1 _1589_/B VDD VSS gf180mcu_fd_sc_mcu7t5v0__or3_1
XFILLER_125_483 VDD VSS VDD VSS gf180mcu_fd_sc_mcu7t5v0__fillcap_4
X_3312_ _3312_/D _3312_/Q wire165/Z VSS _3336_/CLK VDD VDD VSS gf180mcu_fd_sc_mcu7t5v0__dffrnq_1
XFILLER_100_306 VDD VSS VDD VSS gf180mcu_fd_sc_mcu7t5v0__fillcap_4
X_3243_ _3243_/D _3243_/Q _3455_/RN VSS clkload7/I VDD VDD VSS gf180mcu_fd_sc_mcu7t5v0__dffrnq_1
XFILLER_112_177 VDD VSS VDD VSS gf180mcu_fd_sc_mcu7t5v0__fillcap_16
X_3174_ _3174_/D _3174_/Q _3344_/RN VSS _3212_/CLK VDD VDD VSS gf180mcu_fd_sc_mcu7t5v0__dffrnq_1
X_2125_ VDD VSS _3117_/D _3117_/Q _2125_/A2 VDD VSS gf180mcu_fd_sc_mcu7t5v0__and2_1
XFILLER_81_212 VDD VSS VDD VSS gf180mcu_fd_sc_mcu7t5v0__fillcap_16
XFILLER_254_387 VDD VSS VDD VSS gf180mcu_fd_sc_mcu7t5v0__fillcap_64
XFILLER_242_527 VDD VSS VDD VSS gf180mcu_fd_sc_mcu7t5v0__fillcap_64
X_2056_ wire28/Z VDD VSS _3089_/D _3305_/Q _3089_/Q VDD VSS gf180mcu_fd_sc_mcu7t5v0__mux2_2
XFILLER_168_807 VDD VSS VDD VSS gf180mcu_fd_sc_mcu7t5v0__fillcap_64
X_2958_ VDD _2958_/Q _2958_/CLK VSS _2958_/D VDD VSS gf180mcu_fd_sc_mcu7t5v0__dffq_1
XFILLER_210_457 VDD VSS VDD VSS gf180mcu_fd_sc_mcu7t5v0__fillcap_64
X_1909_ VDD VSS _1914_/S _1465_/Z _1936_/A2 VDD VSS gf180mcu_fd_sc_mcu7t5v0__and2_1
X_2889_ VDD _2889_/Q _2899_/CLK VSS _2889_/D VDD VSS gf180mcu_fd_sc_mcu7t5v0__dffq_1
XFILLER_148_597 VDD VSS VDD VSS gf180mcu_fd_sc_mcu7t5v0__fillcap_4
XFILLER_136_737 VDD VSS VDD VSS gf180mcu_fd_sc_mcu7t5v0__fillcap_64
XFILLER_163_556 VDD VSS VDD VSS gf180mcu_fd_sc_mcu7t5v0__fillcap_4
XFILLER_237_72 VDD VSS VDD VSS gf180mcu_fd_sc_mcu7t5v0__fillcap_64
XFILLER_190_331 VDD VSS VDD VSS gf180mcu_fd_sc_mcu7t5v0__fillcap_4
XFILLER_150_239 VDD VSS VDD VSS gf180mcu_fd_sc_mcu7t5v0__fillcap_4
XFILLER_264_107 VDD VSS VDD VSS gf180mcu_fd_sc_mcu7t5v0__fillcap_64
XFILLER_131_486 VDD VSS VDD VSS gf180mcu_fd_sc_mcu7t5v0__fillcap_4
XFILLER_85_562 VDD VSS VDD VSS gf180mcu_fd_sc_mcu7t5v0__fillcap_64
XFILLER_73_702 VDD VSS VDD VSS gf180mcu_fd_sc_mcu7t5v0__fillcap_64
XFILLER_246_877 VDD VSS VDD VSS gf180mcu_fd_sc_mcu7t5v0__fillcap_8
XFILLER_261_836 VDD VSS VDD VSS gf180mcu_fd_sc_mcu7t5v0__fillcap_4
XFILLER_72_267 VDD VSS VDD VSS gf180mcu_fd_sc_mcu7t5v0__fillcap_32
XFILLER_53_492 VDD VSS VDD VSS gf180mcu_fd_sc_mcu7t5v0__fillcap_64
XFILLER_41_632 VDD VSS VDD VSS gf180mcu_fd_sc_mcu7t5v0__fillcap_64
XFILLER_158_317 VDD VSS VDD VSS gf180mcu_fd_sc_mcu7t5v0__fillcap_64
XFILLER_185_136 VDD VSS VDD VSS gf180mcu_fd_sc_mcu7t5v0__fillcap_4
XFILLER_154_567 VDD VSS VDD VSS gf180mcu_fd_sc_mcu7t5v0__fillcap_16
XFILLER_126_247 VDD VSS VDD VSS gf180mcu_fd_sc_mcu7t5v0__fillcap_16
XFILLER_31_72 VDD VSS VDD VSS gf180mcu_fd_sc_mcu7t5v0__fillcap_64
XFILLER_147_72 VDD VSS VDD VSS gf180mcu_fd_sc_mcu7t5v0__fillcap_8
XFILLER_181_364 VDD VSS VDD VSS gf180mcu_fd_sc_mcu7t5v0__fillcap_8
XFILLER_141_228 VDD VSS VDD VSS gf180mcu_fd_sc_mcu7t5v0__fillcap_8
XFILLER_1_772 VDD VSS VDD VSS gf180mcu_fd_sc_mcu7t5v0__fillcap_64
XFILLER_63_212 VDD VSS VDD VSS gf180mcu_fd_sc_mcu7t5v0__fillcap_64
XFILLER_236_387 VDD VSS VDD VSS gf180mcu_fd_sc_mcu7t5v0__fillcap_64
XFILLER_224_527 VDD VSS VDD VSS gf180mcu_fd_sc_mcu7t5v0__fillcap_64
XFILLER_251_346 VDD VSS VDD VSS gf180mcu_fd_sc_mcu7t5v0__fillcap_4
XFILLER_204_240 VDD VSS VDD VSS gf180mcu_fd_sc_mcu7t5v0__fillcap_4
XFILLER_31_142 VDD VSS VDD VSS gf180mcu_fd_sc_mcu7t5v0__fillcap_64
X_2812_ VDD _2812_/Q _2867_/CLK VSS _2812_/D VDD VSS gf180mcu_fd_sc_mcu7t5v0__dffq_1
XFILLER_176_147 VDD VSS VDD VSS gf180mcu_fd_sc_mcu7t5v0__fillcap_16
XFILLER_176_169 VDD VSS VDD VSS gf180mcu_fd_sc_mcu7t5v0__fillcap_4
X_2743_ _3060_/Q VSS VDD _3044_/Q _3052_/Q _2743_/S0 _3036_/Q _2743_/S1 _2743_/Z VDD
+ VSS gf180mcu_fd_sc_mcu7t5v0__mux4_1
XFILLER_75_2 VDD VSS VDD VSS gf180mcu_fd_sc_mcu7t5v0__fillcap_8
XFILLER_118_737 VDD VSS VDD VSS gf180mcu_fd_sc_mcu7t5v0__fillcap_64
XFILLER_145_578 VDD VSS VDD VSS gf180mcu_fd_sc_mcu7t5v0__fillcap_32
X_2674_ _2958_/Q VSS VDD _2942_/Q _2950_/Q _2741_/S0 _2934_/Q _2741_/S1 _2674_/Z VDD
+ VSS gf180mcu_fd_sc_mcu7t5v0__mux4_1
X_1625_ VDD VSS _1626_/A3 _3436_/Q _3412_/D VDD VSS gf180mcu_fd_sc_mcu7t5v0__xnor2_1
X_1556_ _1568_/A1 _1555_/Z VDD VSS _1556_/Z _3140_/Q _2179_/A1 VDD VSS gf180mcu_fd_sc_mcu7t5v0__or4_1
XFILLER_132_239 VDD VSS VDD VSS gf180mcu_fd_sc_mcu7t5v0__fillcap_4
XFILLER_99_632 VDD VSS VDD VSS gf180mcu_fd_sc_mcu7t5v0__fillcap_64
XFILLER_246_107 VDD VSS VDD VSS gf180mcu_fd_sc_mcu7t5v0__fillcap_64
X_1487_ VDD VSS _3417_/D wire59/I _1487_/A2 VDD VSS gf180mcu_fd_sc_mcu7t5v0__xnor2_1
X_3226_ _3226_/D _3226_/Q wire145/I VSS _3337_/CLK VDD VDD VSS gf180mcu_fd_sc_mcu7t5v0__dffrnq_1
XFILLER_55_702 VDD VSS VDD VSS gf180mcu_fd_sc_mcu7t5v0__fillcap_64
XFILLER_67_562 VDD VSS VDD VSS gf180mcu_fd_sc_mcu7t5v0__fillcap_64
XFILLER_228_877 VDD VSS VDD VSS gf180mcu_fd_sc_mcu7t5v0__fillcap_8
XFILLER_223_52 VDD VSS VDD VSS gf180mcu_fd_sc_mcu7t5v0__fillcap_8
X_3157_ _3157_/D _3157_/Q wire151/Z VSS _3166_/CLK VDD VDD VSS gf180mcu_fd_sc_mcu7t5v0__dffrnq_1
XFILLER_82_521 VDD VSS VDD VSS gf180mcu_fd_sc_mcu7t5v0__fillcap_4
XFILLER_243_836 VDD VSS VDD VSS gf180mcu_fd_sc_mcu7t5v0__fillcap_4
XFILLER_255_696 VDD VSS VDD VSS gf180mcu_fd_sc_mcu7t5v0__fillcap_4
XFILLER_215_516 VDD VSS VDD VSS gf180mcu_fd_sc_mcu7t5v0__fillcap_32
X_2108_ _2108_/B VDD VSS _3110_/D _2074_/Z _2108_/A2 VDD VSS gf180mcu_fd_sc_mcu7t5v0__aoi21_1
X_3088_ _3088_/D _3088_/Q _3339_/RN VSS _3339_/CLK VDD VDD VSS gf180mcu_fd_sc_mcu7t5v0__dffrnq_1
X_2039_ _2040_/S VDD VSS _3072_/D _3288_/Q _3072_/Q VDD VSS gf180mcu_fd_sc_mcu7t5v0__mux2_2
XFILLER_35_492 VDD VSS VDD VSS gf180mcu_fd_sc_mcu7t5v0__fillcap_64
XFILLER_23_632 VDD VSS VDD VSS gf180mcu_fd_sc_mcu7t5v0__fillcap_64
XFILLER_50_451 VDD VSS VDD VSS gf180mcu_fd_sc_mcu7t5v0__fillcap_4
XFILLER_211_766 VDD VSS VDD VSS gf180mcu_fd_sc_mcu7t5v0__fillcap_4
XFILLER_210_287 VDD VSS VDD VSS gf180mcu_fd_sc_mcu7t5v0__fillcap_8
XFILLER_191_640 VDD VSS VDD VSS gf180mcu_fd_sc_mcu7t5v0__fillcap_4
XFILLER_108_247 VDD VSS VDD VSS gf180mcu_fd_sc_mcu7t5v0__fillcap_4
XFILLER_184_37 VDD VSS VDD VSS gf180mcu_fd_sc_mcu7t5v0__fillcap_32
XFILLER_89_142 VDD VSS VDD VSS gf180mcu_fd_sc_mcu7t5v0__fillcap_16
XFILLER_265_416 VDD VSS VDD VSS gf180mcu_fd_sc_mcu7t5v0__fillcap_4
XFILLER_86_871 VDD VSS VDD VSS gf180mcu_fd_sc_mcu7t5v0__fillcap_4
XFILLER_206_527 VDD VSS VDD VSS gf180mcu_fd_sc_mcu7t5v0__fillcap_64
XFILLER_218_387 VDD VSS VDD VSS gf180mcu_fd_sc_mcu7t5v0__fillcap_16
XFILLER_45_212 VDD VSS VDD VSS gf180mcu_fd_sc_mcu7t5v0__fillcap_64
XFILLER_233_346 VDD VSS VDD VSS gf180mcu_fd_sc_mcu7t5v0__fillcap_4
XFILLER_214_582 VDD VSS VDD VSS gf180mcu_fd_sc_mcu7t5v0__fillcap_8
XFILLER_159_626 VDD VSS VDD VSS gf180mcu_fd_sc_mcu7t5v0__fillcap_4
XFILLER_13_142 VDD VSS VDD VSS gf180mcu_fd_sc_mcu7t5v0__fillcap_64
XFILLER_10_871 VDD VSS VDD VSS gf180mcu_fd_sc_mcu7t5v0__fillcap_4
XFILLER_5_352 VDD VSS VDD VSS gf180mcu_fd_sc_mcu7t5v0__fillcap_64
X_1410_ VDD VSS _3115_/Q _2123_/A1 VDD VSS gf180mcu_fd_sc_mcu7t5v0__clkinv_1
X_2390_ _2862_/Q VSS VDD _2846_/Q _2854_/Q wire78/Z _2838_/Q wire76/Z _2390_/Z VDD
+ VSS gf180mcu_fd_sc_mcu7t5v0__mux4_1
XFILLER_228_107 VDD VSS VDD VSS gf180mcu_fd_sc_mcu7t5v0__fillcap_64
XFILLER_49_562 VDD VSS VDD VSS gf180mcu_fd_sc_mcu7t5v0__fillcap_64
XFILLER_37_702 VDD VSS VDD VSS gf180mcu_fd_sc_mcu7t5v0__fillcap_64
X_3011_ VDD _3011_/Q _3022_/CLK VSS _3011_/D VDD VSS gf180mcu_fd_sc_mcu7t5v0__dffq_1
XFILLER_237_696 VDD VSS VDD VSS gf180mcu_fd_sc_mcu7t5v0__fillcap_4
XFILLER_225_836 VDD VSS VDD VSS gf180mcu_fd_sc_mcu7t5v0__fillcap_4
XFILLER_76_381 VDD VSS VDD VSS gf180mcu_fd_sc_mcu7t5v0__fillcap_4
XFILLER_64_521 VDD VSS VDD VSS gf180mcu_fd_sc_mcu7t5v0__fillcap_4
XFILLER_92_885 VDD VSS VDD VSS gf180mcu_fd_sc_mcu7t5v0__fillcap_4
XFILLER_17_492 VDD VSS VDD VSS gf180mcu_fd_sc_mcu7t5v0__fillcap_64
XFILLER_196_209 VDD VSS VDD VSS gf180mcu_fd_sc_mcu7t5v0__fillcap_32
XFILLER_177_401 VDD VSS VDD VSS gf180mcu_fd_sc_mcu7t5v0__fillcap_16
XFILLER_32_451 VDD VSS VDD VSS gf180mcu_fd_sc_mcu7t5v0__fillcap_4
XFILLER_149_136 VDD VSS VDD VSS gf180mcu_fd_sc_mcu7t5v0__fillcap_4
X_2726_ wire20/I _3067_/Q VDD VSS _2727_/A3 _3315_/Q _2749_/C VDD VSS gf180mcu_fd_sc_mcu7t5v0__aoi22_1
X_2657_ _2758_/A2 _2657_/B2 VDD VSS _2666_/A1 _3310_/Q _2749_/C VDD VSS gf180mcu_fd_sc_mcu7t5v0__aoi22_1
X_1608_ VDD VSS _1613_/B _3396_/Q _3372_/D VDD VSS gf180mcu_fd_sc_mcu7t5v0__xnor2_1
XFILLER_133_537 VDD VSS VDD VSS gf180mcu_fd_sc_mcu7t5v0__fillcap_4
X_2588_ _2596_/S VDD VSS _3256_/D _3248_/Q _3256_/Q VDD VSS gf180mcu_fd_sc_mcu7t5v0__mux2_2
X_1539_ _3275_/Q VDD VSS _2652_/A2 _3273_/Q _3274_/Q VDD VSS gf180mcu_fd_sc_mcu7t5v0__nor3_1
XFILLER_86_101 VDD VSS VDD VSS gf180mcu_fd_sc_mcu7t5v0__fillcap_4
XFILLER_247_416 VDD VSS VDD VSS gf180mcu_fd_sc_mcu7t5v0__fillcap_4
XFILLER_259_276 VDD VSS VDD VSS gf180mcu_fd_sc_mcu7t5v0__fillcap_4
X_3209_ _3209_/D _3209_/Q _3359_/RN VSS _3359_/CLK VDD VDD VSS gf180mcu_fd_sc_mcu7t5v0__dffrnq_1
XFILLER_68_871 VDD VSS VDD VSS gf180mcu_fd_sc_mcu7t5v0__fillcap_4
XFILLER_27_212 VDD VSS VDD VSS gf180mcu_fd_sc_mcu7t5v0__fillcap_64
XFILLER_95_690 VDD VSS VDD VSS gf180mcu_fd_sc_mcu7t5v0__fillcap_8
XFILLER_215_346 VDD VSS VDD VSS gf180mcu_fd_sc_mcu7t5v0__fillcap_4
XFILLER_83_874 VDD VSS VDD VSS gf180mcu_fd_sc_mcu7t5v0__fillcap_16
XFILLER_82_373 VDD VSS VDD VSS gf180mcu_fd_sc_mcu7t5v0__fillcap_8
XFILLER_168_434 VDD VSS VDD VSS gf180mcu_fd_sc_mcu7t5v0__fillcap_16
XFILLER_195_220 VDD VSS VDD VSS gf180mcu_fd_sc_mcu7t5v0__fillcap_32
XFILLER_10_101 VDD VSS VDD VSS gf180mcu_fd_sc_mcu7t5v0__fillcap_4
Xmax_length124 VSS wire123/I _3176_/Q VDD VDD VSS gf180mcu_fd_sc_mcu7t5v0__buf_2
XFILLER_12_30 VDD VSS VDD VSS gf180mcu_fd_sc_mcu7t5v0__fillcap_4
Xmax_length135 VSS _1864_/I0 _3121_/Q VDD VDD VSS gf180mcu_fd_sc_mcu7t5v0__buf_2
Xmax_length146 _3457_/RN wire147/Z VDD VSS VDD VSS gf180mcu_fd_sc_mcu7t5v0__buf_8
Xmax_length157 wire145/I _3335_/RN VDD VSS VDD VSS gf180mcu_fd_sc_mcu7t5v0__buf_12
Xmax_length168 wire165/I wire169/Z VDD VSS VDD VSS gf180mcu_fd_sc_mcu7t5v0__buf_8
XFILLER_2_311 VDD VSS VDD VSS gf180mcu_fd_sc_mcu7t5v0__fillcap_4
XFILLER_5_2 VDD VSS VDD VSS gf180mcu_fd_sc_mcu7t5v0__fillcap_64
XFILLER_19_702 VDD VSS VDD VSS gf180mcu_fd_sc_mcu7t5v0__fillcap_64
XFILLER_207_836 VDD VSS VDD VSS gf180mcu_fd_sc_mcu7t5v0__fillcap_4
XFILLER_46_521 VDD VSS VDD VSS gf180mcu_fd_sc_mcu7t5v0__fillcap_4
XFILLER_58_381 VDD VSS VDD VSS gf180mcu_fd_sc_mcu7t5v0__fillcap_4
XFILLER_92_148 VDD VSS VDD VSS gf180mcu_fd_sc_mcu7t5v0__fillcap_8
XFILLER_74_885 VDD VSS VDD VSS gf180mcu_fd_sc_mcu7t5v0__fillcap_4
XFILLER_160_94 VDD VSS VDD VSS gf180mcu_fd_sc_mcu7t5v0__fillcap_8
XFILLER_14_451 VDD VSS VDD VSS gf180mcu_fd_sc_mcu7t5v0__fillcap_4
X_1890_ _1891_/S VDD VSS _2949_/D _2949_/Q wire126/Z VDD VSS gf180mcu_fd_sc_mcu7t5v0__mux2_2
XFILLER_155_673 VDD VSS VDD VSS gf180mcu_fd_sc_mcu7t5v0__fillcap_16
X_2511_ _2525_/B1 _3325_/Q VDD VSS _2514_/A2 _3317_/Q _1640_/I VDD VSS gf180mcu_fd_sc_mcu7t5v0__aoi22_1
XFILLER_6_661 VDD VSS VDD VSS gf180mcu_fd_sc_mcu7t5v0__fillcap_4
XFILLER_170_654 VDD VSS VDD VSS gf180mcu_fd_sc_mcu7t5v0__fillcap_8
X_2442_ _2442_/S VDD VSS _2442_/Z _2440_/Z _2441_/Z VDD VSS gf180mcu_fd_sc_mcu7t5v0__mux2_2
XFILLER_102_209 VDD VSS VDD VSS gf180mcu_fd_sc_mcu7t5v0__fillcap_16
X_2373_ VDD VSS _2376_/A2 _2459_/A1 _2372_/Z VDD VSS gf180mcu_fd_sc_mcu7t5v0__nand2_1
XFILLER_38_2 VDD VSS VDD VSS gf180mcu_fd_sc_mcu7t5v0__fillcap_32
XFILLER_68_101 VDD VSS VDD VSS gf180mcu_fd_sc_mcu7t5v0__fillcap_4
XFILLER_229_416 VDD VSS VDD VSS gf180mcu_fd_sc_mcu7t5v0__fillcap_4
XFILLER_204_54 VDD VSS VDD VSS gf180mcu_fd_sc_mcu7t5v0__fillcap_16
XFILLER_65_874 VDD VSS VDD VSS gf180mcu_fd_sc_mcu7t5v0__fillcap_16
XFILLER_220_64 VDD VSS VDD VSS gf180mcu_fd_sc_mcu7t5v0__fillcap_4
XFILLER_80_877 VDD VSS VDD VSS gf180mcu_fd_sc_mcu7t5v0__fillcap_8
XFILLER_193_702 VDD VSS VDD VSS gf180mcu_fd_sc_mcu7t5v0__fillcap_4
XFILLER_149_18 VDD VSS VDD VSS gf180mcu_fd_sc_mcu7t5v0__fillcap_32
X_2709_ _2993_/Q VSS VDD _2977_/Q _2985_/Q _2743_/S0 _2969_/Q _2743_/S1 _2709_/Z VDD
+ VSS gf180mcu_fd_sc_mcu7t5v0__mux4_1
XFILLER_161_632 VDD VSS VDD VSS gf180mcu_fd_sc_mcu7t5v0__fillcap_64
XFILLER_245_72 VDD VSS VDD VSS gf180mcu_fd_sc_mcu7t5v0__fillcap_64
XFILLER_99_270 VDD VSS VDD VSS gf180mcu_fd_sc_mcu7t5v0__fillcap_8
XFILLER_58_37 VDD VSS VDD VSS gf180mcu_fd_sc_mcu7t5v0__fillcap_64
XFILLER_28_521 VDD VSS VDD VSS gf180mcu_fd_sc_mcu7t5v0__fillcap_4
XFILLER_56_885 VDD VSS VDD VSS gf180mcu_fd_sc_mcu7t5v0__fillcap_4
XFILLER_70_387 VDD VSS VDD VSS gf180mcu_fd_sc_mcu7t5v0__fillcap_64
XFILLER_142_2 VDD VSS VDD VSS gf180mcu_fd_sc_mcu7t5v0__fillcap_16
XFILLER_183_212 VDD VSS VDD VSS gf180mcu_fd_sc_mcu7t5v0__fillcap_4
XFILLER_151_142 VDD VSS VDD VSS gf180mcu_fd_sc_mcu7t5v0__fillcap_8
XFILLER_47_874 VDD VSS VDD VSS gf180mcu_fd_sc_mcu7t5v0__fillcap_16
XFILLER_93_479 VDD VSS VDD VSS gf180mcu_fd_sc_mcu7t5v0__fillcap_8
XFILLER_261_282 VDD VSS VDD VSS gf180mcu_fd_sc_mcu7t5v0__fillcap_64
XFILLER_62_877 VDD VSS VDD VSS gf180mcu_fd_sc_mcu7t5v0__fillcap_8
X_2991_ VDD _2991_/Q _3023_/CLK VSS _2991_/D VDD VSS gf180mcu_fd_sc_mcu7t5v0__dffq_1
XFILLER_175_702 VDD VSS VDD VSS gf180mcu_fd_sc_mcu7t5v0__fillcap_64
X_1942_ _1942_/S VDD VSS _2994_/D wire116/Z _2994_/Q VDD VSS gf180mcu_fd_sc_mcu7t5v0__mux2_2
X_1873_ _1877_/S VDD VSS _2936_/D _2936_/Q _3178_/Q VDD VSS gf180mcu_fd_sc_mcu7t5v0__mux2_2
XFILLER_127_150 VDD VSS VDD VSS gf180mcu_fd_sc_mcu7t5v0__fillcap_4
XFILLER_155_492 VDD VSS VDD VSS gf180mcu_fd_sc_mcu7t5v0__fillcap_64
XFILLER_143_632 VDD VSS VDD VSS gf180mcu_fd_sc_mcu7t5v0__fillcap_8
X_2425_ VDD VSS _2438_/B _3201_/Q _2467_/A1 VDD VSS gf180mcu_fd_sc_mcu7t5v0__nand2_1
X_2356_ VDD VSS _2360_/A1 _2362_/B _2356_/A2 VDD VSS gf180mcu_fd_sc_mcu7t5v0__nor2_1
XFILLER_111_562 VDD VSS VDD VSS gf180mcu_fd_sc_mcu7t5v0__fillcap_4
X_2287_ _2288_/S VDD VSS _3180_/D _2287_/I0 _3200_/Q VDD VSS gf180mcu_fd_sc_mcu7t5v0__mux2_2
XFILLER_84_457 VDD VSS VDD VSS gf180mcu_fd_sc_mcu7t5v0__fillcap_64
XFILLER_253_772 VDD VSS VDD VSS gf180mcu_fd_sc_mcu7t5v0__fillcap_64
XFILLER_38_885 VDD VSS VDD VSS gf180mcu_fd_sc_mcu7t5v0__fillcap_4
XFILLER_52_387 VDD VSS VDD VSS gf180mcu_fd_sc_mcu7t5v0__fillcap_64
XFILLER_213_647 VDD VSS VDD VSS gf180mcu_fd_sc_mcu7t5v0__fillcap_32
XFILLER_40_527 VDD VSS VDD VSS gf180mcu_fd_sc_mcu7t5v0__fillcap_64
XFILLER_114_6 VDD VSS VDD VSS gf180mcu_fd_sc_mcu7t5v0__fillcap_16
XFILLER_192_37 VDD VSS VDD VSS gf180mcu_fd_sc_mcu7t5v0__fillcap_16
XFILLER_130_871 VDD VSS VDD VSS gf180mcu_fd_sc_mcu7t5v0__fillcap_4
XFILLER_29_874 VDD VSS VDD VSS gf180mcu_fd_sc_mcu7t5v0__fillcap_16
XFILLER_62_107 VDD VSS VDD VSS gf180mcu_fd_sc_mcu7t5v0__fillcap_64
XFILLER_231_422 VDD VSS VDD VSS gf180mcu_fd_sc_mcu7t5v0__fillcap_64
XFILLER_243_282 VDD VSS VDD VSS gf180mcu_fd_sc_mcu7t5v0__fillcap_64
XFILLER_44_877 VDD VSS VDD VSS gf180mcu_fd_sc_mcu7t5v0__fillcap_8
XFILLER_70_162 VDD VSS VDD VSS gf180mcu_fd_sc_mcu7t5v0__fillcap_8
XFILLER_157_702 VDD VSS VDD VSS gf180mcu_fd_sc_mcu7t5v0__fillcap_64
XFILLER_71_696 VDD VSS VDD VSS gf180mcu_fd_sc_mcu7t5v0__fillcap_4
XFILLER_169_562 VDD VSS VDD VSS gf180mcu_fd_sc_mcu7t5v0__fillcap_16
Xwire131 VSS wire131/Z wire132/Z VDD VDD VSS gf180mcu_fd_sc_mcu7t5v0__buf_2
XFILLER_211_190 VDD VSS VDD VSS gf180mcu_fd_sc_mcu7t5v0__fillcap_16
XFILLER_129_437 VDD VSS VDD VSS gf180mcu_fd_sc_mcu7t5v0__fillcap_8
Xwire142 VSS wire142/Z _2802_/Q VDD VDD VSS gf180mcu_fd_sc_mcu7t5v0__clkbuf_1
Xwire153 wire153/Z VSS VDD wire153/I VDD VSS gf180mcu_fd_sc_mcu7t5v0__clkbuf_8
XFILLER_137_492 VDD VSS VDD VSS gf180mcu_fd_sc_mcu7t5v0__fillcap_8
XFILLER_125_632 VDD VSS VDD VSS gf180mcu_fd_sc_mcu7t5v0__fillcap_8
XFILLER_140_613 VDD VSS VDD VSS gf180mcu_fd_sc_mcu7t5v0__fillcap_4
XFILLER_98_527 VDD VSS VDD VSS gf180mcu_fd_sc_mcu7t5v0__fillcap_8
XFILLER_140_657 VDD VSS VDD VSS gf180mcu_fd_sc_mcu7t5v0__fillcap_8
X_2210_ _2219_/S VDD VSS _3156_/D wire88/Z _3156_/Q VDD VSS gf180mcu_fd_sc_mcu7t5v0__mux2_2
XFILLER_267_842 VDD VSS VDD VSS gf180mcu_fd_sc_mcu7t5v0__fillcap_32
X_3190_ _3190_/D _3190_/Q _3344_/RN VSS _3212_/CLK VDD VDD VSS gf180mcu_fd_sc_mcu7t5v0__dffrnq_1
XFILLER_182_92 VDD VSS VDD VSS gf180mcu_fd_sc_mcu7t5v0__fillcap_8
X_2141_ VDD VSS _2142_/A2 _3147_/Q _3148_/Q VDD VSS gf180mcu_fd_sc_mcu7t5v0__nand2_1
X_2072_ _2072_/S VDD VSS _3101_/D _3309_/Q _3101_/Q VDD VSS gf180mcu_fd_sc_mcu7t5v0__mux2_2
XFILLER_66_457 VDD VSS VDD VSS gf180mcu_fd_sc_mcu7t5v0__fillcap_64
XFILLER_93_298 VDD VSS VDD VSS gf180mcu_fd_sc_mcu7t5v0__fillcap_4
XFILLER_81_416 VDD VSS VDD VSS gf180mcu_fd_sc_mcu7t5v0__fillcap_4
XFILLER_235_772 VDD VSS VDD VSS gf180mcu_fd_sc_mcu7t5v0__fillcap_64
XFILLER_250_731 VDD VSS VDD VSS gf180mcu_fd_sc_mcu7t5v0__fillcap_4
XFILLER_262_591 VDD VSS VDD VSS gf180mcu_fd_sc_mcu7t5v0__fillcap_4
XFILLER_34_387 VDD VSS VDD VSS gf180mcu_fd_sc_mcu7t5v0__fillcap_64
XFILLER_201_99 VDD VSS VDD VSS gf180mcu_fd_sc_mcu7t5v0__fillcap_16
XFILLER_201_88 VDD VSS VDD VSS gf180mcu_fd_sc_mcu7t5v0__fillcap_4
X_2974_ VDD _2974_/Q clkload9/I VSS _2974_/D VDD VSS gf180mcu_fd_sc_mcu7t5v0__dffq_1
XFILLER_22_527 VDD VSS VDD VSS gf180mcu_fd_sc_mcu7t5v0__fillcap_64
XFILLER_188_871 VDD VSS VDD VSS gf180mcu_fd_sc_mcu7t5v0__fillcap_4
XFILLER_148_724 VDD VSS VDD VSS gf180mcu_fd_sc_mcu7t5v0__fillcap_8
X_1925_ _1926_/S VDD VSS _2979_/D wire114/I _2979_/Q VDD VSS gf180mcu_fd_sc_mcu7t5v0__mux2_2
XFILLER_147_212 VDD VSS VDD VSS gf180mcu_fd_sc_mcu7t5v0__fillcap_8
X_1856_ _1860_/S VDD VSS _2920_/D wire133/Z _2920_/Q VDD VSS gf180mcu_fd_sc_mcu7t5v0__mux2_2
XFILLER_147_256 VDD VSS VDD VSS gf180mcu_fd_sc_mcu7t5v0__fillcap_16
XFILLER_135_407 VDD VSS VDD VSS gf180mcu_fd_sc_mcu7t5v0__fillcap_8
X_1787_ VDD VSS _1795_/S _1861_/A1 _1787_/A2 VDD VSS gf180mcu_fd_sc_mcu7t5v0__and2_1
XFILLER_162_215 VDD VSS VDD VSS gf180mcu_fd_sc_mcu7t5v0__fillcap_16
XFILLER_226_30 VDD VSS VDD VSS gf180mcu_fd_sc_mcu7t5v0__fillcap_4
XFILLER_89_527 VDD VSS VDD VSS gf180mcu_fd_sc_mcu7t5v0__fillcap_4
XFILLER_130_101 VDD VSS VDD VSS gf180mcu_fd_sc_mcu7t5v0__fillcap_4
X_3457_ _3457_/D _3458_/D _3457_/RN VSS _3457_/CLK VDD VDD VSS gf180mcu_fd_sc_mcu7t5v0__dffrnq_1
XFILLER_170_281 VDD VSS VDD VSS gf180mcu_fd_sc_mcu7t5v0__fillcap_16
Xclkbuf_leaf_44_clk_i _3441_/CLK VSS VDD clkload2/I VDD VSS gf180mcu_fd_sc_mcu7t5v0__clkbuf_2
X_3388_ _3388_/D _3388_/Q wire161/Z VSS _3395_/CLK VDD VDD VSS gf180mcu_fd_sc_mcu7t5v0__dffrnq_1
X_2408_ _2408_/A3 VDD VSS _2409_/B _1654_/Z _2408_/A2 VDD VSS gf180mcu_fd_sc_mcu7t5v0__nand3_1
XFILLER_112_871 VDD VSS VDD VSS gf180mcu_fd_sc_mcu7t5v0__fillcap_4
XFILLER_130_145 VDD VSS VDD VSS gf180mcu_fd_sc_mcu7t5v0__fillcap_8
XFILLER_257_352 VDD VSS VDD VSS gf180mcu_fd_sc_mcu7t5v0__fillcap_64
X_2339_ _2339_/B VDD VSS _3190_/D _2339_/A1 _2339_/A2 VDD VSS gf180mcu_fd_sc_mcu7t5v0__aoi21_1
XFILLER_85_766 VDD VSS VDD VSS gf180mcu_fd_sc_mcu7t5v0__fillcap_4
XFILLER_44_107 VDD VSS VDD VSS gf180mcu_fd_sc_mcu7t5v0__fillcap_64
Xclkbuf_leaf_59_clk_i _3341_/CLK VSS VDD clkload2/I VDD VSS gf180mcu_fd_sc_mcu7t5v0__clkbuf_2
XFILLER_225_282 VDD VSS VDD VSS gf180mcu_fd_sc_mcu7t5v0__fillcap_64
XFILLER_26_877 VDD VSS VDD VSS gf180mcu_fd_sc_mcu7t5v0__fillcap_8
XFILLER_240_241 VDD VSS VDD VSS gf180mcu_fd_sc_mcu7t5v0__fillcap_4
XFILLER_41_836 VDD VSS VDD VSS gf180mcu_fd_sc_mcu7t5v0__fillcap_4
XFILLER_53_696 VDD VSS VDD VSS gf180mcu_fd_sc_mcu7t5v0__fillcap_4
XFILLER_139_702 VDD VSS VDD VSS gf180mcu_fd_sc_mcu7t5v0__fillcap_8
XFILLER_178_381 VDD VSS VDD VSS gf180mcu_fd_sc_mcu7t5v0__fillcap_4
XFILLER_194_885 VDD VSS VDD VSS gf180mcu_fd_sc_mcu7t5v0__fillcap_4
XFILLER_193_395 VDD VSS VDD VSS gf180mcu_fd_sc_mcu7t5v0__fillcap_4
XFILLER_107_632 VDD VSS VDD VSS gf180mcu_fd_sc_mcu7t5v0__fillcap_64
XFILLER_134_451 VDD VSS VDD VSS gf180mcu_fd_sc_mcu7t5v0__fillcap_4
XFILLER_4_247 VDD VSS VDD VSS gf180mcu_fd_sc_mcu7t5v0__fillcap_64
XFILLER_105_2 VDD VSS VDD VSS gf180mcu_fd_sc_mcu7t5v0__fillcap_16
XFILLER_249_842 VDD VSS VDD VSS gf180mcu_fd_sc_mcu7t5v0__fillcap_32
XFILLER_264_801 VDD VSS VDD VSS gf180mcu_fd_sc_mcu7t5v0__fillcap_4
XFILLER_121_189 VDD VSS VDD VSS gf180mcu_fd_sc_mcu7t5v0__fillcap_16
XFILLER_48_457 VDD VSS VDD VSS gf180mcu_fd_sc_mcu7t5v0__fillcap_64
XFILLER_29_72 VDD VSS VDD VSS gf180mcu_fd_sc_mcu7t5v0__fillcap_64
XFILLER_63_416 VDD VSS VDD VSS gf180mcu_fd_sc_mcu7t5v0__fillcap_4
XFILLER_217_772 VDD VSS VDD VSS gf180mcu_fd_sc_mcu7t5v0__fillcap_64
XFILLER_232_731 VDD VSS VDD VSS gf180mcu_fd_sc_mcu7t5v0__fillcap_4
XFILLER_244_591 VDD VSS VDD VSS gf180mcu_fd_sc_mcu7t5v0__fillcap_4
XFILLER_16_387 VDD VSS VDD VSS gf180mcu_fd_sc_mcu7t5v0__fillcap_64
XFILLER_31_346 VDD VSS VDD VSS gf180mcu_fd_sc_mcu7t5v0__fillcap_4
XFILLER_129_212 VDD VSS VDD VSS gf180mcu_fd_sc_mcu7t5v0__fillcap_8
XFILLER_185_874 VDD VSS VDD VSS gf180mcu_fd_sc_mcu7t5v0__fillcap_16
XFILLER_200_683 VDD VSS VDD VSS gf180mcu_fd_sc_mcu7t5v0__fillcap_4
X_1710_ _1710_/B _2488_/B VDD VSS _2802_/D _1720_/A2 _1710_/A2 VDD VSS gf180mcu_fd_sc_mcu7t5v0__aoi211_1
XFILLER_184_340 VDD VSS VDD VSS gf180mcu_fd_sc_mcu7t5v0__fillcap_32
X_2690_ _2690_/A3 _2689_/Z VDD VSS _3312_/D _2690_/A1 _2796_/A1 VDD VSS gf180mcu_fd_sc_mcu7t5v0__nand4_1
XFILLER_8_597 VDD VSS VDD VSS gf180mcu_fd_sc_mcu7t5v0__fillcap_64
X_1641_ _3222_/Q VDD VSS _2549_/A1 _3223_/Q _3221_/Q VDD VSS gf180mcu_fd_sc_mcu7t5v0__nand3_1
X_1572_ VDD VSS _1591_/B2 _3348_/Q _2470_/B VDD VSS gf180mcu_fd_sc_mcu7t5v0__nand2_1
X_3311_ _3311_/D _3311_/Q _3455_/RN VSS clkload7/I VDD VDD VSS gf180mcu_fd_sc_mcu7t5v0__dffrnq_1
XFILLER_99_836 VDD VSS VDD VSS gf180mcu_fd_sc_mcu7t5v0__fillcap_4
XFILLER_152_270 VDD VSS VDD VSS gf180mcu_fd_sc_mcu7t5v0__fillcap_8
X_3242_ _3242_/D _3242_/Q wire165/Z VSS _3336_/CLK VDD VDD VSS gf180mcu_fd_sc_mcu7t5v0__dffrnq_1
XFILLER_86_519 VDD VSS VDD VSS gf180mcu_fd_sc_mcu7t5v0__fillcap_4
X_3173_ _3173_/D _3173_/Q _3359_/RN VSS _3359_/CLK VDD VDD VSS gf180mcu_fd_sc_mcu7t5v0__dffrnq_1
XFILLER_239_352 VDD VSS VDD VSS gf180mcu_fd_sc_mcu7t5v0__fillcap_64
XFILLER_20_2 VDD VSS VDD VSS gf180mcu_fd_sc_mcu7t5v0__fillcap_32
XFILLER_254_311 VDD VSS VDD VSS gf180mcu_fd_sc_mcu7t5v0__fillcap_4
XFILLER_266_171 VDD VSS VDD VSS gf180mcu_fd_sc_mcu7t5v0__fillcap_4
X_2124_ VDD VSS _3116_/D _3116_/Q _2125_/A2 VDD VSS gf180mcu_fd_sc_mcu7t5v0__and2_1
XFILLER_67_766 VDD VSS VDD VSS gf180mcu_fd_sc_mcu7t5v0__fillcap_4
XFILLER_94_574 VDD VSS VDD VSS gf180mcu_fd_sc_mcu7t5v0__fillcap_4
XFILLER_26_107 VDD VSS VDD VSS gf180mcu_fd_sc_mcu7t5v0__fillcap_64
X_2055_ _2058_/S VDD VSS _3088_/D _3304_/Q _3088_/Q VDD VSS gf180mcu_fd_sc_mcu7t5v0__mux2_2
XFILLER_207_282 VDD VSS VDD VSS gf180mcu_fd_sc_mcu7t5v0__fillcap_64
XFILLER_222_241 VDD VSS VDD VSS gf180mcu_fd_sc_mcu7t5v0__fillcap_4
XFILLER_210_403 VDD VSS VDD VSS gf180mcu_fd_sc_mcu7t5v0__fillcap_8
XFILLER_35_696 VDD VSS VDD VSS gf180mcu_fd_sc_mcu7t5v0__fillcap_4
XFILLER_23_836 VDD VSS VDD VSS gf180mcu_fd_sc_mcu7t5v0__fillcap_4
XFILLER_148_521 VDD VSS VDD VSS gf180mcu_fd_sc_mcu7t5v0__fillcap_4
XFILLER_148_543 VDD VSS VDD VSS gf180mcu_fd_sc_mcu7t5v0__fillcap_8
X_2957_ VDD _2957_/Q _2958_/CLK VSS _2957_/D VDD VSS gf180mcu_fd_sc_mcu7t5v0__dffq_1
X_2888_ VDD _2888_/Q _2899_/CLK VSS _2888_/D VDD VSS gf180mcu_fd_sc_mcu7t5v0__dffq_1
XFILLER_176_885 VDD VSS VDD VSS gf180mcu_fd_sc_mcu7t5v0__fillcap_4
X_1908_ VDD VSS _1936_/A2 _3409_/Q _1945_/A2 VDD VSS gf180mcu_fd_sc_mcu7t5v0__nor2_1
XFILLER_108_418 VDD VSS VDD VSS gf180mcu_fd_sc_mcu7t5v0__fillcap_32
X_1839_ _1842_/S VDD VSS _2905_/D wire131/Z _2905_/Q VDD VSS gf180mcu_fd_sc_mcu7t5v0__mux2_2
XFILLER_135_204 VDD VSS VDD VSS gf180mcu_fd_sc_mcu7t5v0__fillcap_4
XFILLER_190_387 VDD VSS VDD VSS gf180mcu_fd_sc_mcu7t5v0__fillcap_64
XFILLER_116_473 VDD VSS VDD VSS gf180mcu_fd_sc_mcu7t5v0__fillcap_4
XFILLER_1_206 VDD VSS VDD VSS gf180mcu_fd_sc_mcu7t5v0__fillcap_4
XFILLER_173_39 VDD VSS VDD VSS gf180mcu_fd_sc_mcu7t5v0__fillcap_16
XFILLER_89_346 VDD VSS VDD VSS gf180mcu_fd_sc_mcu7t5v0__fillcap_4
XFILLER_246_801 VDD VSS VDD VSS gf180mcu_fd_sc_mcu7t5v0__fillcap_4
XFILLER_258_661 VDD VSS VDD VSS gf180mcu_fd_sc_mcu7t5v0__fillcap_4
XFILLER_253_72 VDD VSS VDD VSS gf180mcu_fd_sc_mcu7t5v0__fillcap_64
XFILLER_66_37 VDD VSS VDD VSS gf180mcu_fd_sc_mcu7t5v0__fillcap_64
XFILLER_100_885 VDD VSS VDD VSS gf180mcu_fd_sc_mcu7t5v0__fillcap_4
XFILLER_57_276 VDD VSS VDD VSS gf180mcu_fd_sc_mcu7t5v0__fillcap_4
XFILLER_45_416 VDD VSS VDD VSS gf180mcu_fd_sc_mcu7t5v0__fillcap_4
XFILLER_214_731 VDD VSS VDD VSS gf180mcu_fd_sc_mcu7t5v0__fillcap_4
XFILLER_226_591 VDD VSS VDD VSS gf180mcu_fd_sc_mcu7t5v0__fillcap_4
XFILLER_13_346 VDD VSS VDD VSS gf180mcu_fd_sc_mcu7t5v0__fillcap_4
XFILLER_201_458 VDD VSS VDD VSS gf180mcu_fd_sc_mcu7t5v0__fillcap_8
XFILLER_167_874 VDD VSS VDD VSS gf180mcu_fd_sc_mcu7t5v0__fillcap_16
XFILLER_222_2 VDD VSS VDD VSS gf180mcu_fd_sc_mcu7t5v0__fillcap_8
XFILLER_182_877 VDD VSS VDD VSS gf180mcu_fd_sc_mcu7t5v0__fillcap_8
XFILLER_126_237 VDD VSS VDD VSS gf180mcu_fd_sc_mcu7t5v0__fillcap_8
XFILLER_5_556 VDD VSS VDD VSS gf180mcu_fd_sc_mcu7t5v0__fillcap_4
XFILLER_163_72 VDD VSS VDD VSS gf180mcu_fd_sc_mcu7t5v0__fillcap_32
XFILLER_122_487 VDD VSS VDD VSS gf180mcu_fd_sc_mcu7t5v0__fillcap_32
XFILLER_236_311 VDD VSS VDD VSS gf180mcu_fd_sc_mcu7t5v0__fillcap_4
XFILLER_248_171 VDD VSS VDD VSS gf180mcu_fd_sc_mcu7t5v0__fillcap_4
XFILLER_49_766 VDD VSS VDD VSS gf180mcu_fd_sc_mcu7t5v0__fillcap_4
XFILLER_17_696 VDD VSS VDD VSS gf180mcu_fd_sc_mcu7t5v0__fillcap_4
XFILLER_177_616 VDD VSS VDD VSS gf180mcu_fd_sc_mcu7t5v0__fillcap_8
X_2811_ VDD _2811_/Q _3457_/CLK VSS _2811_/D VDD VSS gf180mcu_fd_sc_mcu7t5v0__dffq_1
XFILLER_158_885 VDD VSS VDD VSS gf180mcu_fd_sc_mcu7t5v0__fillcap_4
XFILLER_157_340 VDD VSS VDD VSS gf180mcu_fd_sc_mcu7t5v0__fillcap_8
X_2742_ _3028_/Q VSS VDD _3012_/Q _3020_/Q _2743_/S0 _3004_/Q _2742_/S1 _2742_/Z VDD
+ VSS gf180mcu_fd_sc_mcu7t5v0__mux4_1
XFILLER_117_204 VDD VSS VDD VSS gf180mcu_fd_sc_mcu7t5v0__fillcap_4
X_2673_ _2990_/Q VSS VDD _2974_/Q _2982_/Q _2740_/S0 _2966_/Q _2740_/S1 _2673_/Z VDD
+ VSS gf180mcu_fd_sc_mcu7t5v0__mux4_1
XFILLER_68_2 VDD VSS VDD VSS gf180mcu_fd_sc_mcu7t5v0__fillcap_32
XFILLER_172_387 VDD VSS VDD VSS gf180mcu_fd_sc_mcu7t5v0__fillcap_16
X_1624_ VDD VSS _1626_/A2 _3438_/Q _3414_/D VDD VSS gf180mcu_fd_sc_mcu7t5v0__xnor2_1
X_1555_ VDD VSS _1555_/Z _3138_/Q _3139_/Q VDD VSS gf180mcu_fd_sc_mcu7t5v0__and2_1
XFILLER_141_763 VDD VSS VDD VSS gf180mcu_fd_sc_mcu7t5v0__fillcap_4
XFILLER_228_801 VDD VSS VDD VSS gf180mcu_fd_sc_mcu7t5v0__fillcap_4
XFILLER_140_262 VDD VSS VDD VSS gf180mcu_fd_sc_mcu7t5v0__fillcap_16
X_3225_ _3225_/D _3225_/Q wire145/I VSS _3337_/CLK VDD VDD VSS gf180mcu_fd_sc_mcu7t5v0__dffrnq_1
X_1486_ VDD VSS _3422_/D _1484_/Z _1491_/A2 VDD VSS gf180mcu_fd_sc_mcu7t5v0__nor2_1
X_3156_ _3156_/D _3156_/Q wire151/I VSS _3165_/CLK VDD VDD VSS gf180mcu_fd_sc_mcu7t5v0__dffrnq_1
XFILLER_27_416 VDD VSS VDD VSS gf180mcu_fd_sc_mcu7t5v0__fillcap_4
XFILLER_39_276 VDD VSS VDD VSS gf180mcu_fd_sc_mcu7t5v0__fillcap_4
X_2107_ VDD VSS _2108_/A2 _2075_/Z _2111_/A2 VDD VSS gf180mcu_fd_sc_mcu7t5v0__nand2_1
X_3087_ _3087_/D _3087_/Q _3335_/RN VSS _3453_/CLK VDD VDD VSS gf180mcu_fd_sc_mcu7t5v0__dffrnq_1
X_2038_ _2040_/S VDD VSS _3071_/D _3287_/Q _3071_/Q VDD VSS gf180mcu_fd_sc_mcu7t5v0__mux2_2
XFILLER_195_413 VDD VSS VDD VSS gf180mcu_fd_sc_mcu7t5v0__fillcap_4
XFILLER_210_233 VDD VSS VDD VSS gf180mcu_fd_sc_mcu7t5v0__fillcap_8
XFILLER_149_874 VDD VSS VDD VSS gf180mcu_fd_sc_mcu7t5v0__fillcap_16
XFILLER_182_107 VDD VSS VDD VSS gf180mcu_fd_sc_mcu7t5v0__fillcap_4
XFILLER_148_373 VDD VSS VDD VSS gf180mcu_fd_sc_mcu7t5v0__fillcap_8
XFILLER_164_877 VDD VSS VDD VSS gf180mcu_fd_sc_mcu7t5v0__fillcap_8
XFILLER_191_696 VDD VSS VDD VSS gf180mcu_fd_sc_mcu7t5v0__fillcap_4
XFILLER_190_195 VDD VSS VDD VSS gf180mcu_fd_sc_mcu7t5v0__fillcap_16
XFILLER_77_338 VDD VSS VDD VSS gf180mcu_fd_sc_mcu7t5v0__fillcap_8
XFILLER_132_796 VDD VSS VDD VSS gf180mcu_fd_sc_mcu7t5v0__fillcap_8
XFILLER_218_311 VDD VSS VDD VSS gf180mcu_fd_sc_mcu7t5v0__fillcap_4
XFILLER_172_2 VDD VSS VDD VSS gf180mcu_fd_sc_mcu7t5v0__fillcap_32
XFILLER_260_177 VDD VSS VDD VSS gf180mcu_fd_sc_mcu7t5v0__fillcap_64
XFILLER_186_446 VDD VSS VDD VSS gf180mcu_fd_sc_mcu7t5v0__fillcap_8
XFILLER_201_244 VDD VSS VDD VSS gf180mcu_fd_sc_mcu7t5v0__fillcap_8
XFILLER_186_457 VDD VSS VDD VSS gf180mcu_fd_sc_mcu7t5v0__fillcap_32
XFILLER_9_136 VDD VSS VDD VSS gf180mcu_fd_sc_mcu7t5v0__fillcap_4
XFILLER_154_310 VDD VSS VDD VSS gf180mcu_fd_sc_mcu7t5v0__fillcap_4
XFILLER_181_195 VDD VSS VDD VSS gf180mcu_fd_sc_mcu7t5v0__fillcap_8
XFILLER_154_387 VDD VSS VDD VSS gf180mcu_fd_sc_mcu7t5v0__fillcap_8
XFILLER_174_93 VDD VSS VDD VSS gf180mcu_fd_sc_mcu7t5v0__fillcap_4
XFILLER_3_66 VDD VSS VDD VSS gf180mcu_fd_sc_mcu7t5v0__fillcap_4
X_3010_ VDD _3010_/Q _3023_/CLK VSS _3010_/D VDD VSS gf180mcu_fd_sc_mcu7t5v0__dffq_1
XFILLER_209_377 VDD VSS VDD VSS gf180mcu_fd_sc_mcu7t5v0__fillcap_8
XFILLER_91_352 VDD VSS VDD VSS gf180mcu_fd_sc_mcu7t5v0__fillcap_16
Xwire28 VSS wire28/Z wire28/I VDD VDD VSS gf180mcu_fd_sc_mcu7t5v0__buf_2
XFILLER_252_667 VDD VSS VDD VSS gf180mcu_fd_sc_mcu7t5v0__fillcap_64
XFILLER_240_807 VDD VSS VDD VSS gf180mcu_fd_sc_mcu7t5v0__fillcap_64
XFILLER_220_597 VDD VSS VDD VSS gf180mcu_fd_sc_mcu7t5v0__fillcap_8
XFILLER_164_107 VDD VSS VDD VSS gf180mcu_fd_sc_mcu7t5v0__fillcap_4
X_2725_ VDD VSS _2727_/A2 _3099_/Q _2668_/Z VDD VSS gf180mcu_fd_sc_mcu7t5v0__nand2_1
XFILLER_146_877 VDD VSS VDD VSS gf180mcu_fd_sc_mcu7t5v0__fillcap_8
X_2656_ VDD VSS _2657_/B2 _2656_/A1 _2656_/A2 VDD VSS gf180mcu_fd_sc_mcu7t5v0__nand2_1
X_1607_ _1606_/Z VDD VSS _3395_/D _1607_/A1 _1605_/Z VDD VSS gf180mcu_fd_sc_mcu7t5v0__nor3_1
XFILLER_173_696 VDD VSS VDD VSS gf180mcu_fd_sc_mcu7t5v0__fillcap_4
XFILLER_161_836 VDD VSS VDD VSS gf180mcu_fd_sc_mcu7t5v0__fillcap_4
XFILLER_126_590 VDD VSS VDD VSS gf180mcu_fd_sc_mcu7t5v0__fillcap_4
X_2587_ _2587_/S VDD VSS _3255_/D _3247_/Q _3255_/Q VDD VSS gf180mcu_fd_sc_mcu7t5v0__mux2_2
X_1538_ _3171_/Q VDD VSS _1538_/Z _3172_/Q _3173_/Q VDD VSS gf180mcu_fd_sc_mcu7t5v0__and3_1
XFILLER_113_251 VDD VSS VDD VSS gf180mcu_fd_sc_mcu7t5v0__fillcap_8
X_1469_ VDD VSS _3407_/D _3407_/Q _1469_/A2 VDD VSS gf180mcu_fd_sc_mcu7t5v0__xor2_1
X_3208_ _3208_/D _3208_/Q _3359_/RN VSS _3359_/CLK VDD VDD VSS gf180mcu_fd_sc_mcu7t5v0__dffrnq_1
X_3139_ _3139_/D _3139_/Q wire147/Z VSS _3364_/CLK VDD VDD VSS gf180mcu_fd_sc_mcu7t5v0__dffrnq_1
XFILLER_83_842 VDD VSS VDD VSS gf180mcu_fd_sc_mcu7t5v0__fillcap_32
XFILLER_82_341 VDD VSS VDD VSS gf180mcu_fd_sc_mcu7t5v0__fillcap_32
XFILLER_242_177 VDD VSS VDD VSS gf180mcu_fd_sc_mcu7t5v0__fillcap_64
XFILLER_230_317 VDD VSS VDD VSS gf180mcu_fd_sc_mcu7t5v0__fillcap_64
XFILLER_168_402 VDD VSS VDD VSS gf180mcu_fd_sc_mcu7t5v0__fillcap_32
XFILLER_51_772 VDD VSS VDD VSS gf180mcu_fd_sc_mcu7t5v0__fillcap_64
XFILLER_183_416 VDD VSS VDD VSS gf180mcu_fd_sc_mcu7t5v0__fillcap_4
XFILLER_195_276 VDD VSS VDD VSS gf180mcu_fd_sc_mcu7t5v0__fillcap_4
Xmax_length103 VSS _1400_/I _3210_/Q VDD VDD VSS gf180mcu_fd_sc_mcu7t5v0__buf_2
XFILLER_109_524 VDD VSS VDD VSS gf180mcu_fd_sc_mcu7t5v0__fillcap_8
Xmax_length125 _2011_/I0 wire126/Z VDD VSS VDD VSS gf180mcu_fd_sc_mcu7t5v0__buf_4
Xmax_length136 _1863_/I0 _3120_/Q VDD VSS VDD VSS gf180mcu_fd_sc_mcu7t5v0__buf_4
Xmax_length158 _3335_/RN wire169/Z VDD VSS VDD VSS gf180mcu_fd_sc_mcu7t5v0__buf_8
XFILLER_128_53 VDD VSS VDD VSS gf180mcu_fd_sc_mcu7t5v0__fillcap_4
XFILLER_136_387 VDD VSS VDD VSS gf180mcu_fd_sc_mcu7t5v0__fillcap_4
XFILLER_124_527 VDD VSS VDD VSS gf180mcu_fd_sc_mcu7t5v0__fillcap_16
XFILLER_88_79 VDD VSS VDD VSS gf180mcu_fd_sc_mcu7t5v0__fillcap_16
XFILLER_266_737 VDD VSS VDD VSS gf180mcu_fd_sc_mcu7t5v0__fillcap_64
XFILLER_73_352 VDD VSS VDD VSS gf180mcu_fd_sc_mcu7t5v0__fillcap_64
XFILLER_37_72 VDD VSS VDD VSS gf180mcu_fd_sc_mcu7t5v0__fillcap_64
XFILLER_234_667 VDD VSS VDD VSS gf180mcu_fd_sc_mcu7t5v0__fillcap_64
XFILLER_222_807 VDD VSS VDD VSS gf180mcu_fd_sc_mcu7t5v0__fillcap_64
XFILLER_261_486 VDD VSS VDD VSS gf180mcu_fd_sc_mcu7t5v0__fillcap_4
XFILLER_41_282 VDD VSS VDD VSS gf180mcu_fd_sc_mcu7t5v0__fillcap_64
XFILLER_202_597 VDD VSS VDD VSS gf180mcu_fd_sc_mcu7t5v0__fillcap_16
XFILLER_159_479 VDD VSS VDD VSS gf180mcu_fd_sc_mcu7t5v0__fillcap_8
XFILLER_146_107 VDD VSS VDD VSS gf180mcu_fd_sc_mcu7t5v0__fillcap_8
XFILLER_127_343 VDD VSS VDD VSS gf180mcu_fd_sc_mcu7t5v0__fillcap_4
XFILLER_128_877 VDD VSS VDD VSS gf180mcu_fd_sc_mcu7t5v0__fillcap_8
X_2510_ _2524_/B1 _3340_/Q VDD VSS _2513_/A3 _3332_/Q _2554_/A2 VDD VSS gf180mcu_fd_sc_mcu7t5v0__aoi22_1
XFILLER_143_836 VDD VSS VDD VSS gf180mcu_fd_sc_mcu7t5v0__fillcap_4
X_2441_ _2930_/Q VSS VDD _2914_/Q _2922_/Q _2454_/S0 _2906_/Q _2454_/S1 _2441_/Z VDD
+ VSS gf180mcu_fd_sc_mcu7t5v0__mux4_1
X_2372_ _2829_/Q VSS VDD _2813_/Q _2821_/Q wire78/I _2805_/Q wire76/Z _2372_/Z VDD
+ VSS gf180mcu_fd_sc_mcu7t5v0__mux4_1
XFILLER_96_411 VDD VSS VDD VSS gf180mcu_fd_sc_mcu7t5v0__fillcap_4
XFILLER_256_247 VDD VSS VDD VSS gf180mcu_fd_sc_mcu7t5v0__fillcap_64
XFILLER_111_766 VDD VSS VDD VSS gf180mcu_fd_sc_mcu7t5v0__fillcap_4
XFILLER_65_842 VDD VSS VDD VSS gf180mcu_fd_sc_mcu7t5v0__fillcap_32
XFILLER_83_116 VDD VSS VDD VSS gf180mcu_fd_sc_mcu7t5v0__fillcap_16
XFILLER_92_661 VDD VSS VDD VSS gf180mcu_fd_sc_mcu7t5v0__fillcap_4
XFILLER_80_801 VDD VSS VDD VSS gf180mcu_fd_sc_mcu7t5v0__fillcap_4
XFILLER_197_508 VDD VSS VDD VSS gf180mcu_fd_sc_mcu7t5v0__fillcap_8
XFILLER_224_177 VDD VSS VDD VSS gf180mcu_fd_sc_mcu7t5v0__fillcap_64
XFILLER_212_317 VDD VSS VDD VSS gf180mcu_fd_sc_mcu7t5v0__fillcap_16
XFILLER_33_772 VDD VSS VDD VSS gf180mcu_fd_sc_mcu7t5v0__fillcap_64
XFILLER_60_591 VDD VSS VDD VSS gf180mcu_fd_sc_mcu7t5v0__fillcap_4
XFILLER_193_714 VDD VSS VDD VSS gf180mcu_fd_sc_mcu7t5v0__fillcap_8
XFILLER_177_276 VDD VSS VDD VSS gf180mcu_fd_sc_mcu7t5v0__fillcap_4
XFILLER_146_641 VDD VSS VDD VSS gf180mcu_fd_sc_mcu7t5v0__fillcap_4
X_2708_ VDD VSS _2715_/B wire85/Z _2749_/C VDD VSS gf180mcu_fd_sc_mcu7t5v0__nand2_1
XFILLER_118_387 VDD VSS VDD VSS gf180mcu_fd_sc_mcu7t5v0__fillcap_16
XFILLER_106_527 VDD VSS VDD VSS gf180mcu_fd_sc_mcu7t5v0__fillcap_64
X_2639_ wire46/Z VDD VSS _3302_/D _3260_/Q _3302_/Q VDD VSS gf180mcu_fd_sc_mcu7t5v0__mux2_2
XFILLER_248_737 VDD VSS VDD VSS gf180mcu_fd_sc_mcu7t5v0__fillcap_64
XFILLER_99_282 VDD VSS VDD VSS gf180mcu_fd_sc_mcu7t5v0__fillcap_16
XFILLER_114_22 VDD VSS VDD VSS gf180mcu_fd_sc_mcu7t5v0__fillcap_8
XFILLER_261_72 VDD VSS VDD VSS gf180mcu_fd_sc_mcu7t5v0__fillcap_64
XFILLER_55_352 VDD VSS VDD VSS gf180mcu_fd_sc_mcu7t5v0__fillcap_64
XFILLER_216_667 VDD VSS VDD VSS gf180mcu_fd_sc_mcu7t5v0__fillcap_64
XFILLER_204_807 VDD VSS VDD VSS gf180mcu_fd_sc_mcu7t5v0__fillcap_64
XFILLER_70_311 VDD VSS VDD VSS gf180mcu_fd_sc_mcu7t5v0__fillcap_4
XFILLER_243_486 VDD VSS VDD VSS gf180mcu_fd_sc_mcu7t5v0__fillcap_4
XFILLER_231_626 VDD VSS VDD VSS gf180mcu_fd_sc_mcu7t5v0__fillcap_4
Xclkbuf_3_0__f_clk_i VDD VSS clkbuf_3_0__f_clk_i/Z clkbuf_0_clk_i/Z VDD VSS gf180mcu_fd_sc_mcu7t5v0__clkbuf_16
XFILLER_11_422 VDD VSS VDD VSS gf180mcu_fd_sc_mcu7t5v0__fillcap_64
XFILLER_169_766 VDD VSS VDD VSS gf180mcu_fd_sc_mcu7t5v0__fillcap_4
XFILLER_23_282 VDD VSS VDD VSS gf180mcu_fd_sc_mcu7t5v0__fillcap_64
XFILLER_128_107 VDD VSS VDD VSS gf180mcu_fd_sc_mcu7t5v0__fillcap_16
XFILLER_109_321 VDD VSS VDD VSS gf180mcu_fd_sc_mcu7t5v0__fillcap_4
XFILLER_109_343 VDD VSS VDD VSS gf180mcu_fd_sc_mcu7t5v0__fillcap_4
XFILLER_164_493 VDD VSS VDD VSS gf180mcu_fd_sc_mcu7t5v0__fillcap_16
XFILLER_125_836 VDD VSS VDD VSS gf180mcu_fd_sc_mcu7t5v0__fillcap_4
XFILLER_124_346 VDD VSS VDD VSS gf180mcu_fd_sc_mcu7t5v0__fillcap_4
XFILLER_3_632 VDD VSS VDD VSS gf180mcu_fd_sc_mcu7t5v0__fillcap_64
XFILLER_238_247 VDD VSS VDD VSS gf180mcu_fd_sc_mcu7t5v0__fillcap_64
XFILLER_253_206 VDD VSS VDD VSS gf180mcu_fd_sc_mcu7t5v0__fillcap_4
XFILLER_171_72 VDD VSS VDD VSS gf180mcu_fd_sc_mcu7t5v0__fillcap_64
XFILLER_47_842 VDD VSS VDD VSS gf180mcu_fd_sc_mcu7t5v0__fillcap_32
XFILLER_219_483 VDD VSS VDD VSS gf180mcu_fd_sc_mcu7t5v0__fillcap_4
XFILLER_74_661 VDD VSS VDD VSS gf180mcu_fd_sc_mcu7t5v0__fillcap_4
XFILLER_62_801 VDD VSS VDD VSS gf180mcu_fd_sc_mcu7t5v0__fillcap_4
XFILLER_221_103 VDD VSS VDD VSS gf180mcu_fd_sc_mcu7t5v0__fillcap_8
XFILLER_206_177 VDD VSS VDD VSS gf180mcu_fd_sc_mcu7t5v0__fillcap_16
XFILLER_222_659 VDD VSS VDD VSS gf180mcu_fd_sc_mcu7t5v0__fillcap_4
X_2990_ VDD _2990_/Q _3006_/CLK VSS _2990_/D VDD VSS gf180mcu_fd_sc_mcu7t5v0__dffq_1
XFILLER_15_772 VDD VSS VDD VSS gf180mcu_fd_sc_mcu7t5v0__fillcap_64
XFILLER_42_591 VDD VSS VDD VSS gf180mcu_fd_sc_mcu7t5v0__fillcap_4
XFILLER_30_731 VDD VSS VDD VSS gf180mcu_fd_sc_mcu7t5v0__fillcap_4
X_1941_ _1944_/S VDD VSS _2993_/D _2015_/I0 _2993_/Q VDD VSS gf180mcu_fd_sc_mcu7t5v0__mux2_2
X_1872_ _1877_/S VDD VSS _2935_/D _2935_/Q wire122/Z VDD VSS gf180mcu_fd_sc_mcu7t5v0__mux2_2
XFILLER_187_596 VDD VSS VDD VSS gf180mcu_fd_sc_mcu7t5v0__fillcap_16
XFILLER_159_276 VDD VSS VDD VSS gf180mcu_fd_sc_mcu7t5v0__fillcap_4
XFILLER_174_279 VDD VSS VDD VSS gf180mcu_fd_sc_mcu7t5v0__fillcap_16
XFILLER_50_2 VDD VSS VDD VSS gf180mcu_fd_sc_mcu7t5v0__fillcap_32
X_2424_ VDD _2424_/B _2424_/A2 _3200_/D _2467_/A1 VSS VDD VSS gf180mcu_fd_sc_mcu7t5v0__oai21_1
XFILLER_69_422 VDD VSS VDD VSS gf180mcu_fd_sc_mcu7t5v0__fillcap_64
X_2355_ VDD VSS _2356_/A2 _2365_/A2 _2361_/A3 VDD VSS gf180mcu_fd_sc_mcu7t5v0__nor2_1
XFILLER_130_349 VDD VSS VDD VSS gf180mcu_fd_sc_mcu7t5v0__fillcap_4
XFILLER_96_230 VDD VSS VDD VSS gf180mcu_fd_sc_mcu7t5v0__fillcap_8
XFILLER_257_556 VDD VSS VDD VSS gf180mcu_fd_sc_mcu7t5v0__fillcap_4
XFILLER_96_263 VDD VSS VDD VSS gf180mcu_fd_sc_mcu7t5v0__fillcap_4
X_2286_ _2289_/S VDD VSS _3179_/D _3179_/Q _3199_/Q VDD VSS gf180mcu_fd_sc_mcu7t5v0__mux2_2
XFILLER_52_311 VDD VSS VDD VSS gf180mcu_fd_sc_mcu7t5v0__fillcap_4
XFILLER_37_352 VDD VSS VDD VSS gf180mcu_fd_sc_mcu7t5v0__fillcap_64
XFILLER_225_486 VDD VSS VDD VSS gf180mcu_fd_sc_mcu7t5v0__fillcap_4
XFILLER_64_171 VDD VSS VDD VSS gf180mcu_fd_sc_mcu7t5v0__fillcap_4
XFILLER_197_316 VDD VSS VDD VSS gf180mcu_fd_sc_mcu7t5v0__fillcap_8
XFILLER_20_241 VDD VSS VDD VSS gf180mcu_fd_sc_mcu7t5v0__fillcap_4
XFILLER_165_235 VDD VSS VDD VSS gf180mcu_fd_sc_mcu7t5v0__fillcap_8
XFILLER_119_663 VDD VSS VDD VSS gf180mcu_fd_sc_mcu7t5v0__fillcap_8
XFILLER_180_216 VDD VSS VDD VSS gf180mcu_fd_sc_mcu7t5v0__fillcap_16
XFILLER_107_836 VDD VSS VDD VSS gf180mcu_fd_sc_mcu7t5v0__fillcap_4
XFILLER_161_430 VDD VSS VDD VSS gf180mcu_fd_sc_mcu7t5v0__fillcap_4
XFILLER_133_187 VDD VSS VDD VSS gf180mcu_fd_sc_mcu7t5v0__fillcap_16
XFILLER_88_731 VDD VSS VDD VSS gf180mcu_fd_sc_mcu7t5v0__fillcap_4
XFILLER_125_65 VDD VSS VDD VSS gf180mcu_fd_sc_mcu7t5v0__fillcap_4
XFILLER_235_206 VDD VSS VDD VSS gf180mcu_fd_sc_mcu7t5v0__fillcap_4
XFILLER_29_842 VDD VSS VDD VSS gf180mcu_fd_sc_mcu7t5v0__fillcap_32
XFILLER_56_661 VDD VSS VDD VSS gf180mcu_fd_sc_mcu7t5v0__fillcap_4
XFILLER_44_801 VDD VSS VDD VSS gf180mcu_fd_sc_mcu7t5v0__fillcap_4
XFILLER_252_2 VDD VSS VDD VSS gf180mcu_fd_sc_mcu7t5v0__fillcap_32
XFILLER_203_158 VDD VSS VDD VSS gf180mcu_fd_sc_mcu7t5v0__fillcap_8
Xspi_opentarget_i3c_top_200 spi_mosi_i_PD VDD VSS VDD VSS gf180mcu_fd_sc_mcu7t5v0__tiel
XFILLER_24_591 VDD VSS VDD VSS gf180mcu_fd_sc_mcu7t5v0__fillcap_4
XFILLER_12_731 VDD VSS VDD VSS gf180mcu_fd_sc_mcu7t5v0__fillcap_4
XFILLER_196_371 VDD VSS VDD VSS gf180mcu_fd_sc_mcu7t5v0__fillcap_8
Xwire132 VSS wire132/Z _3123_/Q VDD VDD VSS gf180mcu_fd_sc_mcu7t5v0__buf_2
Xwire110 VSS wire110/Z _3198_/Q VDD VDD VSS gf180mcu_fd_sc_mcu7t5v0__buf_2
XFILLER_7_212 VDD VSS VDD VSS gf180mcu_fd_sc_mcu7t5v0__fillcap_64
Xwire121 wire121/Z VSS VDD wire122/Z VDD VSS gf180mcu_fd_sc_mcu7t5v0__clkbuf_3
Xwire165 wire165/Z wire165/I VDD VSS VDD VSS gf180mcu_fd_sc_mcu7t5v0__buf_8
XFILLER_137_482 VDD VSS VDD VSS gf180mcu_fd_sc_mcu7t5v0__fillcap_8
Xclkbuf_4_3_0_host_clk_i _3405_/CLK VSS VDD clkbuf_0_host_clk_i/Z VDD VSS gf180mcu_fd_sc_mcu7t5v0__clkbuf_2
XFILLER_140_625 VDD VSS VDD VSS gf180mcu_fd_sc_mcu7t5v0__fillcap_32
XFILLER_239_556 VDD VSS VDD VSS gf180mcu_fd_sc_mcu7t5v0__fillcap_4
X_2140_ _3364_/D VDD VSS _3128_/D _3128_/Q _3178_/Q VDD VSS gf180mcu_fd_sc_mcu7t5v0__mux2_2
X_2071_ _2072_/S VDD VSS _3100_/D wire90/Z _3100_/Q VDD VSS gf180mcu_fd_sc_mcu7t5v0__mux2_2
XFILLER_19_352 VDD VSS VDD VSS gf180mcu_fd_sc_mcu7t5v0__fillcap_64
XFILLER_75_80 VDD VSS VDD VSS gf180mcu_fd_sc_mcu7t5v0__fillcap_4
XFILLER_207_486 VDD VSS VDD VSS gf180mcu_fd_sc_mcu7t5v0__fillcap_4
XFILLER_34_311 VDD VSS VDD VSS gf180mcu_fd_sc_mcu7t5v0__fillcap_4
XFILLER_46_171 VDD VSS VDD VSS gf180mcu_fd_sc_mcu7t5v0__fillcap_4
XFILLER_222_445 VDD VSS VDD VSS gf180mcu_fd_sc_mcu7t5v0__fillcap_8
X_2973_ VDD _2973_/Q _3463_/CLK VSS _2973_/D VDD VSS gf180mcu_fd_sc_mcu7t5v0__dffq_1
XFILLER_98_2 VDD VSS VDD VSS gf180mcu_fd_sc_mcu7t5v0__fillcap_16
XFILLER_187_360 VDD VSS VDD VSS gf180mcu_fd_sc_mcu7t5v0__fillcap_4
XFILLER_194_308 VDD VSS VDD VSS gf180mcu_fd_sc_mcu7t5v0__fillcap_4
X_1924_ _1924_/S VDD VSS _2978_/D wire116/Z _2978_/Q VDD VSS gf180mcu_fd_sc_mcu7t5v0__mux2_2
XFILLER_175_544 VDD VSS VDD VSS gf180mcu_fd_sc_mcu7t5v0__fillcap_16
X_1855_ _1860_/S VDD VSS _2919_/D _1864_/I0 _2919_/Q VDD VSS gf180mcu_fd_sc_mcu7t5v0__mux2_2
X_1786_ _1786_/S VDD VSS _2860_/D _1869_/I0 _2860_/Q VDD VSS gf180mcu_fd_sc_mcu7t5v0__mux2_2
XFILLER_171_772 VDD VSS VDD VSS gf180mcu_fd_sc_mcu7t5v0__fillcap_64
XFILLER_131_625 VDD VSS VDD VSS gf180mcu_fd_sc_mcu7t5v0__fillcap_4
X_3456_ _3456_/D _3456_/Q _3457_/RN VSS _3457_/CLK VDD VDD VSS gf180mcu_fd_sc_mcu7t5v0__dffrnq_1
X_3387_ _3387_/D _3387_/Q _3403_/RN VSS _3395_/CLK VDD VDD VSS gf180mcu_fd_sc_mcu7t5v0__dffrnq_1
X_2407_ VDD VSS _2408_/A3 _2449_/A1 _3131_/Q VDD VSS gf180mcu_fd_sc_mcu7t5v0__nand2_1
X_2338_ _2339_/B VDD VSS _3189_/D _2338_/A1 _2338_/A2 VDD VSS gf180mcu_fd_sc_mcu7t5v0__aoi21_1
X_2269_ _2269_/B1 _2259_/Z VDD VSS _2270_/I1 _2269_/A1 _2263_/B VDD VSS gf180mcu_fd_sc_mcu7t5v0__aoi22_1
XFILLER_38_661 VDD VSS VDD VSS gf180mcu_fd_sc_mcu7t5v0__fillcap_4
XFILLER_26_801 VDD VSS VDD VSS gf180mcu_fd_sc_mcu7t5v0__fillcap_4
XFILLER_71_38 VDD VSS VDD VSS gf180mcu_fd_sc_mcu7t5v0__fillcap_4
XFILLER_193_341 VDD VSS VDD VSS gf180mcu_fd_sc_mcu7t5v0__fillcap_8
XFILLER_193_352 VDD VSS VDD VSS gf180mcu_fd_sc_mcu7t5v0__fillcap_16
XFILLER_166_588 VDD VSS VDD VSS gf180mcu_fd_sc_mcu7t5v0__fillcap_4
XFILLER_136_53 VDD VSS VDD VSS gf180mcu_fd_sc_mcu7t5v0__fillcap_4
XFILLER_0_410 VDD VSS VDD VSS gf180mcu_fd_sc_mcu7t5v0__fillcap_32
XFILLER_121_135 VDD VSS VDD VSS gf180mcu_fd_sc_mcu7t5v0__fillcap_4
XFILLER_88_572 VDD VSS VDD VSS gf180mcu_fd_sc_mcu7t5v0__fillcap_16
XFILLER_189_603 VDD VSS VDD VSS gf180mcu_fd_sc_mcu7t5v0__fillcap_16
XFILLER_90_247 VDD VSS VDD VSS gf180mcu_fd_sc_mcu7t5v0__fillcap_8
XFILLER_16_311 VDD VSS VDD VSS gf180mcu_fd_sc_mcu7t5v0__fillcap_4
XFILLER_28_171 VDD VSS VDD VSS gf180mcu_fd_sc_mcu7t5v0__fillcap_4
XFILLER_45_72 VDD VSS VDD VSS gf180mcu_fd_sc_mcu7t5v0__fillcap_64
XFILLER_185_842 VDD VSS VDD VSS gf180mcu_fd_sc_mcu7t5v0__fillcap_32
XFILLER_8_521 VDD VSS VDD VSS gf180mcu_fd_sc_mcu7t5v0__fillcap_4
X_1640_ VDD VSS _1640_/I _1649_/A2 VDD VSS gf180mcu_fd_sc_mcu7t5v0__clkinv_1
X_1571_ _1569_/Z VDD VSS _1589_/B _1571_/A1 _1589_/C VDD VSS gf180mcu_fd_sc_mcu7t5v0__nor3_1
XFILLER_153_772 VDD VSS VDD VSS gf180mcu_fd_sc_mcu7t5v0__fillcap_64
X_3310_ _3310_/D _3310_/Q wire163/I VSS _3462_/CLK VDD VDD VSS gf180mcu_fd_sc_mcu7t5v0__dffrnq_1
XFILLER_140_433 VDD VSS VDD VSS gf180mcu_fd_sc_mcu7t5v0__fillcap_16
X_3241_ _3241_/D _3241_/Q _3336_/RN VSS _3316_/CLK VDD VDD VSS gf180mcu_fd_sc_mcu7t5v0__dffrnq_1
X_3172_ VSS _3360_/CLK VDD _3172_/D _3172_/Q _3359_/RN VDD VSS gf180mcu_fd_sc_mcu7t5v0__dffsnq_1
X_2123_ _2121_/B _2123_/B1 _2123_/B2 VDD VSS _3115_/D _2123_/A1 VDD VSS gf180mcu_fd_sc_mcu7t5v0__oai22_1
XFILLER_13_2 VDD VSS VDD VSS gf180mcu_fd_sc_mcu7t5v0__fillcap_64
XFILLER_82_737 VDD VSS VDD VSS gf180mcu_fd_sc_mcu7t5v0__fillcap_64
X_2054_ wire28/Z VDD VSS _3087_/D _3303_/Q _3087_/Q VDD VSS gf180mcu_fd_sc_mcu7t5v0__mux2_2
XFILLER_50_667 VDD VSS VDD VSS gf180mcu_fd_sc_mcu7t5v0__fillcap_64
X_2956_ VDD _2956_/Q _3150_/CLK VSS _2956_/D VDD VSS gf180mcu_fd_sc_mcu7t5v0__dffq_1
XFILLER_194_127 VDD VSS VDD VSS gf180mcu_fd_sc_mcu7t5v0__fillcap_4
X_1907_ _1907_/S VDD VSS _2964_/D _3182_/Q _2964_/Q VDD VSS gf180mcu_fd_sc_mcu7t5v0__mux2_2
X_2887_ VDD _2887_/Q _3403_/CLK VSS _2887_/D VDD VSS gf180mcu_fd_sc_mcu7t5v0__dffq_1
XFILLER_175_352 VDD VSS VDD VSS gf180mcu_fd_sc_mcu7t5v0__fillcap_64
X_1838_ _1842_/S VDD VSS _2904_/D wire133/Z _2904_/Q VDD VSS gf180mcu_fd_sc_mcu7t5v0__mux2_2
X_1769_ VDD VSS _1777_/S _1843_/A1 _1787_/A2 VDD VSS gf180mcu_fd_sc_mcu7t5v0__nand2_1
XFILLER_131_422 VDD VSS VDD VSS gf180mcu_fd_sc_mcu7t5v0__fillcap_64
XFILLER_143_282 VDD VSS VDD VSS gf180mcu_fd_sc_mcu7t5v0__fillcap_16
X_3439_ _3439_/D _3439_/Q wire161/I VSS _3445_/CLK VDD VDD VSS gf180mcu_fd_sc_mcu7t5v0__dffrnq_1
XFILLER_218_504 VDD VSS VDD VSS gf180mcu_fd_sc_mcu7t5v0__fillcap_16
XFILLER_72_247 VDD VSS VDD VSS gf180mcu_fd_sc_mcu7t5v0__fillcap_4
XFILLER_82_37 VDD VSS VDD VSS gf180mcu_fd_sc_mcu7t5v0__fillcap_8
XFILLER_241_562 VDD VSS VDD VSS gf180mcu_fd_sc_mcu7t5v0__fillcap_64
XFILLER_201_437 VDD VSS VDD VSS gf180mcu_fd_sc_mcu7t5v0__fillcap_16
XFILLER_167_842 VDD VSS VDD VSS gf180mcu_fd_sc_mcu7t5v0__fillcap_32
XFILLER_40_177 VDD VSS VDD VSS gf180mcu_fd_sc_mcu7t5v0__fillcap_64
XFILLER_182_801 VDD VSS VDD VSS gf180mcu_fd_sc_mcu7t5v0__fillcap_4
XFILLER_181_344 VDD VSS VDD VSS gf180mcu_fd_sc_mcu7t5v0__fillcap_4
XFILLER_135_772 VDD VSS VDD VSS gf180mcu_fd_sc_mcu7t5v0__fillcap_64
Xoutput6 VDD wire142/Z VSS irq_o_OUT VDD VSS gf180mcu_fd_sc_mcu7t5v0__dlyb_1
XFILLER_181_388 VDD VSS VDD VSS gf180mcu_fd_sc_mcu7t5v0__fillcap_16
XFILLER_96_807 VDD VSS VDD VSS gf180mcu_fd_sc_mcu7t5v0__fillcap_64
XFILLER_0_240 VDD VSS VDD VSS gf180mcu_fd_sc_mcu7t5v0__fillcap_32
XFILLER_263_142 VDD VSS VDD VSS gf180mcu_fd_sc_mcu7t5v0__fillcap_64
XFILLER_64_737 VDD VSS VDD VSS gf180mcu_fd_sc_mcu7t5v0__fillcap_64
XFILLER_76_597 VDD VSS VDD VSS gf180mcu_fd_sc_mcu7t5v0__fillcap_64
XFILLER_260_871 VDD VSS VDD VSS gf180mcu_fd_sc_mcu7t5v0__fillcap_4
XFILLER_189_422 VDD VSS VDD VSS gf180mcu_fd_sc_mcu7t5v0__fillcap_8
XFILLER_20_807 VDD VSS VDD VSS gf180mcu_fd_sc_mcu7t5v0__fillcap_64
XFILLER_32_667 VDD VSS VDD VSS gf180mcu_fd_sc_mcu7t5v0__fillcap_64
X_2810_ VDD _2810_/Q _3405_/CLK VSS _2810_/D VDD VSS gf180mcu_fd_sc_mcu7t5v0__dffq_1
XFILLER_188_70 VDD VSS VDD VSS gf180mcu_fd_sc_mcu7t5v0__fillcap_32
X_2741_ _2964_/Q VSS VDD _2948_/Q _2956_/Q _2741_/S0 _2940_/Q _2741_/S1 _2741_/Z VDD
+ VSS gf180mcu_fd_sc_mcu7t5v0__mux4_1
Xclkbuf_leaf_43_clk_i _3414_/CLK VSS VDD clkload2/I VDD VSS gf180mcu_fd_sc_mcu7t5v0__clkbuf_2
XFILLER_9_874 VDD VSS VDD VSS gf180mcu_fd_sc_mcu7t5v0__fillcap_16
X_2672_ _2758_/A2 _2672_/B2 VDD VSS _2679_/A1 _3311_/Q _2749_/C VDD VSS gf180mcu_fd_sc_mcu7t5v0__aoi22_1
X_1623_ VDD VSS _1628_/A1 _3439_/Q _3415_/D VDD VSS gf180mcu_fd_sc_mcu7t5v0__xnor2_1
XFILLER_153_591 VDD VSS VDD VSS gf180mcu_fd_sc_mcu7t5v0__fillcap_4
X_1554_ VDD VSS _1568_/A1 _3138_/Q _3139_/Q VDD VSS gf180mcu_fd_sc_mcu7t5v0__nor2_1
Xclkbuf_leaf_58_clk_i _3181_/CLK VSS VDD clkload2/I VDD VSS gf180mcu_fd_sc_mcu7t5v0__clkbuf_2
XFILLER_125_282 VDD VSS VDD VSS gf180mcu_fd_sc_mcu7t5v0__fillcap_16
X_1485_ wire59/I VDD VSS _1491_/A2 _3421_/Q _1485_/A2 VDD VSS gf180mcu_fd_sc_mcu7t5v0__aoi21_1
XFILLER_98_144 VDD VSS VDD VSS gf180mcu_fd_sc_mcu7t5v0__fillcap_8
XFILLER_98_177 VDD VSS VDD VSS gf180mcu_fd_sc_mcu7t5v0__fillcap_16
X_3224_ _3224_/D _3224_/Q wire145/I VSS _3274_/CLK VDD VDD VSS gf180mcu_fd_sc_mcu7t5v0__dffrnq_1
.ends
