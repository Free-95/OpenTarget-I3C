* NGSPICE file created from spi_opentarget_i3c_top.ext - technology: gf180mcuD

.subckt gf180mcu_fd_sc_mcu7t5v0__fillcap_64 VDD VSS VNW VPW
X0 a_4604_375# a_4516_472# VSS VPW nfet_05v0 ad=0.3608p pd=2.52u as=0.3608p ps=2.52u w=0.82u l=1u
X1 VDD a_572_375# a_484_472# VNW pfet_05v0 ad=0.5368p pd=3.32u as=0.5368p ps=3.32u w=1.22u l=1u
X2 VDD a_2364_375# a_2276_472# VNW pfet_05v0 ad=0.5368p pd=3.32u as=0.5368p ps=3.32u w=1.22u l=1u
X3 a_4156_375# a_4068_472# VSS VPW nfet_05v0 ad=0.3608p pd=2.52u as=0.3608p ps=2.52u w=0.82u l=1u
X4 a_5500_375# a_5412_472# VSS VPW nfet_05v0 ad=0.3608p pd=2.52u as=0.3608p ps=2.52u w=0.82u l=1u
X5 a_572_375# a_484_472# VSS VPW nfet_05v0 ad=0.3608p pd=2.52u as=0.3608p ps=2.52u w=0.82u l=1u
X6 VDD a_5052_375# a_4964_472# VNW pfet_05v0 ad=0.5368p pd=3.32u as=0.5368p ps=3.32u w=1.22u l=1u
X7 VDD a_6844_375# a_6756_472# VNW pfet_05v0 ad=0.5368p pd=3.32u as=0.5368p ps=3.32u w=1.22u l=1u
X8 VDD a_1916_375# a_1828_472# VNW pfet_05v0 ad=0.5368p pd=3.32u as=0.5368p ps=3.32u w=1.22u l=1u
X9 a_124_375# a_36_472# VSS VPW nfet_05v0 ad=0.3608p pd=2.52u as=0.3608p ps=2.52u w=0.82u l=1u
X10 a_5052_375# a_4964_472# VSS VPW nfet_05v0 ad=0.3608p pd=2.52u as=0.3608p ps=2.52u w=0.82u l=1u
X11 a_1916_375# a_1828_472# VSS VPW nfet_05v0 ad=0.3608p pd=2.52u as=0.3608p ps=2.52u w=0.82u l=1u
X12 VDD a_4604_375# a_4516_472# VNW pfet_05v0 ad=0.5368p pd=3.32u as=0.5368p ps=3.32u w=1.22u l=1u
X13 a_1468_375# a_1380_472# VSS VPW nfet_05v0 ad=0.3608p pd=2.52u as=0.3608p ps=2.52u w=0.82u l=1u
X14 a_2812_375# a_2724_472# VSS VPW nfet_05v0 ad=0.3608p pd=2.52u as=0.3608p ps=2.52u w=0.82u l=1u
X15 VDD a_3260_375# a_3172_472# VNW pfet_05v0 ad=0.5368p pd=3.32u as=0.5368p ps=3.32u w=1.22u l=1u
X16 a_2364_375# a_2276_472# VSS VPW nfet_05v0 ad=0.3608p pd=2.52u as=0.3608p ps=2.52u w=0.82u l=1u
X17 a_5948_375# a_5860_472# VSS VPW nfet_05v0 ad=0.3608p pd=2.52u as=0.3608p ps=2.52u w=0.82u l=1u
X18 VDD a_2812_375# a_2724_472# VNW pfet_05v0 ad=0.5368p pd=3.32u as=0.5368p ps=3.32u w=1.22u l=1u
X19 a_3260_375# a_3172_472# VSS VPW nfet_05v0 ad=0.3608p pd=2.52u as=0.3608p ps=2.52u w=0.82u l=1u
X20 VDD a_1020_375# a_932_472# VNW pfet_05v0 ad=0.5368p pd=3.32u as=0.5368p ps=3.32u w=1.22u l=1u
X21 VDD a_5500_375# a_5412_472# VNW pfet_05v0 ad=0.5368p pd=3.32u as=0.5368p ps=3.32u w=1.22u l=1u
X22 a_6844_375# a_6756_472# VSS VPW nfet_05v0 ad=0.3608p pd=2.52u as=0.3608p ps=2.52u w=0.82u l=1u
X23 a_6396_375# a_6308_472# VSS VPW nfet_05v0 ad=0.3608p pd=2.52u as=0.3608p ps=2.52u w=0.82u l=1u
X24 VDD a_6396_375# a_6308_472# VNW pfet_05v0 ad=0.5368p pd=3.32u as=0.5368p ps=3.32u w=1.22u l=1u
X25 VDD a_1468_375# a_1380_472# VNW pfet_05v0 ad=0.5368p pd=3.32u as=0.5368p ps=3.32u w=1.22u l=1u
X26 VDD a_4156_375# a_4068_472# VNW pfet_05v0 ad=0.5368p pd=3.32u as=0.5368p ps=3.32u w=1.22u l=1u
X27 VDD a_5948_375# a_5860_472# VNW pfet_05v0 ad=0.5368p pd=3.32u as=0.5368p ps=3.32u w=1.22u l=1u
X28 VDD a_124_375# a_36_472# VNW pfet_05v0 ad=0.5368p pd=3.32u as=0.5368p ps=3.32u w=1.22u l=1u
X29 a_3708_375# a_3620_472# VSS VPW nfet_05v0 ad=0.3608p pd=2.52u as=0.3608p ps=2.52u w=0.82u l=1u
X30 VDD a_3708_375# a_3620_472# VNW pfet_05v0 ad=0.5368p pd=3.32u as=0.5368p ps=3.32u w=1.22u l=1u
X31 a_1020_375# a_932_472# VSS VPW nfet_05v0 ad=0.3608p pd=2.52u as=0.3608p ps=2.52u w=0.82u l=1u
.ends

.subckt gf180mcu_fd_sc_mcu7t5v0__nor2_1 VDD VSS ZN A1 A2 VNW VPW
X0 ZN A1 a_224_472# VNW pfet_05v0 ad=0.5368p pd=3.32u as=0.4087p ps=1.89u w=1.22u l=0.5u
X1 VSS A1 ZN VPW nfet_05v0 ad=0.2486p pd=2.01u as=0.1469p ps=1.085u w=0.565u l=0.6u
X2 a_224_472# A2 VDD VNW pfet_05v0 ad=0.4087p pd=1.89u as=0.5368p ps=3.32u w=1.22u l=0.5u
X3 ZN A2 VSS VPW nfet_05v0 ad=0.1469p pd=1.085u as=0.2486p ps=2.01u w=0.565u l=0.6u
.ends

.subckt gf180mcu_fd_sc_mcu7t5v0__oai21_1 VDD B A2 ZN A1 VSS VNW VPW
X0 VSS B a_36_68# VPW nfet_05v0 ad=0.3608p pd=2.52u as=0.2132p ps=1.34u w=0.82u l=0.6u
X1 ZN A2 a_36_68# VPW nfet_05v0 ad=0.2132p pd=1.34u as=0.3608p ps=2.52u w=0.82u l=0.6u
X2 VDD B ZN VNW pfet_05v0 ad=0.4972p pd=3.14u as=0.4248p ps=1.94u w=1.13u l=0.5u
X3 a_244_472# A2 VDD VNW pfet_05v0 ad=0.3172p pd=1.74u as=0.5978p ps=3.42u w=1.22u l=0.5u
X4 ZN A1 a_244_472# VNW pfet_05v0 ad=0.4248p pd=1.94u as=0.3172p ps=1.74u w=1.22u l=0.5u
X5 a_36_68# A1 ZN VPW nfet_05v0 ad=0.2132p pd=1.34u as=0.2132p ps=1.34u w=0.82u l=0.6u
.ends

.subckt gf180mcu_fd_sc_mcu7t5v0__fillcap_8 VDD VSS VNW VPW
X0 VDD a_572_375# a_484_472# VNW pfet_05v0 ad=0.5368p pd=3.32u as=0.5368p ps=3.32u w=1.22u l=1u
X1 a_572_375# a_484_472# VSS VPW nfet_05v0 ad=0.3608p pd=2.52u as=0.3608p ps=2.52u w=0.82u l=1u
X2 a_124_375# a_36_472# VSS VPW nfet_05v0 ad=0.3608p pd=2.52u as=0.3608p ps=2.52u w=0.82u l=1u
X3 VDD a_124_375# a_36_472# VNW pfet_05v0 ad=0.5368p pd=3.32u as=0.5368p ps=3.32u w=1.22u l=1u
.ends

.subckt gf180mcu_fd_sc_mcu7t5v0__nor3_1 A3 VDD VSS ZN A1 A2 VNW VPW
X0 ZN A1 a_448_472# VNW pfet_05v0 ad=0.5368p pd=3.32u as=0.3782p ps=1.84u w=1.22u l=0.5u
X1 ZN A1 VSS VPW nfet_05v0 ad=0.2046p pd=1.81u as=0.1209p ps=0.985u w=0.465u l=0.6u
X2 a_244_472# A3 VDD VNW pfet_05v0 ad=0.3172p pd=1.74u as=0.5368p ps=3.32u w=1.22u l=0.5u
X3 a_448_472# A2 a_244_472# VNW pfet_05v0 ad=0.3782p pd=1.84u as=0.3172p ps=1.74u w=1.22u l=0.5u
X4 VSS A2 ZN VPW nfet_05v0 ad=0.1209p pd=0.985u as=0.1209p ps=0.985u w=0.465u l=0.6u
X5 ZN A3 VSS VPW nfet_05v0 ad=0.1209p pd=0.985u as=0.2046p ps=1.81u w=0.465u l=0.6u
.ends

.subckt gf180mcu_fd_sc_mcu7t5v0__dffq_1 VDD Q CLK VSS D VNW VPW
X0 VSS CLK a_36_151# VPW nfet_05v0 ad=0.1053p pd=0.925u as=0.1782p ps=1.69u w=0.405u l=0.6u
X1 Q a_2304_115# VSS VPW nfet_05v0 ad=0.3608p pd=2.52u as=0.3608p ps=2.52u w=0.82u l=0.6u
X2 a_2304_115# a_2011_527# VSS VPW nfet_05v0 ad=0.176p pd=1.68u as=0.142p ps=1.14u w=0.4u l=0.6u
X3 a_1004_159# D a_836_159# VPW nfet_05v0 ad=0.207p pd=1.51u as=43.2f ps=0.6u w=0.36u l=0.6u
X4 a_1004_159# D a_880_527# VNW pfet_05v0 ad=0.1872p pd=1.4u as=54f ps=0.66u w=0.36u l=0.5u
X5 a_2011_527# a_36_151# a_1376_115# VNW pfet_05v0 ad=0.1665p pd=1.285u as=0.1791p ps=1.355u w=0.36u l=0.5u
X6 a_2296_527# a_448_472# a_2011_527# VNW pfet_05v0 ad=50.4f pd=0.64u as=0.1665p ps=1.285u w=0.36u l=0.5u
X7 a_1376_115# a_1004_159# VDD VNW pfet_05v0 ad=0.1791p pd=1.355u as=0.1044p ps=0.94u w=0.36u l=0.5u
X8 VDD CLK a_36_151# VNW pfet_05v0 ad=0.2249p pd=1.385u as=0.3806p ps=2.61u w=0.865u l=0.5u
X9 VSS a_1376_115# a_1328_159# VPW nfet_05v0 ad=0.2637p pd=1.825u as=43.2f ps=0.6u w=0.36u l=0.6u
X10 a_2011_527# a_448_472# a_1376_115# VPW nfet_05v0 ad=93.59999f pd=0.88u as=93.59999f ps=0.88u w=0.36u l=0.6u
X11 a_448_472# a_36_151# VDD VNW pfet_05v0 ad=0.3806p pd=2.61u as=0.2249p ps=1.385u w=0.865u l=0.5u
X12 Q a_2304_115# VDD VNW pfet_05v0 ad=0.5368p pd=3.32u as=0.5368p ps=3.32u w=1.22u l=0.5u
X13 a_1376_115# a_1004_159# VSS VPW nfet_05v0 ad=93.59999f pd=0.88u as=0.2637p ps=1.825u w=0.36u l=0.6u
X14 VSS a_2304_115# a_2256_159# VPW nfet_05v0 ad=0.142p pd=1.14u as=43.2f ps=0.6u w=0.36u l=0.6u
X15 a_836_159# a_36_151# VSS VPW nfet_05v0 ad=43.2f pd=0.6u as=0.1584p ps=1.6u w=0.36u l=0.6u
X16 a_448_472# a_36_151# VSS VPW nfet_05v0 ad=0.1782p pd=1.69u as=0.1053p ps=0.925u w=0.405u l=0.6u
X17 a_2256_159# a_36_151# a_2011_527# VPW nfet_05v0 ad=43.2f pd=0.6u as=93.59999f ps=0.88u w=0.36u l=0.6u
X18 a_880_527# a_448_472# VDD VNW pfet_05v0 ad=54f pd=0.66u as=0.4554p ps=3.25u w=0.36u l=0.5u
X19 a_1348_527# a_36_151# a_1004_159# VNW pfet_05v0 ad=43.2f pd=0.6u as=0.1872p ps=1.4u w=0.36u l=0.5u
X20 a_1328_159# a_448_472# a_1004_159# VPW nfet_05v0 ad=43.2f pd=0.6u as=0.207p ps=1.51u w=0.36u l=0.6u
X21 VDD a_1376_115# a_1348_527# VNW pfet_05v0 ad=0.1044p pd=0.94u as=43.2f ps=0.6u w=0.36u l=0.5u
X22 VDD a_2304_115# a_2296_527# VNW pfet_05v0 ad=0.23p pd=1.54u as=50.4f ps=0.64u w=0.36u l=0.5u
X23 a_2304_115# a_2011_527# VDD VNW pfet_05v0 ad=0.352p pd=2.48u as=0.23p ps=1.54u w=0.8u l=0.5u
.ends

.subckt gf180mcu_fd_sc_mcu7t5v0__fillcap_16 VDD VSS VNW VPW
X0 VDD a_572_375# a_484_472# VNW pfet_05v0 ad=0.5368p pd=3.32u as=0.5368p ps=3.32u w=1.22u l=1u
X1 a_572_375# a_484_472# VSS VPW nfet_05v0 ad=0.3608p pd=2.52u as=0.3608p ps=2.52u w=0.82u l=1u
X2 a_124_375# a_36_472# VSS VPW nfet_05v0 ad=0.3608p pd=2.52u as=0.3608p ps=2.52u w=0.82u l=1u
X3 a_1468_375# a_1380_472# VSS VPW nfet_05v0 ad=0.3608p pd=2.52u as=0.3608p ps=2.52u w=0.82u l=1u
X4 VDD a_1020_375# a_932_472# VNW pfet_05v0 ad=0.5368p pd=3.32u as=0.5368p ps=3.32u w=1.22u l=1u
X5 VDD a_1468_375# a_1380_472# VNW pfet_05v0 ad=0.5368p pd=3.32u as=0.5368p ps=3.32u w=1.22u l=1u
X6 VDD a_124_375# a_36_472# VNW pfet_05v0 ad=0.5368p pd=3.32u as=0.5368p ps=3.32u w=1.22u l=1u
X7 a_1020_375# a_932_472# VSS VPW nfet_05v0 ad=0.3608p pd=2.52u as=0.3608p ps=2.52u w=0.82u l=1u
.ends

.subckt gf180mcu_fd_sc_mcu7t5v0__fillcap_4 VDD VSS VNW VPW
X0 a_124_375# a_36_472# VSS VPW nfet_05v0 ad=0.3608p pd=2.52u as=0.3608p ps=2.52u w=0.82u l=1u
X1 VDD a_124_375# a_36_472# VNW pfet_05v0 ad=0.5368p pd=3.32u as=0.5368p ps=3.32u w=1.22u l=1u
.ends

.subckt gf180mcu_fd_sc_mcu7t5v0__oai211_1 B C VDD VSS ZN A1 A2 VNW VPW
X0 a_692_68# B a_36_68# VPW nfet_05v0 ad=0.2132p pd=1.34u as=0.2132p ps=1.34u w=0.82u l=0.6u
X1 ZN A2 a_36_68# VPW nfet_05v0 ad=0.2132p pd=1.34u as=0.3608p ps=2.52u w=0.82u l=0.6u
X2 a_244_472# A2 VDD VNW pfet_05v0 ad=0.3172p pd=1.74u as=0.5978p ps=3.42u w=1.22u l=0.5u
X3 VDD B ZN VNW pfet_05v0 ad=0.2561p pd=1.505u as=0.4016p ps=1.94u w=0.985u l=0.5u
X4 ZN A1 a_244_472# VNW pfet_05v0 ad=0.4016p pd=1.94u as=0.3172p ps=1.74u w=1.22u l=0.5u
X5 ZN C VDD VNW pfet_05v0 ad=0.44325p pd=2.87u as=0.2561p ps=1.505u w=0.985u l=0.5u
X6 VSS C a_692_68# VPW nfet_05v0 ad=0.3608p pd=2.52u as=0.2132p ps=1.34u w=0.82u l=0.6u
X7 a_36_68# A1 ZN VPW nfet_05v0 ad=0.2132p pd=1.34u as=0.2132p ps=1.34u w=0.82u l=0.6u
.ends

.subckt gf180mcu_fd_sc_mcu7t5v0__fillcap_32 VDD VSS VNW VPW
X0 VDD a_572_375# a_484_472# VNW pfet_05v0 ad=0.5368p pd=3.32u as=0.5368p ps=3.32u w=1.22u l=1u
X1 VDD a_2364_375# a_2276_472# VNW pfet_05v0 ad=0.5368p pd=3.32u as=0.5368p ps=3.32u w=1.22u l=1u
X2 a_572_375# a_484_472# VSS VPW nfet_05v0 ad=0.3608p pd=2.52u as=0.3608p ps=2.52u w=0.82u l=1u
X3 VDD a_1916_375# a_1828_472# VNW pfet_05v0 ad=0.5368p pd=3.32u as=0.5368p ps=3.32u w=1.22u l=1u
X4 a_124_375# a_36_472# VSS VPW nfet_05v0 ad=0.3608p pd=2.52u as=0.3608p ps=2.52u w=0.82u l=1u
X5 a_1916_375# a_1828_472# VSS VPW nfet_05v0 ad=0.3608p pd=2.52u as=0.3608p ps=2.52u w=0.82u l=1u
X6 a_1468_375# a_1380_472# VSS VPW nfet_05v0 ad=0.3608p pd=2.52u as=0.3608p ps=2.52u w=0.82u l=1u
X7 a_2812_375# a_2724_472# VSS VPW nfet_05v0 ad=0.3608p pd=2.52u as=0.3608p ps=2.52u w=0.82u l=1u
X8 VDD a_3260_375# a_3172_472# VNW pfet_05v0 ad=0.5368p pd=3.32u as=0.5368p ps=3.32u w=1.22u l=1u
X9 a_2364_375# a_2276_472# VSS VPW nfet_05v0 ad=0.3608p pd=2.52u as=0.3608p ps=2.52u w=0.82u l=1u
X10 VDD a_2812_375# a_2724_472# VNW pfet_05v0 ad=0.5368p pd=3.32u as=0.5368p ps=3.32u w=1.22u l=1u
X11 a_3260_375# a_3172_472# VSS VPW nfet_05v0 ad=0.3608p pd=2.52u as=0.3608p ps=2.52u w=0.82u l=1u
X12 VDD a_1020_375# a_932_472# VNW pfet_05v0 ad=0.5368p pd=3.32u as=0.5368p ps=3.32u w=1.22u l=1u
X13 VDD a_1468_375# a_1380_472# VNW pfet_05v0 ad=0.5368p pd=3.32u as=0.5368p ps=3.32u w=1.22u l=1u
X14 VDD a_124_375# a_36_472# VNW pfet_05v0 ad=0.5368p pd=3.32u as=0.5368p ps=3.32u w=1.22u l=1u
X15 a_1020_375# a_932_472# VSS VPW nfet_05v0 ad=0.3608p pd=2.52u as=0.3608p ps=2.52u w=0.82u l=1u
.ends

.subckt gf180mcu_fd_sc_mcu7t5v0__dffrnq_1 D Q RN VSS CLK VDD VNW VPW
X0 VSS CLK a_36_151# VPW nfet_05v0 ad=0.1053p pd=0.925u as=0.1782p ps=1.69u w=0.405u l=0.6u
X1 VSS RN a_1456_156# VPW nfet_05v0 ad=0.2016p pd=1.48u as=43.2f ps=0.6u w=0.36u l=0.6u
X2 Q a_2665_112# VDD VNW pfet_05v0 ad=0.5346p pd=3.31u as=0.5346p ps=3.31u w=1.215u l=0.5u
X3 a_796_472# D VSS VPW nfet_05v0 ad=93.59999f pd=0.88u as=0.1584p ps=1.6u w=0.36u l=0.6u
X4 VSS a_2665_112# a_2560_156# VPW nfet_05v0 ad=0.1224p pd=1.04u as=94.5f ps=0.885u w=0.36u l=0.6u
X5 a_2665_112# a_2248_156# a_3041_156# VPW nfet_05v0 ad=0.176p pd=1.68u as=0.134p ps=1.1u w=0.4u l=0.6u
X6 a_1000_472# a_448_472# a_796_472# VNW pfet_05v0 ad=0.2028p pd=1.3u as=0.2028p ps=1.3u w=0.78u l=0.5u
X7 a_2248_156# a_36_151# a_1308_423# VNW pfet_05v0 ad=0.25375p pd=1.51u as=0.2424p ps=1.465u w=0.505u l=0.5u
X8 a_2248_156# a_448_472# a_1308_423# VPW nfet_05v0 ad=0.2007p pd=1.475u as=0.2007p ps=1.475u w=0.36u l=0.6u
X9 VDD CLK a_36_151# VNW pfet_05v0 ad=0.2249p pd=1.385u as=0.3806p ps=2.61u w=0.865u l=0.5u
X10 a_1456_156# a_1308_423# a_1288_156# VPW nfet_05v0 ad=43.2f pd=0.6u as=43.2f ps=0.6u w=0.36u l=0.6u
X11 a_1308_423# a_1000_472# VSS VPW nfet_05v0 ad=0.2007p pd=1.475u as=0.2016p ps=1.48u w=0.36u l=0.6u
X12 Q a_2665_112# VSS VPW nfet_05v0 ad=0.3586p pd=2.51u as=0.3586p ps=2.51u w=0.815u l=0.6u
X13 a_448_472# a_36_151# VDD VNW pfet_05v0 ad=0.3806p pd=2.61u as=0.2249p ps=1.385u w=0.865u l=0.5u
X14 a_1204_472# a_36_151# a_1000_472# VNW pfet_05v0 ad=0.2028p pd=1.3u as=0.2028p ps=1.3u w=0.78u l=0.5u
X15 a_1204_472# RN VDD VNW pfet_05v0 ad=0.3432p pd=2.44u as=0.45p ps=2.02u w=0.78u l=0.5u
X16 a_2665_112# RN VDD VNW pfet_05v0 ad=0.26p pd=1.52u as=0.29465p ps=1.74u w=1u l=0.5u
X17 a_2560_156# a_36_151# a_2248_156# VPW nfet_05v0 ad=94.5f pd=0.885u as=0.2007p ps=1.475u w=0.36u l=0.6u
X18 VDD a_2248_156# a_2665_112# VNW pfet_05v0 ad=0.44p pd=2.88u as=0.26p ps=1.52u w=1u l=0.5u
X19 a_1288_156# a_448_472# a_1000_472# VPW nfet_05v0 ad=43.2f pd=0.6u as=93.59999f ps=0.88u w=0.36u l=0.6u
X20 VDD a_1308_423# a_1204_472# VNW pfet_05v0 ad=0.45p pd=2.02u as=0.2028p ps=1.3u w=0.78u l=0.5u
X21 a_2560_156# a_448_472# a_2248_156# VNW pfet_05v0 ad=0.1313p pd=1.025u as=0.25375p ps=1.51u w=0.505u l=0.5u
X22 a_448_472# a_36_151# VSS VPW nfet_05v0 ad=0.1782p pd=1.69u as=0.1053p ps=0.925u w=0.405u l=0.6u
X23 a_3041_156# RN VSS VPW nfet_05v0 ad=0.134p pd=1.1u as=0.1224p ps=1.04u w=0.36u l=0.6u
X24 VDD a_2665_112# a_2560_156# VNW pfet_05v0 ad=0.29465p pd=1.74u as=0.1313p ps=1.025u w=0.505u l=0.5u
X25 a_1308_423# a_1000_472# VDD VNW pfet_05v0 ad=0.2424p pd=1.465u as=0.2222p ps=1.89u w=0.505u l=0.5u
X26 a_1000_472# a_36_151# a_796_472# VPW nfet_05v0 ad=93.59999f pd=0.88u as=93.59999f ps=0.88u w=0.36u l=0.6u
X27 a_796_472# D VDD VNW pfet_05v0 ad=0.2028p pd=1.3u as=0.3432p ps=2.44u w=0.78u l=0.5u
.ends

.subckt gf180mcu_fd_sc_mcu7t5v0__buf_2 VSS Z I VDD VNW VPW
X0 Z a_36_68# VDD VNW pfet_05v0 ad=0.3782p pd=1.84u as=0.4941p ps=2.03u w=1.22u l=0.5u
X1 VSS I a_36_68# VPW nfet_05v0 ad=0.2911p pd=1.53u as=0.3608p ps=2.52u w=0.82u l=0.6u
X2 Z a_36_68# VSS VPW nfet_05v0 ad=0.2132p pd=1.34u as=0.2911p ps=1.53u w=0.82u l=0.6u
X3 VDD I a_36_68# VNW pfet_05v0 ad=0.4941p pd=2.03u as=0.5368p ps=3.32u w=1.22u l=0.5u
X4 VSS a_36_68# Z VPW nfet_05v0 ad=0.3608p pd=2.52u as=0.2132p ps=1.34u w=0.82u l=0.6u
X5 VDD a_36_68# Z VNW pfet_05v0 ad=0.5368p pd=3.32u as=0.3782p ps=1.84u w=1.22u l=0.5u
.ends

.subckt gf180mcu_fd_sc_mcu7t5v0__buf_4 Z I VDD VSS VNW VPW
X0 Z a_224_472# VDD VNW pfet_05v0 ad=0.3782p pd=1.84u as=0.3782p ps=1.84u w=1.22u l=0.5u
X1 Z a_224_472# VSS VPW nfet_05v0 ad=0.2132p pd=1.34u as=0.2132p ps=1.34u w=0.82u l=0.6u
X2 VDD a_224_472# Z VNW pfet_05v0 ad=0.5368p pd=3.32u as=0.3782p ps=1.84u w=1.22u l=0.5u
X3 a_224_472# I VSS VPW nfet_05v0 ad=0.2132p pd=1.34u as=0.3608p ps=2.52u w=0.82u l=0.6u
X4 VDD I a_224_472# VNW pfet_05v0 ad=0.3782p pd=1.84u as=0.3782p ps=1.84u w=1.22u l=0.5u
X5 Z a_224_472# VDD VNW pfet_05v0 ad=0.3782p pd=1.84u as=0.3782p ps=1.84u w=1.22u l=0.5u
X6 VDD a_224_472# Z VNW pfet_05v0 ad=0.3782p pd=1.84u as=0.3782p ps=1.84u w=1.22u l=0.5u
X7 VSS a_224_472# Z VPW nfet_05v0 ad=0.3608p pd=2.52u as=0.2132p ps=1.34u w=0.82u l=0.6u
X8 VSS a_224_472# Z VPW nfet_05v0 ad=0.2132p pd=1.34u as=0.2132p ps=1.34u w=0.82u l=0.6u
X9 a_224_472# I VDD VNW pfet_05v0 ad=0.3782p pd=1.84u as=0.5368p ps=3.32u w=1.22u l=0.5u
X10 VSS I a_224_472# VPW nfet_05v0 ad=0.2132p pd=1.34u as=0.2132p ps=1.34u w=0.82u l=0.6u
X11 Z a_224_472# VSS VPW nfet_05v0 ad=0.2132p pd=1.34u as=0.2132p ps=1.34u w=0.82u l=0.6u
.ends

.subckt gf180mcu_fd_sc_mcu7t5v0__clkbuf_8 Z VSS VDD I VNW VPW
X0 Z a_224_552# VSS VPW nfet_05v0 ad=0.1118p pd=0.95u as=0.1892p ps=1.74u w=0.43u l=0.6u
X1 VSS a_224_552# Z VPW nfet_05v0 ad=0.1118p pd=0.95u as=0.1118p ps=0.95u w=0.43u l=0.6u
X2 VDD a_224_552# Z VNW pfet_05v0 ad=0.3172p pd=1.74u as=0.4392p ps=1.94u w=1.22u l=0.5u
X3 a_224_552# I VDD VNW pfet_05v0 ad=0.2952p pd=1.54u as=0.3608p ps=2.52u w=0.82u l=0.5u
X4 VDD I a_224_552# VNW pfet_05v0 ad=0.2132p pd=1.34u as=0.2952p ps=1.54u w=0.82u l=0.5u
X5 Z a_224_552# VDD VNW pfet_05v0 ad=0.4392p pd=1.94u as=0.3172p ps=1.74u w=1.22u l=0.5u
X6 VDD a_224_552# Z VNW pfet_05v0 ad=0.3172p pd=1.74u as=0.4392p ps=1.94u w=1.22u l=0.5u
X7 VSS I a_224_552# VPW nfet_05v0 ad=0.1053p pd=0.925u as=0.1053p ps=0.925u w=0.405u l=0.6u
X8 a_224_552# I VDD VNW pfet_05v0 ad=0.2952p pd=1.54u as=0.2132p ps=1.34u w=0.82u l=0.5u
X9 VDD a_224_552# Z VNW pfet_05v0 ad=0.3172p pd=1.74u as=0.4392p ps=1.94u w=1.22u l=0.5u
X10 VSS a_224_552# Z VPW nfet_05v0 ad=0.1892p pd=1.74u as=0.1118p ps=0.95u w=0.43u l=0.6u
X11 Z a_224_552# VDD VNW pfet_05v0 ad=0.4392p pd=1.94u as=0.3172p ps=1.74u w=1.22u l=0.5u
X12 Z a_224_552# VSS VPW nfet_05v0 ad=0.1118p pd=0.95u as=0.1118p ps=0.95u w=0.43u l=0.6u
X13 VSS a_224_552# Z VPW nfet_05v0 ad=0.1118p pd=0.95u as=0.1118p ps=0.95u w=0.43u l=0.6u
X14 Z a_224_552# VSS VPW nfet_05v0 ad=0.1118p pd=0.95u as=0.1118p ps=0.95u w=0.43u l=0.6u
X15 Z a_224_552# VDD VNW pfet_05v0 ad=0.4392p pd=1.94u as=0.3172p ps=1.74u w=1.22u l=0.5u
X16 VDD I a_224_552# VNW pfet_05v0 ad=0.367p pd=1.92u as=0.2952p ps=1.54u w=0.82u l=0.5u
X17 VDD a_224_552# Z VNW pfet_05v0 ad=0.5368p pd=3.32u as=0.4392p ps=1.94u w=1.22u l=0.5u
X18 a_224_552# I VSS VPW nfet_05v0 ad=0.1053p pd=0.925u as=0.1782p ps=1.69u w=0.405u l=0.6u
X19 Z a_224_552# VSS VPW nfet_05v0 ad=0.1118p pd=0.95u as=0.1118p ps=0.95u w=0.43u l=0.6u
X20 Z a_224_552# VDD VNW pfet_05v0 ad=0.4392p pd=1.94u as=0.367p ps=1.92u w=1.22u l=0.5u
X21 a_224_552# I VSS VPW nfet_05v0 ad=0.1782p pd=1.69u as=0.1053p ps=0.925u w=0.405u l=0.6u
X22 VSS a_224_552# Z VPW nfet_05v0 ad=0.1118p pd=0.95u as=0.1118p ps=0.95u w=0.43u l=0.6u
.ends

.subckt gf180mcu_fd_sc_mcu7t5v0__mux2_2 S VDD VSS Z I0 I1 VNW VPW
X0 a_1152_472# S a_124_24# VNW pfet_05v0 ad=0.1464p pd=1.46u as=0.3172p ps=1.74u w=1.22u l=0.5u
X1 a_692_68# I1 VSS VPW nfet_05v0 ad=98.39999f pd=1.06u as=0.2132p ps=1.34u w=0.82u l=0.6u
X2 a_124_24# S a_692_68# VPW nfet_05v0 ad=0.2132p pd=1.34u as=98.39999f ps=1.06u w=0.82u l=0.6u
X3 Z a_124_24# VSS VPW nfet_05v0 ad=0.2132p pd=1.34u as=0.3608p ps=2.52u w=0.82u l=0.6u
X4 a_848_380# S VSS VPW nfet_05v0 ad=0.3608p pd=2.52u as=0.2132p ps=1.34u w=0.82u l=0.6u
X5 VDD a_124_24# Z VNW pfet_05v0 ad=0.4392p pd=1.94u as=0.3477p ps=1.79u w=1.22u l=0.5u
X6 VDD I0 a_1152_472# VNW pfet_05v0 ad=0.3172p pd=1.74u as=0.1464p ps=1.46u w=1.22u l=0.5u
X7 a_692_472# I1 VDD VNW pfet_05v0 ad=0.4758p pd=2u as=0.4392p ps=1.94u w=1.22u l=0.5u
X8 a_848_380# S VDD VNW pfet_05v0 ad=0.5368p pd=3.32u as=0.3172p ps=1.74u w=1.22u l=0.5u
X9 Z a_124_24# VDD VNW pfet_05v0 ad=0.3477p pd=1.79u as=0.5368p ps=3.32u w=1.22u l=0.5u
X10 VSS I0 a_1084_68# VPW nfet_05v0 ad=0.2132p pd=1.34u as=0.1968p ps=1.3u w=0.82u l=0.6u
X11 a_1084_68# a_848_380# a_124_24# VPW nfet_05v0 ad=0.1968p pd=1.3u as=0.2132p ps=1.34u w=0.82u l=0.6u
X12 VSS a_124_24# Z VPW nfet_05v0 ad=0.2132p pd=1.34u as=0.2132p ps=1.34u w=0.82u l=0.6u
X13 a_124_24# a_848_380# a_692_472# VNW pfet_05v0 ad=0.3172p pd=1.74u as=0.4758p ps=2u w=1.22u l=0.5u
.ends

.subckt gf180mcu_fd_sc_mcu7t5v0__aoi22_1 B1 B2 VDD VSS ZN A1 A2 VNW VPW
X0 ZN B1 a_257_69# VPW nfet_05v0 ad=0.2119p pd=1.335u as=0.1304p ps=1.135u w=0.815u l=0.6u
X1 VDD B2 a_49_472# VNW pfet_05v0 ad=0.3159p pd=1.735u as=0.5346p ps=3.31u w=1.215u l=0.5u
X2 a_49_472# B1 VDD VNW pfet_05v0 ad=0.3159p pd=1.735u as=0.3159p ps=1.735u w=1.215u l=0.5u
X3 ZN A1 a_49_472# VNW pfet_05v0 ad=0.3159p pd=1.735u as=0.3159p ps=1.735u w=1.215u l=0.5u
X4 a_49_472# A2 ZN VNW pfet_05v0 ad=0.5346p pd=3.31u as=0.3159p ps=1.735u w=1.215u l=0.5u
X5 a_257_69# B2 VSS VPW nfet_05v0 ad=0.1304p pd=1.135u as=0.3586p ps=2.51u w=0.815u l=0.6u
X6 a_665_69# A1 ZN VPW nfet_05v0 ad=0.1304p pd=1.135u as=0.2119p ps=1.335u w=0.815u l=0.6u
X7 VSS A2 a_665_69# VPW nfet_05v0 ad=0.3586p pd=2.51u as=0.1304p ps=1.135u w=0.815u l=0.6u
.ends

.subckt gf180mcu_fd_sc_mcu7t5v0__or3_1 A3 VDD VSS Z A1 A2 VNW VPW
X0 a_224_604# A1 a_36_88# VNW pfet_05v0 ad=0.1736p pd=1.18u as=0.2464p ps=2u w=0.56u l=0.5u
X1 a_36_88# A2 VSS VPW nfet_05v0 ad=0.14p pd=1.1u as=0.104p ps=0.92u w=0.4u l=0.6u
X2 Z a_36_88# VDD VNW pfet_05v0 ad=0.5368p pd=3.32u as=0.389p ps=2.02u w=1.22u l=0.5u
X3 VSS A1 a_36_88# VPW nfet_05v0 ad=0.104p pd=0.92u as=0.176p ps=1.68u w=0.4u l=0.6u
X4 a_448_604# A2 a_224_604# VNW pfet_05v0 ad=0.224p pd=1.36u as=0.1736p ps=1.18u w=0.56u l=0.5u
X5 VSS A3 a_36_88# VPW nfet_05v0 ad=0.224p pd=1.52u as=0.14p ps=1.1u w=0.4u l=0.6u
X6 VDD A3 a_448_604# VNW pfet_05v0 ad=0.389p pd=2.02u as=0.224p ps=1.36u w=0.56u l=0.5u
X7 Z a_36_88# VSS VPW nfet_05v0 ad=0.3608p pd=2.52u as=0.224p ps=1.52u w=0.82u l=0.6u
.ends

.subckt gf180mcu_fd_sc_mcu7t5v0__oai31_1 VDD ZN B A1 A2 VSS A3 VNW VPW
X0 a_468_497# A1 ZN VNW pfet_05v0 ad=0.58035p pd=2.155u as=0.4012p ps=1.85u w=1.095u l=0.5u
X1 a_244_69# A2 ZN VPW nfet_05v0 ad=0.2119p pd=1.335u as=0.4137p ps=1.9u w=0.815u l=0.6u
X2 a_780_497# A2 a_468_497# VNW pfet_05v0 ad=0.2847p pd=1.615u as=0.58035p ps=2.155u w=1.095u l=0.5u
X3 ZN A1 a_244_69# VPW nfet_05v0 ad=0.4137p pd=1.9u as=0.2119p ps=1.335u w=0.815u l=0.6u
X4 VDD A3 a_780_497# VNW pfet_05v0 ad=0.5913p pd=3.27u as=0.2847p ps=1.615u w=1.095u l=0.5u
X5 a_244_69# B VSS VPW nfet_05v0 ad=0.2119p pd=1.335u as=0.3586p ps=2.51u w=0.815u l=0.6u
X6 ZN B VDD VNW pfet_05v0 ad=0.4012p pd=1.85u as=0.4972p ps=3.14u w=1.13u l=0.5u
X7 ZN A3 a_244_69# VPW nfet_05v0 ad=0.3586p pd=2.51u as=0.2119p ps=1.335u w=0.815u l=0.6u
.ends

.subckt gf180mcu_fd_sc_mcu7t5v0__oai221_1 B1 C VDD VSS ZN A1 A2 B2 VNW VPW
X0 a_692_68# C a_36_68# VPW nfet_05v0 ad=0.246p pd=1.42u as=0.2132p ps=1.34u w=0.82u l=0.6u
X1 a_932_472# A2 VDD VNW pfet_05v0 ad=0.3172p pd=1.74u as=0.38575p ps=1.92u w=1.22u l=0.5u
X2 VSS B2 a_36_68# VPW nfet_05v0 ad=0.2132p pd=1.34u as=0.3608p ps=2.52u w=0.82u l=0.6u
X3 ZN A2 a_692_68# VPW nfet_05v0 ad=0.2132p pd=1.34u as=0.246p ps=1.42u w=0.82u l=0.6u
X4 a_244_472# B2 VDD VNW pfet_05v0 ad=0.3172p pd=1.74u as=0.6588p ps=3.52u w=1.22u l=0.5u
X5 ZN A1 a_932_472# VNW pfet_05v0 ad=0.5368p pd=3.32u as=0.3172p ps=1.74u w=1.22u l=0.5u
X6 VDD C ZN VNW pfet_05v0 ad=0.38575p pd=1.92u as=0.3952p ps=1.94u w=0.945u l=0.5u
X7 ZN B1 a_244_472# VNW pfet_05v0 ad=0.3952p pd=1.94u as=0.3172p ps=1.74u w=1.22u l=0.5u
X8 a_36_68# B1 VSS VPW nfet_05v0 ad=0.2132p pd=1.34u as=0.2132p ps=1.34u w=0.82u l=0.6u
X9 a_692_68# A1 ZN VPW nfet_05v0 ad=0.3608p pd=2.52u as=0.2132p ps=1.34u w=0.82u l=0.6u
.ends

.subckt gf180mcu_fd_sc_mcu7t5v0__clkbuf_2 Z VSS VDD I VNW VPW
X0 VDD I a_36_160# VNW pfet_05v0 ad=0.458p pd=2.02u as=0.4488p ps=2.92u w=1.02u l=0.5u
X1 VSS I a_36_160# VPW nfet_05v0 ad=0.151p pd=1.185u as=0.1584p ps=1.6u w=0.36u l=0.6u
X2 VDD a_36_160# Z VNW pfet_05v0 ad=0.5368p pd=3.32u as=0.3782p ps=1.84u w=1.22u l=0.5u
X3 Z a_36_160# VDD VNW pfet_05v0 ad=0.3782p pd=1.84u as=0.458p ps=2.02u w=1.22u l=0.5u
X4 VSS a_36_160# Z VPW nfet_05v0 ad=0.2134p pd=1.85u as=0.1261p ps=1.005u w=0.485u l=0.6u
X5 Z a_36_160# VSS VPW nfet_05v0 ad=0.1261p pd=1.005u as=0.151p ps=1.185u w=0.485u l=0.6u
.ends

.subckt gf180mcu_fd_sc_mcu7t5v0__clkinv_1 VDD VSS I ZN VNW VPW
X0 ZN I VSS VPW nfet_05v0 ad=0.2112p pd=1.84u as=0.2112p ps=1.84u w=0.48u l=0.6u
X1 ZN I VDD VNW pfet_05v0 ad=0.5368p pd=3.32u as=0.5368p ps=3.32u w=1.22u l=0.5u
.ends

.subckt gf180mcu_fd_sc_mcu7t5v0__nand3_1 A3 VDD VSS ZN A1 A2 VNW VPW
X0 ZN A1 a_455_68# VPW nfet_05v0 ad=0.3608p pd=2.52u as=0.1722p ps=1.24u w=0.82u l=0.6u
X1 ZN A3 VDD VNW pfet_05v0 ad=0.2561p pd=1.505u as=0.4334p ps=2.85u w=0.985u l=0.5u
X2 VDD A2 ZN VNW pfet_05v0 ad=0.2561p pd=1.505u as=0.2561p ps=1.505u w=0.985u l=0.5u
X3 ZN A1 VDD VNW pfet_05v0 ad=0.4334p pd=2.85u as=0.2561p ps=1.505u w=0.985u l=0.5u
X4 a_271_68# A3 VSS VPW nfet_05v0 ad=0.1312p pd=1.14u as=0.3608p ps=2.52u w=0.82u l=0.6u
X5 a_455_68# A2 a_271_68# VPW nfet_05v0 ad=0.1722p pd=1.24u as=0.1312p ps=1.14u w=0.82u l=0.6u
.ends

.subckt gf180mcu_fd_sc_mcu7t5v0__nand2_1 VDD VSS ZN A1 A2 VNW VPW
X0 ZN A2 VDD VNW pfet_05v0 ad=0.2938p pd=1.65u as=0.4972p ps=3.14u w=1.13u l=0.5u
X1 ZN A1 a_245_68# VPW nfet_05v0 ad=0.3608p pd=2.52u as=0.1312p ps=1.14u w=0.82u l=0.6u
X2 VDD A1 ZN VNW pfet_05v0 ad=0.4972p pd=3.14u as=0.2938p ps=1.65u w=1.13u l=0.5u
X3 a_245_68# A2 VSS VPW nfet_05v0 ad=0.1312p pd=1.14u as=0.3608p ps=2.52u w=0.82u l=0.6u
.ends

.subckt gf180mcu_fd_sc_mcu7t5v0__inv_4 VSS ZN I VDD VNW VPW
X0 ZN I VDD VNW pfet_05v0 ad=0.4392p pd=1.94u as=0.3172p ps=1.74u w=1.22u l=0.5u
X1 ZN I VSS VPW nfet_05v0 ad=0.2132p pd=1.34u as=0.2132p ps=1.34u w=0.82u l=0.6u
X2 ZN I VSS VPW nfet_05v0 ad=0.2132p pd=1.34u as=0.3608p ps=2.52u w=0.82u l=0.6u
X3 VDD I ZN VNW pfet_05v0 ad=0.5368p pd=3.32u as=0.4392p ps=1.94u w=1.22u l=0.5u
X4 VSS I ZN VPW nfet_05v0 ad=0.3608p pd=2.52u as=0.2132p ps=1.34u w=0.82u l=0.6u
X5 ZN I VDD VNW pfet_05v0 ad=0.4392p pd=1.94u as=0.5368p ps=3.32u w=1.22u l=0.5u
X6 VSS I ZN VPW nfet_05v0 ad=0.2132p pd=1.34u as=0.2132p ps=1.34u w=0.82u l=0.6u
X7 VDD I ZN VNW pfet_05v0 ad=0.3172p pd=1.74u as=0.4392p ps=1.94u w=1.22u l=0.5u
.ends

.subckt gf180mcu_fd_sc_mcu7t5v0__tiel ZN VDD VSS VNW VPW
X0 ZN a_124_24# VSS VPW nfet_05v0 ad=0.3608p pd=2.52u as=0.3608p ps=2.52u w=0.82u l=0.6u
X1 a_124_24# a_124_24# VDD VNW pfet_05v0 ad=0.5368p pd=3.32u as=0.5368p ps=3.32u w=1.22u l=0.5u
.ends

.subckt gf180mcu_fd_sc_mcu7t5v0__clkbuf_1 VSS Z I VDD VNW VPW
X0 VDD I a_36_113# VNW pfet_05v0 ad=0.4015p pd=1.92u as=0.462p ps=2.98u w=1.05u l=0.5u
X1 Z a_36_113# VDD VNW pfet_05v0 ad=0.5368p pd=3.32u as=0.4015p ps=1.92u w=1.22u l=0.5u
X2 Z a_36_113# VSS VPW nfet_05v0 ad=0.2178p pd=1.87u as=0.153p ps=1.195u w=0.495u l=0.6u
X3 VSS I a_36_113# VPW nfet_05v0 ad=0.153p pd=1.195u as=0.1584p ps=1.6u w=0.36u l=0.6u
.ends

.subckt gf180mcu_fd_sc_mcu7t5v0__aoi21_1 B VDD VSS ZN A1 A2 VNW VPW
X0 a_244_68# A2 VSS VPW nfet_05v0 ad=0.1312p pd=1.14u as=0.3608p ps=2.52u w=0.82u l=0.6u
X1 ZN A1 a_244_68# VPW nfet_05v0 ad=0.2569p pd=1.56u as=0.1312p ps=1.14u w=0.82u l=0.6u
X2 VDD B a_36_472# VNW pfet_05v0 ad=0.5346p pd=3.31u as=0.44955p ps=1.955u w=1.215u l=0.5u
X3 ZN A2 a_36_472# VNW pfet_05v0 ad=0.3159p pd=1.735u as=0.5346p ps=3.31u w=1.215u l=0.5u
X4 a_36_472# A1 ZN VNW pfet_05v0 ad=0.44955p pd=1.955u as=0.3159p ps=1.735u w=1.215u l=0.5u
X5 VSS B ZN VPW nfet_05v0 ad=0.2244p pd=1.9u as=0.2569p ps=1.56u w=0.51u l=0.6u
.ends

.subckt gf180mcu_fd_sc_mcu7t5v0__xnor2_1 VDD VSS ZN A1 A2 VNW VPW
X0 ZN a_64_93# VDD VNW pfet_05v0 ad=0.31207p pd=1.665u as=0.34437p ps=1.895u w=1.095u l=0.5u
X1 a_272_93# A2 a_64_93# VPW nfet_05v0 ad=57.59999f pd=0.68u as=0.1584p ps=1.6u w=0.36u l=0.6u
X2 VSS A1 a_272_93# VPW nfet_05v0 ad=0.218p pd=1.52u as=57.59999f ps=0.68u w=0.36u l=0.6u
X3 a_716_68# a_64_93# VSS VPW nfet_05v0 ad=0.2132p pd=1.34u as=0.218p ps=1.52u w=0.82u l=0.6u
X4 VDD A2 a_930_497# VNW pfet_05v0 ad=0.4818p pd=3.07u as=0.55297p ps=2.105u w=1.095u l=0.5u
X5 ZN A1 a_716_68# VPW nfet_05v0 ad=0.4161p pd=1.905u as=0.2132p ps=1.34u w=0.82u l=0.6u
X6 a_64_93# A2 VDD VNW pfet_05v0 ad=0.1456p pd=1.08u as=0.2464p ps=2u w=0.56u l=0.5u
X7 a_716_68# A2 ZN VPW nfet_05v0 ad=0.3608p pd=2.52u as=0.4161p ps=1.905u w=0.82u l=0.6u
X8 VDD A1 a_64_93# VNW pfet_05v0 ad=0.34437p pd=1.895u as=0.1456p ps=1.08u w=0.56u l=0.5u
X9 a_930_497# A1 ZN VNW pfet_05v0 ad=0.55297p pd=2.105u as=0.31207p ps=1.665u w=1.095u l=0.5u
.ends

.subckt gf180mcu_fd_sc_mcu7t5v0__aoi211_1 B C VDD VSS ZN A1 A2 VNW VPW
X0 ZN A2 a_37_472# VNW pfet_05v0 ad=0.3159p pd=1.735u as=0.5346p ps=3.31u w=1.215u l=0.5u
X1 VSS B ZN VPW nfet_05v0 ad=0.1209p pd=0.985u as=0.21175p ps=1.41u w=0.465u l=0.6u
X2 a_37_472# A1 ZN VNW pfet_05v0 ad=0.37665p pd=1.835u as=0.3159p ps=1.735u w=1.215u l=0.5u
X3 VDD C a_653_472# VNW pfet_05v0 ad=0.5346p pd=3.31u as=0.37665p ps=1.835u w=1.215u l=0.5u
X4 a_245_90# A2 VSS VPW nfet_05v0 ad=85.2f pd=0.95u as=0.3124p ps=2.3u w=0.71u l=0.6u
X5 ZN A1 a_245_90# VPW nfet_05v0 ad=0.21175p pd=1.41u as=85.2f ps=0.95u w=0.71u l=0.6u
X6 a_653_472# B a_37_472# VNW pfet_05v0 ad=0.37665p pd=1.835u as=0.37665p ps=1.835u w=1.215u l=0.5u
X7 ZN C VSS VPW nfet_05v0 ad=0.2046p pd=1.81u as=0.1209p ps=0.985u w=0.465u l=0.6u
.ends

.subckt gf180mcu_fd_sc_mcu7t5v0__dlyb_1 VDD I VSS Z VNW VPW
X0 a_523_68# a_47_68# VSS VPW nfet_05v0 ad=43.2f pd=0.6u as=93.59999f ps=0.88u w=0.36u l=0.6u
X1 a_671_644# a_47_68# a_523_68# VPW nfet_05v0 ad=0.369p pd=2.77u as=43.2f ps=0.6u w=0.36u l=0.6u
X2 a_503_644# a_47_68# VDD VNW pfet_05v0 ad=61.19999f pd=0.7u as=0.1116p ps=0.98u w=0.36u l=0.5u
X3 VDD a_671_644# a_1127_622# VNW pfet_05v0 ad=0.379p pd=2.37u as=61.19999f ps=0.7u w=0.36u l=0.5u
X4 VDD I a_47_68# VNW pfet_05v0 ad=0.1116p pd=0.98u as=0.3852p ps=2.86u w=0.36u l=0.5u
X5 Z a_895_68# VSS VPW nfet_05v0 ad=0.3608p pd=2.52u as=0.28262p ps=1.87u w=0.82u l=0.6u
X6 a_1147_68# a_671_644# a_895_68# VPW nfet_05v0 ad=43.8f pd=0.605u as=0.3705p ps=2.77u w=0.365u l=0.6u
X7 a_1127_622# a_671_644# a_895_68# VNW pfet_05v0 ad=61.19999f pd=0.7u as=0.3456p ps=2.64u w=0.36u l=0.5u
X8 VSS a_671_644# a_1147_68# VPW nfet_05v0 ad=0.28262p pd=1.87u as=43.8f ps=0.605u w=0.365u l=0.6u
X9 a_671_644# a_47_68# a_503_644# VNW pfet_05v0 ad=0.3852p pd=2.86u as=61.19999f ps=0.7u w=0.36u l=0.5u
X10 VSS I a_47_68# VPW nfet_05v0 ad=93.59999f pd=0.88u as=0.333p ps=2.57u w=0.36u l=0.6u
X11 Z a_895_68# VDD VNW pfet_05v0 ad=0.5368p pd=3.32u as=0.379p ps=2.37u w=1.22u l=0.5u
.ends

.subckt gf180mcu_fd_sc_mcu7t5v0__mux4_1 I0 VSS VDD I2 I1 S0 I3 S1 Z VNW VPW
X0 VDD S1 a_1525_369# VNW pfet_05v0 ad=0.17515p pd=1.185u as=0.2486p ps=2.01u w=0.565u l=0.5u
X1 a_2929_515# S0 a_1901_156# VNW pfet_05v0 ad=0.2034p pd=1.285u as=0.1469p ps=1.085u w=0.565u l=0.5u
X2 Z a_1081_112# VSS VPW nfet_05v0 ad=0.1672p pd=1.64u as=0.13075p ps=1.08u w=0.38u l=0.6u
X3 VSS I3 a_712_156# VPW nfet_05v0 ad=0.13075p pd=1.08u as=99.45f ps=0.91u w=0.365u l=0.6u
X4 Z a_1081_112# VDD VNW pfet_05v0 ad=0.3432p pd=2.44u as=0.24075p ps=1.48u w=0.78u l=0.5u
X5 VSS I0 a_2929_515# VPW nfet_05v0 ad=94.89999f pd=0.885u as=94.89999f ps=0.885u w=0.365u l=0.6u
X6 VDD I3 a_712_156# VNW pfet_05v0 ad=0.24075p pd=1.48u as=0.1596p ps=1.13u w=0.565u l=0.5u
X7 a_1901_156# S0 a_2521_156# VPW nfet_05v0 ad=94.89999f pd=0.885u as=94.89999f ps=0.885u w=0.365u l=0.6u
X8 a_468_156# a_348_112# a_224_515# VPW nfet_05v0 ad=0.11315p pd=0.985u as=94.89999f ps=0.885u w=0.365u l=0.6u
X9 a_468_156# S0 a_224_515# VNW pfet_05v0 ad=0.18645p pd=1.225u as=0.24295p ps=1.425u w=0.565u l=0.5u
X10 a_224_515# I2 VDD VNW pfet_05v0 ad=0.24295p pd=1.425u as=0.2486p ps=2.01u w=0.565u l=0.5u
X11 a_1901_156# S1 a_1081_112# VNW pfet_05v0 ad=0.2486p pd=2.01u as=0.2486p ps=1.445u w=0.565u l=0.5u
X12 a_712_156# S0 a_468_156# VPW nfet_05v0 ad=99.45f pd=0.91u as=0.11315p ps=0.985u w=0.365u l=0.6u
X13 a_348_112# S0 VDD VNW pfet_05v0 ad=0.2486p pd=2.01u as=0.17515p ps=1.185u w=0.565u l=0.5u
X14 a_1081_112# a_1525_369# a_468_156# VNW pfet_05v0 ad=0.2486p pd=1.445u as=0.36725p ps=2.43u w=0.565u l=0.5u
X15 a_712_156# a_348_112# a_468_156# VNW pfet_05v0 ad=0.1596p pd=1.13u as=0.18645p ps=1.225u w=0.565u l=0.5u
X16 a_2521_156# I1 VSS VPW nfet_05v0 ad=94.89999f pd=0.885u as=94.89999f ps=0.885u w=0.365u l=0.6u
X17 a_224_515# I2 VSS VPW nfet_05v0 ad=94.89999f pd=0.885u as=0.1606p ps=1.61u w=0.365u l=0.6u
X18 a_348_112# S0 VSS VPW nfet_05v0 ad=0.1606p pd=1.61u as=94.89999f ps=0.885u w=0.365u l=0.6u
X19 a_2521_156# I1 VDD VNW pfet_05v0 ad=0.1469p pd=1.085u as=0.17515p ps=1.185u w=0.565u l=0.5u
X20 VSS S1 a_1525_369# VPW nfet_05v0 ad=94.89999f pd=0.885u as=0.1606p ps=1.61u w=0.365u l=0.6u
X21 VDD I0 a_2929_515# VNW pfet_05v0 ad=0.17515p pd=1.185u as=0.2034p ps=1.285u w=0.565u l=0.5u
X22 a_2929_515# a_348_112# a_1901_156# VPW nfet_05v0 ad=94.89999f pd=0.885u as=94.89999f ps=0.885u w=0.365u l=0.6u
X23 a_1081_112# S1 a_468_156# VPW nfet_05v0 ad=0.11315p pd=0.985u as=0.26462p ps=2.18u w=0.365u l=0.6u
X24 a_1901_156# a_348_112# a_2521_156# VNW pfet_05v0 ad=0.1469p pd=1.085u as=0.1469p ps=1.085u w=0.565u l=0.5u
X25 a_1901_156# a_1525_369# a_1081_112# VPW nfet_05v0 ad=0.1606p pd=1.61u as=0.11315p ps=0.985u w=0.365u l=0.6u
.ends

.subckt gf180mcu_fd_sc_mcu7t5v0__aoi221_1 B2 C VDD VSS ZN A1 A2 B1 VNW VPW
X0 a_672_472# C a_56_472# VNW pfet_05v0 ad=0.3402p pd=1.775u as=0.37665p ps=1.835u w=1.215u l=0.5u
X1 VDD B2 a_56_472# VNW pfet_05v0 ad=0.3159p pd=1.735u as=0.5346p ps=3.31u w=1.215u l=0.5u
X2 ZN A1 a_940_90# VPW nfet_05v0 ad=0.3124p pd=2.3u as=85.2f ps=0.95u w=0.71u l=0.6u
X3 a_56_472# B1 VDD VNW pfet_05v0 ad=0.37665p pd=1.835u as=0.3159p ps=1.735u w=1.215u l=0.5u
X4 a_672_472# A1 ZN VNW pfet_05v0 ad=0.5346p pd=3.31u as=0.37665p ps=1.835u w=1.215u l=0.5u
X5 ZN A2 a_672_472# VNW pfet_05v0 ad=0.37665p pd=1.835u as=0.3402p ps=1.775u w=1.215u l=0.5u
X6 a_244_90# B2 VSS VPW nfet_05v0 ad=85.2f pd=0.95u as=0.3124p ps=2.3u w=0.71u l=0.6u
X7 ZN B1 a_244_90# VPW nfet_05v0 ad=0.21175p pd=1.41u as=85.2f ps=0.95u w=0.71u l=0.6u
X8 a_940_90# A2 VSS VPW nfet_05v0 ad=85.2f pd=0.95u as=0.22595p ps=1.45u w=0.71u l=0.6u
X9 VSS C ZN VPW nfet_05v0 ad=0.22595p pd=1.45u as=0.21175p ps=1.41u w=0.465u l=0.6u
.ends

.subckt gf180mcu_fd_sc_mcu7t5v0__buf_3 VSS Z I VDD VNW VPW
X0 Z a_36_68# VDD VNW pfet_05v0 ad=0.3782p pd=1.84u as=0.4941p ps=2.03u w=1.22u l=0.5u
X1 VSS I a_36_68# VPW nfet_05v0 ad=0.2911p pd=1.53u as=0.3608p ps=2.52u w=0.82u l=0.6u
X2 Z a_36_68# VDD VNW pfet_05v0 ad=0.5368p pd=3.32u as=0.3782p ps=1.84u w=1.22u l=0.5u
X3 Z a_36_68# VSS VPW nfet_05v0 ad=0.3608p pd=2.52u as=0.2132p ps=1.34u w=0.82u l=0.6u
X4 Z a_36_68# VSS VPW nfet_05v0 ad=0.2132p pd=1.34u as=0.2911p ps=1.53u w=0.82u l=0.6u
X5 VDD I a_36_68# VNW pfet_05v0 ad=0.4941p pd=2.03u as=0.5368p ps=3.32u w=1.22u l=0.5u
X6 VSS a_36_68# Z VPW nfet_05v0 ad=0.2132p pd=1.34u as=0.2132p ps=1.34u w=0.82u l=0.6u
X7 VDD a_36_68# Z VNW pfet_05v0 ad=0.3782p pd=1.84u as=0.3782p ps=1.84u w=1.22u l=0.5u
.ends

.subckt gf180mcu_fd_sc_mcu7t5v0__and2_1 VDD VSS Z A1 A2 VNW VPW
X0 VDD A2 a_36_159# VNW pfet_05v0 ad=0.40575p pd=2.055u as=0.156p ps=1.12u w=0.6u l=0.5u
X1 Z a_36_159# VDD VNW pfet_05v0 ad=0.5346p pd=3.31u as=0.40575p ps=2.055u w=1.215u l=0.5u
X2 Z a_36_159# VSS VPW nfet_05v0 ad=0.3586p pd=2.51u as=0.23405p ps=1.555u w=0.815u l=0.6u
X3 VSS A2 a_244_159# VPW nfet_05v0 ad=0.23405p pd=1.555u as=58.39999f ps=0.685u w=0.365u l=0.6u
X4 a_244_159# A1 a_36_159# VPW nfet_05v0 ad=58.39999f pd=0.685u as=0.1606p ps=1.61u w=0.365u l=0.6u
X5 a_36_159# A1 VDD VNW pfet_05v0 ad=0.156p pd=1.12u as=0.264p ps=2.08u w=0.6u l=0.5u
.ends

.subckt gf180mcu_fd_sc_mcu7t5v0__buf_1 VSS Z I VDD VNW VPW
X0 Z a_36_160# VSS VPW nfet_05v0 ad=0.3608p pd=2.52u as=0.2344p ps=1.56u w=0.82u l=0.6u
X1 Z a_36_160# VDD VNW pfet_05v0 ad=0.5368p pd=3.32u as=0.35315p ps=1.96u w=1.22u l=0.5u
X2 VDD I a_36_160# VNW pfet_05v0 ad=0.35315p pd=1.96u as=0.2486p ps=2.01u w=0.565u l=0.5u
X3 VSS I a_36_160# VPW nfet_05v0 ad=0.2344p pd=1.56u as=0.1584p ps=1.6u w=0.36u l=0.6u
.ends

.subckt gf180mcu_fd_sc_mcu7t5v0__nor4_1 A3 A4 VDD VSS ZN A1 A2 VNW VPW
X0 a_672_472# A2 a_448_472# VNW pfet_05v0 ad=0.3782p pd=1.84u as=0.3782p ps=1.84u w=1.22u l=0.5u
X1 VSS A1 ZN VPW nfet_05v0 ad=0.1584p pd=1.6u as=93.59999f ps=0.88u w=0.36u l=0.6u
X2 VSS A3 ZN VPW nfet_05v0 ad=93.59999f pd=0.88u as=93.59999f ps=0.88u w=0.36u l=0.6u
X3 a_244_472# A4 VDD VNW pfet_05v0 ad=0.3172p pd=1.74u as=0.5368p ps=3.32u w=1.22u l=0.5u
X4 a_448_472# A3 a_244_472# VNW pfet_05v0 ad=0.3782p pd=1.84u as=0.3172p ps=1.74u w=1.22u l=0.5u
X5 ZN A2 VSS VPW nfet_05v0 ad=93.59999f pd=0.88u as=93.59999f ps=0.88u w=0.36u l=0.6u
X6 ZN A4 VSS VPW nfet_05v0 ad=93.59999f pd=0.88u as=0.1584p ps=1.6u w=0.36u l=0.6u
X7 ZN A1 a_672_472# VNW pfet_05v0 ad=0.5368p pd=3.32u as=0.3782p ps=1.84u w=1.22u l=0.5u
.ends

.subckt gf180mcu_fd_sc_mcu7t5v0__and4_1 A3 A4 VDD VSS Z A1 A2 VNW VPW
X0 a_48_148# A1 VDD VNW pfet_05v0 ad=0.156p pd=1.12u as=0.264p ps=2.08u w=0.6u l=0.5u
X1 a_440_148# A2 a_256_148# VPW nfet_05v0 ad=88.2f pd=0.84u as=67.2f ps=0.74u w=0.42u l=0.6u
X2 Z a_48_148# VSS VPW nfet_05v0 ad=0.3586p pd=2.51u as=0.226p ps=1.515u w=0.815u l=0.6u
X3 VDD A2 a_48_148# VNW pfet_05v0 ad=0.156p pd=1.12u as=0.156p ps=1.12u w=0.6u l=0.5u
X4 Z a_48_148# VDD VNW pfet_05v0 ad=0.5368p pd=3.32u as=0.395p ps=2.02u w=1.22u l=0.5u
X5 a_644_148# A3 a_440_148# VPW nfet_05v0 ad=88.2f pd=0.84u as=88.2f ps=0.84u w=0.42u l=0.6u
X6 a_48_148# A3 VDD VNW pfet_05v0 ad=0.156p pd=1.12u as=0.156p ps=1.12u w=0.6u l=0.5u
X7 VSS A4 a_644_148# VPW nfet_05v0 ad=0.226p pd=1.515u as=88.2f ps=0.84u w=0.42u l=0.6u
X8 VDD A4 a_48_148# VNW pfet_05v0 ad=0.395p pd=2.02u as=0.156p ps=1.12u w=0.6u l=0.5u
X9 a_256_148# A1 a_48_148# VPW nfet_05v0 ad=67.2f pd=0.74u as=0.1848p ps=1.72u w=0.42u l=0.6u
.ends

.subckt gf180mcu_fd_sc_mcu7t5v0__xor2_1 VDD VSS Z A1 A2 VNW VPW
X0 a_728_472# a_56_604# VDD VNW pfet_05v0 ad=0.3172p pd=1.74u as=0.4005p ps=2.12u w=1.22u l=0.5u
X1 Z A1 a_728_472# VNW pfet_05v0 ad=0.3172p pd=1.74u as=0.3172p ps=1.74u w=1.22u l=0.5u
X2 VSS A1 a_56_604# VPW nfet_05v0 ad=0.218p pd=1.52u as=93.59999f ps=0.88u w=0.36u l=0.6u
X3 a_728_472# A2 Z VNW pfet_05v0 ad=0.5368p pd=3.32u as=0.3172p ps=1.74u w=1.22u l=0.5u
X4 Z a_56_604# VSS VPW nfet_05v0 ad=0.2132p pd=1.34u as=0.218p ps=1.52u w=0.82u l=0.6u
X5 VSS A2 a_952_68# VPW nfet_05v0 ad=0.3608p pd=2.52u as=0.1312p ps=1.14u w=0.82u l=0.6u
X6 a_244_604# A2 a_56_604# VNW pfet_05v0 ad=0.1456p pd=1.08u as=0.2464p ps=2u w=0.56u l=0.5u
X7 a_56_604# A2 VSS VPW nfet_05v0 ad=93.59999f pd=0.88u as=0.1584p ps=1.6u w=0.36u l=0.6u
X8 a_952_68# A1 Z VPW nfet_05v0 ad=0.1312p pd=1.14u as=0.2132p ps=1.34u w=0.82u l=0.6u
X9 VDD A1 a_244_604# VNW pfet_05v0 ad=0.4005p pd=2.12u as=0.1456p ps=1.08u w=0.56u l=0.5u
.ends

.subckt gf180mcu_fd_sc_mcu7t5v0__aoi222_1 VSS VDD C2 C1 B2 B1 A2 A1 ZN VNW VPW
X0 a_291_68# C2 VSS VPW nfet_05v0 ad=98.39999f pd=1.06u as=0.3608p ps=2.52u w=0.82u l=0.6u
X1 a_1235_68# A2 VSS VPW nfet_05v0 ad=0.1722p pd=1.24u as=0.2132p ps=1.34u w=0.82u l=0.6u
X2 a_619_484# A1 ZN VNW pfet_05v0 ad=0.5104p pd=3.2u as=0.3596p ps=1.78u w=1.16u l=0.5u
X3 a_255_484# B1 a_619_484# VNW pfet_05v0 ad=0.3016p pd=1.68u as=0.5104p ps=3.2u w=1.16u l=0.5u
X4 a_619_484# B2 a_255_484# VNW pfet_05v0 ad=0.3016p pd=1.68u as=0.3016p ps=1.68u w=1.16u l=0.5u
X5 a_255_484# C2 VDD VNW pfet_05v0 ad=0.3016p pd=1.68u as=0.5104p ps=3.2u w=1.16u l=0.5u
X6 ZN C1 a_291_68# VPW nfet_05v0 ad=0.33825p pd=1.645u as=98.39999f ps=1.06u w=0.82u l=0.6u
X7 ZN A1 a_1235_68# VPW nfet_05v0 ad=0.3608p pd=2.52u as=0.1722p ps=1.24u w=0.82u l=0.6u
X8 VSS B2 a_744_68# VPW nfet_05v0 ad=0.2132p pd=1.34u as=0.30135p ps=1.555u w=0.82u l=0.6u
X9 VDD C1 a_255_484# VNW pfet_05v0 ad=0.5104p pd=3.2u as=0.3016p ps=1.68u w=1.16u l=0.5u
X10 ZN A2 a_619_484# VNW pfet_05v0 ad=0.3596p pd=1.78u as=0.3016p ps=1.68u w=1.16u l=0.5u
X11 a_744_68# B1 ZN VPW nfet_05v0 ad=0.30135p pd=1.555u as=0.33825p ps=1.645u w=0.82u l=0.6u
.ends

.subckt gf180mcu_fd_sc_mcu7t5v0__clkinv_8 VDD VSS ZN I VNW VPW
X0 ZN I VDD VNW pfet_05v0 ad=0.3782p pd=1.84u as=0.3782p ps=1.84u w=1.22u l=0.5u
X1 ZN I VSS VPW nfet_05v0 ad=0.1248p pd=1u as=0.1248p ps=1u w=0.48u l=0.6u
X2 VSS I ZN VPW nfet_05v0 ad=0.1248p pd=1u as=0.1248p ps=1u w=0.48u l=0.6u
X3 VDD I ZN VNW pfet_05v0 ad=0.3782p pd=1.84u as=0.3782p ps=1.84u w=1.22u l=0.5u
X4 ZN I VSS VPW nfet_05v0 ad=0.1248p pd=1u as=0.1248p ps=1u w=0.48u l=0.6u
X5 VDD I ZN VNW pfet_05v0 ad=0.5368p pd=3.32u as=0.3782p ps=1.84u w=1.22u l=0.5u
X6 ZN I VSS VPW nfet_05v0 ad=0.1248p pd=1u as=0.2112p ps=1.84u w=0.48u l=0.6u
X7 VDD I ZN VNW pfet_05v0 ad=0.3782p pd=1.84u as=0.3782p ps=1.84u w=1.22u l=0.5u
X8 ZN I VSS VPW nfet_05v0 ad=0.1248p pd=1u as=0.1248p ps=1u w=0.48u l=0.6u
X9 ZN I VDD VNW pfet_05v0 ad=0.3782p pd=1.84u as=0.3782p ps=1.84u w=1.22u l=0.5u
X10 VDD I ZN VNW pfet_05v0 ad=0.3782p pd=1.84u as=0.3782p ps=1.84u w=1.22u l=0.5u
X11 VSS I ZN VPW nfet_05v0 ad=0.1248p pd=1u as=0.1248p ps=1u w=0.48u l=0.6u
X12 ZN I VDD VNW pfet_05v0 ad=0.3782p pd=1.84u as=0.3782p ps=1.84u w=1.22u l=0.5u
X13 VSS I ZN VPW nfet_05v0 ad=0.2112p pd=1.84u as=0.1248p ps=1u w=0.48u l=0.6u
X14 ZN I VDD VNW pfet_05v0 ad=0.3782p pd=1.84u as=0.5368p ps=3.32u w=1.22u l=0.5u
X15 VSS I ZN VPW nfet_05v0 ad=0.1248p pd=1u as=0.1248p ps=1u w=0.48u l=0.6u
.ends

.subckt gf180mcu_fd_sc_mcu7t5v0__tieh Z VDD VSS VNW VPW
X0 Z a_125_24# VDD VNW pfet_05v0 ad=0.5368p pd=3.32u as=0.5368p ps=3.32u w=1.22u l=0.5u
X1 a_125_24# a_125_24# VSS VPW nfet_05v0 ad=0.3608p pd=2.52u as=0.3608p ps=2.52u w=0.82u l=0.6u
.ends

.subckt gf180mcu_fd_sc_mcu7t5v0__nand4_1 A3 A4 VDD VSS ZN A1 A2 VNW VPW
X0 ZN A4 VDD VNW pfet_05v0 ad=0.2197p pd=1.365u as=0.3718p ps=2.57u w=0.845u l=0.5u
X1 VDD A3 ZN VNW pfet_05v0 ad=0.2197p pd=1.365u as=0.2197p ps=1.365u w=0.845u l=0.5u
X2 ZN A2 VDD VNW pfet_05v0 ad=0.2197p pd=1.365u as=0.2197p ps=1.365u w=0.845u l=0.5u
X3 VDD A1 ZN VNW pfet_05v0 ad=0.3718p pd=2.57u as=0.2197p ps=1.365u w=0.845u l=0.5u
X4 a_275_68# A4 VSS VPW nfet_05v0 ad=0.1517p pd=1.19u as=0.3608p ps=2.52u w=0.82u l=0.6u
X5 a_673_68# A2 a_469_68# VPW nfet_05v0 ad=0.1517p pd=1.19u as=0.1722p ps=1.24u w=0.82u l=0.6u
X6 a_469_68# A3 a_275_68# VPW nfet_05v0 ad=0.1722p pd=1.24u as=0.1517p ps=1.19u w=0.82u l=0.6u
X7 ZN A1 a_673_68# VPW nfet_05v0 ad=0.3608p pd=2.52u as=0.1517p ps=1.19u w=0.82u l=0.6u
.ends

.subckt gf180mcu_fd_sc_mcu7t5v0__and3_1 A3 VDD VSS Z A1 A2 VNW VPW
X0 Z a_36_148# VDD VNW pfet_05v0 ad=0.5346p pd=3.31u as=0.4268p ps=2.175u w=1.215u l=0.5u
X1 a_428_148# A2 a_244_148# VPW nfet_05v0 ad=79.8f pd=0.8u as=60.8f ps=0.7u w=0.38u l=0.6u
X2 Z a_36_148# VSS VPW nfet_05v0 ad=0.341p pd=2.43u as=0.2424p ps=1.635u w=0.775u l=0.6u
X3 VSS A3 a_428_148# VPW nfet_05v0 ad=0.2424p pd=1.635u as=79.8f ps=0.8u w=0.38u l=0.6u
X4 a_244_148# A1 a_36_148# VPW nfet_05v0 ad=60.8f pd=0.7u as=0.1672p ps=1.64u w=0.38u l=0.6u
X5 VDD A1 a_36_148# VNW pfet_05v0 ad=0.1391p pd=1.055u as=0.2354p ps=1.95u w=0.535u l=0.5u
X6 a_36_148# A2 VDD VNW pfet_05v0 ad=0.1391p pd=1.055u as=0.1391p ps=1.055u w=0.535u l=0.5u
X7 VDD A3 a_36_148# VNW pfet_05v0 ad=0.4268p pd=2.175u as=0.1391p ps=1.055u w=0.535u l=0.5u
.ends

.subckt gf180mcu_fd_sc_mcu7t5v0__or4_1 A3 A4 VDD VSS Z A1 A2 VNW VPW
X0 VSS A4 a_56_604# VPW nfet_05v0 ad=0.218p pd=1.52u as=93.59999f ps=0.88u w=0.36u l=0.6u
X1 Z a_56_604# VSS VPW nfet_05v0 ad=0.3608p pd=2.52u as=0.218p ps=1.52u w=0.82u l=0.6u
X2 Z a_56_604# VDD VNW pfet_05v0 ad=0.5368p pd=3.32u as=0.389p ps=2.02u w=1.22u l=0.5u
X3 VSS A2 a_56_604# VPW nfet_05v0 ad=93.59999f pd=0.88u as=0.126p ps=1.06u w=0.36u l=0.6u
X4 VDD A4 a_708_604# VNW pfet_05v0 ad=0.389p pd=2.02u as=0.1736p ps=1.18u w=0.56u l=0.5u
X5 a_244_604# A1 a_56_604# VNW pfet_05v0 ad=0.196p pd=1.26u as=0.2464p ps=2u w=0.56u l=0.5u
X6 a_56_604# A1 VSS VPW nfet_05v0 ad=0.126p pd=1.06u as=0.1584p ps=1.6u w=0.36u l=0.6u
X7 a_56_604# A3 VSS VPW nfet_05v0 ad=93.59999f pd=0.88u as=93.59999f ps=0.88u w=0.36u l=0.6u
X8 a_708_604# A3 a_484_604# VNW pfet_05v0 ad=0.1736p pd=1.18u as=0.1736p ps=1.18u w=0.56u l=0.5u
X9 a_484_604# A2 a_244_604# VNW pfet_05v0 ad=0.1736p pd=1.18u as=0.196p ps=1.26u w=0.56u l=0.5u
.ends

.subckt gf180mcu_fd_sc_mcu7t5v0__oai22_2 B2 VDD VSS ZN A1 A2 B1 VNW VPW
X0 VDD A2 a_1612_497# VNW pfet_05v0 ad=0.4818p pd=3.07u as=0.4599p ps=1.935u w=1.095u l=0.5u
X1 ZN B1 a_244_497# VNW pfet_05v0 ad=0.2847p pd=1.615u as=0.33945p ps=1.715u w=1.095u l=0.5u
X2 a_672_497# B1 ZN VNW pfet_05v0 ad=0.33945p pd=1.715u as=0.2847p ps=1.615u w=1.095u l=0.5u
X3 a_1140_497# A2 VDD VNW pfet_05v0 ad=0.4599p pd=1.935u as=0.3942p ps=1.815u w=1.095u l=0.5u
X4 VSS B1 a_36_68# VPW nfet_05v0 ad=0.2132p pd=1.34u as=0.2132p ps=1.34u w=0.82u l=0.6u
X5 VSS B2 a_36_68# VPW nfet_05v0 ad=0.2132p pd=1.34u as=0.3608p ps=2.52u w=0.82u l=0.6u
X6 a_36_68# A2 ZN VPW nfet_05v0 ad=0.3608p pd=2.52u as=0.30965p ps=1.685u w=0.82u l=0.6u
X7 a_244_497# B2 VDD VNW pfet_05v0 ad=0.33945p pd=1.715u as=0.4818p ps=3.07u w=1.095u l=0.5u
X8 a_36_68# A1 ZN VPW nfet_05v0 ad=0.2132p pd=1.34u as=0.30965p ps=1.685u w=0.82u l=0.6u
X9 ZN A1 a_1140_497# VNW pfet_05v0 ad=0.2847p pd=1.615u as=0.4599p ps=1.935u w=1.095u l=0.5u
X10 VDD B2 a_672_497# VNW pfet_05v0 ad=0.3942p pd=1.815u as=0.33945p ps=1.715u w=1.095u l=0.5u
X11 a_1612_497# A1 ZN VNW pfet_05v0 ad=0.4599p pd=1.935u as=0.2847p ps=1.615u w=1.095u l=0.5u
X12 ZN A1 a_36_68# VPW nfet_05v0 ad=0.30965p pd=1.685u as=0.2132p ps=1.34u w=0.82u l=0.6u
X13 a_36_68# B2 VSS VPW nfet_05v0 ad=0.2132p pd=1.34u as=0.2132p ps=1.34u w=0.82u l=0.6u
X14 a_36_68# B1 VSS VPW nfet_05v0 ad=0.2132p pd=1.34u as=0.2132p ps=1.34u w=0.82u l=0.6u
X15 ZN A2 a_36_68# VPW nfet_05v0 ad=0.30965p pd=1.685u as=0.2132p ps=1.34u w=0.82u l=0.6u
.ends

.subckt gf180mcu_fd_sc_mcu7t5v0__dffsnq_1 VSS CLK VDD D Q SETN VNW VPW
X0 VSS CLK a_36_151# VPW nfet_05v0 ad=0.1053p pd=0.925u as=0.1782p ps=1.69u w=0.405u l=0.6u
X1 a_1353_112# SETN a_1697_156# VPW nfet_05v0 ad=0.1989p pd=1.465u as=86.39999f ps=0.84u w=0.36u l=0.6u
X2 a_836_156# D VDD VNW pfet_05v0 ad=0.1313p pd=1.025u as=0.22725p ps=1.91u w=0.505u l=0.5u
X3 a_1040_527# a_36_151# a_836_156# VPW nfet_05v0 ad=93.59999f pd=0.88u as=93.59999f ps=0.88u w=0.36u l=0.6u
X4 a_1040_527# a_448_472# a_836_156# VNW pfet_05v0 ad=0.19315p pd=1.27u as=0.1313p ps=1.025u w=0.505u l=0.5u
X5 a_2225_156# a_36_151# a_1353_112# VNW pfet_05v0 ad=0.1079p pd=0.935u as=0.27805p ps=2.17u w=0.415u l=0.5u
X6 VSS a_1353_112# a_1284_156# VPW nfet_05v0 ad=93.59999f pd=0.88u as=62.1f ps=0.705u w=0.36u l=0.6u
X7 a_2225_156# a_448_472# a_1353_112# VPW nfet_05v0 ad=93.59999f pd=0.88u as=0.1989p ps=1.465u w=0.36u l=0.6u
X8 VDD CLK a_36_151# VNW pfet_05v0 ad=0.2249p pd=1.385u as=0.3806p ps=2.61u w=0.865u l=0.5u
X9 a_2449_156# a_448_472# a_2225_156# VNW pfet_05v0 ad=0.1826p pd=1.71u as=0.1079p ps=0.935u w=0.415u l=0.5u
X10 VDD a_3129_107# a_2449_156# VNW pfet_05v0 ad=0.3276p pd=1.62u as=0.2028p ps=1.3u w=0.78u l=0.5u
X11 Q a_3129_107# VSS VPW nfet_05v0 ad=0.3586p pd=2.51u as=0.3586p ps=2.51u w=0.815u l=0.6u
X12 a_448_472# a_36_151# VDD VNW pfet_05v0 ad=0.3806p pd=2.61u as=0.2249p ps=1.385u w=0.865u l=0.5u
X13 a_2449_156# SETN VDD VNW pfet_05v0 ad=0.2028p pd=1.3u as=0.3432p ps=2.44u w=0.78u l=0.5u
X14 VSS a_3129_107# a_3081_151# VPW nfet_05v0 ad=0.14985p pd=1.145u as=48.6f ps=0.645u w=0.405u l=0.6u
X15 a_836_156# D VSS VPW nfet_05v0 ad=93.59999f pd=0.88u as=0.1584p ps=1.6u w=0.36u l=0.6u
X16 a_448_472# a_36_151# VSS VPW nfet_05v0 ad=0.1782p pd=1.69u as=0.1053p ps=0.925u w=0.405u l=0.6u
X17 a_1353_112# a_1040_527# VDD VNW pfet_05v0 ad=0.1521p pd=1.105u as=0.3975p ps=2.185u w=0.585u l=0.5u
X18 a_3129_107# a_2225_156# VSS VPW nfet_05v0 ad=0.1782p pd=1.69u as=0.14985p ps=1.145u w=0.405u l=0.6u
X19 VDD SETN a_1353_112# VNW pfet_05v0 ad=0.4149p pd=2.65u as=0.1521p ps=1.105u w=0.585u l=0.5u
X20 a_1284_156# a_448_472# a_1040_527# VPW nfet_05v0 ad=62.1f pd=0.705u as=93.59999f ps=0.88u w=0.36u l=0.6u
X21 VDD a_1353_112# a_1293_527# VNW pfet_05v0 ad=0.3975p pd=2.185u as=0.101p ps=0.905u w=0.505u l=0.5u
X22 Q a_3129_107# VDD VNW pfet_05v0 ad=0.6561p pd=3.51u as=0.5346p ps=3.31u w=1.215u l=0.5u
X23 a_3129_107# a_2225_156# VDD VNW pfet_05v0 ad=0.3432p pd=2.44u as=0.3276p ps=1.62u w=0.78u l=0.5u
X24 a_2449_156# a_36_151# a_2225_156# VPW nfet_05v0 ad=0.2898p pd=2.33u as=93.59999f ps=0.88u w=0.36u l=0.6u
X25 a_1293_527# a_36_151# a_1040_527# VNW pfet_05v0 ad=0.101p pd=0.905u as=0.19315p ps=1.27u w=0.505u l=0.5u
X26 a_1697_156# a_1040_527# VSS VPW nfet_05v0 ad=86.39999f pd=0.84u as=93.59999f ps=0.88u w=0.36u l=0.6u
X27 a_3081_151# SETN a_2449_156# VPW nfet_05v0 ad=48.6f pd=0.645u as=0.3123p ps=2.38u w=0.405u l=0.6u
.ends

.subckt gf180mcu_fd_sc_mcu7t5v0__clkbuf_16 VDD VSS Z I VNW VPW
X0 VSS I a_224_552# VPW nfet_05v0 ad=0.1053p pd=0.925u as=0.1053p ps=0.925u w=0.405u l=0.6u
X1 VSS a_224_552# Z VPW nfet_05v0 ad=0.1261p pd=1.005u as=0.1261p ps=1.005u w=0.485u l=0.6u
X2 a_224_552# I VDD VNW pfet_05v0 ad=0.2542p pd=1.44u as=0.2542p ps=1.44u w=0.82u l=0.5u
X3 Z a_224_552# VDD VNW pfet_05v0 ad=0.3782p pd=1.84u as=0.3782p ps=1.84u w=1.22u l=0.5u
X4 Z a_224_552# VSS VPW nfet_05v0 ad=0.1261p pd=1.005u as=0.1261p ps=1.005u w=0.485u l=0.6u
X5 VDD a_224_552# Z VNW pfet_05v0 ad=0.3782p pd=1.84u as=0.3782p ps=1.84u w=1.22u l=0.5u
X6 VDD a_224_552# Z VNW pfet_05v0 ad=0.3782p pd=1.84u as=0.3782p ps=1.84u w=1.22u l=0.5u
X7 Z a_224_552# VDD VNW pfet_05v0 ad=0.3782p pd=1.84u as=0.3782p ps=1.84u w=1.22u l=0.5u
X8 a_224_552# I VDD VNW pfet_05v0 ad=0.2542p pd=1.44u as=0.3608p ps=2.52u w=0.82u l=0.5u
X9 VDD a_224_552# Z VNW pfet_05v0 ad=0.3782p pd=1.84u as=0.3782p ps=1.84u w=1.22u l=0.5u
X10 Z a_224_552# VSS VPW nfet_05v0 ad=0.1261p pd=1.005u as=0.1261p ps=1.005u w=0.485u l=0.6u
X11 VSS a_224_552# Z VPW nfet_05v0 ad=0.1261p pd=1.005u as=0.1261p ps=1.005u w=0.485u l=0.6u
X12 VSS a_224_552# Z VPW nfet_05v0 ad=0.1261p pd=1.005u as=0.1261p ps=1.005u w=0.485u l=0.6u
X13 VDD a_224_552# Z VNW pfet_05v0 ad=0.5368p pd=3.32u as=0.3782p ps=1.84u w=1.22u l=0.5u
X14 Z a_224_552# VSS VPW nfet_05v0 ad=0.1261p pd=1.005u as=0.1261p ps=1.005u w=0.485u l=0.6u
X15 VSS I a_224_552# VPW nfet_05v0 ad=0.1053p pd=0.925u as=0.1782p ps=1.69u w=0.405u l=0.6u
X16 a_224_552# I VDD VNW pfet_05v0 ad=0.2542p pd=1.44u as=0.2542p ps=1.44u w=0.82u l=0.5u
X17 a_224_552# I VSS VPW nfet_05v0 ad=0.1053p pd=0.925u as=0.1053p ps=0.925u w=0.405u l=0.6u
X18 VSS a_224_552# Z VPW nfet_05v0 ad=0.1261p pd=1.005u as=0.1261p ps=1.005u w=0.485u l=0.6u
X19 Z a_224_552# VDD VNW pfet_05v0 ad=0.3782p pd=1.84u as=0.428p ps=2.02u w=1.22u l=0.5u
X20 VDD I a_224_552# VNW pfet_05v0 ad=0.2542p pd=1.44u as=0.2542p ps=1.44u w=0.82u l=0.5u
X21 Z a_224_552# VDD VNW pfet_05v0 ad=0.3782p pd=1.84u as=0.3782p ps=1.84u w=1.22u l=0.5u
X22 Z a_224_552# VDD VNW pfet_05v0 ad=0.3782p pd=1.84u as=0.3782p ps=1.84u w=1.22u l=0.5u
X23 VSS I a_224_552# VPW nfet_05v0 ad=0.1053p pd=0.925u as=0.1053p ps=0.925u w=0.405u l=0.6u
X24 VDD a_224_552# Z VNW pfet_05v0 ad=0.3782p pd=1.84u as=0.3782p ps=1.84u w=1.22u l=0.5u
X25 Z a_224_552# VSS VPW nfet_05v0 ad=0.1261p pd=1.005u as=0.1261p ps=1.005u w=0.485u l=0.6u
X26 VSS a_224_552# Z VPW nfet_05v0 ad=0.1261p pd=1.005u as=0.1261p ps=1.005u w=0.485u l=0.6u
X27 VSS a_224_552# Z VPW nfet_05v0 ad=0.1261p pd=1.005u as=0.1261p ps=1.005u w=0.485u l=0.6u
X28 VDD I a_224_552# VNW pfet_05v0 ad=0.428p pd=2.02u as=0.2542p ps=1.44u w=0.82u l=0.5u
X29 Z a_224_552# VDD VNW pfet_05v0 ad=0.3782p pd=1.84u as=0.3782p ps=1.84u w=1.22u l=0.5u
X30 a_224_552# I VSS VPW nfet_05v0 ad=0.1782p pd=1.69u as=0.1053p ps=0.925u w=0.405u l=0.6u
X31 Z a_224_552# VSS VPW nfet_05v0 ad=0.1261p pd=1.005u as=0.1261p ps=1.005u w=0.485u l=0.6u
X32 VSS a_224_552# Z VPW nfet_05v0 ad=0.1261p pd=1.005u as=0.1261p ps=1.005u w=0.485u l=0.6u
X33 Z a_224_552# VDD VNW pfet_05v0 ad=0.3782p pd=1.84u as=0.3782p ps=1.84u w=1.22u l=0.5u
X34 VSS a_224_552# Z VPW nfet_05v0 ad=0.2134p pd=1.85u as=0.1261p ps=1.005u w=0.485u l=0.6u
X35 VDD I a_224_552# VNW pfet_05v0 ad=0.2542p pd=1.44u as=0.2542p ps=1.44u w=0.82u l=0.5u
X36 VDD a_224_552# Z VNW pfet_05v0 ad=0.3782p pd=1.84u as=0.3782p ps=1.84u w=1.22u l=0.5u
X37 VDD a_224_552# Z VNW pfet_05v0 ad=0.3782p pd=1.84u as=0.3782p ps=1.84u w=1.22u l=0.5u
X38 Z a_224_552# VDD VNW pfet_05v0 ad=0.3782p pd=1.84u as=0.3782p ps=1.84u w=1.22u l=0.5u
X39 a_224_552# I VDD VNW pfet_05v0 ad=0.2542p pd=1.44u as=0.2542p ps=1.44u w=0.82u l=0.5u
X40 a_224_552# I VSS VPW nfet_05v0 ad=0.1053p pd=0.925u as=0.1053p ps=0.925u w=0.405u l=0.6u
X41 Z a_224_552# VSS VPW nfet_05v0 ad=0.1261p pd=1.005u as=0.2134p ps=1.85u w=0.485u l=0.6u
X42 VDD I a_224_552# VNW pfet_05v0 ad=0.2542p pd=1.44u as=0.2542p ps=1.44u w=0.82u l=0.5u
X43 VDD a_224_552# Z VNW pfet_05v0 ad=0.3782p pd=1.84u as=0.3782p ps=1.84u w=1.22u l=0.5u
X44 Z a_224_552# VSS VPW nfet_05v0 ad=0.1261p pd=1.005u as=0.1261p ps=1.005u w=0.485u l=0.6u
X45 Z a_224_552# VSS VPW nfet_05v0 ad=0.1261p pd=1.005u as=0.1261p ps=1.005u w=0.485u l=0.6u
.ends

.subckt gf180mcu_fd_sc_mcu7t5v0__or2_1 VDD VSS Z A1 A2 VNW VPW
X0 a_255_603# A1 a_67_603# VNW pfet_05v0 ad=0.1469p pd=1.085u as=0.2486p ps=2.01u w=0.565u l=0.5u
X1 Z a_67_603# VSS VPW nfet_05v0 ad=0.3608p pd=2.52u as=0.2288p ps=1.58u w=0.82u l=0.6u
X2 VDD A2 a_255_603# VNW pfet_05v0 ad=0.38705p pd=2.08u as=0.1469p ps=1.085u w=0.565u l=0.5u
X3 VSS A2 a_67_603# VPW nfet_05v0 ad=0.2288p pd=1.58u as=93.59999f ps=0.88u w=0.36u l=0.6u
X4 Z a_67_603# VDD VNW pfet_05v0 ad=0.5368p pd=3.32u as=0.38705p ps=2.08u w=1.22u l=0.5u
X5 a_67_603# A1 VSS VPW nfet_05v0 ad=93.59999f pd=0.88u as=0.1584p ps=1.6u w=0.36u l=0.6u
.ends

.subckt gf180mcu_fd_sc_mcu7t5v0__inv_3 VSS ZN I VDD VNW VPW
X0 ZN I VDD VNW pfet_05v0 ad=0.5368p pd=3.32u as=0.3172p ps=1.74u w=1.22u l=0.5u
X1 ZN I VSS VPW nfet_05v0 ad=0.3608p pd=2.52u as=0.2132p ps=1.34u w=0.82u l=0.6u
X2 ZN I VSS VPW nfet_05v0 ad=0.2132p pd=1.34u as=0.3608p ps=2.52u w=0.82u l=0.6u
X3 ZN I VDD VNW pfet_05v0 ad=0.4392p pd=1.94u as=0.5368p ps=3.32u w=1.22u l=0.5u
X4 VSS I ZN VPW nfet_05v0 ad=0.2132p pd=1.34u as=0.2132p ps=1.34u w=0.82u l=0.6u
X5 VDD I ZN VNW pfet_05v0 ad=0.3172p pd=1.74u as=0.4392p ps=1.94u w=1.22u l=0.5u
.ends

.subckt gf180mcu_fd_sc_mcu7t5v0__clkbuf_3 Z VSS VDD I VNW VPW
X0 VDD a_224_552# Z VNW pfet_05v0 ad=0.3782p pd=1.84u as=0.3782p ps=1.84u w=1.22u l=0.5u
X1 a_224_552# I VDD VNW pfet_05v0 ad=0.2542p pd=1.44u as=0.3608p ps=2.52u w=0.82u l=0.5u
X2 VSS a_224_552# Z VPW nfet_05v0 ad=0.1183p pd=0.975u as=0.1183p ps=0.975u w=0.455u l=0.6u
X3 VDD a_224_552# Z VNW pfet_05v0 ad=0.5368p pd=3.32u as=0.3782p ps=1.84u w=1.22u l=0.5u
X4 VSS a_224_552# Z VPW nfet_05v0 ad=0.2002p pd=1.79u as=0.1183p ps=0.975u w=0.455u l=0.6u
X5 Z a_224_552# VDD VNW pfet_05v0 ad=0.3782p pd=1.84u as=0.428p ps=2.02u w=1.22u l=0.5u
X6 Z a_224_552# VSS VPW nfet_05v0 ad=0.1183p pd=0.975u as=0.23432p ps=1.94u w=0.455u l=0.6u
X7 VDD I a_224_552# VNW pfet_05v0 ad=0.428p pd=2.02u as=0.2542p ps=1.44u w=0.82u l=0.5u
X8 Z a_224_552# VDD VNW pfet_05v0 ad=0.3782p pd=1.84u as=0.3782p ps=1.84u w=1.22u l=0.5u
X9 a_224_552# I VSS VPW nfet_05v0 ad=0.51425p pd=2.91u as=0.2662p ps=2.09u w=0.605u l=0.6u
X10 Z a_224_552# VSS VPW nfet_05v0 ad=0.1183p pd=0.975u as=0.1183p ps=0.975u w=0.455u l=0.6u
.ends

.subckt gf180mcu_fd_sc_mcu7t5v0__nor2_2 VDD VSS ZN A1 A2 VNW VPW
X0 a_672_472# A1 ZN VNW pfet_05v0 ad=0.4087p pd=1.89u as=0.3477p ps=1.79u w=1.22u l=0.5u
X1 ZN A1 VSS VPW nfet_05v0 ad=0.1469p pd=1.085u as=0.1469p ps=1.085u w=0.565u l=0.6u
X2 ZN A1 a_234_472# VNW pfet_05v0 ad=0.3477p pd=1.79u as=0.3782p ps=1.84u w=1.22u l=0.5u
X3 VSS A1 ZN VPW nfet_05v0 ad=0.1469p pd=1.085u as=0.1469p ps=1.085u w=0.565u l=0.6u
X4 a_234_472# A2 VDD VNW pfet_05v0 ad=0.3782p pd=1.84u as=0.5368p ps=3.32u w=1.22u l=0.5u
X5 VDD A2 a_672_472# VNW pfet_05v0 ad=0.5368p pd=3.32u as=0.4087p ps=1.89u w=1.22u l=0.5u
X6 VSS A2 ZN VPW nfet_05v0 ad=0.2486p pd=2.01u as=0.1469p ps=1.085u w=0.565u l=0.6u
X7 ZN A2 VSS VPW nfet_05v0 ad=0.1469p pd=1.085u as=0.2486p ps=2.01u w=0.565u l=0.6u
.ends

.subckt gf180mcu_fd_sc_mcu7t5v0__inv_8 VSS ZN I VDD VNW VPW
X0 ZN I VDD VNW pfet_05v0 ad=0.4392p pd=1.94u as=0.3172p ps=1.74u w=1.22u l=0.5u
X1 VDD I ZN VNW pfet_05v0 ad=0.5368p pd=3.32u as=0.4392p ps=1.94u w=1.22u l=0.5u
X2 ZN I VSS VPW nfet_05v0 ad=0.2132p pd=1.34u as=0.2132p ps=1.34u w=0.82u l=0.6u
X3 ZN I VSS VPW nfet_05v0 ad=0.2132p pd=1.34u as=0.3608p ps=2.52u w=0.82u l=0.6u
X4 ZN I VSS VPW nfet_05v0 ad=0.2132p pd=1.34u as=0.2132p ps=1.34u w=0.82u l=0.6u
X5 VDD I ZN VNW pfet_05v0 ad=0.3172p pd=1.74u as=0.4392p ps=1.94u w=1.22u l=0.5u
X6 ZN I VDD VNW pfet_05v0 ad=0.4392p pd=1.94u as=0.3172p ps=1.74u w=1.22u l=0.5u
X7 VSS I ZN VPW nfet_05v0 ad=0.3608p pd=2.52u as=0.2132p ps=1.34u w=0.82u l=0.6u
X8 VDD I ZN VNW pfet_05v0 ad=0.3172p pd=1.74u as=0.4392p ps=1.94u w=1.22u l=0.5u
X9 VSS I ZN VPW nfet_05v0 ad=0.2132p pd=1.34u as=0.2132p ps=1.34u w=0.82u l=0.6u
X10 ZN I VDD VNW pfet_05v0 ad=0.4392p pd=1.94u as=0.3172p ps=1.74u w=1.22u l=0.5u
X11 VSS I ZN VPW nfet_05v0 ad=0.2132p pd=1.34u as=0.2132p ps=1.34u w=0.82u l=0.6u
X12 ZN I VDD VNW pfet_05v0 ad=0.4392p pd=1.94u as=0.5368p ps=3.32u w=1.22u l=0.5u
X13 VSS I ZN VPW nfet_05v0 ad=0.2132p pd=1.34u as=0.2132p ps=1.34u w=0.82u l=0.6u
X14 ZN I VSS VPW nfet_05v0 ad=0.2132p pd=1.34u as=0.2132p ps=1.34u w=0.82u l=0.6u
X15 VDD I ZN VNW pfet_05v0 ad=0.3172p pd=1.74u as=0.4392p ps=1.94u w=1.22u l=0.5u
.ends

.subckt gf180mcu_fd_sc_mcu7t5v0__clkinv_2 VDD VSS I ZN VNW VPW
X0 ZN I VSS VPW nfet_05v0 ad=0.1248p pd=1u as=0.2112p ps=1.84u w=0.48u l=0.6u
X1 VDD I ZN VNW pfet_05v0 ad=0.5368p pd=3.32u as=0.3782p ps=1.84u w=1.22u l=0.5u
X2 ZN I VDD VNW pfet_05v0 ad=0.3782p pd=1.84u as=0.5368p ps=3.32u w=1.22u l=0.5u
X3 VSS I ZN VPW nfet_05v0 ad=0.2112p pd=1.84u as=0.1248p ps=1u w=0.48u l=0.6u
.ends

.subckt gf180mcu_fd_sc_mcu7t5v0__oai32_1 A3 B1 B2 VDD VSS ZN A1 A2 VNW VPW
X0 ZN A1 a_468_472# VNW pfet_05v0 ad=0.4392p pd=1.94u as=0.3172p ps=1.74u w=1.22u l=0.5u
X1 a_244_68# A1 VSS VPW nfet_05v0 ad=0.2132p pd=1.34u as=0.2132p ps=1.34u w=0.82u l=0.6u
X2 a_244_68# A3 VSS VPW nfet_05v0 ad=0.2132p pd=1.34u as=0.3608p ps=2.52u w=0.82u l=0.6u
X3 a_916_472# B1 ZN VNW pfet_05v0 ad=0.3172p pd=1.74u as=0.4392p ps=1.94u w=1.22u l=0.5u
X4 VDD B2 a_916_472# VNW pfet_05v0 ad=0.5368p pd=3.32u as=0.3172p ps=1.74u w=1.22u l=0.5u
X5 ZN B1 a_244_68# VPW nfet_05v0 ad=0.2132p pd=1.34u as=0.2132p ps=1.34u w=0.82u l=0.6u
X6 a_224_472# A3 VDD VNW pfet_05v0 ad=0.4392p pd=1.94u as=0.5368p ps=3.32u w=1.22u l=0.5u
X7 VSS A2 a_244_68# VPW nfet_05v0 ad=0.2132p pd=1.34u as=0.2132p ps=1.34u w=0.82u l=0.6u
X8 a_244_68# B2 ZN VPW nfet_05v0 ad=0.3608p pd=2.52u as=0.2132p ps=1.34u w=0.82u l=0.6u
X9 a_468_472# A2 a_224_472# VNW pfet_05v0 ad=0.3172p pd=1.74u as=0.4392p ps=1.94u w=1.22u l=0.5u
.ends

.subckt gf180mcu_fd_sc_mcu7t5v0__dffrnq_2 D Q RN VDD VSS CLK VNW VPW
X0 VSS CLK a_36_151# VPW nfet_05v0 ad=0.1053p pd=0.925u as=0.1782p ps=1.69u w=0.405u l=0.6u
X1 Q a_2665_112# VDD VNW pfet_05v0 ad=0.3159p pd=1.735u as=0.5346p ps=3.31u w=1.215u l=0.5u
X2 VSS RN a_1456_156# VPW nfet_05v0 ad=0.2016p pd=1.48u as=43.2f ps=0.6u w=0.36u l=0.6u
X3 VDD a_2665_112# Q VNW pfet_05v0 ad=0.5346p pd=3.31u as=0.3159p ps=1.735u w=1.215u l=0.5u
X4 a_796_472# D VSS VPW nfet_05v0 ad=93.59999f pd=0.88u as=0.1584p ps=1.6u w=0.36u l=0.6u
X5 VSS a_2665_112# a_2560_156# VPW nfet_05v0 ad=0.1224p pd=1.04u as=94.5f ps=0.885u w=0.36u l=0.6u
X6 a_1000_472# a_448_472# a_796_472# VNW pfet_05v0 ad=0.2028p pd=1.3u as=0.2028p ps=1.3u w=0.78u l=0.5u
X7 a_2248_156# a_36_151# a_1308_423# VNW pfet_05v0 ad=0.25375p pd=1.51u as=0.2424p ps=1.465u w=0.505u l=0.5u
X8 a_2248_156# a_448_472# a_1308_423# VPW nfet_05v0 ad=0.2007p pd=1.475u as=0.2007p ps=1.475u w=0.36u l=0.6u
X9 VDD CLK a_36_151# VNW pfet_05v0 ad=0.2249p pd=1.385u as=0.3806p ps=2.61u w=0.865u l=0.5u
X10 a_1456_156# a_1308_423# a_1288_156# VPW nfet_05v0 ad=43.2f pd=0.6u as=43.2f ps=0.6u w=0.36u l=0.6u
X11 a_1308_423# a_1000_472# VSS VPW nfet_05v0 ad=0.2007p pd=1.475u as=0.2016p ps=1.48u w=0.36u l=0.6u
X12 Q a_2665_112# VSS VPW nfet_05v0 ad=0.2119p pd=1.335u as=0.3586p ps=2.51u w=0.815u l=0.6u
X13 a_2665_112# a_2248_156# a_3041_156# VPW nfet_05v0 ad=0.3586p pd=2.51u as=0.217p ps=1.515u w=0.815u l=0.6u
X14 a_448_472# a_36_151# VDD VNW pfet_05v0 ad=0.3806p pd=2.61u as=0.2249p ps=1.385u w=0.865u l=0.5u
X15 a_1204_472# a_36_151# a_1000_472# VNW pfet_05v0 ad=0.2028p pd=1.3u as=0.2028p ps=1.3u w=0.78u l=0.5u
X16 a_1204_472# RN VDD VNW pfet_05v0 ad=0.3432p pd=2.44u as=0.45p ps=2.02u w=0.78u l=0.5u
X17 a_2560_156# a_36_151# a_2248_156# VPW nfet_05v0 ad=94.5f pd=0.885u as=0.2007p ps=1.475u w=0.36u l=0.6u
X18 a_1288_156# a_448_472# a_1000_472# VPW nfet_05v0 ad=43.2f pd=0.6u as=93.59999f ps=0.88u w=0.36u l=0.6u
X19 a_2665_112# RN VDD VNW pfet_05v0 ad=0.3159p pd=1.735u as=0.33755p ps=1.955u w=1.215u l=0.5u
X20 VDD a_1308_423# a_1204_472# VNW pfet_05v0 ad=0.45p pd=2.02u as=0.2028p ps=1.3u w=0.78u l=0.5u
X21 a_2560_156# a_448_472# a_2248_156# VNW pfet_05v0 ad=0.1313p pd=1.025u as=0.25375p ps=1.51u w=0.505u l=0.5u
X22 a_448_472# a_36_151# VSS VPW nfet_05v0 ad=0.1782p pd=1.69u as=0.1053p ps=0.925u w=0.405u l=0.6u
X23 VDD a_2248_156# a_2665_112# VNW pfet_05v0 ad=0.5346p pd=3.31u as=0.3159p ps=1.735u w=1.215u l=0.5u
X24 a_3041_156# RN VSS VPW nfet_05v0 ad=0.217p pd=1.515u as=0.1224p ps=1.04u w=0.36u l=0.6u
X25 VSS a_2665_112# Q VPW nfet_05v0 ad=0.3586p pd=2.51u as=0.2119p ps=1.335u w=0.815u l=0.6u
X26 VDD a_2665_112# a_2560_156# VNW pfet_05v0 ad=0.33755p pd=1.955u as=0.1313p ps=1.025u w=0.505u l=0.5u
X27 a_1308_423# a_1000_472# VDD VNW pfet_05v0 ad=0.2424p pd=1.465u as=0.2222p ps=1.89u w=0.505u l=0.5u
X28 a_1000_472# a_36_151# a_796_472# VPW nfet_05v0 ad=93.59999f pd=0.88u as=93.59999f ps=0.88u w=0.36u l=0.6u
X29 a_796_472# D VDD VNW pfet_05v0 ad=0.2028p pd=1.3u as=0.3432p ps=2.44u w=0.78u l=0.5u
.ends

.subckt gf180mcu_fd_sc_mcu7t5v0__oai22_1 A2 B1 B2 VDD VSS ZN A1 VNW VPW
X0 ZN A1 a_36_68# VPW nfet_05v0 ad=0.2132p pd=1.34u as=0.2132p ps=1.34u w=0.82u l=0.6u
X1 VSS B2 a_36_68# VPW nfet_05v0 ad=0.2132p pd=1.34u as=0.3608p ps=2.52u w=0.82u l=0.6u
X2 a_244_472# B2 VDD VNW pfet_05v0 ad=0.3782p pd=1.84u as=0.6588p ps=3.52u w=1.22u l=0.5u
X3 a_692_472# A1 ZN VNW pfet_05v0 ad=0.3172p pd=1.74u as=0.3782p ps=1.84u w=1.22u l=0.5u
X4 VDD A2 a_692_472# VNW pfet_05v0 ad=0.5368p pd=3.32u as=0.3172p ps=1.74u w=1.22u l=0.5u
X5 a_36_68# A2 ZN VPW nfet_05v0 ad=0.3608p pd=2.52u as=0.2132p ps=1.34u w=0.82u l=0.6u
X6 a_36_68# B1 VSS VPW nfet_05v0 ad=0.2132p pd=1.34u as=0.2132p ps=1.34u w=0.82u l=0.6u
X7 ZN B1 a_244_472# VNW pfet_05v0 ad=0.3782p pd=1.84u as=0.3782p ps=1.84u w=1.22u l=0.5u
.ends

.subckt gf180mcu_fd_sc_mcu7t5v0__oai21_2 A2 ZN A1 VSS B VDD VNW VPW
X0 ZN A1 a_692_497# VNW pfet_05v0 ad=0.2847p pd=1.615u as=0.4599p ps=1.935u w=1.095u l=0.5u
X1 ZN A2 a_36_68# VPW nfet_05v0 ad=0.30965p pd=1.685u as=0.2132p ps=1.34u w=0.82u l=0.6u
X2 VSS B a_36_68# VPW nfet_05v0 ad=0.2132p pd=1.34u as=0.3608p ps=2.52u w=0.82u l=0.6u
X3 a_36_68# A2 ZN VPW nfet_05v0 ad=0.3608p pd=2.52u as=0.31215p ps=1.685u w=0.82u l=0.6u
X4 a_36_68# A1 ZN VPW nfet_05v0 ad=0.2132p pd=1.34u as=0.30965p ps=1.685u w=0.82u l=0.6u
X5 a_1164_497# A1 ZN VNW pfet_05v0 ad=0.4599p pd=1.935u as=0.2847p ps=1.615u w=1.095u l=0.5u
X6 ZN B VDD VNW pfet_05v0 ad=0.2483p pd=1.475u as=0.4202p ps=2.79u w=0.955u l=0.5u
X7 a_692_497# A2 VDD VNW pfet_05v0 ad=0.4599p pd=1.935u as=0.3718p ps=1.815u w=1.095u l=0.5u
X8 VDD B ZN VNW pfet_05v0 ad=0.3718p pd=1.815u as=0.2483p ps=1.475u w=0.955u l=0.5u
X9 VDD A2 a_1164_497# VNW pfet_05v0 ad=0.4818p pd=3.07u as=0.4599p ps=1.935u w=1.095u l=0.5u
X10 a_36_68# B VSS VPW nfet_05v0 ad=0.2132p pd=1.34u as=0.2132p ps=1.34u w=0.82u l=0.6u
X11 ZN A1 a_36_68# VPW nfet_05v0 ad=0.31215p pd=1.685u as=0.2132p ps=1.34u w=0.82u l=0.6u
.ends

.subckt gf180mcu_fd_sc_mcu7t5v0__nor4_2 A3 A4 VDD VSS ZN A1 A2 VNW VPW
X0 VSS A3 ZN VPW nfet_05v0 ad=0.126p pd=1.06u as=0.126p ps=1.06u w=0.36u l=0.6u
X1 a_1213_472# A2 a_943_472# VNW pfet_05v0 ad=0.3477p pd=1.79u as=0.5185p ps=2.07u w=1.22u l=0.5u
X2 VSS A2 ZN VPW nfet_05v0 ad=0.1584p pd=1.6u as=93.59999f ps=0.88u w=0.36u l=0.6u
X3 a_943_472# A3 a_683_472# VNW pfet_05v0 ad=0.5185p pd=2.07u as=0.488p ps=2.02u w=1.22u l=0.5u
X4 VSS A1 ZN VPW nfet_05v0 ad=93.59999f pd=0.88u as=93.59999f ps=0.88u w=0.36u l=0.6u
X5 a_1661_472# A1 ZN VNW pfet_05v0 ad=0.3172p pd=1.74u as=0.4087p ps=1.89u w=1.22u l=0.5u
X6 VSS A4 ZN VPW nfet_05v0 ad=93.59999f pd=0.88u as=93.59999f ps=0.88u w=0.36u l=0.6u
X7 a_57_472# A2 a_1661_472# VNW pfet_05v0 ad=0.5368p pd=3.32u as=0.3172p ps=1.74u w=1.22u l=0.5u
X8 ZN A1 VSS VPW nfet_05v0 ad=93.59999f pd=0.88u as=93.59999f ps=0.88u w=0.36u l=0.6u
X9 VDD A4 a_245_472# VNW pfet_05v0 ad=0.3782p pd=1.84u as=0.3477p ps=1.79u w=1.22u l=0.5u
X10 ZN A2 VSS VPW nfet_05v0 ad=93.59999f pd=0.88u as=0.126p ps=1.06u w=0.36u l=0.6u
X11 ZN A4 VSS VPW nfet_05v0 ad=0.126p pd=1.06u as=93.59999f ps=0.88u w=0.36u l=0.6u
X12 a_245_472# A3 a_57_472# VNW pfet_05v0 ad=0.3477p pd=1.79u as=0.5368p ps=3.32u w=1.22u l=0.5u
X13 ZN A3 VSS VPW nfet_05v0 ad=93.59999f pd=0.88u as=0.1584p ps=1.6u w=0.36u l=0.6u
X14 ZN A1 a_1213_472# VNW pfet_05v0 ad=0.4087p pd=1.89u as=0.3477p ps=1.79u w=1.22u l=0.5u
X15 a_683_472# A4 VDD VNW pfet_05v0 ad=0.488p pd=2.02u as=0.3782p ps=1.84u w=1.22u l=0.5u
.ends

.subckt gf180mcu_fd_sc_mcu7t5v0__inv_1 VSS ZN I VDD VNW VPW
X0 ZN I VSS VPW nfet_05v0 ad=0.3608p pd=2.52u as=0.3608p ps=2.52u w=0.82u l=0.6u
X1 ZN I VDD VNW pfet_05v0 ad=0.5368p pd=3.32u as=0.5368p ps=3.32u w=1.22u l=0.5u
.ends

.subckt gf180mcu_fd_sc_mcu7t5v0__buf_8 Z I VDD VSS VNW VPW
X0 a_224_472# I VDD VNW pfet_05v0 ad=0.3782p pd=1.84u as=0.3782p ps=1.84u w=1.22u l=0.5u
X1 Z a_224_472# VDD VNW pfet_05v0 ad=0.3782p pd=1.84u as=0.3782p ps=1.84u w=1.22u l=0.5u
X2 a_224_472# I VSS VPW nfet_05v0 ad=0.2132p pd=1.34u as=0.2132p ps=1.34u w=0.82u l=0.6u
X3 VSS a_224_472# Z VPW nfet_05v0 ad=0.3608p pd=2.52u as=0.2132p ps=1.34u w=0.82u l=0.6u
X4 VDD a_224_472# Z VNW pfet_05v0 ad=0.3782p pd=1.84u as=0.3782p ps=1.84u w=1.22u l=0.5u
X5 Z a_224_472# VDD VNW pfet_05v0 ad=0.3782p pd=1.84u as=0.3782p ps=1.84u w=1.22u l=0.5u
X6 a_224_472# I VSS VPW nfet_05v0 ad=0.2132p pd=1.34u as=0.3608p ps=2.52u w=0.82u l=0.6u
X7 Z a_224_472# VSS VPW nfet_05v0 ad=0.2132p pd=1.34u as=0.2132p ps=1.34u w=0.82u l=0.6u
X8 VDD a_224_472# Z VNW pfet_05v0 ad=0.3782p pd=1.84u as=0.3782p ps=1.84u w=1.22u l=0.5u
X9 Z a_224_472# VSS VPW nfet_05v0 ad=0.2132p pd=1.34u as=0.2132p ps=1.34u w=0.82u l=0.6u
X10 Z a_224_472# VSS VPW nfet_05v0 ad=0.2132p pd=1.34u as=0.2132p ps=1.34u w=0.82u l=0.6u
X11 VDD I a_224_472# VNW pfet_05v0 ad=0.3782p pd=1.84u as=0.3782p ps=1.84u w=1.22u l=0.5u
X12 VDD a_224_472# Z VNW pfet_05v0 ad=0.3782p pd=1.84u as=0.3782p ps=1.84u w=1.22u l=0.5u
X13 Z a_224_472# VDD VNW pfet_05v0 ad=0.3782p pd=1.84u as=0.3782p ps=1.84u w=1.22u l=0.5u
X14 VSS a_224_472# Z VPW nfet_05v0 ad=0.2132p pd=1.34u as=0.2132p ps=1.34u w=0.82u l=0.6u
X15 VDD I a_224_472# VNW pfet_05v0 ad=0.3782p pd=1.84u as=0.3782p ps=1.84u w=1.22u l=0.5u
X16 VSS a_224_472# Z VPW nfet_05v0 ad=0.2132p pd=1.34u as=0.2132p ps=1.34u w=0.82u l=0.6u
X17 VDD a_224_472# Z VNW pfet_05v0 ad=0.5368p pd=3.32u as=0.3782p ps=1.84u w=1.22u l=0.5u
X18 VSS a_224_472# Z VPW nfet_05v0 ad=0.2132p pd=1.34u as=0.2132p ps=1.34u w=0.82u l=0.6u
X19 Z a_224_472# VDD VNW pfet_05v0 ad=0.3782p pd=1.84u as=0.3782p ps=1.84u w=1.22u l=0.5u
X20 VSS I a_224_472# VPW nfet_05v0 ad=0.2132p pd=1.34u as=0.2132p ps=1.34u w=0.82u l=0.6u
X21 a_224_472# I VDD VNW pfet_05v0 ad=0.3782p pd=1.84u as=0.5368p ps=3.32u w=1.22u l=0.5u
X22 VSS I a_224_472# VPW nfet_05v0 ad=0.2132p pd=1.34u as=0.2132p ps=1.34u w=0.82u l=0.6u
X23 Z a_224_472# VSS VPW nfet_05v0 ad=0.2132p pd=1.34u as=0.2132p ps=1.34u w=0.82u l=0.6u
.ends

.subckt gf180mcu_fd_sc_mcu7t5v0__clkbuf_12 VDD VSS Z I VNW VPW
X0 VSS I a_224_552# VPW nfet_05v0 ad=94.89999f pd=0.885u as=94.89999f ps=0.885u w=0.365u l=0.6u
X1 VSS a_224_552# Z VPW nfet_05v0 ad=0.1248p pd=1u as=0.1248p ps=1u w=0.48u l=0.6u
X2 a_224_552# I VSS VPW nfet_05v0 ad=0.1606p pd=1.61u as=94.89999f ps=0.885u w=0.365u l=0.6u
X3 VDD a_224_552# Z VNW pfet_05v0 ad=0.3782p pd=1.84u as=0.3782p ps=1.84u w=1.22u l=0.5u
X4 Z a_224_552# VDD VNW pfet_05v0 ad=0.3782p pd=1.84u as=0.3782p ps=1.84u w=1.22u l=0.5u
X5 VSS I a_224_552# VPW nfet_05v0 ad=94.89999f pd=0.885u as=94.89999f ps=0.885u w=0.365u l=0.6u
X6 a_224_552# I VDD VNW pfet_05v0 ad=0.2542p pd=1.44u as=0.3608p ps=2.52u w=0.82u l=0.5u
X7 VDD a_224_552# Z VNW pfet_05v0 ad=0.3782p pd=1.84u as=0.3782p ps=1.84u w=1.22u l=0.5u
X8 VSS a_224_552# Z VPW nfet_05v0 ad=0.1248p pd=1u as=0.1248p ps=1u w=0.48u l=0.6u
X9 Z a_224_552# VDD VNW pfet_05v0 ad=0.3782p pd=1.84u as=0.408p ps=2.02u w=1.22u l=0.5u
X10 Z a_224_552# VSS VPW nfet_05v0 ad=0.1248p pd=1u as=0.1248p ps=1u w=0.48u l=0.6u
X11 a_224_552# I VDD VNW pfet_05v0 ad=0.2542p pd=1.44u as=0.2542p ps=1.44u w=0.82u l=0.5u
X12 VSS a_224_552# Z VPW nfet_05v0 ad=0.1248p pd=1u as=0.1248p ps=1u w=0.48u l=0.6u
X13 a_224_552# I VSS VPW nfet_05v0 ad=94.89999f pd=0.885u as=0.1606p ps=1.61u w=0.365u l=0.6u
X14 Z a_224_552# VSS VPW nfet_05v0 ad=0.1248p pd=1u as=0.2112p ps=1.84u w=0.48u l=0.6u
X15 Z a_224_552# VDD VNW pfet_05v0 ad=0.3782p pd=1.84u as=0.3782p ps=1.84u w=1.22u l=0.5u
X16 VDD I a_224_552# VNW pfet_05v0 ad=0.408p pd=2.02u as=0.2542p ps=1.44u w=0.82u l=0.5u
X17 VDD a_224_552# Z VNW pfet_05v0 ad=0.3782p pd=1.84u as=0.3782p ps=1.84u w=1.22u l=0.5u
X18 a_224_552# I VSS VPW nfet_05v0 ad=94.89999f pd=0.885u as=94.89999f ps=0.885u w=0.365u l=0.6u
X19 Z a_224_552# VSS VPW nfet_05v0 ad=0.1248p pd=1u as=0.1248p ps=1u w=0.48u l=0.6u
X20 Z a_224_552# VDD VNW pfet_05v0 ad=0.3782p pd=1.84u as=0.3782p ps=1.84u w=1.22u l=0.5u
X21 VSS a_224_552# Z VPW nfet_05v0 ad=0.1248p pd=1u as=0.1248p ps=1u w=0.48u l=0.6u
X22 Z a_224_552# VDD VNW pfet_05v0 ad=0.3782p pd=1.84u as=0.3782p ps=1.84u w=1.22u l=0.5u
X23 Z a_224_552# VSS VPW nfet_05v0 ad=0.1248p pd=1u as=0.1248p ps=1u w=0.48u l=0.6u
X24 VDD I a_224_552# VNW pfet_05v0 ad=0.2542p pd=1.44u as=0.2542p ps=1.44u w=0.82u l=0.5u
X25 VDD a_224_552# Z VNW pfet_05v0 ad=0.3782p pd=1.84u as=0.3782p ps=1.84u w=1.22u l=0.5u
X26 VDD a_224_552# Z VNW pfet_05v0 ad=0.5368p pd=3.32u as=0.3782p ps=1.84u w=1.22u l=0.5u
X27 Z a_224_552# VDD VNW pfet_05v0 ad=0.3782p pd=1.84u as=0.3782p ps=1.84u w=1.22u l=0.5u
X28 a_224_552# I VDD VNW pfet_05v0 ad=0.2542p pd=1.44u as=0.2542p ps=1.44u w=0.82u l=0.5u
X29 VDD a_224_552# Z VNW pfet_05v0 ad=0.3782p pd=1.84u as=0.3782p ps=1.84u w=1.22u l=0.5u
X30 Z a_224_552# VSS VPW nfet_05v0 ad=0.1248p pd=1u as=0.1248p ps=1u w=0.48u l=0.6u
X31 VSS a_224_552# Z VPW nfet_05v0 ad=0.1248p pd=1u as=0.1248p ps=1u w=0.48u l=0.6u
X32 VSS a_224_552# Z VPW nfet_05v0 ad=0.2112p pd=1.84u as=0.1248p ps=1u w=0.48u l=0.6u
X33 VDD I a_224_552# VNW pfet_05v0 ad=0.2542p pd=1.44u as=0.2542p ps=1.44u w=0.82u l=0.5u
X34 Z a_224_552# VSS VPW nfet_05v0 ad=0.1248p pd=1u as=0.1248p ps=1u w=0.48u l=0.6u
.ends

.subckt gf180mcu_fd_sc_mcu7t5v0__oai33_1 A3 B1 B2 B3 VDD VSS ZN A1 A2 VNW VPW
X0 a_244_68# A2 ZN VPW nfet_05v0 ad=0.2132p pd=1.34u as=0.4161p ps=1.905u w=0.82u l=0.6u
X1 ZN B1 a_448_497# VNW pfet_05v0 ad=0.33945p pd=1.715u as=0.33945p ps=1.715u w=1.095u l=0.5u
X2 a_244_68# B1 VSS VPW nfet_05v0 ad=0.2132p pd=1.34u as=0.2132p ps=1.34u w=0.82u l=0.6u
X3 a_244_68# B3 VSS VPW nfet_05v0 ad=0.2132p pd=1.34u as=0.3608p ps=2.52u w=0.82u l=0.6u
X4 ZN A3 a_244_68# VPW nfet_05v0 ad=0.3608p pd=2.52u as=0.2132p ps=1.34u w=0.82u l=0.6u
X5 a_448_497# B2 a_224_497# VNW pfet_05v0 ad=0.33945p pd=1.715u as=0.33945p ps=1.715u w=1.095u l=0.5u
X6 a_896_497# A1 ZN VNW pfet_05v0 ad=0.6351p pd=2.255u as=0.33945p ps=1.715u w=1.095u l=0.5u
X7 a_1228_497# A2 a_896_497# VNW pfet_05v0 ad=0.2847p pd=1.615u as=0.6351p ps=2.255u w=1.095u l=0.5u
X8 ZN A1 a_244_68# VPW nfet_05v0 ad=0.4161p pd=1.905u as=0.2132p ps=1.34u w=0.82u l=0.6u
X9 VDD A3 a_1228_497# VNW pfet_05v0 ad=0.4818p pd=3.07u as=0.2847p ps=1.615u w=1.095u l=0.5u
X10 VSS B2 a_244_68# VPW nfet_05v0 ad=0.2132p pd=1.34u as=0.2132p ps=1.34u w=0.82u l=0.6u
X11 a_224_497# B3 VDD VNW pfet_05v0 ad=0.33945p pd=1.715u as=0.4818p ps=3.07u w=1.095u l=0.5u
.ends

.subckt gf180mcu_fd_sc_mcu7t5v0__dlyc_1 Z VSS I VDD VNW VPW
X0 a_666_644# a_42_68# a_498_644# VNW pfet_05v0 ad=0.3852p pd=2.86u as=61.19999f ps=0.7u w=0.36u l=0.5u
X1 VSS I a_42_68# VPW nfet_05v0 ad=93.59999f pd=0.88u as=0.333p ps=2.57u w=0.36u l=0.6u
X2 a_1702_68# a_870_562# a_1554_644# VNW pfet_05v0 ad=0.3852p pd=2.86u as=61.19999f ps=0.7u w=0.36u l=0.5u
X3 Z a_1926_68# VDD VNW pfet_05v0 ad=0.5368p pd=3.32u as=0.379p ps=2.37u w=1.22u l=0.5u
X4 a_498_644# a_42_68# VDD VNW pfet_05v0 ad=61.19999f pd=0.7u as=0.1116p ps=0.98u w=0.36u l=0.5u
X5 a_1554_644# a_870_562# VDD VNW pfet_05v0 ad=61.19999f pd=0.7u as=0.1656p ps=1.28u w=0.36u l=0.5u
X6 a_1102_644# a_666_644# a_870_562# VNW pfet_05v0 ad=61.19999f pd=0.7u as=0.3852p ps=2.86u w=0.36u l=0.5u
X7 VDD I a_42_68# VNW pfet_05v0 ad=0.1116p pd=0.98u as=0.3852p ps=2.86u w=0.36u l=0.5u
X8 a_1534_68# a_870_562# VSS VPW nfet_05v0 ad=43.2f pd=0.6u as=93.59999f ps=0.88u w=0.36u l=0.6u
X9 a_1702_68# a_870_562# a_1534_68# VPW nfet_05v0 ad=0.369p pd=2.77u as=43.2f ps=0.6u w=0.36u l=0.6u
X10 Z a_1926_68# VSS VPW nfet_05v0 ad=0.3608p pd=2.52u as=0.28262p ps=1.87u w=0.82u l=0.6u
X11 VDD a_1702_68# a_2158_622# VNW pfet_05v0 ad=0.379p pd=2.37u as=61.19999f ps=0.7u w=0.36u l=0.5u
X12 a_518_68# a_42_68# VSS VPW nfet_05v0 ad=43.2f pd=0.6u as=93.59999f ps=0.88u w=0.36u l=0.6u
X13 a_666_644# a_42_68# a_518_68# VPW nfet_05v0 ad=0.369p pd=2.77u as=43.2f ps=0.6u w=0.36u l=0.6u
X14 a_1142_68# a_666_644# a_870_562# VPW nfet_05v0 ad=43.2f pd=0.6u as=0.369p ps=2.77u w=0.36u l=0.6u
X15 a_2158_622# a_1702_68# a_1926_68# VNW pfet_05v0 ad=61.19999f pd=0.7u as=0.3456p ps=2.64u w=0.36u l=0.5u
X16 a_2178_68# a_1702_68# a_1926_68# VPW nfet_05v0 ad=43.8f pd=0.605u as=0.3705p ps=2.77u w=0.365u l=0.6u
X17 VSS a_666_644# a_1142_68# VPW nfet_05v0 ad=93.59999f pd=0.88u as=43.2f ps=0.6u w=0.36u l=0.6u
X18 VSS a_1702_68# a_2178_68# VPW nfet_05v0 ad=0.28262p pd=1.87u as=43.8f ps=0.605u w=0.365u l=0.6u
X19 VDD a_666_644# a_1102_644# VNW pfet_05v0 ad=0.1656p pd=1.28u as=61.19999f ps=0.7u w=0.36u l=0.5u
.ends

.subckt gf180mcu_fd_sc_mcu7t5v0__nand4_2 A3 A4 VDD VSS ZN A1 A2 VNW VPW
X0 a_1458_68# A3 a_1254_68# VPW nfet_05v0 ad=0.1517p pd=1.19u as=0.1722p ps=1.24u w=0.82u l=0.6u
X1 a_632_68# A2 a_438_68# VPW nfet_05v0 ad=0.1722p pd=1.24u as=0.1517p ps=1.19u w=0.82u l=0.6u
X2 VDD A4 ZN VNW pfet_05v0 ad=0.2197p pd=1.365u as=0.3718p ps=2.57u w=0.845u l=0.5u
X3 a_244_68# A4 VSS VPW nfet_05v0 ad=0.1517p pd=1.19u as=0.3608p ps=2.52u w=0.82u l=0.6u
X4 ZN A3 VDD VNW pfet_05v0 ad=0.2197p pd=1.365u as=0.2197p ps=1.365u w=0.845u l=0.5u
X5 a_438_68# A3 a_244_68# VPW nfet_05v0 ad=0.1517p pd=1.19u as=0.1517p ps=1.19u w=0.82u l=0.6u
X6 VDD A2 ZN VNW pfet_05v0 ad=0.2197p pd=1.365u as=0.2197p ps=1.365u w=0.845u l=0.5u
X7 ZN A1 a_632_68# VPW nfet_05v0 ad=0.2132p pd=1.34u as=0.1722p ps=1.24u w=0.82u l=0.6u
X8 ZN A1 VDD VNW pfet_05v0 ad=0.2197p pd=1.365u as=0.2197p ps=1.365u w=0.845u l=0.5u
X9 VDD A1 ZN VNW pfet_05v0 ad=0.2197p pd=1.365u as=0.2197p ps=1.365u w=0.845u l=0.5u
X10 a_1060_68# A1 ZN VPW nfet_05v0 ad=0.1517p pd=1.19u as=0.2132p ps=1.34u w=0.82u l=0.6u
X11 a_1254_68# A2 a_1060_68# VPW nfet_05v0 ad=0.1722p pd=1.24u as=0.1517p ps=1.19u w=0.82u l=0.6u
X12 ZN A2 VDD VNW pfet_05v0 ad=0.2197p pd=1.365u as=0.2197p ps=1.365u w=0.845u l=0.5u
X13 VSS A4 a_1458_68# VPW nfet_05v0 ad=0.3608p pd=2.52u as=0.1517p ps=1.19u w=0.82u l=0.6u
X14 VDD A3 ZN VNW pfet_05v0 ad=0.2197p pd=1.365u as=0.2197p ps=1.365u w=0.845u l=0.5u
X15 ZN A4 VDD VNW pfet_05v0 ad=0.3718p pd=2.57u as=0.2197p ps=1.365u w=0.845u l=0.5u
.ends

.subckt gf180mcu_fd_sc_mcu7t5v0__buf_12 Z I VDD VSS VNW VPW
X0 a_224_472# I VDD VNW pfet_05v0 ad=0.3782p pd=1.84u as=0.3782p ps=1.84u w=1.22u l=0.5u
X1 VDD a_224_472# Z VNW pfet_05v0 ad=0.3782p pd=1.84u as=0.3782p ps=1.84u w=1.22u l=0.5u
X2 Z a_224_472# VDD VNW pfet_05v0 ad=0.3782p pd=1.84u as=0.3782p ps=1.84u w=1.22u l=0.5u
X3 a_224_472# I VSS VPW nfet_05v0 ad=0.2132p pd=1.34u as=0.2132p ps=1.34u w=0.82u l=0.6u
X4 VSS a_224_472# Z VPW nfet_05v0 ad=0.2132p pd=1.34u as=0.2132p ps=1.34u w=0.82u l=0.6u
X5 VSS a_224_472# Z VPW nfet_05v0 ad=0.3608p pd=2.52u as=0.2132p ps=1.34u w=0.82u l=0.6u
X6 VDD I a_224_472# VNW pfet_05v0 ad=0.3782p pd=1.84u as=0.3782p ps=1.84u w=1.22u l=0.5u
X7 Z a_224_472# VDD VNW pfet_05v0 ad=0.3782p pd=1.84u as=0.3782p ps=1.84u w=1.22u l=0.5u
X8 a_224_472# I VSS VPW nfet_05v0 ad=0.2132p pd=1.34u as=0.3608p ps=2.52u w=0.82u l=0.6u
X9 Z a_224_472# VSS VPW nfet_05v0 ad=0.2132p pd=1.34u as=0.2132p ps=1.34u w=0.82u l=0.6u
X10 VSS a_224_472# Z VPW nfet_05v0 ad=0.2132p pd=1.34u as=0.2132p ps=1.34u w=0.82u l=0.6u
X11 VSS a_224_472# Z VPW nfet_05v0 ad=0.2132p pd=1.34u as=0.2132p ps=1.34u w=0.82u l=0.6u
X12 VDD a_224_472# Z VNW pfet_05v0 ad=0.3782p pd=1.84u as=0.3782p ps=1.84u w=1.22u l=0.5u
X13 Z a_224_472# VSS VPW nfet_05v0 ad=0.2132p pd=1.34u as=0.2132p ps=1.34u w=0.82u l=0.6u
X14 Z a_224_472# VSS VPW nfet_05v0 ad=0.2132p pd=1.34u as=0.2132p ps=1.34u w=0.82u l=0.6u
X15 Z a_224_472# VDD VNW pfet_05v0 ad=0.3782p pd=1.84u as=0.3782p ps=1.84u w=1.22u l=0.5u
X16 Z a_224_472# VSS VPW nfet_05v0 ad=0.2132p pd=1.34u as=0.2132p ps=1.34u w=0.82u l=0.6u
X17 VDD I a_224_472# VNW pfet_05v0 ad=0.3782p pd=1.84u as=0.3782p ps=1.84u w=1.22u l=0.5u
X18 VDD a_224_472# Z VNW pfet_05v0 ad=0.5368p pd=3.32u as=0.3782p ps=1.84u w=1.22u l=0.5u
X19 VDD a_224_472# Z VNW pfet_05v0 ad=0.3782p pd=1.84u as=0.3782p ps=1.84u w=1.22u l=0.5u
X20 Z a_224_472# VDD VNW pfet_05v0 ad=0.3782p pd=1.84u as=0.3782p ps=1.84u w=1.22u l=0.5u
X21 Z a_224_472# VSS VPW nfet_05v0 ad=0.2132p pd=1.34u as=0.2132p ps=1.34u w=0.82u l=0.6u
X22 a_224_472# I VDD VNW pfet_05v0 ad=0.3782p pd=1.84u as=0.3782p ps=1.84u w=1.22u l=0.5u
X23 VSS a_224_472# Z VPW nfet_05v0 ad=0.2132p pd=1.34u as=0.2132p ps=1.34u w=0.82u l=0.6u
X24 VDD I a_224_472# VNW pfet_05v0 ad=0.3782p pd=1.84u as=0.3782p ps=1.84u w=1.22u l=0.5u
X25 VSS I a_224_472# VPW nfet_05v0 ad=0.2132p pd=1.34u as=0.2132p ps=1.34u w=0.82u l=0.6u
X26 VDD a_224_472# Z VNW pfet_05v0 ad=0.3782p pd=1.84u as=0.3782p ps=1.84u w=1.22u l=0.5u
X27 VSS a_224_472# Z VPW nfet_05v0 ad=0.2132p pd=1.34u as=0.2132p ps=1.34u w=0.82u l=0.6u
X28 Z a_224_472# VDD VNW pfet_05v0 ad=0.3782p pd=1.84u as=0.3782p ps=1.84u w=1.22u l=0.5u
X29 VSS I a_224_472# VPW nfet_05v0 ad=0.2132p pd=1.34u as=0.2132p ps=1.34u w=0.82u l=0.6u
X30 a_224_472# I VDD VNW pfet_05v0 ad=0.3782p pd=1.84u as=0.5368p ps=3.32u w=1.22u l=0.5u
X31 VDD a_224_472# Z VNW pfet_05v0 ad=0.3782p pd=1.84u as=0.3782p ps=1.84u w=1.22u l=0.5u
X32 VSS I a_224_472# VPW nfet_05v0 ad=0.2132p pd=1.34u as=0.2132p ps=1.34u w=0.82u l=0.6u
X33 Z a_224_472# VSS VPW nfet_05v0 ad=0.2132p pd=1.34u as=0.2132p ps=1.34u w=0.82u l=0.6u
X34 Z a_224_472# VDD VNW pfet_05v0 ad=0.3782p pd=1.84u as=0.3782p ps=1.84u w=1.22u l=0.5u
X35 a_224_472# I VSS VPW nfet_05v0 ad=0.2132p pd=1.34u as=0.2132p ps=1.34u w=0.82u l=0.6u
.ends

.subckt gf180mcu_fd_sc_mcu7t5v0__nand2_2 VDD VSS ZN A1 A2 VNW VPW
X0 a_244_68# A2 VSS VPW nfet_05v0 ad=0.1312p pd=1.14u as=0.3608p ps=2.52u w=0.82u l=0.6u
X1 ZN A1 a_244_68# VPW nfet_05v0 ad=0.2132p pd=1.34u as=0.1312p ps=1.14u w=0.82u l=0.6u
X2 ZN A2 VDD VNW pfet_05v0 ad=0.2938p pd=1.65u as=0.4972p ps=3.14u w=1.13u l=0.5u
X3 VDD A1 ZN VNW pfet_05v0 ad=0.2938p pd=1.65u as=0.2938p ps=1.65u w=1.13u l=0.5u
X4 a_652_68# A1 ZN VPW nfet_05v0 ad=0.1312p pd=1.14u as=0.2132p ps=1.34u w=0.82u l=0.6u
X5 VSS A2 a_652_68# VPW nfet_05v0 ad=0.3608p pd=2.52u as=0.1312p ps=1.14u w=0.82u l=0.6u
X6 ZN A1 VDD VNW pfet_05v0 ad=0.2938p pd=1.65u as=0.2938p ps=1.65u w=1.13u l=0.5u
X7 VDD A2 ZN VNW pfet_05v0 ad=0.4972p pd=3.14u as=0.2938p ps=1.65u w=1.13u l=0.5u
.ends

.subckt gf180mcu_fd_sc_mcu7t5v0__xor3_1 A3 VDD VSS Z A1 A2 VNW VPW
X0 a_952_93# A1 a_728_93# VPW nfet_05v0 ad=57.59999f pd=0.68u as=93.59999f ps=0.88u w=0.36u l=0.6u
X1 a_728_93# A1 a_718_524# VNW pfet_05v0 ad=0.1469p pd=1.085u as=0.16102p ps=1.135u w=0.565u l=0.5u
X2 a_1524_472# a_728_93# a_1336_472# VNW pfet_05v0 ad=90.4f pd=0.885u as=0.2486p ps=2.01u w=0.565u l=0.5u
X3 a_244_524# A2 a_56_524# VNW pfet_05v0 ad=93.59999f pd=0.88u as=0.1584p ps=1.6u w=0.36u l=0.5u
X4 a_718_524# a_56_524# VDD VNW pfet_05v0 ad=0.16102p pd=1.135u as=0.194p ps=1.415u w=0.565u l=0.5u
X5 a_718_524# A2 a_728_93# VNW pfet_05v0 ad=0.2486p pd=2.01u as=0.1469p ps=1.085u w=0.565u l=0.5u
X6 VSS A1 a_56_524# VPW nfet_05v0 ad=0.126p pd=1.06u as=93.59999f ps=0.88u w=0.36u l=0.6u
X7 a_1336_472# a_728_93# VSS VPW nfet_05v0 ad=93.59999f pd=0.88u as=0.1584p ps=1.6u w=0.36u l=0.6u
X8 VDD A1 a_244_524# VNW pfet_05v0 ad=0.194p pd=1.415u as=93.59999f ps=0.88u w=0.36u l=0.5u
X9 a_56_524# A2 VSS VPW nfet_05v0 ad=93.59999f pd=0.88u as=0.1584p ps=1.6u w=0.36u l=0.6u
X10 VSS A3 a_1336_472# VPW nfet_05v0 ad=0.218p pd=1.52u as=93.59999f ps=0.88u w=0.36u l=0.6u
X11 a_2215_68# A3 Z VPW nfet_05v0 ad=0.1312p pd=1.14u as=0.2132p ps=1.34u w=0.82u l=0.6u
X12 VSS a_728_93# a_2215_68# VPW nfet_05v0 ad=0.3608p pd=2.52u as=0.1312p ps=1.14u w=0.82u l=0.6u
X13 Z a_1336_472# VSS VPW nfet_05v0 ad=0.2132p pd=1.34u as=0.218p ps=1.52u w=0.82u l=0.6u
X14 Z A3 a_1936_472# VNW pfet_05v0 ad=0.3172p pd=1.74u as=0.3172p ps=1.74u w=1.22u l=0.5u
X15 a_728_93# a_56_524# VSS VPW nfet_05v0 ad=93.59999f pd=0.88u as=0.126p ps=1.06u w=0.36u l=0.6u
X16 a_1936_472# a_728_93# Z VNW pfet_05v0 ad=0.5368p pd=3.32u as=0.3172p ps=1.74u w=1.22u l=0.5u
X17 VSS A2 a_952_93# VPW nfet_05v0 ad=0.1584p pd=1.6u as=57.59999f ps=0.68u w=0.36u l=0.6u
X18 VDD A3 a_1524_472# VNW pfet_05v0 ad=0.35315p pd=1.96u as=90.4f ps=0.885u w=0.565u l=0.5u
X19 a_1936_472# a_1336_472# VDD VNW pfet_05v0 ad=0.3172p pd=1.74u as=0.35315p ps=1.96u w=1.22u l=0.5u
.ends

.subckt spi_opentarget_i3c_top VDD VSS clk_i clk_i_PD clk_i_PU host_clk_i host_clk_i_PD
+ host_clk_i_PU irq_o_CS irq_o_IE irq_o_IN irq_o_OE irq_o_OUT irq_o_PD irq_o_PDRV0
+ irq_o_PDRV1 irq_o_PU irq_o_SL rst_ni rst_ni_PD rst_ni_PU scl_pad_i scl_pad_i_PD
+ scl_pad_i_PU sda_pad_CS sda_pad_IE sda_pad_IN sda_pad_OUT sda_pad_PD sda_pad_PDRV0
+ sda_pad_PDRV1 sda_pad_PU sda_pad_SL sda_pad_oe spi_cs_ni spi_cs_ni_PD spi_cs_ni_PU
+ spi_miso_o_CS spi_miso_o_IE spi_miso_o_IN spi_miso_o_OE spi_miso_o_OUT spi_miso_o_PD
+ spi_miso_o_PDRV0 spi_miso_o_PDRV1 spi_miso_o_PU spi_miso_o_SL spi_mosi_i spi_mosi_i_PD
+ spi_mosi_i_PU spi_sclk_i spi_sclk_i_PD spi_sclk_i_PU
XFILLER_255_632 VDD VSS VDD VSS gf180mcu_fd_sc_mcu7t5v0__fillcap_64
X_3155_ VDD VSS _3159_/A1 _4551_/Q _3887_/Q VDD VSS gf180mcu_fd_sc_mcu7t5v0__nor2_1
XFILLER_267_492 VDD VSS VDD VSS gf180mcu_fd_sc_mcu7t5v0__fillcap_64
X_3086_ VDD _3170_/B _3086_/A2 _3087_/C _3214_/A1 VSS VDD VSS gf180mcu_fd_sc_mcu7t5v0__oai21_1
X_2106_ VDD VSS _2108_/A2 _4540_/Q _2102_/Z VDD VSS gf180mcu_fd_sc_mcu7t5v0__nor2_1
XFILLER_208_581 VDD VSS VDD VSS gf180mcu_fd_sc_mcu7t5v0__fillcap_8
X_2037_ _4429_/Q VDD VSS _3453_/A3 _4428_/Q _4427_/Q VDD VSS gf180mcu_fd_sc_mcu7t5v0__nor3_1
XFILLER_54_247 VDD VSS VDD VSS gf180mcu_fd_sc_mcu7t5v0__fillcap_64
X_3988_ VDD _3988_/Q _3989_/CLK VSS _3988_/D VDD VSS gf180mcu_fd_sc_mcu7t5v0__dffq_1
XFILLER_149_842 VDD VSS VDD VSS gf180mcu_fd_sc_mcu7t5v0__fillcap_16
XFILLER_250_381 VDD VSS VDD VSS gf180mcu_fd_sc_mcu7t5v0__fillcap_4
XFILLER_10_317 VDD VSS VDD VSS gf180mcu_fd_sc_mcu7t5v0__fillcap_64
X_2939_ _2939_/B _4370_/Q VDD VSS _2945_/A1 _2939_/A1 _4369_/Q VDD VSS gf180mcu_fd_sc_mcu7t5v0__oai211_1
XFILLER_22_177 VDD VSS VDD VSS gf180mcu_fd_sc_mcu7t5v0__fillcap_64
XFILLER_109_728 VDD VSS VDD VSS gf180mcu_fd_sc_mcu7t5v0__fillcap_8
XFILLER_148_396 VDD VSS VDD VSS gf180mcu_fd_sc_mcu7t5v0__fillcap_32
XFILLER_191_664 VDD VSS VDD VSS gf180mcu_fd_sc_mcu7t5v0__fillcap_8
X_4609_ _4609_/D _4609_/Q _4616_/RN VSS _4614_/CLK VDD VDD VSS gf180mcu_fd_sc_mcu7t5v0__dffrnq_1
XFILLER_117_772 VDD VSS VDD VSS gf180mcu_fd_sc_mcu7t5v0__fillcap_32
XFILLER_104_400 VDD VSS VDD VSS gf180mcu_fd_sc_mcu7t5v0__fillcap_8
XFILLER_2_527 VDD VSS VDD VSS gf180mcu_fd_sc_mcu7t5v0__fillcap_64
XFILLER_78_807 VDD VSS VDD VSS gf180mcu_fd_sc_mcu7t5v0__fillcap_64
XFILLER_219_824 VDD VSS VDD VSS gf180mcu_fd_sc_mcu7t5v0__fillcap_16
XFILLER_206_518 VDD VSS VDD VSS gf180mcu_fd_sc_mcu7t5v0__fillcap_4
XFILLER_245_142 VDD VSS VDD VSS gf180mcu_fd_sc_mcu7t5v0__fillcap_64
XFILLER_58_597 VDD VSS VDD VSS gf180mcu_fd_sc_mcu7t5v0__fillcap_64
XFILLER_46_737 VDD VSS VDD VSS gf180mcu_fd_sc_mcu7t5v0__fillcap_64
XFILLER_260_101 VDD VSS VDD VSS gf180mcu_fd_sc_mcu7t5v0__fillcap_4
XFILLER_73_556 VDD VSS VDD VSS gf180mcu_fd_sc_mcu7t5v0__fillcap_4
XFILLER_242_871 VDD VSS VDD VSS gf180mcu_fd_sc_mcu7t5v0__fillcap_4
XFILLER_159_606 VDD VSS VDD VSS gf180mcu_fd_sc_mcu7t5v0__fillcap_8
XFILLER_198_241 VDD VSS VDD VSS gf180mcu_fd_sc_mcu7t5v0__fillcap_4
XFILLER_14_667 VDD VSS VDD VSS gf180mcu_fd_sc_mcu7t5v0__fillcap_64
XFILLER_41_486 VDD VSS VDD VSS gf180mcu_fd_sc_mcu7t5v0__fillcap_4
XFILLER_166_171 VDD VSS VDD VSS gf180mcu_fd_sc_mcu7t5v0__fillcap_4
XFILLER_127_536 VDD VSS VDD VSS gf180mcu_fd_sc_mcu7t5v0__fillcap_16
Xmax_length80 VSS _3590_/C _4593_/Q VDD VDD VSS gf180mcu_fd_sc_mcu7t5v0__buf_2
Xmax_length91 _3564_/S _4591_/Q VDD VSS VDD VSS gf180mcu_fd_sc_mcu7t5v0__buf_4
XFILLER_142_506 VDD VSS VDD VSS gf180mcu_fd_sc_mcu7t5v0__fillcap_4
XFILLER_181_130 VDD VSS VDD VSS gf180mcu_fd_sc_mcu7t5v0__fillcap_8
XFILLER_6_877 VDD VSS VDD VSS gf180mcu_fd_sc_mcu7t5v0__fillcap_8
XFILLER_107_282 VDD VSS VDD VSS gf180mcu_fd_sc_mcu7t5v0__fillcap_8
XFILLER_68_317 VDD VSS VDD VSS gf180mcu_fd_sc_mcu7t5v0__fillcap_64
XFILLER_249_492 VDD VSS VDD VSS gf180mcu_fd_sc_mcu7t5v0__fillcap_64
XFILLER_264_451 VDD VSS VDD VSS gf180mcu_fd_sc_mcu7t5v0__fillcap_4
XFILLER_92_843 VDD VSS VDD VSS gf180mcu_fd_sc_mcu7t5v0__fillcap_16
Xwire29 wire29/Z VSS VDD wire29/I VDD VSS gf180mcu_fd_sc_mcu7t5v0__clkbuf_8
XFILLER_36_247 VDD VSS VDD VSS gf180mcu_fd_sc_mcu7t5v0__fillcap_64
XFILLER_51_206 VDD VSS VDD VSS gf180mcu_fd_sc_mcu7t5v0__fillcap_4
X_3911_ VDD _3911_/Q _3936_/CLK VSS _3911_/D VDD VSS gf180mcu_fd_sc_mcu7t5v0__dffq_1
XFILLER_205_562 VDD VSS VDD VSS gf180mcu_fd_sc_mcu7t5v0__fillcap_8
XFILLER_189_252 VDD VSS VDD VSS gf180mcu_fd_sc_mcu7t5v0__fillcap_16
X_3842_ _3848_/S VDD VSS _3995_/D wire179/Z _3995_/Q VDD VSS gf180mcu_fd_sc_mcu7t5v0__mux2_2
XFILLER_232_381 VDD VSS VDD VSS gf180mcu_fd_sc_mcu7t5v0__fillcap_4
XFILLER_158_650 VDD VSS VDD VSS gf180mcu_fd_sc_mcu7t5v0__fillcap_8
XFILLER_80_2 VDD VSS VDD VSS gf180mcu_fd_sc_mcu7t5v0__fillcap_32
X_3773_ _3777_/S VDD VSS _3941_/D _4292_/Q _3941_/Q VDD VSS gf180mcu_fd_sc_mcu7t5v0__mux2_2
X_2724_ _2728_/S VDD VSS _4258_/D _4258_/Q _4274_/Q VDD VSS gf180mcu_fd_sc_mcu7t5v0__mux2_2
X_2655_ _2665_/B1 _2655_/B2 VDD VSS _4226_/D _3106_/A2 _2666_/C VDD VSS gf180mcu_fd_sc_mcu7t5v0__aoi22_1
XFILLER_173_664 VDD VSS VDD VSS gf180mcu_fd_sc_mcu7t5v0__fillcap_4
XFILLER_118_569 VDD VSS VDD VSS gf180mcu_fd_sc_mcu7t5v0__fillcap_8
XFILLER_259_212 VDD VSS VDD VSS gf180mcu_fd_sc_mcu7t5v0__fillcap_64
X_2586_ _2896_/B VDD VSS _2586_/Z _4219_/Q _2588_/A2 VDD VSS gf180mcu_fd_sc_mcu7t5v0__or3_1
X_4325_ _4325_/D _4325_/Q wire199/Z VSS _4529_/CLK VDD VDD VSS gf180mcu_fd_sc_mcu7t5v0__dffrnq_1
XFILLER_114_764 VDD VSS VDD VSS gf180mcu_fd_sc_mcu7t5v0__fillcap_8
XFILLER_101_414 VDD VSS VDD VSS gf180mcu_fd_sc_mcu7t5v0__fillcap_4
XFILLER_87_626 VDD VSS VDD VSS gf180mcu_fd_sc_mcu7t5v0__fillcap_4
XFILLER_99_486 VDD VSS VDD VSS gf180mcu_fd_sc_mcu7t5v0__fillcap_4
X_4256_ _4256_/D _4256_/Q _4284_/RN VSS _4271_/CLK VDD VDD VSS gf180mcu_fd_sc_mcu7t5v0__dffrnq_1
X_3207_ VDD _4342_/D _3207_/B _2883_/C _2829_/C VSS _3207_/A3 VDD VSS gf180mcu_fd_sc_mcu7t5v0__oai31_1
X_4187_ _4187_/D _4187_/Q wire210/Z VSS _4499_/CLK VDD VDD VSS gf180mcu_fd_sc_mcu7t5v0__dffrnq_1
XFILLER_95_670 VDD VSS VDD VSS gf180mcu_fd_sc_mcu7t5v0__fillcap_16
XFILLER_216_827 VDD VSS VDD VSS gf180mcu_fd_sc_mcu7t5v0__fillcap_32
X_3138_ _3138_/B1 _3159_/C VDD VSS _3139_/B _3138_/A1 _3138_/A2 _3138_/B2 VDD VSS
+ gf180mcu_fd_sc_mcu7t5v0__oai221_1
XFILLER_227_142 VDD VSS VDD VSS gf180mcu_fd_sc_mcu7t5v0__fillcap_64
XFILLER_28_737 VDD VSS VDD VSS gf180mcu_fd_sc_mcu7t5v0__fillcap_64
XFILLER_242_101 VDD VSS VDD VSS gf180mcu_fd_sc_mcu7t5v0__fillcap_4
XFILLER_55_556 VDD VSS VDD VSS gf180mcu_fd_sc_mcu7t5v0__fillcap_4
XFILLER_103_57 VDD VSS VDD VSS gf180mcu_fd_sc_mcu7t5v0__fillcap_8
X_3069_ VDD _4332_/D _3069_/B wire13/Z _3069_/A2 VSS _3069_/A3 VDD VSS gf180mcu_fd_sc_mcu7t5v0__oai31_1
XFILLER_259_72 VDD VSS VDD VSS gf180mcu_fd_sc_mcu7t5v0__fillcap_64
XFILLER_23_486 VDD VSS VDD VSS gf180mcu_fd_sc_mcu7t5v0__fillcap_4
XFILLER_11_626 VDD VSS VDD VSS gf180mcu_fd_sc_mcu7t5v0__fillcap_4
XFILLER_137_823 VDD VSS VDD VSS gf180mcu_fd_sc_mcu7t5v0__fillcap_4
XFILLER_155_119 VDD VSS VDD VSS gf180mcu_fd_sc_mcu7t5v0__fillcap_16
XFILLER_6_107 VDD VSS VDD VSS gf180mcu_fd_sc_mcu7t5v0__fillcap_64
XFILLER_176_480 VDD VSS VDD VSS gf180mcu_fd_sc_mcu7t5v0__fillcap_16
Xmax_length148 VSS _3008_/B2 _4323_/Q VDD VDD VSS gf180mcu_fd_sc_mcu7t5v0__buf_2
Xmax_length126 VSS wire125/I wire127/Z VDD VDD VSS gf180mcu_fd_sc_mcu7t5v0__buf_2
XFILLER_164_675 VDD VSS VDD VSS gf180mcu_fd_sc_mcu7t5v0__fillcap_8
Xmax_length159 VSS _2505_/I0 wire160/Z VDD VDD VSS gf180mcu_fd_sc_mcu7t5v0__buf_2
XFILLER_163_174 VDD VSS VDD VSS gf180mcu_fd_sc_mcu7t5v0__fillcap_16
XFILLER_3_836 VDD VSS VDD VSS gf180mcu_fd_sc_mcu7t5v0__fillcap_4
Xclkbuf_4_8_0_host_clk_i _3965_/CLK VSS VDD clkbuf_0_host_clk_i/Z VDD VSS gf180mcu_fd_sc_mcu7t5v0__clkbuf_2
XFILLER_105_731 VDD VSS VDD VSS gf180mcu_fd_sc_mcu7t5v0__fillcap_4
XFILLER_77_136 VDD VSS VDD VSS gf180mcu_fd_sc_mcu7t5v0__fillcap_4
XFILLER_246_451 VDD VSS VDD VSS gf180mcu_fd_sc_mcu7t5v0__fillcap_4
XFILLER_18_247 VDD VSS VDD VSS gf180mcu_fd_sc_mcu7t5v0__fillcap_64
XFILLER_33_206 VDD VSS VDD VSS gf180mcu_fd_sc_mcu7t5v0__fillcap_4
XFILLER_214_381 VDD VSS VDD VSS gf180mcu_fd_sc_mcu7t5v0__fillcap_4
XFILLER_53_72 VDD VSS VDD VSS gf180mcu_fd_sc_mcu7t5v0__fillcap_64
XFILLER_230_885 VDD VSS VDD VSS gf180mcu_fd_sc_mcu7t5v0__fillcap_4
XFILLER_174_428 VDD VSS VDD VSS gf180mcu_fd_sc_mcu7t5v0__fillcap_8
XFILLER_128_801 VDD VSS VDD VSS gf180mcu_fd_sc_mcu7t5v0__fillcap_4
X_2440_ _2441_/S VDD VSS _4072_/D _4072_/Q wire152/Z VDD VSS gf180mcu_fd_sc_mcu7t5v0__mux2_2
XFILLER_170_667 VDD VSS VDD VSS gf180mcu_fd_sc_mcu7t5v0__fillcap_32
XFILLER_69_626 VDD VSS VDD VSS gf180mcu_fd_sc_mcu7t5v0__fillcap_4
X_2371_ wire14/Z VDD VSS _4015_/D _4015_/Q wire155/Z VDD VSS gf180mcu_fd_sc_mcu7t5v0__mux2_2
X_4110_ VDD _4110_/Q _4122_/CLK VSS _4110_/D VDD VSS gf180mcu_fd_sc_mcu7t5v0__dffq_1
XFILLER_84_629 VDD VSS VDD VSS gf180mcu_fd_sc_mcu7t5v0__fillcap_4
XFILLER_96_489 VDD VSS VDD VSS gf180mcu_fd_sc_mcu7t5v0__fillcap_8
X_4041_ VDD _4041_/Q _4065_/CLK VSS _4041_/D VDD VSS gf180mcu_fd_sc_mcu7t5v0__dffq_1
XFILLER_209_142 VDD VSS VDD VSS gf180mcu_fd_sc_mcu7t5v0__fillcap_8
XFILLER_224_101 VDD VSS VDD VSS gf180mcu_fd_sc_mcu7t5v0__fillcap_4
XFILLER_37_556 VDD VSS VDD VSS gf180mcu_fd_sc_mcu7t5v0__fillcap_4
XFILLER_206_871 VDD VSS VDD VSS gf180mcu_fd_sc_mcu7t5v0__fillcap_4
XFILLER_233_690 VDD VSS VDD VSS gf180mcu_fd_sc_mcu7t5v0__fillcap_8
XFILLER_177_200 VDD VSS VDD VSS gf180mcu_fd_sc_mcu7t5v0__fillcap_8
XFILLER_221_874 VDD VSS VDD VSS gf180mcu_fd_sc_mcu7t5v0__fillcap_16
X_3825_ _3830_/S VDD VSS _3980_/D wire177/Z _3980_/Q VDD VSS gf180mcu_fd_sc_mcu7t5v0__mux2_2
X_3756_ VDD VSS _3757_/B _3766_/I0 _3758_/S VDD VSS gf180mcu_fd_sc_mcu7t5v0__nor2_1
XFILLER_192_247 VDD VSS VDD VSS gf180mcu_fd_sc_mcu7t5v0__fillcap_4
XFILLER_118_333 VDD VSS VDD VSS gf180mcu_fd_sc_mcu7t5v0__fillcap_8
XFILLER_118_311 VDD VSS VDD VSS gf180mcu_fd_sc_mcu7t5v0__fillcap_4
X_2707_ _2713_/B1 _4280_/Q VDD VSS _2708_/I _4248_/Q _2226_/B VDD VSS gf180mcu_fd_sc_mcu7t5v0__aoi22_1
X_3687_ _3696_/S VDD VSS _3874_/D _3874_/Q _4289_/Q VDD VSS gf180mcu_fd_sc_mcu7t5v0__mux2_2
X_2638_ VDD _3209_/B _2987_/B _4219_/D _2638_/A1 VSS VDD VSS gf180mcu_fd_sc_mcu7t5v0__oai21_1
X_2569_ wire29/Z VDD VSS _4192_/D _4466_/Q _4192_/Q VDD VSS gf180mcu_fd_sc_mcu7t5v0__mux2_2
XFILLER_160_177 VDD VSS VDD VSS gf180mcu_fd_sc_mcu7t5v0__fillcap_16
X_4308_ VDD _4308_/Q _4510_/CLK VSS _4308_/D VDD VSS gf180mcu_fd_sc_mcu7t5v0__dffq_1
XFILLER_101_222 VDD VSS VDD VSS gf180mcu_fd_sc_mcu7t5v0__fillcap_32
XFILLER_59_136 VDD VSS VDD VSS gf180mcu_fd_sc_mcu7t5v0__fillcap_4
X_4239_ _4239_/D _4239_/Q _4616_/RN VSS _4615_/CLK VDD VDD VSS gf180mcu_fd_sc_mcu7t5v0__dffrnq_1
XFILLER_228_451 VDD VSS VDD VSS gf180mcu_fd_sc_mcu7t5v0__fillcap_4
XFILLER_15_206 VDD VSS VDD VSS gf180mcu_fd_sc_mcu7t5v0__fillcap_4
XFILLER_90_37 VDD VSS VDD VSS gf180mcu_fd_sc_mcu7t5v0__fillcap_64
XFILLER_212_885 VDD VSS VDD VSS gf180mcu_fd_sc_mcu7t5v0__fillcap_4
XFILLER_129_609 VDD VSS VDD VSS gf180mcu_fd_sc_mcu7t5v0__fillcap_16
XFILLER_196_586 VDD VSS VDD VSS gf180mcu_fd_sc_mcu7t5v0__fillcap_8
XFILLER_184_737 VDD VSS VDD VSS gf180mcu_fd_sc_mcu7t5v0__fillcap_16
XFILLER_196_597 VDD VSS VDD VSS gf180mcu_fd_sc_mcu7t5v0__fillcap_4
XFILLER_183_236 VDD VSS VDD VSS gf180mcu_fd_sc_mcu7t5v0__fillcap_4
XFILLER_128_2 VDD VSS VDD VSS gf180mcu_fd_sc_mcu7t5v0__fillcap_16
XFILLER_7_416 VDD VSS VDD VSS gf180mcu_fd_sc_mcu7t5v0__fillcap_4
XFILLER_164_450 VDD VSS VDD VSS gf180mcu_fd_sc_mcu7t5v0__fillcap_4
XFILLER_125_848 VDD VSS VDD VSS gf180mcu_fd_sc_mcu7t5v0__fillcap_16
XFILLER_152_667 VDD VSS VDD VSS gf180mcu_fd_sc_mcu7t5v0__fillcap_64
XFILLER_152_645 VDD VSS VDD VSS gf180mcu_fd_sc_mcu7t5v0__fillcap_8
XFILLER_140_807 VDD VSS VDD VSS gf180mcu_fd_sc_mcu7t5v0__fillcap_4
XFILLER_155_63 VDD VSS VDD VSS gf180mcu_fd_sc_mcu7t5v0__fillcap_4
XFILLER_206_101 VDD VSS VDD VSS gf180mcu_fd_sc_mcu7t5v0__fillcap_4
XFILLER_19_556 VDD VSS VDD VSS gf180mcu_fd_sc_mcu7t5v0__fillcap_4
XFILLER_222_638 VDD VSS VDD VSS gf180mcu_fd_sc_mcu7t5v0__fillcap_16
X_1940_ VDD VSS _4341_/Q _3214_/A1 VDD VSS gf180mcu_fd_sc_mcu7t5v0__clkinv_1
XFILLER_9_66 VDD VSS VDD VSS gf180mcu_fd_sc_mcu7t5v0__fillcap_4
X_4590_ _4590_/D _4615_/D _4616_/RN VSS _4604_/CLK VDD VDD VSS gf180mcu_fd_sc_mcu7t5v0__dffrnq_1
X_3610_ _3610_/A3 VDD VSS _3611_/A3 wire78/Z _3610_/A2 VDD VSS gf180mcu_fd_sc_mcu7t5v0__nand3_1
XFILLER_190_707 VDD VSS VDD VSS gf180mcu_fd_sc_mcu7t5v0__fillcap_4
XFILLER_174_247 VDD VSS VDD VSS gf180mcu_fd_sc_mcu7t5v0__fillcap_16
X_3541_ _3541_/B _3609_/C VDD VSS _3544_/A2 wire82/I _3537_/Z VDD VSS gf180mcu_fd_sc_mcu7t5v0__oai211_1
XFILLER_116_848 VDD VSS VDD VSS gf180mcu_fd_sc_mcu7t5v0__fillcap_16
X_3472_ _3472_/B _4593_/Q VDD VSS _3473_/A3 _4592_/Q _3469_/Z VDD VSS gf180mcu_fd_sc_mcu7t5v0__oai211_1
XFILLER_142_166 VDD VSS VDD VSS gf180mcu_fd_sc_mcu7t5v0__fillcap_8
XFILLER_142_177 VDD VSS VDD VSS gf180mcu_fd_sc_mcu7t5v0__fillcap_8
X_2423_ VDD VSS _2431_/S _2501_/A1 _2423_/A2 VDD VSS gf180mcu_fd_sc_mcu7t5v0__nand2_1
XFILLER_124_881 VDD VSS VDD VSS gf180mcu_fd_sc_mcu7t5v0__fillcap_8
XFILLER_43_2 VDD VSS VDD VSS gf180mcu_fd_sc_mcu7t5v0__fillcap_64
X_2354_ _2357_/S VDD VSS _4004_/D _4004_/Q _2467_/I0 VDD VSS gf180mcu_fd_sc_mcu7t5v0__mux2_2
XFILLER_215_66 VDD VSS VDD VSS gf180mcu_fd_sc_mcu7t5v0__fillcap_4
X_2285_ _3318_/B VDD VSS _3325_/B _3852_/D _2285_/A2 VDD VSS gf180mcu_fd_sc_mcu7t5v0__nand3_1
X_4024_ VDD _4024_/Q _4032_/CLK VSS _4024_/D VDD VSS gf180mcu_fd_sc_mcu7t5v0__dffq_1
XFILLER_198_807 VDD VSS VDD VSS gf180mcu_fd_sc_mcu7t5v0__fillcap_4
XFILLER_240_457 VDD VSS VDD VSS gf180mcu_fd_sc_mcu7t5v0__fillcap_64
XFILLER_178_575 VDD VSS VDD VSS gf180mcu_fd_sc_mcu7t5v0__fillcap_16
X_3808_ wire15/Z VDD VSS _3966_/D _3845_/I0 _3966_/Q VDD VSS gf180mcu_fd_sc_mcu7t5v0__mux2_2
XFILLER_178_597 VDD VSS VDD VSS gf180mcu_fd_sc_mcu7t5v0__fillcap_16
XFILLER_166_737 VDD VSS VDD VSS gf180mcu_fd_sc_mcu7t5v0__fillcap_8
XFILLER_193_556 VDD VSS VDD VSS gf180mcu_fd_sc_mcu7t5v0__fillcap_4
XFILLER_193_578 VDD VSS VDD VSS gf180mcu_fd_sc_mcu7t5v0__fillcap_8
X_3739_ VDD VSS _3747_/S _3739_/A1 _3759_/A2 VDD VSS gf180mcu_fd_sc_mcu7t5v0__nand2_1
XFILLER_119_686 VDD VSS VDD VSS gf180mcu_fd_sc_mcu7t5v0__fillcap_8
XFILLER_106_347 VDD VSS VDD VSS gf180mcu_fd_sc_mcu7t5v0__fillcap_16
XFILLER_118_185 VDD VSS VDD VSS gf180mcu_fd_sc_mcu7t5v0__fillcap_8
XFILLER_122_807 VDD VSS VDD VSS gf180mcu_fd_sc_mcu7t5v0__fillcap_8
Xclkload90 VSS clkload90/ZN _3969_/CLK VDD VDD VSS gf180mcu_fd_sc_mcu7t5v0__inv_4
XFILLER_125_33 VDD VSS VDD VSS gf180mcu_fd_sc_mcu7t5v0__fillcap_32
XFILLER_0_614 VDD VSS VDD VSS gf180mcu_fd_sc_mcu7t5v0__fillcap_32
XFILLER_125_88 VDD VSS VDD VSS gf180mcu_fd_sc_mcu7t5v0__fillcap_8
XFILLER_102_597 VDD VSS VDD VSS gf180mcu_fd_sc_mcu7t5v0__fillcap_32
XFILLER_189_818 VDD VSS VDD VSS gf180mcu_fd_sc_mcu7t5v0__fillcap_16
XFILLER_83_492 VDD VSS VDD VSS gf180mcu_fd_sc_mcu7t5v0__fillcap_16
XFILLER_71_632 VDD VSS VDD VSS gf180mcu_fd_sc_mcu7t5v0__fillcap_64
XFILLER_216_498 VDD VSS VDD VSS gf180mcu_fd_sc_mcu7t5v0__fillcap_16
XFILLER_169_542 VDD VSS VDD VSS gf180mcu_fd_sc_mcu7t5v0__fillcap_4
XFILLER_245_2 VDD VSS VDD VSS gf180mcu_fd_sc_mcu7t5v0__fillcap_64
Xspi_opentarget_i3c_top_223 irq_o_SL VDD VSS VDD VSS gf180mcu_fd_sc_mcu7t5v0__tiel
Xspi_opentarget_i3c_top_234 spi_cs_ni_PD VDD VSS VDD VSS gf180mcu_fd_sc_mcu7t5v0__tiel
Xspi_opentarget_i3c_top_245 spi_sclk_i_PD VDD VSS VDD VSS gf180mcu_fd_sc_mcu7t5v0__tiel
Xwire111 VSS wire111/Z _4511_/Q VDD VDD VSS gf180mcu_fd_sc_mcu7t5v0__clkbuf_1
Xwire166 VSS wire166/Z _4307_/Q VDD VDD VSS gf180mcu_fd_sc_mcu7t5v0__buf_2
Xwire155 VSS wire155/Z _4311_/Q VDD VDD VSS gf180mcu_fd_sc_mcu7t5v0__buf_2
XFILLER_200_877 VDD VSS VDD VSS gf180mcu_fd_sc_mcu7t5v0__fillcap_8
XFILLER_156_247 VDD VSS VDD VSS gf180mcu_fd_sc_mcu7t5v0__fillcap_16
Xwire133 VSS wire133/Z _4439_/Q VDD VDD VSS gf180mcu_fd_sc_mcu7t5v0__buf_2
Xwire177 VSS wire177/Z _4291_/Q VDD VDD VSS gf180mcu_fd_sc_mcu7t5v0__buf_2
Xwire199 wire199/Z VSS VDD wire199/I VDD VSS gf180mcu_fd_sc_mcu7t5v0__clkbuf_8
XFILLER_171_217 VDD VSS VDD VSS gf180mcu_fd_sc_mcu7t5v0__fillcap_16
XFILLER_164_291 VDD VSS VDD VSS gf180mcu_fd_sc_mcu7t5v0__fillcap_16
XFILLER_112_317 VDD VSS VDD VSS gf180mcu_fd_sc_mcu7t5v0__fillcap_32
XFILLER_124_177 VDD VSS VDD VSS gf180mcu_fd_sc_mcu7t5v0__fillcap_16
XFILLER_93_212 VDD VSS VDD VSS gf180mcu_fd_sc_mcu7t5v0__fillcap_8
XFILLER_266_387 VDD VSS VDD VSS gf180mcu_fd_sc_mcu7t5v0__fillcap_64
XFILLER_254_527 VDD VSS VDD VSS gf180mcu_fd_sc_mcu7t5v0__fillcap_64
X_2070_ _4566_/Q VDD VSS _2082_/A1 _3157_/A1 _2899_/B2 VDD VSS gf180mcu_fd_sc_mcu7t5v0__nor3_1
XFILLER_207_410 VDD VSS VDD VSS gf180mcu_fd_sc_mcu7t5v0__fillcap_8
XFILLER_235_763 VDD VSS VDD VSS gf180mcu_fd_sc_mcu7t5v0__fillcap_4
XFILLER_61_142 VDD VSS VDD VSS gf180mcu_fd_sc_mcu7t5v0__fillcap_64
XFILLER_222_457 VDD VSS VDD VSS gf180mcu_fd_sc_mcu7t5v0__fillcap_16
X_2972_ VDD _4328_/Q _3271_/A1 _2974_/A2 _1911_/I VSS VDD VSS gf180mcu_fd_sc_mcu7t5v0__oai21_1
XFILLER_188_862 VDD VSS VDD VSS gf180mcu_fd_sc_mcu7t5v0__fillcap_8
X_1923_ VDD VSS wire96/Z wire71/I VDD VSS gf180mcu_fd_sc_mcu7t5v0__clkinv_1
XFILLER_148_737 VDD VSS VDD VSS gf180mcu_fd_sc_mcu7t5v0__fillcap_8
XFILLER_175_556 VDD VSS VDD VSS gf180mcu_fd_sc_mcu7t5v0__fillcap_4
XFILLER_163_718 VDD VSS VDD VSS gf180mcu_fd_sc_mcu7t5v0__fillcap_8
X_4573_ _4573_/D _4573_/Q _4573_/RN VSS _4573_/CLK VDD VDD VSS gf180mcu_fd_sc_mcu7t5v0__dffrnq_1
X_3524_ VDD VSS _3525_/B2 _3619_/B1 _3524_/A2 VDD VSS gf180mcu_fd_sc_mcu7t5v0__nand2_1
X_3455_ VDD VSS _3619_/B1 _4436_/Q _2522_/B VDD VSS gf180mcu_fd_sc_mcu7t5v0__nor2_1
XFILLER_115_166 VDD VSS VDD VSS gf180mcu_fd_sc_mcu7t5v0__fillcap_4
XFILLER_116_667 VDD VSS VDD VSS gf180mcu_fd_sc_mcu7t5v0__fillcap_32
XFILLER_143_486 VDD VSS VDD VSS gf180mcu_fd_sc_mcu7t5v0__fillcap_4
X_2406_ VDD VSS _2407_/B wire164/Z _2413_/S VDD VSS gf180mcu_fd_sc_mcu7t5v0__nor2_1
X_3386_ _3386_/B VDD VSS _4431_/D _3386_/A1 wire56/Z VDD VSS gf180mcu_fd_sc_mcu7t5v0__aoi21_1
XFILLER_97_562 VDD VSS VDD VSS gf180mcu_fd_sc_mcu7t5v0__fillcap_32
XFILLER_258_877 VDD VSS VDD VSS gf180mcu_fd_sc_mcu7t5v0__fillcap_8
X_2337_ _4330_/Q VDD VSS _3023_/A2 _3226_/A1 _4327_/Q VDD VSS gf180mcu_fd_sc_mcu7t5v0__nor3_1
X_2268_ VDD VSS _2273_/A2 _4610_/Q _4586_/D VDD VSS gf180mcu_fd_sc_mcu7t5v0__xnor2_1
XFILLER_85_757 VDD VSS VDD VSS gf180mcu_fd_sc_mcu7t5v0__fillcap_8
X_4007_ VDD _4007_/Q _4032_/CLK VSS _4007_/D VDD VSS gf180mcu_fd_sc_mcu7t5v0__dffq_1
X_2199_ _2199_/A3 VDD VSS _2202_/A2 _2205_/B _2199_/A2 VDD VSS gf180mcu_fd_sc_mcu7t5v0__nand3_1
XFILLER_65_492 VDD VSS VDD VSS gf180mcu_fd_sc_mcu7t5v0__fillcap_64
XFILLER_53_632 VDD VSS VDD VSS gf180mcu_fd_sc_mcu7t5v0__fillcap_64
XFILLER_226_796 VDD VSS VDD VSS gf180mcu_fd_sc_mcu7t5v0__fillcap_8
XFILLER_198_637 VDD VSS VDD VSS gf180mcu_fd_sc_mcu7t5v0__fillcap_4
XFILLER_80_451 VDD VSS VDD VSS gf180mcu_fd_sc_mcu7t5v0__fillcap_4
XFILLER_241_766 VDD VSS VDD VSS gf180mcu_fd_sc_mcu7t5v0__fillcap_4
XFILLER_197_136 VDD VSS VDD VSS gf180mcu_fd_sc_mcu7t5v0__fillcap_4
XFILLER_200_107 VDD VSS VDD VSS gf180mcu_fd_sc_mcu7t5v0__fillcap_16
XFILLER_21_562 VDD VSS VDD VSS gf180mcu_fd_sc_mcu7t5v0__fillcap_64
XFILLER_138_247 VDD VSS VDD VSS gf180mcu_fd_sc_mcu7t5v0__fillcap_8
XFILLER_267_72 VDD VSS VDD VSS gf180mcu_fd_sc_mcu7t5v0__fillcap_64
XFILLER_217_6 VDD VSS VDD VSS gf180mcu_fd_sc_mcu7t5v0__fillcap_64
XFILLER_162_784 VDD VSS VDD VSS gf180mcu_fd_sc_mcu7t5v0__fillcap_8
XFILLER_106_166 VDD VSS VDD VSS gf180mcu_fd_sc_mcu7t5v0__fillcap_8
XFILLER_106_177 VDD VSS VDD VSS gf180mcu_fd_sc_mcu7t5v0__fillcap_32
XFILLER_0_444 VDD VSS VDD VSS gf180mcu_fd_sc_mcu7t5v0__fillcap_32
XFILLER_195_2 VDD VSS VDD VSS gf180mcu_fd_sc_mcu7t5v0__fillcap_16
XFILLER_75_212 VDD VSS VDD VSS gf180mcu_fd_sc_mcu7t5v0__fillcap_64
XFILLER_248_387 VDD VSS VDD VSS gf180mcu_fd_sc_mcu7t5v0__fillcap_64
XFILLER_263_346 VDD VSS VDD VSS gf180mcu_fd_sc_mcu7t5v0__fillcap_4
XFILLER_189_615 VDD VSS VDD VSS gf180mcu_fd_sc_mcu7t5v0__fillcap_8
XFILLER_43_142 VDD VSS VDD VSS gf180mcu_fd_sc_mcu7t5v0__fillcap_64
XFILLER_189_648 VDD VSS VDD VSS gf180mcu_fd_sc_mcu7t5v0__fillcap_4
XFILLER_231_276 VDD VSS VDD VSS gf180mcu_fd_sc_mcu7t5v0__fillcap_4
XFILLER_157_534 VDD VSS VDD VSS gf180mcu_fd_sc_mcu7t5v0__fillcap_16
XFILLER_129_203 VDD VSS VDD VSS gf180mcu_fd_sc_mcu7t5v0__fillcap_4
XFILLER_40_871 VDD VSS VDD VSS gf180mcu_fd_sc_mcu7t5v0__fillcap_4
XFILLER_61_72 VDD VSS VDD VSS gf180mcu_fd_sc_mcu7t5v0__fillcap_64
XFILLER_145_729 VDD VSS VDD VSS gf180mcu_fd_sc_mcu7t5v0__fillcap_16
XFILLER_177_72 VDD VSS VDD VSS gf180mcu_fd_sc_mcu7t5v0__fillcap_8
XFILLER_129_269 VDD VSS VDD VSS gf180mcu_fd_sc_mcu7t5v0__fillcap_8
XFILLER_138_792 VDD VSS VDD VSS gf180mcu_fd_sc_mcu7t5v0__fillcap_8
XFILLER_258_107 VDD VSS VDD VSS gf180mcu_fd_sc_mcu7t5v0__fillcap_64
XFILLER_113_648 VDD VSS VDD VSS gf180mcu_fd_sc_mcu7t5v0__fillcap_4
X_3240_ _3240_/B VDD VSS _4353_/D _3240_/A1 _3240_/A2 VDD VSS gf180mcu_fd_sc_mcu7t5v0__aoi21_1
XFILLER_3_282 VDD VSS VDD VSS gf180mcu_fd_sc_mcu7t5v0__fillcap_64
X_3171_ _3171_/B VDD VSS _3173_/A2 _2854_/B _3171_/A2 VDD VSS gf180mcu_fd_sc_mcu7t5v0__aoi21_1
XFILLER_79_562 VDD VSS VDD VSS gf180mcu_fd_sc_mcu7t5v0__fillcap_64
XFILLER_67_702 VDD VSS VDD VSS gf180mcu_fd_sc_mcu7t5v0__fillcap_64
X_2122_ VDD VSS _2122_/I _4131_/D VDD VSS gf180mcu_fd_sc_mcu7t5v0__clkinv_1
XFILLER_255_836 VDD VSS VDD VSS gf180mcu_fd_sc_mcu7t5v0__fillcap_4
XFILLER_267_696 VDD VSS VDD VSS gf180mcu_fd_sc_mcu7t5v0__fillcap_4
XFILLER_94_543 VDD VSS VDD VSS gf180mcu_fd_sc_mcu7t5v0__fillcap_8
XFILLER_94_521 VDD VSS VDD VSS gf180mcu_fd_sc_mcu7t5v0__fillcap_4
XFILLER_47_492 VDD VSS VDD VSS gf180mcu_fd_sc_mcu7t5v0__fillcap_64
X_2053_ VDD VSS _4593_/D _2051_/Z _2099_/A2 VDD VSS gf180mcu_fd_sc_mcu7t5v0__nor2_1
XFILLER_35_632 VDD VSS VDD VSS gf180mcu_fd_sc_mcu7t5v0__fillcap_64
XFILLER_207_273 VDD VSS VDD VSS gf180mcu_fd_sc_mcu7t5v0__fillcap_4
XFILLER_62_451 VDD VSS VDD VSS gf180mcu_fd_sc_mcu7t5v0__fillcap_4
XFILLER_179_114 VDD VSS VDD VSS gf180mcu_fd_sc_mcu7t5v0__fillcap_8
X_2955_ VDD wire45/I _2892_/B _2958_/B _3032_/A2 VSS VDD VSS gf180mcu_fd_sc_mcu7t5v0__oai21_1
X_2886_ _2886_/B _2886_/C VDD VSS _2887_/A3 _4325_/Q _2886_/A2 VDD VSS gf180mcu_fd_sc_mcu7t5v0__aoi211_1
X_1906_ VDD VSS _4429_/Q _3383_/A1 VDD VSS gf180mcu_fd_sc_mcu7t5v0__clkinv_1
XFILLER_30_381 VDD VSS VDD VSS gf180mcu_fd_sc_mcu7t5v0__fillcap_4
XFILLER_136_729 VDD VSS VDD VSS gf180mcu_fd_sc_mcu7t5v0__fillcap_4
X_4556_ _4556_/D _4556_/Q wire187/Z VSS _4562_/CLK VDD VDD VSS gf180mcu_fd_sc_mcu7t5v0__dffrnq_1
XFILLER_190_345 VDD VSS VDD VSS gf180mcu_fd_sc_mcu7t5v0__fillcap_16
XFILLER_116_442 VDD VSS VDD VSS gf180mcu_fd_sc_mcu7t5v0__fillcap_8
XFILLER_150_209 VDD VSS VDD VSS gf180mcu_fd_sc_mcu7t5v0__fillcap_16
X_3507_ _3507_/B _4593_/Q VDD VSS _3510_/A2 wire82/I _3504_/Z VDD VSS gf180mcu_fd_sc_mcu7t5v0__oai211_1
XFILLER_103_114 VDD VSS VDD VSS gf180mcu_fd_sc_mcu7t5v0__fillcap_16
XFILLER_104_615 VDD VSS VDD VSS gf180mcu_fd_sc_mcu7t5v0__fillcap_16
X_4487_ _4487_/D _4487_/Q wire209/Z VSS clkload8/I VDD VDD VSS gf180mcu_fd_sc_mcu7t5v0__dffrnq_1
X_3438_ _3438_/B wire82/Z VDD VSS _3439_/B _3597_/S _3438_/A2 VDD VSS gf180mcu_fd_sc_mcu7t5v0__oai211_1
X_3369_ wire21/Z VDD VSS _4416_/D _4408_/Q _4416_/Q VDD VSS gf180mcu_fd_sc_mcu7t5v0__mux2_2
XFILLER_218_527 VDD VSS VDD VSS gf180mcu_fd_sc_mcu7t5v0__fillcap_64
XFILLER_57_212 VDD VSS VDD VSS gf180mcu_fd_sc_mcu7t5v0__fillcap_64
XFILLER_245_346 VDD VSS VDD VSS gf180mcu_fd_sc_mcu7t5v0__fillcap_4
XFILLER_233_508 VDD VSS VDD VSS gf180mcu_fd_sc_mcu7t5v0__fillcap_8
XFILLER_226_571 VDD VSS VDD VSS gf180mcu_fd_sc_mcu7t5v0__fillcap_8
XFILLER_25_142 VDD VSS VDD VSS gf180mcu_fd_sc_mcu7t5v0__fillcap_64
XFILLER_81_793 VDD VSS VDD VSS gf180mcu_fd_sc_mcu7t5v0__fillcap_16
XFILLER_40_101 VDD VSS VDD VSS gf180mcu_fd_sc_mcu7t5v0__fillcap_4
XFILLER_201_416 VDD VSS VDD VSS gf180mcu_fd_sc_mcu7t5v0__fillcap_4
XFILLER_167_810 VDD VSS VDD VSS gf180mcu_fd_sc_mcu7t5v0__fillcap_16
XFILLER_22_871 VDD VSS VDD VSS gf180mcu_fd_sc_mcu7t5v0__fillcap_4
XFILLER_139_556 VDD VSS VDD VSS gf180mcu_fd_sc_mcu7t5v0__fillcap_4
XFILLER_110_2 VDD VSS VDD VSS gf180mcu_fd_sc_mcu7t5v0__fillcap_32
XFILLER_208_2 VDD VSS VDD VSS gf180mcu_fd_sc_mcu7t5v0__fillcap_32
XFILLER_147_64 VDD VSS VDD VSS gf180mcu_fd_sc_mcu7t5v0__fillcap_4
Xoutput7 VDD output7/I VSS sda_pad_OUT VDD VSS gf180mcu_fd_sc_mcu7t5v0__dlyb_1
XFILLER_49_702 VDD VSS VDD VSS gf180mcu_fd_sc_mcu7t5v0__fillcap_64
XFILLER_122_489 VDD VSS VDD VSS gf180mcu_fd_sc_mcu7t5v0__fillcap_16
XFILLER_237_836 VDD VSS VDD VSS gf180mcu_fd_sc_mcu7t5v0__fillcap_4
XFILLER_249_696 VDD VSS VDD VSS gf180mcu_fd_sc_mcu7t5v0__fillcap_4
XFILLER_88_381 VDD VSS VDD VSS gf180mcu_fd_sc_mcu7t5v0__fillcap_4
XFILLER_76_521 VDD VSS VDD VSS gf180mcu_fd_sc_mcu7t5v0__fillcap_4
XFILLER_0_274 VDD VSS VDD VSS gf180mcu_fd_sc_mcu7t5v0__fillcap_32
XFILLER_17_632 VDD VSS VDD VSS gf180mcu_fd_sc_mcu7t5v0__fillcap_64
XFILLER_29_492 VDD VSS VDD VSS gf180mcu_fd_sc_mcu7t5v0__fillcap_64
XFILLER_44_451 VDD VSS VDD VSS gf180mcu_fd_sc_mcu7t5v0__fillcap_4
XFILLER_205_788 VDD VSS VDD VSS gf180mcu_fd_sc_mcu7t5v0__fillcap_8
X_2740_ _2748_/S VDD VSS _4274_/D _4274_/Q wire128/Z VDD VSS gf180mcu_fd_sc_mcu7t5v0__mux2_2
XFILLER_9_842 VDD VSS VDD VSS gf180mcu_fd_sc_mcu7t5v0__fillcap_32
XFILLER_12_381 VDD VSS VDD VSS gf180mcu_fd_sc_mcu7t5v0__fillcap_4
X_2671_ VDD _2671_/B _4503_/D _4233_/D _2671_/A1 VSS VDD VSS gf180mcu_fd_sc_mcu7t5v0__oai21_1
XFILLER_184_150 VDD VSS VDD VSS gf180mcu_fd_sc_mcu7t5v0__fillcap_16
XFILLER_172_334 VDD VSS VDD VSS gf180mcu_fd_sc_mcu7t5v0__fillcap_32
X_4410_ _4410_/D _4410_/Q _4498_/RN VSS _4498_/CLK VDD VDD VSS gf180mcu_fd_sc_mcu7t5v0__dffrnq_1
XFILLER_117_228 VDD VSS VDD VSS gf180mcu_fd_sc_mcu7t5v0__fillcap_4
XFILLER_207_34 VDD VSS VDD VSS gf180mcu_fd_sc_mcu7t5v0__fillcap_8
X_4341_ _4341_/D _4341_/Q _4371_/RN VSS _4346_/CLK VDD VDD VSS gf180mcu_fd_sc_mcu7t5v0__dffrnq_1
XFILLER_259_416 VDD VSS VDD VSS gf180mcu_fd_sc_mcu7t5v0__fillcap_4
X_4272_ _4272_/D _4272_/Q wire199/I VSS _4523_/CLK VDD VDD VSS gf180mcu_fd_sc_mcu7t5v0__dffrnq_1
XFILLER_4_591 VDD VSS VDD VSS gf180mcu_fd_sc_mcu7t5v0__fillcap_4
X_3223_ VDD _3223_/B _3241_/A1 _3225_/A2 _3241_/B2 VSS VDD VSS gf180mcu_fd_sc_mcu7t5v0__oai21_1
XFILLER_140_264 VDD VSS VDD VSS gf180mcu_fd_sc_mcu7t5v0__fillcap_8
XFILLER_98_167 VDD VSS VDD VSS gf180mcu_fd_sc_mcu7t5v0__fillcap_8
XFILLER_39_212 VDD VSS VDD VSS gf180mcu_fd_sc_mcu7t5v0__fillcap_64
X_3154_ _3935_/Q VSS VDD _3919_/Q _3927_/Q _2846_/S _3911_/Q _3180_/B _3154_/Z VDD
+ VSS gf180mcu_fd_sc_mcu7t5v0__mux4_1
XFILLER_227_346 VDD VSS VDD VSS gf180mcu_fd_sc_mcu7t5v0__fillcap_4
XFILLER_223_66 VDD VSS VDD VSS gf180mcu_fd_sc_mcu7t5v0__fillcap_4
X_2105_ VDD VSS _4544_/D _4540_/Q _2105_/A2 VDD VSS gf180mcu_fd_sc_mcu7t5v0__xnor2_1
X_3085_ _4508_/Q VDD VSS wire67/I _4248_/Q _4256_/Q VDD VSS gf180mcu_fd_sc_mcu7t5v0__mux2_2
XFILLER_82_535 VDD VSS VDD VSS gf180mcu_fd_sc_mcu7t5v0__fillcap_4
X_2036_ _4434_/Q VDD VSS _3453_/A2 _4432_/Q _4433_/Q VDD VSS gf180mcu_fd_sc_mcu7t5v0__nor3_1
XFILLER_82_568 VDD VSS VDD VSS gf180mcu_fd_sc_mcu7t5v0__fillcap_16
XFILLER_22_101 VDD VSS VDD VSS gf180mcu_fd_sc_mcu7t5v0__fillcap_4
X_3987_ VDD _3987_/Q _3998_/CLK VSS _3987_/D VDD VSS gf180mcu_fd_sc_mcu7t5v0__dffq_1
X_2938_ _2939_/A1 _2938_/C VDD VSS _2939_/B _2944_/A1 _4366_/Q _4369_/Q VDD VSS gf180mcu_fd_sc_mcu7t5v0__aoi221_1
XFILLER_191_632 VDD VSS VDD VSS gf180mcu_fd_sc_mcu7t5v0__fillcap_32
XFILLER_175_183 VDD VSS VDD VSS gf180mcu_fd_sc_mcu7t5v0__fillcap_16
X_2869_ _2869_/A3 VDD VSS _2869_/Z _2869_/A1 _3218_/B1 VDD VSS gf180mcu_fd_sc_mcu7t5v0__or3_1
X_4608_ _4608_/D _4608_/Q _4613_/RN VSS _4616_/CLK VDD VDD VSS gf180mcu_fd_sc_mcu7t5v0__dffrnq_1
XFILLER_190_131 VDD VSS VDD VSS gf180mcu_fd_sc_mcu7t5v0__fillcap_4
XFILLER_144_570 VDD VSS VDD VSS gf180mcu_fd_sc_mcu7t5v0__fillcap_16
X_4539_ _4539_/D _4539_/Q _4573_/RN VSS _4573_/CLK VDD VDD VSS gf180mcu_fd_sc_mcu7t5v0__dffrnq_1
XFILLER_132_743 VDD VSS VDD VSS gf180mcu_fd_sc_mcu7t5v0__fillcap_16
XFILLER_58_521 VDD VSS VDD VSS gf180mcu_fd_sc_mcu7t5v0__fillcap_4
XFILLER_86_885 VDD VSS VDD VSS gf180mcu_fd_sc_mcu7t5v0__fillcap_4
XFILLER_93_26 VDD VSS VDD VSS gf180mcu_fd_sc_mcu7t5v0__fillcap_4
XFILLER_26_451 VDD VSS VDD VSS gf180mcu_fd_sc_mcu7t5v0__fillcap_4
XFILLER_158_2 VDD VSS VDD VSS gf180mcu_fd_sc_mcu7t5v0__fillcap_32
XFILLER_186_448 VDD VSS VDD VSS gf180mcu_fd_sc_mcu7t5v0__fillcap_4
Xmax_length70 VSS _3188_/C wire71/Z VDD VDD VSS gf180mcu_fd_sc_mcu7t5v0__buf_2
XFILLER_167_684 VDD VSS VDD VSS gf180mcu_fd_sc_mcu7t5v0__fillcap_4
XFILLER_6_801 VDD VSS VDD VSS gf180mcu_fd_sc_mcu7t5v0__fillcap_4
Xmax_length92 _3182_/B wire93/Z VDD VSS VDD VSS gf180mcu_fd_sc_mcu7t5v0__buf_4
XFILLER_155_835 VDD VSS VDD VSS gf180mcu_fd_sc_mcu7t5v0__fillcap_4
XFILLER_158_85 VDD VSS VDD VSS gf180mcu_fd_sc_mcu7t5v0__fillcap_4
XFILLER_10_885 VDD VSS VDD VSS gf180mcu_fd_sc_mcu7t5v0__fillcap_4
Xmax_length81 VSS _3515_/C _4592_/Q VDD VDD VSS gf180mcu_fd_sc_mcu7t5v0__buf_2
XFILLER_181_142 VDD VSS VDD VSS gf180mcu_fd_sc_mcu7t5v0__fillcap_16
XFILLER_154_378 VDD VSS VDD VSS gf180mcu_fd_sc_mcu7t5v0__fillcap_4
XFILLER_123_765 VDD VSS VDD VSS gf180mcu_fd_sc_mcu7t5v0__fillcap_4
XFILLER_110_437 VDD VSS VDD VSS gf180mcu_fd_sc_mcu7t5v0__fillcap_4
XFILLER_77_874 VDD VSS VDD VSS gf180mcu_fd_sc_mcu7t5v0__fillcap_16
XFILLER_209_346 VDD VSS VDD VSS gf180mcu_fd_sc_mcu7t5v0__fillcap_4
XFILLER_92_877 VDD VSS VDD VSS gf180mcu_fd_sc_mcu7t5v0__fillcap_8
XFILLER_205_552 VDD VSS VDD VSS gf180mcu_fd_sc_mcu7t5v0__fillcap_8
XFILLER_189_220 VDD VSS VDD VSS gf180mcu_fd_sc_mcu7t5v0__fillcap_32
X_3910_ VDD _3910_/Q _3936_/CLK VSS _3910_/D VDD VSS gf180mcu_fd_sc_mcu7t5v0__dffq_1
XFILLER_220_500 VDD VSS VDD VSS gf180mcu_fd_sc_mcu7t5v0__fillcap_8
X_3841_ _3848_/S VDD VSS _3994_/D _3841_/I0 _3994_/Q VDD VSS gf180mcu_fd_sc_mcu7t5v0__mux2_2
X_3772_ _3777_/S VDD VSS _3940_/D _4291_/Q _3940_/Q VDD VSS gf180mcu_fd_sc_mcu7t5v0__mux2_2
X_2723_ _2728_/S VDD VSS _4257_/D _4257_/Q _4273_/Q VDD VSS gf180mcu_fd_sc_mcu7t5v0__mux2_2
XFILLER_73_2 VDD VSS VDD VSS gf180mcu_fd_sc_mcu7t5v0__fillcap_64
XFILLER_173_632 VDD VSS VDD VSS gf180mcu_fd_sc_mcu7t5v0__fillcap_32
XFILLER_8_171 VDD VSS VDD VSS gf180mcu_fd_sc_mcu7t5v0__fillcap_4
X_2654_ _2666_/B1 _4144_/Q VDD VSS _2655_/B2 _4265_/Q _2168_/Z VDD VSS gf180mcu_fd_sc_mcu7t5v0__aoi22_1
X_2585_ _2896_/B VDD VSS _2600_/A1 _4219_/Q _2588_/A2 VDD VSS gf180mcu_fd_sc_mcu7t5v0__nor3_1
X_4324_ _4324_/D _4324_/Q wire199/Z VSS _4525_/CLK VDD VDD VSS gf180mcu_fd_sc_mcu7t5v0__dffrnq_1
XFILLER_141_562 VDD VSS VDD VSS gf180mcu_fd_sc_mcu7t5v0__fillcap_8
X_4255_ _4255_/D _4255_/Q _4284_/RN VSS _4271_/CLK VDD VDD VSS gf180mcu_fd_sc_mcu7t5v0__dffrnq_1
X_4186_ _4186_/D _4186_/Q _4536_/RN VSS _4492_/CLK VDD VDD VSS gf180mcu_fd_sc_mcu7t5v0__dffrnq_1
X_3206_ VDD VSS _3207_/B _4342_/Q _3207_/A3 VDD VSS gf180mcu_fd_sc_mcu7t5v0__nand2_1
XFILLER_68_885 VDD VSS VDD VSS gf180mcu_fd_sc_mcu7t5v0__fillcap_4
X_3137_ VDD _3158_/B _3902_/Q _3138_/B2 _4551_/Q VSS VDD VSS gf180mcu_fd_sc_mcu7t5v0__oai21_1
XFILLER_82_387 VDD VSS VDD VSS gf180mcu_fd_sc_mcu7t5v0__fillcap_64
X_3068_ VDD VSS _3069_/A3 _4331_/Q _3170_/B VDD VSS gf180mcu_fd_sc_mcu7t5v0__nor2_1
XFILLER_70_527 VDD VSS VDD VSS gf180mcu_fd_sc_mcu7t5v0__fillcap_64
X_2019_ VDD VSS _4227_/Q _3128_/A2 VDD VSS gf180mcu_fd_sc_mcu7t5v0__clkinv_1
XFILLER_179_18 VDD VSS VDD VSS gf180mcu_fd_sc_mcu7t5v0__fillcap_8
XFILLER_196_724 VDD VSS VDD VSS gf180mcu_fd_sc_mcu7t5v0__fillcap_8
XFILLER_195_212 VDD VSS VDD VSS gf180mcu_fd_sc_mcu7t5v0__fillcap_8
XFILLER_196_768 VDD VSS VDD VSS gf180mcu_fd_sc_mcu7t5v0__fillcap_16
XFILLER_183_429 VDD VSS VDD VSS gf180mcu_fd_sc_mcu7t5v0__fillcap_32
Xmax_length105 VSS _3113_/S _3176_/S VDD VDD VSS gf180mcu_fd_sc_mcu7t5v0__buf_3
Xmax_length149 VSS _2454_/I0 wire150/Z VDD VDD VSS gf180mcu_fd_sc_mcu7t5v0__buf_2
XFILLER_12_22 VDD VSS VDD VSS gf180mcu_fd_sc_mcu7t5v0__fillcap_8
XFILLER_163_142 VDD VSS VDD VSS gf180mcu_fd_sc_mcu7t5v0__fillcap_32
XFILLER_163_120 VDD VSS VDD VSS gf180mcu_fd_sc_mcu7t5v0__fillcap_8
XFILLER_148_194 VDD VSS VDD VSS gf180mcu_fd_sc_mcu7t5v0__fillcap_4
XFILLER_88_37 VDD VSS VDD VSS gf180mcu_fd_sc_mcu7t5v0__fillcap_64
XFILLER_104_231 VDD VSS VDD VSS gf180mcu_fd_sc_mcu7t5v0__fillcap_8
XFILLER_59_874 VDD VSS VDD VSS gf180mcu_fd_sc_mcu7t5v0__fillcap_16
Xclkbuf_leaf_42_clk_i _4369_/CLK VSS VDD clkload6/I VDD VSS gf180mcu_fd_sc_mcu7t5v0__clkbuf_2
XFILLER_92_107 VDD VSS VDD VSS gf180mcu_fd_sc_mcu7t5v0__fillcap_64
XFILLER_261_422 VDD VSS VDD VSS gf180mcu_fd_sc_mcu7t5v0__fillcap_64
XFILLER_160_53 VDD VSS VDD VSS gf180mcu_fd_sc_mcu7t5v0__fillcap_4
XFILLER_74_877 VDD VSS VDD VSS gf180mcu_fd_sc_mcu7t5v0__fillcap_8
XFILLER_206_349 VDD VSS VDD VSS gf180mcu_fd_sc_mcu7t5v0__fillcap_32
Xclkbuf_leaf_57_clk_i _4363_/CLK VSS VDD clkload6/I VDD VSS gf180mcu_fd_sc_mcu7t5v0__clkbuf_2
XFILLER_187_702 VDD VSS VDD VSS gf180mcu_fd_sc_mcu7t5v0__fillcap_16
XFILLER_159_426 VDD VSS VDD VSS gf180mcu_fd_sc_mcu7t5v0__fillcap_4
XFILLER_187_757 VDD VSS VDD VSS gf180mcu_fd_sc_mcu7t5v0__fillcap_4
XFILLER_174_418 VDD VSS VDD VSS gf180mcu_fd_sc_mcu7t5v0__fillcap_4
XFILLER_155_632 VDD VSS VDD VSS gf180mcu_fd_sc_mcu7t5v0__fillcap_16
XFILLER_182_451 VDD VSS VDD VSS gf180mcu_fd_sc_mcu7t5v0__fillcap_4
XFILLER_143_816 VDD VSS VDD VSS gf180mcu_fd_sc_mcu7t5v0__fillcap_16
XFILLER_185_72 VDD VSS VDD VSS gf180mcu_fd_sc_mcu7t5v0__fillcap_32
XFILLER_154_164 VDD VSS VDD VSS gf180mcu_fd_sc_mcu7t5v0__fillcap_8
XFILLER_142_359 VDD VSS VDD VSS gf180mcu_fd_sc_mcu7t5v0__fillcap_16
XFILLER_123_562 VDD VSS VDD VSS gf180mcu_fd_sc_mcu7t5v0__fillcap_16
X_2370_ wire14/I VDD VSS _4014_/D _4014_/Q wire157/Z VDD VSS gf180mcu_fd_sc_mcu7t5v0__mux2_2
XFILLER_96_457 VDD VSS VDD VSS gf180mcu_fd_sc_mcu7t5v0__fillcap_32
X_4040_ VDD _4040_/Q _4123_/CLK VSS _4040_/D VDD VSS gf180mcu_fd_sc_mcu7t5v0__dffq_1
XFILLER_265_772 VDD VSS VDD VSS gf180mcu_fd_sc_mcu7t5v0__fillcap_64
XFILLER_52_527 VDD VSS VDD VSS gf180mcu_fd_sc_mcu7t5v0__fillcap_64
XFILLER_64_387 VDD VSS VDD VSS gf180mcu_fd_sc_mcu7t5v0__fillcap_64
XFILLER_221_842 VDD VSS VDD VSS gf180mcu_fd_sc_mcu7t5v0__fillcap_32
XFILLER_177_212 VDD VSS VDD VSS gf180mcu_fd_sc_mcu7t5v0__fillcap_4
XFILLER_177_234 VDD VSS VDD VSS gf180mcu_fd_sc_mcu7t5v0__fillcap_16
X_3824_ _3830_/S VDD VSS _3979_/D wire179/Z _3979_/Q VDD VSS gf180mcu_fd_sc_mcu7t5v0__mux2_2
XFILLER_20_457 VDD VSS VDD VSS gf180mcu_fd_sc_mcu7t5v0__fillcap_64
X_3755_ _3758_/S VDD VSS _3927_/D _3765_/I0 _3927_/Q VDD VSS gf180mcu_fd_sc_mcu7t5v0__mux2_2
XFILLER_173_451 VDD VSS VDD VSS gf180mcu_fd_sc_mcu7t5v0__fillcap_8
X_2706_ VDD VSS _2706_/I _4247_/D VDD VSS gf180mcu_fd_sc_mcu7t5v0__clkinv_1
XFILLER_145_142 VDD VSS VDD VSS gf180mcu_fd_sc_mcu7t5v0__fillcap_64
X_3686_ VDD _4500_/D _3686_/B _2522_/B _3479_/C VSS _3686_/A3 VDD VSS gf180mcu_fd_sc_mcu7t5v0__oai31_1
X_2637_ VDD VSS _4218_/D _4218_/Q _2637_/A2 VDD VSS gf180mcu_fd_sc_mcu7t5v0__and2_1
XFILLER_160_101 VDD VSS VDD VSS gf180mcu_fd_sc_mcu7t5v0__fillcap_4
X_2568_ wire28/Z VDD VSS _4191_/D _4465_/Q _4191_/Q VDD VSS gf180mcu_fd_sc_mcu7t5v0__mux2_2
XFILLER_0_818 VDD VSS VDD VSS gf180mcu_fd_sc_mcu7t5v0__fillcap_32
XFILLER_114_551 VDD VSS VDD VSS gf180mcu_fd_sc_mcu7t5v0__fillcap_4
X_4307_ VDD _4307_/Q _4510_/CLK VSS _4307_/D VDD VSS gf180mcu_fd_sc_mcu7t5v0__dffq_1
X_2499_ _2500_/S VDD VSS _4120_/D wire152/Z _4120_/Q VDD VSS gf180mcu_fd_sc_mcu7t5v0__mux2_2
X_4238_ _4238_/D _4238_/Q _4616_/RN VSS _4615_/CLK VDD VDD VSS gf180mcu_fd_sc_mcu7t5v0__dffrnq_1
XFILLER_74_107 VDD VSS VDD VSS gf180mcu_fd_sc_mcu7t5v0__fillcap_64
X_4169_ _4169_/D _4169_/Q _4527_/RN VSS _4199_/CLK VDD VDD VSS gf180mcu_fd_sc_mcu7t5v0__dffrnq_1
XFILLER_243_422 VDD VSS VDD VSS gf180mcu_fd_sc_mcu7t5v0__fillcap_64
XFILLER_255_282 VDD VSS VDD VSS gf180mcu_fd_sc_mcu7t5v0__fillcap_64
XFILLER_56_877 VDD VSS VDD VSS gf180mcu_fd_sc_mcu7t5v0__fillcap_8
XFILLER_71_836 VDD VSS VDD VSS gf180mcu_fd_sc_mcu7t5v0__fillcap_4
XFILLER_169_702 VDD VSS VDD VSS gf180mcu_fd_sc_mcu7t5v0__fillcap_64
XFILLER_211_352 VDD VSS VDD VSS gf180mcu_fd_sc_mcu7t5v0__fillcap_64
XFILLER_149_492 VDD VSS VDD VSS gf180mcu_fd_sc_mcu7t5v0__fillcap_16
XFILLER_192_793 VDD VSS VDD VSS gf180mcu_fd_sc_mcu7t5v0__fillcap_8
XFILLER_136_153 VDD VSS VDD VSS gf180mcu_fd_sc_mcu7t5v0__fillcap_4
XFILLER_151_134 VDD VSS VDD VSS gf180mcu_fd_sc_mcu7t5v0__fillcap_4
XFILLER_105_551 VDD VSS VDD VSS gf180mcu_fd_sc_mcu7t5v0__fillcap_8
XFILLER_3_2 VDD VSS VDD VSS gf180mcu_fd_sc_mcu7t5v0__fillcap_64
XFILLER_2_177 VDD VSS VDD VSS gf180mcu_fd_sc_mcu7t5v0__fillcap_64
XFILLER_78_457 VDD VSS VDD VSS gf180mcu_fd_sc_mcu7t5v0__fillcap_64
XFILLER_93_416 VDD VSS VDD VSS gf180mcu_fd_sc_mcu7t5v0__fillcap_4
XFILLER_247_772 VDD VSS VDD VSS gf180mcu_fd_sc_mcu7t5v0__fillcap_64
XFILLER_207_625 VDD VSS VDD VSS gf180mcu_fd_sc_mcu7t5v0__fillcap_4
XFILLER_262_731 VDD VSS VDD VSS gf180mcu_fd_sc_mcu7t5v0__fillcap_4
XFILLER_0_36 VDD VSS VDD VSS gf180mcu_fd_sc_mcu7t5v0__fillcap_32
XFILLER_46_387 VDD VSS VDD VSS gf180mcu_fd_sc_mcu7t5v0__fillcap_64
XFILLER_34_527 VDD VSS VDD VSS gf180mcu_fd_sc_mcu7t5v0__fillcap_64
XFILLER_215_680 VDD VSS VDD VSS gf180mcu_fd_sc_mcu7t5v0__fillcap_4
XFILLER_203_831 VDD VSS VDD VSS gf180mcu_fd_sc_mcu7t5v0__fillcap_8
XFILLER_61_346 VDD VSS VDD VSS gf180mcu_fd_sc_mcu7t5v0__fillcap_4
XFILLER_230_661 VDD VSS VDD VSS gf180mcu_fd_sc_mcu7t5v0__fillcap_4
XFILLER_159_212 VDD VSS VDD VSS gf180mcu_fd_sc_mcu7t5v0__fillcap_64
XFILLER_202_341 VDD VSS VDD VSS gf180mcu_fd_sc_mcu7t5v0__fillcap_4
XFILLER_202_352 VDD VSS VDD VSS gf180mcu_fd_sc_mcu7t5v0__fillcap_8
XFILLER_127_142 VDD VSS VDD VSS gf180mcu_fd_sc_mcu7t5v0__fillcap_4
X_3540_ _3540_/A3 VDD VSS _3541_/B wire82/I _3540_/A2 VDD VSS gf180mcu_fd_sc_mcu7t5v0__nand3_1
X_3471_ _3471_/B _4592_/Q VDD VSS _3472_/B _3564_/S _3471_/A2 VDD VSS gf180mcu_fd_sc_mcu7t5v0__oai211_1
X_2422_ _2422_/S VDD VSS _4057_/D _2454_/I0 _4057_/Q VDD VSS gf180mcu_fd_sc_mcu7t5v0__mux2_2
X_2353_ _2357_/S VDD VSS _4003_/D _4003_/Q _2466_/I0 VDD VSS gf180mcu_fd_sc_mcu7t5v0__mux2_2
XFILLER_97_755 VDD VSS VDD VSS gf180mcu_fd_sc_mcu7t5v0__fillcap_8
X_4023_ VDD _4023_/Q _4032_/CLK VSS _4023_/D VDD VSS gf180mcu_fd_sc_mcu7t5v0__dffq_1
XFILLER_56_107 VDD VSS VDD VSS gf180mcu_fd_sc_mcu7t5v0__fillcap_64
X_2284_ VDD VSS _3318_/B _3858_/D _3858_/Q VDD VSS gf180mcu_fd_sc_mcu7t5v0__nor2_1
XFILLER_225_422 VDD VSS VDD VSS gf180mcu_fd_sc_mcu7t5v0__fillcap_64
XFILLER_237_282 VDD VSS VDD VSS gf180mcu_fd_sc_mcu7t5v0__fillcap_64
XFILLER_38_877 VDD VSS VDD VSS gf180mcu_fd_sc_mcu7t5v0__fillcap_8
XFILLER_252_241 VDD VSS VDD VSS gf180mcu_fd_sc_mcu7t5v0__fillcap_4
XFILLER_231_66 VDD VSS VDD VSS gf180mcu_fd_sc_mcu7t5v0__fillcap_4
XFILLER_53_836 VDD VSS VDD VSS gf180mcu_fd_sc_mcu7t5v0__fillcap_4
XFILLER_65_696 VDD VSS VDD VSS gf180mcu_fd_sc_mcu7t5v0__fillcap_4
XFILLER_178_543 VDD VSS VDD VSS gf180mcu_fd_sc_mcu7t5v0__fillcap_4
X_3807_ wire15/Z VDD VSS _3965_/D _4292_/Q _3965_/Q VDD VSS gf180mcu_fd_sc_mcu7t5v0__mux2_2
XFILLER_193_524 VDD VSS VDD VSS gf180mcu_fd_sc_mcu7t5v0__fillcap_4
XFILLER_220_171 VDD VSS VDD VSS gf180mcu_fd_sc_mcu7t5v0__fillcap_4
XFILLER_165_204 VDD VSS VDD VSS gf180mcu_fd_sc_mcu7t5v0__fillcap_4
XFILLER_21_766 VDD VSS VDD VSS gf180mcu_fd_sc_mcu7t5v0__fillcap_4
XFILLER_119_610 VDD VSS VDD VSS gf180mcu_fd_sc_mcu7t5v0__fillcap_16
X_1999_ VDD VSS _4476_/Q _3615_/A1 VDD VSS gf180mcu_fd_sc_mcu7t5v0__clkinv_1
X_3738_ _3738_/S VDD VSS _3913_/D _3848_/I0 _3913_/Q VDD VSS gf180mcu_fd_sc_mcu7t5v0__mux2_2
XFILLER_146_473 VDD VSS VDD VSS gf180mcu_fd_sc_mcu7t5v0__fillcap_8
XFILLER_107_816 VDD VSS VDD VSS gf180mcu_fd_sc_mcu7t5v0__fillcap_16
Xclkload80 VSS clkload80/Z _4531_/CLK VDD VDD VSS gf180mcu_fd_sc_mcu7t5v0__clkbuf_1
X_3669_ VDD VSS _3669_/I _4493_/D VDD VSS gf180mcu_fd_sc_mcu7t5v0__clkinv_1
Xclkload91 VSS clkload91/ZN _4541_/CLK VDD VDD VSS gf180mcu_fd_sc_mcu7t5v0__inv_4
XFILLER_102_510 VDD VSS VDD VSS gf180mcu_fd_sc_mcu7t5v0__fillcap_8
XFILLER_0_648 VDD VSS VDD VSS gf180mcu_fd_sc_mcu7t5v0__fillcap_32
XFILLER_87_276 VDD VSS VDD VSS gf180mcu_fd_sc_mcu7t5v0__fillcap_4
XFILLER_75_416 VDD VSS VDD VSS gf180mcu_fd_sc_mcu7t5v0__fillcap_4
XFILLER_130_885 VDD VSS VDD VSS gf180mcu_fd_sc_mcu7t5v0__fillcap_4
XFILLER_229_772 VDD VSS VDD VSS gf180mcu_fd_sc_mcu7t5v0__fillcap_64
XFILLER_244_731 VDD VSS VDD VSS gf180mcu_fd_sc_mcu7t5v0__fillcap_4
XFILLER_256_591 VDD VSS VDD VSS gf180mcu_fd_sc_mcu7t5v0__fillcap_4
XFILLER_28_387 VDD VSS VDD VSS gf180mcu_fd_sc_mcu7t5v0__fillcap_64
XFILLER_16_527 VDD VSS VDD VSS gf180mcu_fd_sc_mcu7t5v0__fillcap_64
XFILLER_43_346 VDD VSS VDD VSS gf180mcu_fd_sc_mcu7t5v0__fillcap_4
XFILLER_238_2 VDD VSS VDD VSS gf180mcu_fd_sc_mcu7t5v0__fillcap_32
XFILLER_140_2 VDD VSS VDD VSS gf180mcu_fd_sc_mcu7t5v0__fillcap_32
Xspi_opentarget_i3c_top_235 spi_cs_ni_PU VDD VSS VDD VSS gf180mcu_fd_sc_mcu7t5v0__tiel
Xspi_opentarget_i3c_top_224 rst_ni_PD VDD VSS VDD VSS gf180mcu_fd_sc_mcu7t5v0__tiel
Xspi_opentarget_i3c_top_246 spi_sclk_i_PU VDD VSS VDD VSS gf180mcu_fd_sc_mcu7t5v0__tiel
Xwire123 VSS wire123/Z wire123/I VDD VDD VSS gf180mcu_fd_sc_mcu7t5v0__buf_1
XFILLER_8_737 VDD VSS VDD VSS gf180mcu_fd_sc_mcu7t5v0__fillcap_64
Xwire112 VSS wire112/Z _4457_/Q VDD VDD VSS gf180mcu_fd_sc_mcu7t5v0__buf_1
Xwire134 VSS wire134/Z wire134/I VDD VDD VSS gf180mcu_fd_sc_mcu7t5v0__buf_1
Xwire145 VSS wire145/Z _1911_/I VDD VDD VSS gf180mcu_fd_sc_mcu7t5v0__clkbuf_1
XFILLER_11_276 VDD VSS VDD VSS gf180mcu_fd_sc_mcu7t5v0__fillcap_4
Xwire178 VSS wire178/Z _4290_/Q VDD VDD VSS gf180mcu_fd_sc_mcu7t5v0__buf_2
XFILLER_166_30 VDD VSS VDD VSS gf180mcu_fd_sc_mcu7t5v0__fillcap_4
XFILLER_109_142 VDD VSS VDD VSS gf180mcu_fd_sc_mcu7t5v0__fillcap_16
Xwire167 VSS wire167/Z wire168/Z VDD VDD VSS gf180mcu_fd_sc_mcu7t5v0__buf_2
XFILLER_137_484 VDD VSS VDD VSS gf180mcu_fd_sc_mcu7t5v0__fillcap_4
XFILLER_3_486 VDD VSS VDD VSS gf180mcu_fd_sc_mcu7t5v0__fillcap_4
XFILLER_266_311 VDD VSS VDD VSS gf180mcu_fd_sc_mcu7t5v0__fillcap_4
XFILLER_79_766 VDD VSS VDD VSS gf180mcu_fd_sc_mcu7t5v0__fillcap_4
XFILLER_59_72 VDD VSS VDD VSS gf180mcu_fd_sc_mcu7t5v0__fillcap_64
XFILLER_120_373 VDD VSS VDD VSS gf180mcu_fd_sc_mcu7t5v0__fillcap_8
XFILLER_38_107 VDD VSS VDD VSS gf180mcu_fd_sc_mcu7t5v0__fillcap_64
XFILLER_235_731 VDD VSS VDD VSS gf180mcu_fd_sc_mcu7t5v0__fillcap_8
XFILLER_219_282 VDD VSS VDD VSS gf180mcu_fd_sc_mcu7t5v0__fillcap_64
XFILLER_207_422 VDD VSS VDD VSS gf180mcu_fd_sc_mcu7t5v0__fillcap_16
XFILLER_234_241 VDD VSS VDD VSS gf180mcu_fd_sc_mcu7t5v0__fillcap_4
XFILLER_35_836 VDD VSS VDD VSS gf180mcu_fd_sc_mcu7t5v0__fillcap_4
XFILLER_47_696 VDD VSS VDD VSS gf180mcu_fd_sc_mcu7t5v0__fillcap_4
X_2971_ _2971_/A3 _2971_/A4 VDD VSS _2980_/A2 _4330_/Q _4329_/Q VDD VSS gf180mcu_fd_sc_mcu7t5v0__nor4_1
XFILLER_203_661 VDD VSS VDD VSS gf180mcu_fd_sc_mcu7t5v0__fillcap_32
XFILLER_188_885 VDD VSS VDD VSS gf180mcu_fd_sc_mcu7t5v0__fillcap_4
X_1922_ VDD VSS _4566_/Q _2081_/A2 VDD VSS gf180mcu_fd_sc_mcu7t5v0__clkinv_1
XFILLER_202_171 VDD VSS VDD VSS gf180mcu_fd_sc_mcu7t5v0__fillcap_4
XFILLER_190_527 VDD VSS VDD VSS gf180mcu_fd_sc_mcu7t5v0__fillcap_4
X_4572_ _4572_/D _4572_/Q wire187/Z VSS _4574_/CLK VDD VDD VSS gf180mcu_fd_sc_mcu7t5v0__dffrnq_1
XFILLER_116_613 VDD VSS VDD VSS gf180mcu_fd_sc_mcu7t5v0__fillcap_8
X_3523_ _3523_/A3 VDD VSS _3524_/A2 _3523_/A1 _3523_/A2 VDD VSS gf180mcu_fd_sc_mcu7t5v0__nand3_1
XFILLER_115_123 VDD VSS VDD VSS gf180mcu_fd_sc_mcu7t5v0__fillcap_16
XFILLER_226_22 VDD VSS VDD VSS gf180mcu_fd_sc_mcu7t5v0__fillcap_8
X_3454_ _3454_/A3 VDD VSS _3456_/A1 _3454_/A1 _3454_/A2 VDD VSS gf180mcu_fd_sc_mcu7t5v0__nand3_1
XFILLER_258_801 VDD VSS VDD VSS gf180mcu_fd_sc_mcu7t5v0__fillcap_4
X_2405_ _2413_/S VDD VSS _4042_/D wire167/Z _4042_/Q VDD VSS gf180mcu_fd_sc_mcu7t5v0__mux2_2
X_3385_ VDD VSS _3386_/B _4391_/Q wire56/Z VDD VSS gf180mcu_fd_sc_mcu7t5v0__nor2_1
XFILLER_130_148 VDD VSS VDD VSS gf180mcu_fd_sc_mcu7t5v0__fillcap_16
XFILLER_242_10 VDD VSS VDD VSS gf180mcu_fd_sc_mcu7t5v0__fillcap_16
X_2336_ VDD VSS _3007_/A1 _2898_/A2 _2898_/A3 VDD VSS gf180mcu_fd_sc_mcu7t5v0__nand2_1
XFILLER_69_276 VDD VSS VDD VSS gf180mcu_fd_sc_mcu7t5v0__fillcap_4
XFILLER_57_416 VDD VSS VDD VSS gf180mcu_fd_sc_mcu7t5v0__fillcap_4
X_2267_ VDD VSS _2273_/A1 _4611_/Q _4582_/D VDD VSS gf180mcu_fd_sc_mcu7t5v0__xnor2_1
XFILLER_238_591 VDD VSS VDD VSS gf180mcu_fd_sc_mcu7t5v0__fillcap_4
X_4006_ VDD _4006_/Q _4033_/CLK VSS _4006_/D VDD VSS gf180mcu_fd_sc_mcu7t5v0__dffq_1
X_2198_ VDD VSS _2199_/A3 _4238_/Q _2192_/B VDD VSS gf180mcu_fd_sc_mcu7t5v0__nand2_1
XFILLER_93_780 VDD VSS VDD VSS gf180mcu_fd_sc_mcu7t5v0__fillcap_4
XFILLER_25_346 VDD VSS VDD VSS gf180mcu_fd_sc_mcu7t5v0__fillcap_4
XFILLER_194_800 VDD VSS VDD VSS gf180mcu_fd_sc_mcu7t5v0__fillcap_4
XFILLER_194_855 VDD VSS VDD VSS gf180mcu_fd_sc_mcu7t5v0__fillcap_16
XFILLER_194_877 VDD VSS VDD VSS gf180mcu_fd_sc_mcu7t5v0__fillcap_8
XFILLER_162_752 VDD VSS VDD VSS gf180mcu_fd_sc_mcu7t5v0__fillcap_32
XFILLER_161_273 VDD VSS VDD VSS gf180mcu_fd_sc_mcu7t5v0__fillcap_4
XFILLER_248_311 VDD VSS VDD VSS gf180mcu_fd_sc_mcu7t5v0__fillcap_4
XFILLER_96_37 VDD VSS VDD VSS gf180mcu_fd_sc_mcu7t5v0__fillcap_8
XFILLER_102_362 VDD VSS VDD VSS gf180mcu_fd_sc_mcu7t5v0__fillcap_8
XFILLER_0_478 VDD VSS VDD VSS gf180mcu_fd_sc_mcu7t5v0__fillcap_32
XFILLER_188_2 VDD VSS VDD VSS gf180mcu_fd_sc_mcu7t5v0__fillcap_32
XFILLER_217_731 VDD VSS VDD VSS gf180mcu_fd_sc_mcu7t5v0__fillcap_16
XFILLER_17_836 VDD VSS VDD VSS gf180mcu_fd_sc_mcu7t5v0__fillcap_4
XFILLER_29_696 VDD VSS VDD VSS gf180mcu_fd_sc_mcu7t5v0__fillcap_4
XFILLER_172_527 VDD VSS VDD VSS gf180mcu_fd_sc_mcu7t5v0__fillcap_16
XFILLER_144_218 VDD VSS VDD VSS gf180mcu_fd_sc_mcu7t5v0__fillcap_16
XFILLER_184_376 VDD VSS VDD VSS gf180mcu_fd_sc_mcu7t5v0__fillcap_8
XFILLER_184_398 VDD VSS VDD VSS gf180mcu_fd_sc_mcu7t5v0__fillcap_32
XFILLER_193_72 VDD VSS VDD VSS gf180mcu_fd_sc_mcu7t5v0__fillcap_16
X_3170_ _3170_/B _3170_/C VDD VSS _3171_/B _3214_/A1 _3170_/A2 VDD VSS gf180mcu_fd_sc_mcu7t5v0__oai211_1
XFILLER_39_416 VDD VSS VDD VSS gf180mcu_fd_sc_mcu7t5v0__fillcap_4
X_2121_ _4131_/Q _2121_/B2 VDD VSS _2122_/I _4314_/Q _4577_/Q VDD VSS gf180mcu_fd_sc_mcu7t5v0__aoi22_1
XFILLER_208_731 VDD VSS VDD VSS gf180mcu_fd_sc_mcu7t5v0__fillcap_4
X_2052_ _4593_/Q VDD VSS _2099_/A2 _4592_/Q _2086_/A1 VDD VSS gf180mcu_fd_sc_mcu7t5v0__aoi21_1
XFILLER_90_783 VDD VSS VDD VSS gf180mcu_fd_sc_mcu7t5v0__fillcap_4
XFILLER_250_597 VDD VSS VDD VSS gf180mcu_fd_sc_mcu7t5v0__fillcap_64
X_2954_ _2954_/B VDD VSS _2959_/B1 _3271_/C _2954_/A2 VDD VSS gf180mcu_fd_sc_mcu7t5v0__aoi21_1
XFILLER_176_877 VDD VSS VDD VSS gf180mcu_fd_sc_mcu7t5v0__fillcap_8
X_2885_ _2885_/B1 _2885_/C VDD VSS _2886_/A2 _3008_/B2 _2885_/A2 _2885_/B2 VDD VSS
+ gf180mcu_fd_sc_mcu7t5v0__oai221_1
X_4555_ _4555_/D _4576_/D wire187/Z VSS _4565_/CLK VDD VDD VSS gf180mcu_fd_sc_mcu7t5v0__dffrnq_1
XFILLER_190_379 VDD VSS VDD VSS gf180mcu_fd_sc_mcu7t5v0__fillcap_4
X_3506_ _3506_/B wire83/I VDD VSS _3507_/B _3564_/S _3506_/A2 VDD VSS gf180mcu_fd_sc_mcu7t5v0__oai211_1
X_4486_ _4486_/D _4486_/Q wire209/Z VSS _4494_/CLK VDD VDD VSS gf180mcu_fd_sc_mcu7t5v0__dffrnq_1
X_3437_ VDD VSS _3438_/B _3597_/S _4066_/Q VDD VSS gf180mcu_fd_sc_mcu7t5v0__nand2_1
X_3368_ wire20/I VDD VSS _4415_/D _4407_/Q _4415_/Q VDD VSS gf180mcu_fd_sc_mcu7t5v0__mux2_2
X_2319_ _3039_/A1 VDD VSS _2793_/A1 _4328_/Q _4330_/Q VDD VSS gf180mcu_fd_sc_mcu7t5v0__nor3_1
XFILLER_112_682 VDD VSS VDD VSS gf180mcu_fd_sc_mcu7t5v0__fillcap_16
X_3299_ _3334_/A2 _4489_/Q VDD VSS _3304_/A2 _4473_/Q _2280_/I VDD VSS gf180mcu_fd_sc_mcu7t5v0__aoi22_1
XFILLER_100_877 VDD VSS VDD VSS gf180mcu_fd_sc_mcu7t5v0__fillcap_8
XFILLER_260_317 VDD VSS VDD VSS gf180mcu_fd_sc_mcu7t5v0__fillcap_64
XFILLER_198_402 VDD VSS VDD VSS gf180mcu_fd_sc_mcu7t5v0__fillcap_4
XFILLER_122_79 VDD VSS VDD VSS gf180mcu_fd_sc_mcu7t5v0__fillcap_16
XFILLER_213_244 VDD VSS VDD VSS gf180mcu_fd_sc_mcu7t5v0__fillcap_16
XFILLER_81_772 VDD VSS VDD VSS gf180mcu_fd_sc_mcu7t5v0__fillcap_4
XFILLER_81_761 VDD VSS VDD VSS gf180mcu_fd_sc_mcu7t5v0__fillcap_8
XFILLER_198_457 VDD VSS VDD VSS gf180mcu_fd_sc_mcu7t5v0__fillcap_16
XFILLER_15_66 VDD VSS VDD VSS gf180mcu_fd_sc_mcu7t5v0__fillcap_4
XFILLER_154_516 VDD VSS VDD VSS gf180mcu_fd_sc_mcu7t5v0__fillcap_8
XFILLER_154_505 VDD VSS VDD VSS gf180mcu_fd_sc_mcu7t5v0__fillcap_4
XFILLER_154_527 VDD VSS VDD VSS gf180mcu_fd_sc_mcu7t5v0__fillcap_8
XFILLER_193_195 VDD VSS VDD VSS gf180mcu_fd_sc_mcu7t5v0__fillcap_8
XFILLER_166_387 VDD VSS VDD VSS gf180mcu_fd_sc_mcu7t5v0__fillcap_4
XFILLER_181_346 VDD VSS VDD VSS gf180mcu_fd_sc_mcu7t5v0__fillcap_4
XFILLER_181_368 VDD VSS VDD VSS gf180mcu_fd_sc_mcu7t5v0__fillcap_8
XFILLER_103_2 VDD VSS VDD VSS gf180mcu_fd_sc_mcu7t5v0__fillcap_16
Xoutput8 VDD output8/I VSS sda_pad_oe VDD VSS gf180mcu_fd_sc_mcu7t5v0__dlyb_1
XFILLER_122_457 VDD VSS VDD VSS gf180mcu_fd_sc_mcu7t5v0__fillcap_16
XFILLER_163_64 VDD VSS VDD VSS gf180mcu_fd_sc_mcu7t5v0__fillcap_4
XFILLER_264_667 VDD VSS VDD VSS gf180mcu_fd_sc_mcu7t5v0__fillcap_64
XFILLER_252_807 VDD VSS VDD VSS gf180mcu_fd_sc_mcu7t5v0__fillcap_64
XFILLER_189_446 VDD VSS VDD VSS gf180mcu_fd_sc_mcu7t5v0__fillcap_4
XFILLER_71_282 VDD VSS VDD VSS gf180mcu_fd_sc_mcu7t5v0__fillcap_64
XFILLER_220_737 VDD VSS VDD VSS gf180mcu_fd_sc_mcu7t5v0__fillcap_64
XFILLER_232_597 VDD VSS VDD VSS gf180mcu_fd_sc_mcu7t5v0__fillcap_16
X_2670_ VDD VSS _2671_/B _4306_/Q _4503_/D VDD VSS gf180mcu_fd_sc_mcu7t5v0__nand2_1
XFILLER_158_877 VDD VSS VDD VSS gf180mcu_fd_sc_mcu7t5v0__fillcap_8
XFILLER_185_696 VDD VSS VDD VSS gf180mcu_fd_sc_mcu7t5v0__fillcap_4
XFILLER_126_763 VDD VSS VDD VSS gf180mcu_fd_sc_mcu7t5v0__fillcap_4
XFILLER_172_379 VDD VSS VDD VSS gf180mcu_fd_sc_mcu7t5v0__fillcap_4
X_4340_ _4340_/D _4340_/Q _4525_/RN VSS _4371_/CLK VDD VDD VSS gf180mcu_fd_sc_mcu7t5v0__dffrnq_1
X_4271_ _4271_/D _4271_/Q _4284_/RN VSS _4271_/CLK VDD VDD VSS gf180mcu_fd_sc_mcu7t5v0__dffrnq_1
X_3222_ VDD VSS _4348_/D _3222_/A1 _3222_/A2 VDD VSS gf180mcu_fd_sc_mcu7t5v0__nor2_1
X_3153_ VDD VSS _3173_/B _4337_/Q wire13/Z VDD VSS gf180mcu_fd_sc_mcu7t5v0__nand2_1
XFILLER_140_287 VDD VSS VDD VSS gf180mcu_fd_sc_mcu7t5v0__fillcap_4
XFILLER_95_842 VDD VSS VDD VSS gf180mcu_fd_sc_mcu7t5v0__fillcap_8
X_2104_ VDD VSS _4539_/D _2102_/Z _2105_/A2 VDD VSS gf180mcu_fd_sc_mcu7t5v0__nor2_1
XFILLER_95_864 VDD VSS VDD VSS gf180mcu_fd_sc_mcu7t5v0__fillcap_16
X_3084_ VDD _3087_/A2 _3084_/B wire93/Z _3084_/A2 VSS _3084_/A3 VDD VSS gf180mcu_fd_sc_mcu7t5v0__oai31_1
XFILLER_254_177 VDD VSS VDD VSS gf180mcu_fd_sc_mcu7t5v0__fillcap_64
XFILLER_242_317 VDD VSS VDD VSS gf180mcu_fd_sc_mcu7t5v0__fillcap_64
X_2035_ _2035_/A3 _3449_/A2 VDD VSS _2035_/Z _4432_/Q _4431_/Q VDD VSS gf180mcu_fd_sc_mcu7t5v0__and4_1
XFILLER_63_772 VDD VSS VDD VSS gf180mcu_fd_sc_mcu7t5v0__fillcap_64
X_3986_ VDD _3986_/Q _3989_/CLK VSS _3986_/D VDD VSS gf180mcu_fd_sc_mcu7t5v0__dffq_1
XFILLER_149_822 VDD VSS VDD VSS gf180mcu_fd_sc_mcu7t5v0__fillcap_4
XFILLER_195_438 VDD VSS VDD VSS gf180mcu_fd_sc_mcu7t5v0__fillcap_4
XFILLER_195_405 VDD VSS VDD VSS gf180mcu_fd_sc_mcu7t5v0__fillcap_8
X_2937_ VDD VSS _2938_/C _4331_/Q _4363_/Q VDD VSS gf180mcu_fd_sc_mcu7t5v0__xor2_1
XFILLER_210_247 VDD VSS VDD VSS gf180mcu_fd_sc_mcu7t5v0__fillcap_4
XFILLER_210_269 VDD VSS VDD VSS gf180mcu_fd_sc_mcu7t5v0__fillcap_4
XFILLER_136_527 VDD VSS VDD VSS gf180mcu_fd_sc_mcu7t5v0__fillcap_4
X_4607_ _4607_/D _4607_/Q _4613_/RN VSS _4616_/CLK VDD VDD VSS gf180mcu_fd_sc_mcu7t5v0__dffrnq_1
X_2868_ VDD VSS _2869_/A3 _2868_/A1 _3037_/A1 VDD VSS gf180mcu_fd_sc_mcu7t5v0__nor2_1
X_2799_ _2799_/A3 VDD VSS _2865_/C _4330_/Q _3039_/A1 VDD VSS gf180mcu_fd_sc_mcu7t5v0__nand3_1
X_4538_ _4538_/D _4538_/Q _4573_/RN VSS _4573_/CLK VDD VDD VSS gf180mcu_fd_sc_mcu7t5v0__dffrnq_1
X_4469_ _4469_/D _4469_/Q _4473_/RN VSS _4469_/CLK VDD VDD VSS gf180mcu_fd_sc_mcu7t5v0__dffrnq_1
XFILLER_116_295 VDD VSS VDD VSS gf180mcu_fd_sc_mcu7t5v0__fillcap_8
XFILLER_104_457 VDD VSS VDD VSS gf180mcu_fd_sc_mcu7t5v0__fillcap_16
XFILLER_85_352 VDD VSS VDD VSS gf180mcu_fd_sc_mcu7t5v0__fillcap_64
XFILLER_246_667 VDD VSS VDD VSS gf180mcu_fd_sc_mcu7t5v0__fillcap_64
XFILLER_234_807 VDD VSS VDD VSS gf180mcu_fd_sc_mcu7t5v0__fillcap_8
XFILLER_261_626 VDD VSS VDD VSS gf180mcu_fd_sc_mcu7t5v0__fillcap_4
XFILLER_198_221 VDD VSS VDD VSS gf180mcu_fd_sc_mcu7t5v0__fillcap_8
XFILLER_41_422 VDD VSS VDD VSS gf180mcu_fd_sc_mcu7t5v0__fillcap_64
XFILLER_199_766 VDD VSS VDD VSS gf180mcu_fd_sc_mcu7t5v0__fillcap_4
XFILLER_53_282 VDD VSS VDD VSS gf180mcu_fd_sc_mcu7t5v0__fillcap_64
XFILLER_202_737 VDD VSS VDD VSS gf180mcu_fd_sc_mcu7t5v0__fillcap_16
XFILLER_214_597 VDD VSS VDD VSS gf180mcu_fd_sc_mcu7t5v0__fillcap_4
XFILLER_158_107 VDD VSS VDD VSS gf180mcu_fd_sc_mcu7t5v0__fillcap_8
XFILLER_220_2 VDD VSS VDD VSS gf180mcu_fd_sc_mcu7t5v0__fillcap_32
Xmax_length60 VSS _3217_/A1 wire59/I VDD VDD VSS gf180mcu_fd_sc_mcu7t5v0__buf_1
XFILLER_154_302 VDD VSS VDD VSS gf180mcu_fd_sc_mcu7t5v0__fillcap_8
XFILLER_110_405 VDD VSS VDD VSS gf180mcu_fd_sc_mcu7t5v0__fillcap_32
XFILLER_1_562 VDD VSS VDD VSS gf180mcu_fd_sc_mcu7t5v0__fillcap_64
XFILLER_77_842 VDD VSS VDD VSS gf180mcu_fd_sc_mcu7t5v0__fillcap_32
XFILLER_89_691 VDD VSS VDD VSS gf180mcu_fd_sc_mcu7t5v0__fillcap_8
XFILLER_67_72 VDD VSS VDD VSS gf180mcu_fd_sc_mcu7t5v0__fillcap_64
XFILLER_92_823 VDD VSS VDD VSS gf180mcu_fd_sc_mcu7t5v0__fillcap_8
XFILLER_218_870 VDD VSS VDD VSS gf180mcu_fd_sc_mcu7t5v0__fillcap_4
XFILLER_236_177 VDD VSS VDD VSS gf180mcu_fd_sc_mcu7t5v0__fillcap_64
XFILLER_224_317 VDD VSS VDD VSS gf180mcu_fd_sc_mcu7t5v0__fillcap_64
XFILLER_251_136 VDD VSS VDD VSS gf180mcu_fd_sc_mcu7t5v0__fillcap_4
XFILLER_45_772 VDD VSS VDD VSS gf180mcu_fd_sc_mcu7t5v0__fillcap_64
XFILLER_72_591 VDD VSS VDD VSS gf180mcu_fd_sc_mcu7t5v0__fillcap_4
XFILLER_60_731 VDD VSS VDD VSS gf180mcu_fd_sc_mcu7t5v0__fillcap_4
X_3840_ VDD VSS _3848_/S _3840_/A1 _3840_/A2 VDD VSS gf180mcu_fd_sc_mcu7t5v0__nand2_1
XFILLER_189_276 VDD VSS VDD VSS gf180mcu_fd_sc_mcu7t5v0__fillcap_4
X_3771_ _3777_/S VDD VSS _3939_/D _4290_/Q _3939_/Q VDD VSS gf180mcu_fd_sc_mcu7t5v0__mux2_2
XFILLER_177_449 VDD VSS VDD VSS gf180mcu_fd_sc_mcu7t5v0__fillcap_4
XFILLER_189_298 VDD VSS VDD VSS gf180mcu_fd_sc_mcu7t5v0__fillcap_4
X_2722_ _2728_/S VDD VSS _4256_/D _4256_/Q _4272_/Q VDD VSS gf180mcu_fd_sc_mcu7t5v0__mux2_2
X_2653_ _2666_/C VDD VSS _2665_/B1 _2653_/A1 _2653_/A2 VDD VSS gf180mcu_fd_sc_mcu7t5v0__aoi21_1
XFILLER_66_2 VDD VSS VDD VSS gf180mcu_fd_sc_mcu7t5v0__fillcap_32
XFILLER_161_828 VDD VSS VDD VSS gf180mcu_fd_sc_mcu7t5v0__fillcap_8
X_2584_ wire27/Z VDD VSS _4202_/D _4468_/Q _4202_/Q VDD VSS gf180mcu_fd_sc_mcu7t5v0__mux2_2
XFILLER_99_422 VDD VSS VDD VSS gf180mcu_fd_sc_mcu7t5v0__fillcap_64
X_4323_ _4323_/D _4323_/Q wire199/Z VSS _4529_/CLK VDD VDD VSS gf180mcu_fd_sc_mcu7t5v0__dffrnq_1
X_4254_ _4254_/D _4254_/Q wire206/Z VSS _4508_/CLK VDD VDD VSS gf180mcu_fd_sc_mcu7t5v0__dffrnq_1
XFILLER_228_645 VDD VSS VDD VSS gf180mcu_fd_sc_mcu7t5v0__fillcap_8
X_4185_ _4185_/D _4185_/Q wire207/Z VSS _4459_/CLK VDD VDD VSS gf180mcu_fd_sc_mcu7t5v0__dffrnq_1
X_3205_ VDD _3205_/B _3205_/A2 _4341_/D _3205_/A1 VSS VDD VSS gf180mcu_fd_sc_mcu7t5v0__oai21_1
XFILLER_67_352 VDD VSS VDD VSS gf180mcu_fd_sc_mcu7t5v0__fillcap_64
XFILLER_83_801 VDD VSS VDD VSS gf180mcu_fd_sc_mcu7t5v0__fillcap_4
XFILLER_228_667 VDD VSS VDD VSS gf180mcu_fd_sc_mcu7t5v0__fillcap_4
X_3136_ VDD VSS _3138_/B1 _3157_/A1 _3894_/Q VDD VSS gf180mcu_fd_sc_mcu7t5v0__nor2_1
XFILLER_82_311 VDD VSS VDD VSS gf180mcu_fd_sc_mcu7t5v0__fillcap_4
XFILLER_83_834 VDD VSS VDD VSS gf180mcu_fd_sc_mcu7t5v0__fillcap_4
XFILLER_95_694 VDD VSS VDD VSS gf180mcu_fd_sc_mcu7t5v0__fillcap_4
XFILLER_243_626 VDD VSS VDD VSS gf180mcu_fd_sc_mcu7t5v0__fillcap_4
XFILLER_255_486 VDD VSS VDD VSS gf180mcu_fd_sc_mcu7t5v0__fillcap_4
X_3067_ _3169_/B _3067_/C VDD VSS _3069_/A2 _2854_/B _3067_/A2 wire68/Z VDD VSS gf180mcu_fd_sc_mcu7t5v0__aoi221_1
X_2018_ VDD VSS _3877_/Q _3691_/A1 VDD VSS gf180mcu_fd_sc_mcu7t5v0__clkinv_1
XFILLER_23_422 VDD VSS VDD VSS gf180mcu_fd_sc_mcu7t5v0__fillcap_64
XFILLER_35_282 VDD VSS VDD VSS gf180mcu_fd_sc_mcu7t5v0__fillcap_64
XFILLER_50_241 VDD VSS VDD VSS gf180mcu_fd_sc_mcu7t5v0__fillcap_4
Xmax_length106 VSS _2846_/S _3176_/S VDD VDD VSS gf180mcu_fd_sc_mcu7t5v0__buf_2
X_3969_ VDD _3969_/Q _3969_/CLK VSS _3969_/D VDD VSS gf180mcu_fd_sc_mcu7t5v0__dffq_1
XFILLER_195_18 VDD VSS VDD VSS gf180mcu_fd_sc_mcu7t5v0__fillcap_4
Xmax_length139 VSS _3394_/I1 _4437_/Q VDD VDD VSS gf180mcu_fd_sc_mcu7t5v0__buf_1
XFILLER_191_430 VDD VSS VDD VSS gf180mcu_fd_sc_mcu7t5v0__fillcap_4
XFILLER_151_327 VDD VSS VDD VSS gf180mcu_fd_sc_mcu7t5v0__fillcap_16
XFILLER_105_766 VDD VSS VDD VSS gf180mcu_fd_sc_mcu7t5v0__fillcap_4
XFILLER_265_206 VDD VSS VDD VSS gf180mcu_fd_sc_mcu7t5v0__fillcap_4
XFILLER_104_287 VDD VSS VDD VSS gf180mcu_fd_sc_mcu7t5v0__fillcap_8
XFILLER_59_842 VDD VSS VDD VSS gf180mcu_fd_sc_mcu7t5v0__fillcap_32
XFILLER_74_801 VDD VSS VDD VSS gf180mcu_fd_sc_mcu7t5v0__fillcap_4
XFILLER_206_317 VDD VSS VDD VSS gf180mcu_fd_sc_mcu7t5v0__fillcap_16
XFILLER_218_177 VDD VSS VDD VSS gf180mcu_fd_sc_mcu7t5v0__fillcap_16
XFILLER_170_2 VDD VSS VDD VSS gf180mcu_fd_sc_mcu7t5v0__fillcap_32
XFILLER_268_2 VDD VSS VDD VSS gf180mcu_fd_sc_mcu7t5v0__fillcap_32
XFILLER_233_136 VDD VSS VDD VSS gf180mcu_fd_sc_mcu7t5v0__fillcap_4
XFILLER_27_772 VDD VSS VDD VSS gf180mcu_fd_sc_mcu7t5v0__fillcap_64
XFILLER_199_552 VDD VSS VDD VSS gf180mcu_fd_sc_mcu7t5v0__fillcap_8
XFILLER_54_591 VDD VSS VDD VSS gf180mcu_fd_sc_mcu7t5v0__fillcap_4
XFILLER_42_731 VDD VSS VDD VSS gf180mcu_fd_sc_mcu7t5v0__fillcap_4
XFILLER_202_545 VDD VSS VDD VSS gf180mcu_fd_sc_mcu7t5v0__fillcap_8
XFILLER_10_661 VDD VSS VDD VSS gf180mcu_fd_sc_mcu7t5v0__fillcap_4
XFILLER_115_508 VDD VSS VDD VSS gf180mcu_fd_sc_mcu7t5v0__fillcap_8
XFILLER_5_142 VDD VSS VDD VSS gf180mcu_fd_sc_mcu7t5v0__fillcap_64
XFILLER_108_582 VDD VSS VDD VSS gf180mcu_fd_sc_mcu7t5v0__fillcap_8
XFILLER_151_850 VDD VSS VDD VSS gf180mcu_fd_sc_mcu7t5v0__fillcap_4
XFILLER_123_541 VDD VSS VDD VSS gf180mcu_fd_sc_mcu7t5v0__fillcap_16
Xspi_opentarget_i3c_top clk_i_PD VDD VSS VDD VSS gf180mcu_fd_sc_mcu7t5v0__tiel
XFILLER_2_871 VDD VSS VDD VSS gf180mcu_fd_sc_mcu7t5v0__fillcap_4
XFILLER_123_596 VDD VSS VDD VSS gf180mcu_fd_sc_mcu7t5v0__fillcap_32
XFILLER_111_747 VDD VSS VDD VSS gf180mcu_fd_sc_mcu7t5v0__fillcap_8
XFILLER_49_352 VDD VSS VDD VSS gf180mcu_fd_sc_mcu7t5v0__fillcap_64
XFILLER_237_486 VDD VSS VDD VSS gf180mcu_fd_sc_mcu7t5v0__fillcap_4
XFILLER_225_626 VDD VSS VDD VSS gf180mcu_fd_sc_mcu7t5v0__fillcap_4
XFILLER_209_166 VDD VSS VDD VSS gf180mcu_fd_sc_mcu7t5v0__fillcap_8
XFILLER_64_311 VDD VSS VDD VSS gf180mcu_fd_sc_mcu7t5v0__fillcap_4
XFILLER_76_171 VDD VSS VDD VSS gf180mcu_fd_sc_mcu7t5v0__fillcap_4
XFILLER_225_648 VDD VSS VDD VSS gf180mcu_fd_sc_mcu7t5v0__fillcap_8
XFILLER_17_282 VDD VSS VDD VSS gf180mcu_fd_sc_mcu7t5v0__fillcap_64
XFILLER_32_241 VDD VSS VDD VSS gf180mcu_fd_sc_mcu7t5v0__fillcap_4
X_3823_ _3830_/S VDD VSS _3978_/D _3841_/I0 _3978_/Q VDD VSS gf180mcu_fd_sc_mcu7t5v0__mux2_2
X_3754_ _3758_/S VDD VSS _3926_/D wire174/Z _3926_/Q VDD VSS gf180mcu_fd_sc_mcu7t5v0__mux2_2
XFILLER_158_482 VDD VSS VDD VSS gf180mcu_fd_sc_mcu7t5v0__fillcap_8
XFILLER_119_836 VDD VSS VDD VSS gf180mcu_fd_sc_mcu7t5v0__fillcap_4
XFILLER_229_66 VDD VSS VDD VSS gf180mcu_fd_sc_mcu7t5v0__fillcap_4
X_2705_ _2713_/B1 _4279_/Q VDD VSS _2706_/I _4247_/Q _2226_/B VDD VSS gf180mcu_fd_sc_mcu7t5v0__aoi22_1
X_3685_ VSS VDD _3685_/C2 _4370_/Q _4202_/Q _3685_/B1 _3685_/A2 _4194_/Q _3686_/A3
+ VDD VSS gf180mcu_fd_sc_mcu7t5v0__aoi222_1
XFILLER_9_492 VDD VSS VDD VSS gf180mcu_fd_sc_mcu7t5v0__fillcap_64
X_2636_ VDD VSS _4217_/D _4217_/Q _2637_/A2 VDD VSS gf180mcu_fd_sc_mcu7t5v0__and2_1
X_2567_ wire28/Z VDD VSS _4190_/D _4464_/Q _4190_/Q VDD VSS gf180mcu_fd_sc_mcu7t5v0__mux2_2
X_4306_ VDD _4306_/Q _4363_/CLK VSS _4306_/D VDD VSS gf180mcu_fd_sc_mcu7t5v0__dffq_1
XFILLER_247_206 VDD VSS VDD VSS gf180mcu_fd_sc_mcu7t5v0__fillcap_4
XFILLER_99_296 VDD VSS VDD VSS gf180mcu_fd_sc_mcu7t5v0__fillcap_32
X_2498_ _2500_/S VDD VSS _4119_/D wire154/Z _4119_/Q VDD VSS gf180mcu_fd_sc_mcu7t5v0__mux2_2
X_4237_ _4237_/D _4237_/Q _4616_/RN VSS _4615_/CLK VDD VDD VSS gf180mcu_fd_sc_mcu7t5v0__dffrnq_1
XFILLER_114_14 VDD VSS VDD VSS gf180mcu_fd_sc_mcu7t5v0__fillcap_4
XFILLER_68_661 VDD VSS VDD VSS gf180mcu_fd_sc_mcu7t5v0__fillcap_4
XFILLER_56_801 VDD VSS VDD VSS gf180mcu_fd_sc_mcu7t5v0__fillcap_4
X_4168_ _4168_/D _4168_/Q _4527_/RN VSS _4199_/CLK VDD VDD VSS gf180mcu_fd_sc_mcu7t5v0__dffrnq_1
X_3119_ VDD _3126_/B2 _3182_/B _3188_/C _3119_/A2 VSS _3119_/A3 VDD VSS gf180mcu_fd_sc_mcu7t5v0__oai31_1
X_4099_ VDD _4099_/Q _4128_/CLK VSS _4099_/D VDD VSS gf180mcu_fd_sc_mcu7t5v0__dffq_1
XFILLER_24_731 VDD VSS VDD VSS gf180mcu_fd_sc_mcu7t5v0__fillcap_4
XFILLER_36_591 VDD VSS VDD VSS gf180mcu_fd_sc_mcu7t5v0__fillcap_4
XFILLER_196_566 VDD VSS VDD VSS gf180mcu_fd_sc_mcu7t5v0__fillcap_4
XFILLER_184_728 VDD VSS VDD VSS gf180mcu_fd_sc_mcu7t5v0__fillcap_4
XFILLER_139_22 VDD VSS VDD VSS gf180mcu_fd_sc_mcu7t5v0__fillcap_8
XFILLER_168_257 VDD VSS VDD VSS gf180mcu_fd_sc_mcu7t5v0__fillcap_16
XFILLER_156_419 VDD VSS VDD VSS gf180mcu_fd_sc_mcu7t5v0__fillcap_16
XFILLER_23_66 VDD VSS VDD VSS gf180mcu_fd_sc_mcu7t5v0__fillcap_4
XFILLER_125_806 VDD VSS VDD VSS gf180mcu_fd_sc_mcu7t5v0__fillcap_16
XFILLER_192_761 VDD VSS VDD VSS gf180mcu_fd_sc_mcu7t5v0__fillcap_32
XFILLER_109_368 VDD VSS VDD VSS gf180mcu_fd_sc_mcu7t5v0__fillcap_4
XFILLER_191_282 VDD VSS VDD VSS gf180mcu_fd_sc_mcu7t5v0__fillcap_32
XFILLER_2_101 VDD VSS VDD VSS gf180mcu_fd_sc_mcu7t5v0__fillcap_4
XFILLER_155_87 VDD VSS VDD VSS gf180mcu_fd_sc_mcu7t5v0__fillcap_32
XFILLER_171_42 VDD VSS VDD VSS gf180mcu_fd_sc_mcu7t5v0__fillcap_4
XFILLER_120_577 VDD VSS VDD VSS gf180mcu_fd_sc_mcu7t5v0__fillcap_4
XFILLER_46_311 VDD VSS VDD VSS gf180mcu_fd_sc_mcu7t5v0__fillcap_4
XFILLER_58_171 VDD VSS VDD VSS gf180mcu_fd_sc_mcu7t5v0__fillcap_4
XFILLER_14_241 VDD VSS VDD VSS gf180mcu_fd_sc_mcu7t5v0__fillcap_4
XFILLER_120_90 VDD VSS VDD VSS gf180mcu_fd_sc_mcu7t5v0__fillcap_8
XFILLER_155_430 VDD VSS VDD VSS gf180mcu_fd_sc_mcu7t5v0__fillcap_4
XFILLER_183_772 VDD VSS VDD VSS gf180mcu_fd_sc_mcu7t5v0__fillcap_16
XFILLER_6_451 VDD VSS VDD VSS gf180mcu_fd_sc_mcu7t5v0__fillcap_4
X_3470_ VDD VSS _3471_/B _3564_/S _4003_/Q VDD VSS gf180mcu_fd_sc_mcu7t5v0__nand2_1
X_2421_ _2422_/S VDD VSS _4056_/D wire152/Z _4056_/Q VDD VSS gf180mcu_fd_sc_mcu7t5v0__mux2_2
XFILLER_97_734 VDD VSS VDD VSS gf180mcu_fd_sc_mcu7t5v0__fillcap_4
X_2352_ _2357_/S VDD VSS _4002_/D _4002_/Q wire167/Z VDD VSS gf180mcu_fd_sc_mcu7t5v0__mux2_2
XFILLER_229_206 VDD VSS VDD VSS gf180mcu_fd_sc_mcu7t5v0__fillcap_4
XFILLER_96_255 VDD VSS VDD VSS gf180mcu_fd_sc_mcu7t5v0__fillcap_4
X_2283_ _4381_/Q VDD VSS _3329_/A1 _4382_/Q _4380_/Q VDD VSS gf180mcu_fd_sc_mcu7t5v0__nand3_1
XFILLER_29_2 VDD VSS VDD VSS gf180mcu_fd_sc_mcu7t5v0__fillcap_64
XFILLER_38_801 VDD VSS VDD VSS gf180mcu_fd_sc_mcu7t5v0__fillcap_4
XFILLER_111_577 VDD VSS VDD VSS gf180mcu_fd_sc_mcu7t5v0__fillcap_32
X_4022_ VDD _4022_/Q _4033_/CLK VSS _4022_/D VDD VSS gf180mcu_fd_sc_mcu7t5v0__dffq_1
XFILLER_18_591 VDD VSS VDD VSS gf180mcu_fd_sc_mcu7t5v0__fillcap_4
XFILLER_80_667 VDD VSS VDD VSS gf180mcu_fd_sc_mcu7t5v0__fillcap_16
XFILLER_212_139 VDD VSS VDD VSS gf180mcu_fd_sc_mcu7t5v0__fillcap_32
X_3806_ wire15/Z VDD VSS _3964_/D _4291_/Q _3964_/Q VDD VSS gf180mcu_fd_sc_mcu7t5v0__mux2_2
X_3737_ _3738_/S VDD VSS _3912_/D _3766_/I0 _3912_/Q VDD VSS gf180mcu_fd_sc_mcu7t5v0__mux2_2
Xclkbuf_leaf_41_clk_i _4371_/CLK VSS VDD clkload6/I VDD VSS gf180mcu_fd_sc_mcu7t5v0__clkbuf_2
X_1998_ VDD VSS _4013_/Q _3506_/A2 VDD VSS gf180mcu_fd_sc_mcu7t5v0__clkinv_1
Xclkload70 VSS clkload70/Z _4521_/CLK VDD VDD VSS gf180mcu_fd_sc_mcu7t5v0__clkbuf_1
XFILLER_173_282 VDD VSS VDD VSS gf180mcu_fd_sc_mcu7t5v0__fillcap_8
XFILLER_161_422 VDD VSS VDD VSS gf180mcu_fd_sc_mcu7t5v0__fillcap_4
X_3668_ _3682_/B1 _4187_/Q VDD VSS _3669_/I _4493_/Q _3682_/A2 VDD VSS gf180mcu_fd_sc_mcu7t5v0__aoi22_1
Xclkload81 VSS clkload81/Z _4366_/CLK VDD VDD VSS gf180mcu_fd_sc_mcu7t5v0__clkbuf_1
Xclkload92 VDD VSS clkload92/ZN _4605_/CLK VDD VSS gf180mcu_fd_sc_mcu7t5v0__clkinv_8
X_2619_ _2619_/A3 VDD VSS _4211_/D _2606_/C _2622_/A2 VDD VSS gf180mcu_fd_sc_mcu7t5v0__nor3_1
XFILLER_133_135 VDD VSS VDD VSS gf180mcu_fd_sc_mcu7t5v0__fillcap_4
X_3599_ VDD VSS _3600_/A3 _3586_/S _4073_/Q VDD VSS gf180mcu_fd_sc_mcu7t5v0__nand2_1
Xclkbuf_leaf_56_clk_i _4366_/CLK VSS VDD clkload5/I VDD VSS gf180mcu_fd_sc_mcu7t5v0__clkbuf_2
XFILLER_142_680 VDD VSS VDD VSS gf180mcu_fd_sc_mcu7t5v0__fillcap_8
XFILLER_121_319 VDD VSS VDD VSS gf180mcu_fd_sc_mcu7t5v0__fillcap_16
XFILLER_115_883 VDD VSS VDD VSS gf180mcu_fd_sc_mcu7t5v0__fillcap_4
XFILLER_229_740 VDD VSS VDD VSS gf180mcu_fd_sc_mcu7t5v0__fillcap_8
XFILLER_28_311 VDD VSS VDD VSS gf180mcu_fd_sc_mcu7t5v0__fillcap_4
XFILLER_141_34 VDD VSS VDD VSS gf180mcu_fd_sc_mcu7t5v0__fillcap_8
XFILLER_70_177 VDD VSS VDD VSS gf180mcu_fd_sc_mcu7t5v0__fillcap_64
Xspi_opentarget_i3c_top_214 clk_i_PU VDD VSS VDD VSS gf180mcu_fd_sc_mcu7t5v0__tiel
XFILLER_212_673 VDD VSS VDD VSS gf180mcu_fd_sc_mcu7t5v0__fillcap_8
XFILLER_169_555 VDD VSS VDD VSS gf180mcu_fd_sc_mcu7t5v0__fillcap_4
Xspi_opentarget_i3c_top_247 irq_o_OE VDD VSS VDD VSS gf180mcu_fd_sc_mcu7t5v0__tieh
Xspi_opentarget_i3c_top_236 spi_miso_o_CS VDD VSS VDD VSS gf180mcu_fd_sc_mcu7t5v0__tiel
Xspi_opentarget_i3c_top_225 rst_ni_PU VDD VSS VDD VSS gf180mcu_fd_sc_mcu7t5v0__tiel
Xwire157 VSS wire157/Z _4310_/Q VDD VDD VSS gf180mcu_fd_sc_mcu7t5v0__buf_2
Xwire179 VSS wire179/Z _4290_/Q VDD VDD VSS gf180mcu_fd_sc_mcu7t5v0__buf_2
XFILLER_165_772 VDD VSS VDD VSS gf180mcu_fd_sc_mcu7t5v0__fillcap_8
Xwire168 VSS wire168/Z wire168/I VDD VDD VSS gf180mcu_fd_sc_mcu7t5v0__buf_2
XFILLER_152_422 VDD VSS VDD VSS gf180mcu_fd_sc_mcu7t5v0__fillcap_32
XFILLER_192_591 VDD VSS VDD VSS gf180mcu_fd_sc_mcu7t5v0__fillcap_4
XFILLER_166_53 VDD VSS VDD VSS gf180mcu_fd_sc_mcu7t5v0__fillcap_8
XFILLER_94_737 VDD VSS VDD VSS gf180mcu_fd_sc_mcu7t5v0__fillcap_64
XFILLER_75_72 VDD VSS VDD VSS gf180mcu_fd_sc_mcu7t5v0__fillcap_64
XFILLER_50_807 VDD VSS VDD VSS gf180mcu_fd_sc_mcu7t5v0__fillcap_64
XFILLER_62_667 VDD VSS VDD VSS gf180mcu_fd_sc_mcu7t5v0__fillcap_64
X_2970_ VDD VSS _2971_/A4 _3038_/C _3214_/A3 VDD VSS gf180mcu_fd_sc_mcu7t5v0__nand2_1
X_1921_ VDD VSS _4305_/Q _2899_/B2 VDD VSS gf180mcu_fd_sc_mcu7t5v0__clkinv_1
XFILLER_187_352 VDD VSS VDD VSS gf180mcu_fd_sc_mcu7t5v0__fillcap_16
XFILLER_30_597 VDD VSS VDD VSS gf180mcu_fd_sc_mcu7t5v0__fillcap_64
XFILLER_128_441 VDD VSS VDD VSS gf180mcu_fd_sc_mcu7t5v0__fillcap_8
X_4571_ _4571_/D _4571_/Q wire187/Z VSS _4595_/CLK VDD VDD VSS gf180mcu_fd_sc_mcu7t5v0__dffrnq_1
XFILLER_143_422 VDD VSS VDD VSS gf180mcu_fd_sc_mcu7t5v0__fillcap_64
XFILLER_155_282 VDD VSS VDD VSS gf180mcu_fd_sc_mcu7t5v0__fillcap_16
X_3522_ _4198_/Q _3622_/C VDD VSS _3523_/A3 _4133_/Q _2039_/Z _3685_/B1 VDD VSS gf180mcu_fd_sc_mcu7t5v0__aoi221_1
XFILLER_170_241 VDD VSS VDD VSS gf180mcu_fd_sc_mcu7t5v0__fillcap_4
X_3453_ _3453_/A3 VDD VSS _3575_/A1 _4431_/Q _3453_/A2 VDD VSS gf180mcu_fd_sc_mcu7t5v0__nand3_1
X_2404_ VDD VSS _2413_/S _2483_/A1 _2423_/A2 VDD VSS gf180mcu_fd_sc_mcu7t5v0__nand2_1
X_3384_ wire56/Z VDD VSS _4430_/D _4390_/Q _4430_/Q VDD VSS gf180mcu_fd_sc_mcu7t5v0__mux2_2
XFILLER_123_190 VDD VSS VDD VSS gf180mcu_fd_sc_mcu7t5v0__fillcap_8
X_2335_ VDD VSS _3208_/A2 _3024_/A2 _2984_/A4 VDD VSS gf180mcu_fd_sc_mcu7t5v0__nor2_1
X_2266_ _2265_/Z VDD VSS _4606_/D _2266_/A1 _2264_/Z VDD VSS gf180mcu_fd_sc_mcu7t5v0__nor3_1
X_2197_ _2677_/A1 _2205_/A2 VDD VSS _2213_/A2 _4234_/Q _4235_/Q VDD VSS gf180mcu_fd_sc_mcu7t5v0__nand4_1
XFILLER_84_247 VDD VSS VDD VSS gf180mcu_fd_sc_mcu7t5v0__fillcap_64
X_4005_ VDD _4005_/Q _4028_/CLK VSS _4005_/D VDD VSS gf180mcu_fd_sc_mcu7t5v0__dffq_1
XFILLER_241_702 VDD VSS VDD VSS gf180mcu_fd_sc_mcu7t5v0__fillcap_64
XFILLER_253_562 VDD VSS VDD VSS gf180mcu_fd_sc_mcu7t5v0__fillcap_64
XFILLER_52_177 VDD VSS VDD VSS gf180mcu_fd_sc_mcu7t5v0__fillcap_64
XFILLER_40_317 VDD VSS VDD VSS gf180mcu_fd_sc_mcu7t5v0__fillcap_64
XFILLER_221_492 VDD VSS VDD VSS gf180mcu_fd_sc_mcu7t5v0__fillcap_64
XFILLER_194_823 VDD VSS VDD VSS gf180mcu_fd_sc_mcu7t5v0__fillcap_32
XFILLER_147_772 VDD VSS VDD VSS gf180mcu_fd_sc_mcu7t5v0__fillcap_16
XFILLER_146_282 VDD VSS VDD VSS gf180mcu_fd_sc_mcu7t5v0__fillcap_16
XFILLER_107_625 VDD VSS VDD VSS gf180mcu_fd_sc_mcu7t5v0__fillcap_4
XFILLER_88_597 VDD VSS VDD VSS gf180mcu_fd_sc_mcu7t5v0__fillcap_64
XFILLER_130_683 VDD VSS VDD VSS gf180mcu_fd_sc_mcu7t5v0__fillcap_8
XFILLER_76_737 VDD VSS VDD VSS gf180mcu_fd_sc_mcu7t5v0__fillcap_64
XFILLER_152_77 VDD VSS VDD VSS gf180mcu_fd_sc_mcu7t5v0__fillcap_4
XFILLER_217_787 VDD VSS VDD VSS gf180mcu_fd_sc_mcu7t5v0__fillcap_4
XFILLER_231_212 VDD VSS VDD VSS gf180mcu_fd_sc_mcu7t5v0__fillcap_64
XFILLER_32_807 VDD VSS VDD VSS gf180mcu_fd_sc_mcu7t5v0__fillcap_64
XFILLER_44_667 VDD VSS VDD VSS gf180mcu_fd_sc_mcu7t5v0__fillcap_64
XFILLER_232_768 VDD VSS VDD VSS gf180mcu_fd_sc_mcu7t5v0__fillcap_16
XFILLER_250_2 VDD VSS VDD VSS gf180mcu_fd_sc_mcu7t5v0__fillcap_32
XFILLER_71_486 VDD VSS VDD VSS gf180mcu_fd_sc_mcu7t5v0__fillcap_4
XFILLER_197_661 VDD VSS VDD VSS gf180mcu_fd_sc_mcu7t5v0__fillcap_16
XFILLER_169_352 VDD VSS VDD VSS gf180mcu_fd_sc_mcu7t5v0__fillcap_4
XFILLER_184_311 VDD VSS VDD VSS gf180mcu_fd_sc_mcu7t5v0__fillcap_4
XFILLER_12_597 VDD VSS VDD VSS gf180mcu_fd_sc_mcu7t5v0__fillcap_64
XFILLER_177_63 VDD VSS VDD VSS gf180mcu_fd_sc_mcu7t5v0__fillcap_4
XFILLER_125_422 VDD VSS VDD VSS gf180mcu_fd_sc_mcu7t5v0__fillcap_32
XFILLER_137_282 VDD VSS VDD VSS gf180mcu_fd_sc_mcu7t5v0__fillcap_16
XFILLER_99_807 VDD VSS VDD VSS gf180mcu_fd_sc_mcu7t5v0__fillcap_16
XFILLER_152_285 VDD VSS VDD VSS gf180mcu_fd_sc_mcu7t5v0__fillcap_8
XFILLER_98_317 VDD VSS VDD VSS gf180mcu_fd_sc_mcu7t5v0__fillcap_16
XFILLER_267_632 VDD VSS VDD VSS gf180mcu_fd_sc_mcu7t5v0__fillcap_64
X_2120_ VDD VSS _2121_/B2 wire134/I _2150_/A2 VDD VSS gf180mcu_fd_sc_mcu7t5v0__nand2_1
XFILLER_120_160 VDD VSS VDD VSS gf180mcu_fd_sc_mcu7t5v0__fillcap_8
X_2051_ _2086_/A1 VDD VSS _2051_/Z _4592_/Q _4593_/Q VDD VSS gf180mcu_fd_sc_mcu7t5v0__and3_1
XFILLER_66_247 VDD VSS VDD VSS gf180mcu_fd_sc_mcu7t5v0__fillcap_64
XFILLER_235_551 VDD VSS VDD VSS gf180mcu_fd_sc_mcu7t5v0__fillcap_8
XFILLER_94_589 VDD VSS VDD VSS gf180mcu_fd_sc_mcu7t5v0__fillcap_4
XFILLER_81_206 VDD VSS VDD VSS gf180mcu_fd_sc_mcu7t5v0__fillcap_4
XFILLER_223_702 VDD VSS VDD VSS gf180mcu_fd_sc_mcu7t5v0__fillcap_8
XFILLER_250_521 VDD VSS VDD VSS gf180mcu_fd_sc_mcu7t5v0__fillcap_4
XFILLER_262_381 VDD VSS VDD VSS gf180mcu_fd_sc_mcu7t5v0__fillcap_4
X_2953_ _2953_/A3 _2953_/A4 VDD VSS _2954_/B _2896_/B _3032_/A2 VDD VSS gf180mcu_fd_sc_mcu7t5v0__or4_1
XFILLER_34_177 VDD VSS VDD VSS gf180mcu_fd_sc_mcu7t5v0__fillcap_64
XFILLER_22_317 VDD VSS VDD VSS gf180mcu_fd_sc_mcu7t5v0__fillcap_64
XFILLER_96_2 VDD VSS VDD VSS gf180mcu_fd_sc_mcu7t5v0__fillcap_32
XFILLER_176_801 VDD VSS VDD VSS gf180mcu_fd_sc_mcu7t5v0__fillcap_4
XFILLER_176_823 VDD VSS VDD VSS gf180mcu_fd_sc_mcu7t5v0__fillcap_8
X_2884_ VDD VSS _2886_/B _4325_/Q _2884_/A2 VDD VSS gf180mcu_fd_sc_mcu7t5v0__nor2_1
XFILLER_129_761 VDD VSS VDD VSS gf180mcu_fd_sc_mcu7t5v0__fillcap_8
XFILLER_129_772 VDD VSS VDD VSS gf180mcu_fd_sc_mcu7t5v0__fillcap_8
X_4554_ _4554_/D wire93/I wire187/Z VSS _4554_/CLK VDD VDD VSS gf180mcu_fd_sc_mcu7t5v0__dffrnq_1
XFILLER_237_66 VDD VSS VDD VSS gf180mcu_fd_sc_mcu7t5v0__fillcap_4
XFILLER_190_369 VDD VSS VDD VSS gf180mcu_fd_sc_mcu7t5v0__fillcap_4
X_3505_ VDD VSS _3506_/B _3564_/S _4005_/Q VDD VSS gf180mcu_fd_sc_mcu7t5v0__nand2_1
XFILLER_143_252 VDD VSS VDD VSS gf180mcu_fd_sc_mcu7t5v0__fillcap_4
X_4485_ _4485_/D _4485_/Q wire209/Z VSS _4485_/CLK VDD VDD VSS gf180mcu_fd_sc_mcu7t5v0__dffrnq_1
XFILLER_104_639 VDD VSS VDD VSS gf180mcu_fd_sc_mcu7t5v0__fillcap_4
X_3436_ _3597_/S VDD VSS _3436_/Z _4090_/Q _4082_/Q VDD VSS gf180mcu_fd_sc_mcu7t5v0__mux2_2
X_3367_ wire20/Z VDD VSS _4414_/D _4406_/Q _4414_/Q VDD VSS gf180mcu_fd_sc_mcu7t5v0__mux2_2
XFILLER_100_801 VDD VSS VDD VSS gf180mcu_fd_sc_mcu7t5v0__fillcap_4
X_2318_ _4524_/D VDD VSS _2829_/C _4524_/Q _2318_/A2 _2318_/B1 VDD VSS gf180mcu_fd_sc_mcu7t5v0__oai22_2
XFILLER_257_142 VDD VSS VDD VSS gf180mcu_fd_sc_mcu7t5v0__fillcap_64
XFILLER_111_160 VDD VSS VDD VSS gf180mcu_fd_sc_mcu7t5v0__fillcap_32
XFILLER_58_737 VDD VSS VDD VSS gf180mcu_fd_sc_mcu7t5v0__fillcap_64
X_3298_ _3298_/B _4382_/Q VDD VSS _3306_/A2 _4380_/Q _3298_/A2 VDD VSS gf180mcu_fd_sc_mcu7t5v0__oai211_1
X_2249_ _2249_/A3 VDD VSS _2250_/A3 _2249_/A1 _2249_/A2 VDD VSS gf180mcu_fd_sc_mcu7t5v0__nand3_1
XFILLER_254_871 VDD VSS VDD VSS gf180mcu_fd_sc_mcu7t5v0__fillcap_4
XFILLER_213_212 VDD VSS VDD VSS gf180mcu_fd_sc_mcu7t5v0__fillcap_32
XFILLER_14_807 VDD VSS VDD VSS gf180mcu_fd_sc_mcu7t5v0__fillcap_64
XFILLER_26_667 VDD VSS VDD VSS gf180mcu_fd_sc_mcu7t5v0__fillcap_64
XFILLER_41_626 VDD VSS VDD VSS gf180mcu_fd_sc_mcu7t5v0__fillcap_4
XFILLER_53_486 VDD VSS VDD VSS gf180mcu_fd_sc_mcu7t5v0__fillcap_4
XFILLER_119_271 VDD VSS VDD VSS gf180mcu_fd_sc_mcu7t5v0__fillcap_8
XFILLER_119_282 VDD VSS VDD VSS gf180mcu_fd_sc_mcu7t5v0__fillcap_8
XFILLER_31_66 VDD VSS VDD VSS gf180mcu_fd_sc_mcu7t5v0__fillcap_4
XFILLER_162_550 VDD VSS VDD VSS gf180mcu_fd_sc_mcu7t5v0__fillcap_4
XFILLER_134_263 VDD VSS VDD VSS gf180mcu_fd_sc_mcu7t5v0__fillcap_8
Xoutput9 VDD wire140/Z VSS spi_miso_o_OUT VDD VSS gf180mcu_fd_sc_mcu7t5v0__dlyb_1
XFILLER_249_632 VDD VSS VDD VSS gf180mcu_fd_sc_mcu7t5v0__fillcap_64
XFILLER_1_766 VDD VSS VDD VSS gf180mcu_fd_sc_mcu7t5v0__fillcap_4
XFILLER_48_247 VDD VSS VDD VSS gf180mcu_fd_sc_mcu7t5v0__fillcap_64
XFILLER_63_206 VDD VSS VDD VSS gf180mcu_fd_sc_mcu7t5v0__fillcap_4
XFILLER_205_724 VDD VSS VDD VSS gf180mcu_fd_sc_mcu7t5v0__fillcap_4
XFILLER_217_562 VDD VSS VDD VSS gf180mcu_fd_sc_mcu7t5v0__fillcap_64
XFILLER_232_543 VDD VSS VDD VSS gf180mcu_fd_sc_mcu7t5v0__fillcap_8
XFILLER_244_381 VDD VSS VDD VSS gf180mcu_fd_sc_mcu7t5v0__fillcap_4
XFILLER_260_885 VDD VSS VDD VSS gf180mcu_fd_sc_mcu7t5v0__fillcap_4
XFILLER_16_177 VDD VSS VDD VSS gf180mcu_fd_sc_mcu7t5v0__fillcap_64
XFILLER_31_136 VDD VSS VDD VSS gf180mcu_fd_sc_mcu7t5v0__fillcap_4
XFILLER_158_845 VDD VSS VDD VSS gf180mcu_fd_sc_mcu7t5v0__fillcap_16
XFILLER_200_473 VDD VSS VDD VSS gf180mcu_fd_sc_mcu7t5v0__fillcap_8
XFILLER_173_804 VDD VSS VDD VSS gf180mcu_fd_sc_mcu7t5v0__fillcap_8
XFILLER_8_387 VDD VSS VDD VSS gf180mcu_fd_sc_mcu7t5v0__fillcap_64
XFILLER_153_594 VDD VSS VDD VSS gf180mcu_fd_sc_mcu7t5v0__fillcap_8
XFILLER_180_380 VDD VSS VDD VSS gf180mcu_fd_sc_mcu7t5v0__fillcap_4
X_4270_ _4270_/D _4270_/Q wire193/Z VSS _4270_/CLK VDD VDD VSS gf180mcu_fd_sc_mcu7t5v0__dffrnq_1
X_3221_ _3038_/C _2858_/B VDD VSS _3222_/A2 _4348_/Q _3213_/B VDD VSS gf180mcu_fd_sc_mcu7t5v0__aoi22_1
X_3152_ VDD _4336_/D _3152_/B wire13/Z _3152_/A2 VSS _3152_/A3 VDD VSS gf180mcu_fd_sc_mcu7t5v0__oai31_1
XFILLER_239_142 VDD VSS VDD VSS gf180mcu_fd_sc_mcu7t5v0__fillcap_64
X_2103_ VDD VSS _2105_/A2 _4539_/Q _2090_/Z VDD VSS gf180mcu_fd_sc_mcu7t5v0__nor2_1
XFILLER_254_101 VDD VSS VDD VSS gf180mcu_fd_sc_mcu7t5v0__fillcap_4
XFILLER_67_556 VDD VSS VDD VSS gf180mcu_fd_sc_mcu7t5v0__fillcap_4
X_3083_ _3083_/B wire71/Z VDD VSS _3084_/A3 wire97/Z _3082_/Z VDD VSS gf180mcu_fd_sc_mcu7t5v0__aoi211_1
XFILLER_236_871 VDD VSS VDD VSS gf180mcu_fd_sc_mcu7t5v0__fillcap_4
XFILLER_223_510 VDD VSS VDD VSS gf180mcu_fd_sc_mcu7t5v0__fillcap_16
X_2034_ _4430_/Q VDD VSS _3449_/A2 _4428_/Q _4427_/Q VDD VSS gf180mcu_fd_sc_mcu7t5v0__nor3_1
XFILLER_251_874 VDD VSS VDD VSS gf180mcu_fd_sc_mcu7t5v0__fillcap_16
XFILLER_35_486 VDD VSS VDD VSS gf180mcu_fd_sc_mcu7t5v0__fillcap_4
XFILLER_23_626 VDD VSS VDD VSS gf180mcu_fd_sc_mcu7t5v0__fillcap_4
X_3985_ VDD _3985_/Q _3998_/CLK VSS _3985_/D VDD VSS gf180mcu_fd_sc_mcu7t5v0__dffq_1
X_2936_ VDD _2936_/B _2936_/A2 _2950_/A1 _2931_/Z VSS VDD VSS gf180mcu_fd_sc_mcu7t5v0__oai21_1
XFILLER_148_333 VDD VSS VDD VSS gf180mcu_fd_sc_mcu7t5v0__fillcap_8
XFILLER_148_311 VDD VSS VDD VSS gf180mcu_fd_sc_mcu7t5v0__fillcap_4
XFILLER_164_815 VDD VSS VDD VSS gf180mcu_fd_sc_mcu7t5v0__fillcap_4
X_2867_ _3169_/B _2967_/B VDD VSS _3218_/B1 _4341_/Q _4232_/Q _3214_/A2 VDD VSS gf180mcu_fd_sc_mcu7t5v0__aoi221_1
XFILLER_136_517 VDD VSS VDD VSS gf180mcu_fd_sc_mcu7t5v0__fillcap_8
X_4606_ VSS _4606_/CLK VDD _4606_/D wire77/I _4616_/RN VDD VSS gf180mcu_fd_sc_mcu7t5v0__dffsnq_1
XFILLER_163_325 VDD VSS VDD VSS gf180mcu_fd_sc_mcu7t5v0__fillcap_16
X_2798_ _2321_/Z VDD VSS _3223_/B _3043_/A1 _4329_/Q VDD VSS gf180mcu_fd_sc_mcu7t5v0__nor3_1
XFILLER_117_753 VDD VSS VDD VSS gf180mcu_fd_sc_mcu7t5v0__fillcap_16
X_4537_ _4537_/D _4537_/Q _4573_/RN VSS _4573_/CLK VDD VDD VSS gf180mcu_fd_sc_mcu7t5v0__dffrnq_1
XFILLER_116_241 VDD VSS VDD VSS gf180mcu_fd_sc_mcu7t5v0__fillcap_4
X_4468_ _4468_/D _4468_/Q _4536_/RN VSS _4468_/CLK VDD VDD VSS gf180mcu_fd_sc_mcu7t5v0__dffrnq_1
XFILLER_89_136 VDD VSS VDD VSS gf180mcu_fd_sc_mcu7t5v0__fillcap_4
X_3419_ _3424_/S VDD VSS _4462_/D _4420_/Q _4462_/Q VDD VSS gf180mcu_fd_sc_mcu7t5v0__mux2_2
XFILLER_132_767 VDD VSS VDD VSS gf180mcu_fd_sc_mcu7t5v0__fillcap_4
XFILLER_258_451 VDD VSS VDD VSS gf180mcu_fd_sc_mcu7t5v0__fillcap_4
X_4399_ _4399_/D _4399_/Q wire196/Z VSS _4441_/CLK VDD VDD VSS gf180mcu_fd_sc_mcu7t5v0__dffrnq_1
XFILLER_45_206 VDD VSS VDD VSS gf180mcu_fd_sc_mcu7t5v0__fillcap_4
XFILLER_226_381 VDD VSS VDD VSS gf180mcu_fd_sc_mcu7t5v0__fillcap_4
XFILLER_242_885 VDD VSS VDD VSS gf180mcu_fd_sc_mcu7t5v0__fillcap_4
XFILLER_13_136 VDD VSS VDD VSS gf180mcu_fd_sc_mcu7t5v0__fillcap_4
XFILLER_201_248 VDD VSS VDD VSS gf180mcu_fd_sc_mcu7t5v0__fillcap_16
Xclkbuf_3_3__f_clk_i VDD VSS clkload2/I clkbuf_0_clk_i/Z VDD VSS gf180mcu_fd_sc_mcu7t5v0__clkbuf_16
Xmax_length61 VSS wire59/I _2987_/B VDD VDD VSS gf180mcu_fd_sc_mcu7t5v0__buf_2
Xmax_length50 VSS _2510_/A2 _2141_/A2 VDD VDD VSS gf180mcu_fd_sc_mcu7t5v0__buf_2
XFILLER_170_807 VDD VSS VDD VSS gf180mcu_fd_sc_mcu7t5v0__fillcap_8
XFILLER_5_346 VDD VSS VDD VSS gf180mcu_fd_sc_mcu7t5v0__fillcap_4
XFILLER_174_53 VDD VSS VDD VSS gf180mcu_fd_sc_mcu7t5v0__fillcap_8
XFILLER_150_597 VDD VSS VDD VSS gf180mcu_fd_sc_mcu7t5v0__fillcap_8
XFILLER_236_101 VDD VSS VDD VSS gf180mcu_fd_sc_mcu7t5v0__fillcap_4
XFILLER_190_30 VDD VSS VDD VSS gf180mcu_fd_sc_mcu7t5v0__fillcap_4
XFILLER_49_556 VDD VSS VDD VSS gf180mcu_fd_sc_mcu7t5v0__fillcap_4
XFILLER_233_874 VDD VSS VDD VSS gf180mcu_fd_sc_mcu7t5v0__fillcap_16
XFILLER_199_72 VDD VSS VDD VSS gf180mcu_fd_sc_mcu7t5v0__fillcap_64
XFILLER_199_50 VDD VSS VDD VSS gf180mcu_fd_sc_mcu7t5v0__fillcap_16
XFILLER_83_72 VDD VSS VDD VSS gf180mcu_fd_sc_mcu7t5v0__fillcap_64
XFILLER_17_486 VDD VSS VDD VSS gf180mcu_fd_sc_mcu7t5v0__fillcap_4
XFILLER_205_598 VDD VSS VDD VSS gf180mcu_fd_sc_mcu7t5v0__fillcap_4
X_3770_ _3777_/S VDD VSS _3938_/D _4289_/Q _3938_/Q VDD VSS gf180mcu_fd_sc_mcu7t5v0__mux2_2
X_2721_ _2728_/S VDD VSS _4255_/D _4255_/Q _4271_/Q VDD VSS gf180mcu_fd_sc_mcu7t5v0__mux2_2
XFILLER_158_697 VDD VSS VDD VSS gf180mcu_fd_sc_mcu7t5v0__fillcap_8
XFILLER_9_696 VDD VSS VDD VSS gf180mcu_fd_sc_mcu7t5v0__fillcap_4
X_2652_ _2652_/B1 _2652_/B2 VDD VSS _4225_/D _3086_/A2 _2666_/C VDD VSS gf180mcu_fd_sc_mcu7t5v0__aoi22_1
XFILLER_145_358 VDD VSS VDD VSS gf180mcu_fd_sc_mcu7t5v0__fillcap_16
XFILLER_173_678 VDD VSS VDD VSS gf180mcu_fd_sc_mcu7t5v0__fillcap_8
XFILLER_172_177 VDD VSS VDD VSS gf180mcu_fd_sc_mcu7t5v0__fillcap_8
XFILLER_160_317 VDD VSS VDD VSS gf180mcu_fd_sc_mcu7t5v0__fillcap_4
X_2583_ wire27/Z VDD VSS _4201_/D wire121/Z _4201_/Q VDD VSS gf180mcu_fd_sc_mcu7t5v0__mux2_2
XFILLER_59_2 VDD VSS VDD VSS gf180mcu_fd_sc_mcu7t5v0__fillcap_64
X_4322_ _4322_/D _4322_/Q _4371_/RN VSS _4528_/CLK VDD VDD VSS gf180mcu_fd_sc_mcu7t5v0__dffrnq_1
XFILLER_114_745 VDD VSS VDD VSS gf180mcu_fd_sc_mcu7t5v0__fillcap_4
X_4253_ _4253_/D _4253_/Q _4284_/RN VSS _4466_/CLK VDD VDD VSS gf180mcu_fd_sc_mcu7t5v0__dffrnq_1
X_3204_ VDD wire45/I _3204_/A2 _3205_/A2 _2967_/B VSS VDD VSS gf180mcu_fd_sc_mcu7t5v0__oai21_1
X_4184_ _4184_/D _4184_/Q wire207/Z VSS _4459_/CLK VDD VDD VSS gf180mcu_fd_sc_mcu7t5v0__dffrnq_1
X_3135_ VDD wire97/I _3878_/Q _3138_/A2 _3157_/A1 VSS VDD VSS gf180mcu_fd_sc_mcu7t5v0__oai21_1
XFILLER_27_206 VDD VSS VDD VSS gf180mcu_fd_sc_mcu7t5v0__fillcap_4
X_3066_ VDD _3170_/B _3066_/A2 _3067_/C _3214_/A1 VSS VDD VSS gf180mcu_fd_sc_mcu7t5v0__oai21_1
X_2017_ VDD VSS _3893_/Q _3713_/A1 VDD VSS gf180mcu_fd_sc_mcu7t5v0__clkinv_1
XFILLER_224_885 VDD VSS VDD VSS gf180mcu_fd_sc_mcu7t5v0__fillcap_4
X_3968_ VDD _3968_/Q _3968_/CLK VSS _3968_/D VDD VSS gf180mcu_fd_sc_mcu7t5v0__dffq_1
XFILLER_196_737 VDD VSS VDD VSS gf180mcu_fd_sc_mcu7t5v0__fillcap_8
XFILLER_211_579 VDD VSS VDD VSS gf180mcu_fd_sc_mcu7t5v0__fillcap_16
X_2919_ _2919_/S VDD VSS _4311_/D _4335_/Q _4311_/Q VDD VSS gf180mcu_fd_sc_mcu7t5v0__mux2_2
XFILLER_149_653 VDD VSS VDD VSS gf180mcu_fd_sc_mcu7t5v0__fillcap_4
Xmax_length107 _3176_/S _4551_/Q VDD VSS VDD VSS gf180mcu_fd_sc_mcu7t5v0__buf_4
X_3899_ VDD _3899_/Q _4541_/CLK VSS _3899_/D VDD VSS gf180mcu_fd_sc_mcu7t5v0__dffq_1
XFILLER_120_704 VDD VSS VDD VSS gf180mcu_fd_sc_mcu7t5v0__fillcap_4
XFILLER_132_597 VDD VSS VDD VSS gf180mcu_fd_sc_mcu7t5v0__fillcap_8
XFILLER_120_715 VDD VSS VDD VSS gf180mcu_fd_sc_mcu7t5v0__fillcap_8
XFILLER_120_737 VDD VSS VDD VSS gf180mcu_fd_sc_mcu7t5v0__fillcap_32
XFILLER_218_101 VDD VSS VDD VSS gf180mcu_fd_sc_mcu7t5v0__fillcap_4
XFILLER_100_450 VDD VSS VDD VSS gf180mcu_fd_sc_mcu7t5v0__fillcap_4
XFILLER_215_874 VDD VSS VDD VSS gf180mcu_fd_sc_mcu7t5v0__fillcap_16
XFILLER_202_502 VDD VSS VDD VSS gf180mcu_fd_sc_mcu7t5v0__fillcap_16
XFILLER_230_877 VDD VSS VDD VSS gf180mcu_fd_sc_mcu7t5v0__fillcap_8
XFILLER_169_42 VDD VSS VDD VSS gf180mcu_fd_sc_mcu7t5v0__fillcap_4
XFILLER_169_86 VDD VSS VDD VSS gf180mcu_fd_sc_mcu7t5v0__fillcap_4
XFILLER_186_247 VDD VSS VDD VSS gf180mcu_fd_sc_mcu7t5v0__fillcap_16
XFILLER_142_317 VDD VSS VDD VSS gf180mcu_fd_sc_mcu7t5v0__fillcap_16
XFILLER_118_90 VDD VSS VDD VSS gf180mcu_fd_sc_mcu7t5v0__fillcap_8
XFILLER_110_247 VDD VSS VDD VSS gf180mcu_fd_sc_mcu7t5v0__fillcap_8
XFILLER_204_37 VDD VSS VDD VSS gf180mcu_fd_sc_mcu7t5v0__fillcap_64
XFILLER_91_142 VDD VSS VDD VSS gf180mcu_fd_sc_mcu7t5v0__fillcap_64
XFILLER_252_457 VDD VSS VDD VSS gf180mcu_fd_sc_mcu7t5v0__fillcap_64
XFILLER_233_671 VDD VSS VDD VSS gf180mcu_fd_sc_mcu7t5v0__fillcap_4
XFILLER_206_885 VDD VSS VDD VSS gf180mcu_fd_sc_mcu7t5v0__fillcap_4
X_3822_ VDD VSS _3830_/S _3822_/A1 _3840_/A2 VDD VSS gf180mcu_fd_sc_mcu7t5v0__nand2_1
XFILLER_178_737 VDD VSS VDD VSS gf180mcu_fd_sc_mcu7t5v0__fillcap_16
XFILLER_158_450 VDD VSS VDD VSS gf180mcu_fd_sc_mcu7t5v0__fillcap_4
XFILLER_119_804 VDD VSS VDD VSS gf180mcu_fd_sc_mcu7t5v0__fillcap_32
XFILLER_220_387 VDD VSS VDD VSS gf180mcu_fd_sc_mcu7t5v0__fillcap_64
X_3753_ _3753_/B VDD VSS _3925_/D _3753_/A1 _3758_/S VDD VSS gf180mcu_fd_sc_mcu7t5v0__aoi21_1
XFILLER_134_807 VDD VSS VDD VSS gf180mcu_fd_sc_mcu7t5v0__fillcap_64
X_2704_ VDD VSS _2704_/Z _4288_/Q _2226_/B VDD VSS gf180mcu_fd_sc_mcu7t5v0__or2_1
X_3684_ VDD VSS _3686_/B _4500_/Q _3479_/C VDD VSS gf180mcu_fd_sc_mcu7t5v0__nand2_1
XFILLER_146_667 VDD VSS VDD VSS gf180mcu_fd_sc_mcu7t5v0__fillcap_64
X_2635_ VDD _4216_/D _2635_/B _2635_/A1 _2606_/C VSS _2635_/A3 VDD VSS gf180mcu_fd_sc_mcu7t5v0__oai31_1
XFILLER_161_648 VDD VSS VDD VSS gf180mcu_fd_sc_mcu7t5v0__fillcap_4
XFILLER_160_136 VDD VSS VDD VSS gf180mcu_fd_sc_mcu7t5v0__fillcap_16
X_4305_ _4305_/D _4305_/Q _4530_/RN VSS _4305_/CLK VDD VDD VSS gf180mcu_fd_sc_mcu7t5v0__dffrnq_1
XFILLER_245_66 VDD VSS VDD VSS gf180mcu_fd_sc_mcu7t5v0__fillcap_4
X_2566_ wire28/Z VDD VSS _4189_/D _4463_/Q _4189_/Q VDD VSS gf180mcu_fd_sc_mcu7t5v0__mux2_2
XFILLER_99_275 VDD VSS VDD VSS gf180mcu_fd_sc_mcu7t5v0__fillcap_4
X_2497_ _2500_/S VDD VSS _4118_/D _2506_/I0 _4118_/Q VDD VSS gf180mcu_fd_sc_mcu7t5v0__mux2_2
XFILLER_114_597 VDD VSS VDD VSS gf180mcu_fd_sc_mcu7t5v0__fillcap_8
XFILLER_102_737 VDD VSS VDD VSS gf180mcu_fd_sc_mcu7t5v0__fillcap_64
X_4236_ _4236_/D _4236_/Q _4534_/RN VSS _4586_/CLK VDD VDD VSS gf180mcu_fd_sc_mcu7t5v0__dffrnq_1
X_4167_ _4167_/D _4167_/Q wire184/Z VSS _4199_/CLK VDD VDD VSS gf180mcu_fd_sc_mcu7t5v0__dffrnq_1
XFILLER_114_37 VDD VSS VDD VSS gf180mcu_fd_sc_mcu7t5v0__fillcap_4
X_3118_ _3118_/B VDD VSS _3119_/A3 _3176_/S _3691_/A1 VDD VSS gf180mcu_fd_sc_mcu7t5v0__aoi21_1
XFILLER_228_465 VDD VSS VDD VSS gf180mcu_fd_sc_mcu7t5v0__fillcap_4
XFILLER_83_632 VDD VSS VDD VSS gf180mcu_fd_sc_mcu7t5v0__fillcap_4
XFILLER_83_621 VDD VSS VDD VSS gf180mcu_fd_sc_mcu7t5v0__fillcap_8
XFILLER_95_492 VDD VSS VDD VSS gf180mcu_fd_sc_mcu7t5v0__fillcap_64
X_4098_ VDD _4098_/Q _4129_/CLK VSS _4098_/D VDD VSS gf180mcu_fd_sc_mcu7t5v0__dffq_1
X_3049_ VDD VSS _3069_/B _4332_/Q wire13/Z VDD VSS gf180mcu_fd_sc_mcu7t5v0__nand2_1
XFILLER_224_660 VDD VSS VDD VSS gf180mcu_fd_sc_mcu7t5v0__fillcap_4
XFILLER_230_107 VDD VSS VDD VSS gf180mcu_fd_sc_mcu7t5v0__fillcap_64
XFILLER_51_562 VDD VSS VDD VSS gf180mcu_fd_sc_mcu7t5v0__fillcap_64
XFILLER_212_877 VDD VSS VDD VSS gf180mcu_fd_sc_mcu7t5v0__fillcap_8
XFILLER_109_314 VDD VSS VDD VSS gf180mcu_fd_sc_mcu7t5v0__fillcap_16
XFILLER_164_442 VDD VSS VDD VSS gf180mcu_fd_sc_mcu7t5v0__fillcap_8
XFILLER_136_122 VDD VSS VDD VSS gf180mcu_fd_sc_mcu7t5v0__fillcap_16
XFILLER_99_49 VDD VSS VDD VSS gf180mcu_fd_sc_mcu7t5v0__fillcap_4
XFILLER_164_497 VDD VSS VDD VSS gf180mcu_fd_sc_mcu7t5v0__fillcap_4
XFILLER_124_317 VDD VSS VDD VSS gf180mcu_fd_sc_mcu7t5v0__fillcap_64
XFILLER_266_527 VDD VSS VDD VSS gf180mcu_fd_sc_mcu7t5v0__fillcap_64
XFILLER_219_454 VDD VSS VDD VSS gf180mcu_fd_sc_mcu7t5v0__fillcap_4
XFILLER_0_27 VDD VSS VDD VSS gf180mcu_fd_sc_mcu7t5v0__fillcap_4
XFILLER_73_142 VDD VSS VDD VSS gf180mcu_fd_sc_mcu7t5v0__fillcap_64
XFILLER_234_457 VDD VSS VDD VSS gf180mcu_fd_sc_mcu7t5v0__fillcap_16
XFILLER_261_276 VDD VSS VDD VSS gf180mcu_fd_sc_mcu7t5v0__fillcap_4
XFILLER_202_310 VDD VSS VDD VSS gf180mcu_fd_sc_mcu7t5v0__fillcap_4
XFILLER_70_871 VDD VSS VDD VSS gf180mcu_fd_sc_mcu7t5v0__fillcap_4
XFILLER_116_807 VDD VSS VDD VSS gf180mcu_fd_sc_mcu7t5v0__fillcap_32
XFILLER_128_667 VDD VSS VDD VSS gf180mcu_fd_sc_mcu7t5v0__fillcap_16
XFILLER_142_125 VDD VSS VDD VSS gf180mcu_fd_sc_mcu7t5v0__fillcap_4
XFILLER_127_188 VDD VSS VDD VSS gf180mcu_fd_sc_mcu7t5v0__fillcap_16
X_2420_ _2422_/S VDD VSS _4055_/D wire154/Z _4055_/Q VDD VSS gf180mcu_fd_sc_mcu7t5v0__mux2_2
XFILLER_97_702 VDD VSS VDD VSS gf180mcu_fd_sc_mcu7t5v0__fillcap_32
XFILLER_170_489 VDD VSS VDD VSS gf180mcu_fd_sc_mcu7t5v0__fillcap_4
X_2351_ VDD VSS _4533_/D wire59/Z _2210_/Z VDD VSS gf180mcu_fd_sc_mcu7t5v0__nor2_1
XFILLER_215_58 VDD VSS VDD VSS gf180mcu_fd_sc_mcu7t5v0__fillcap_8
X_2282_ VDD VSS _3325_/A2 _4380_/Q _4381_/Q VDD VSS gf180mcu_fd_sc_mcu7t5v0__nand2_1
X_4021_ VDD _4021_/Q _4612_/CLK VSS _4021_/D VDD VSS gf180mcu_fd_sc_mcu7t5v0__dffq_1
XFILLER_77_492 VDD VSS VDD VSS gf180mcu_fd_sc_mcu7t5v0__fillcap_64
XFILLER_65_632 VDD VSS VDD VSS gf180mcu_fd_sc_mcu7t5v0__fillcap_64
XFILLER_92_451 VDD VSS VDD VSS gf180mcu_fd_sc_mcu7t5v0__fillcap_4
XFILLER_253_766 VDD VSS VDD VSS gf180mcu_fd_sc_mcu7t5v0__fillcap_4
XFILLER_212_107 VDD VSS VDD VSS gf180mcu_fd_sc_mcu7t5v0__fillcap_16
XFILLER_33_562 VDD VSS VDD VSS gf180mcu_fd_sc_mcu7t5v0__fillcap_64
XFILLER_21_702 VDD VSS VDD VSS gf180mcu_fd_sc_mcu7t5v0__fillcap_64
XFILLER_60_381 VDD VSS VDD VSS gf180mcu_fd_sc_mcu7t5v0__fillcap_4
XFILLER_221_696 VDD VSS VDD VSS gf180mcu_fd_sc_mcu7t5v0__fillcap_4
X_3805_ wire15/Z VDD VSS _3963_/D wire179/Z _3963_/Q VDD VSS gf180mcu_fd_sc_mcu7t5v0__mux2_2
X_1997_ VDD VSS _4077_/Q _3515_/A2 VDD VSS gf180mcu_fd_sc_mcu7t5v0__clkinv_1
X_3736_ _3738_/S VDD VSS _3911_/D _3765_/I0 _3911_/Q VDD VSS gf180mcu_fd_sc_mcu7t5v0__mux2_2
XFILLER_118_155 VDD VSS VDD VSS gf180mcu_fd_sc_mcu7t5v0__fillcap_4
Xclkload71 VSS clkload71/Z _4529_/CLK VDD VDD VSS gf180mcu_fd_sc_mcu7t5v0__clkbuf_1
Xclkload60 VSS clkload60/Z _4467_/CLK VDD VDD VSS gf180mcu_fd_sc_mcu7t5v0__clkbuf_1
XFILLER_173_272 VDD VSS VDD VSS gf180mcu_fd_sc_mcu7t5v0__fillcap_8
XFILLER_106_317 VDD VSS VDD VSS gf180mcu_fd_sc_mcu7t5v0__fillcap_4
X_3667_ VDD VSS _3667_/I _4492_/D VDD VSS gf180mcu_fd_sc_mcu7t5v0__clkinv_1
XFILLER_161_445 VDD VSS VDD VSS gf180mcu_fd_sc_mcu7t5v0__fillcap_16
Xclkload93 VSS clkload93/ZN _4606_/CLK VDD VDD VSS gf180mcu_fd_sc_mcu7t5v0__inv_3
X_2618_ _4211_/Q VDD VSS _2619_/A3 _2586_/Z _2618_/A2 VDD VSS gf180mcu_fd_sc_mcu7t5v0__aoi21_1
Xclkload82 VSS clkload82/Z _4199_/CLK VDD VDD VSS gf180mcu_fd_sc_mcu7t5v0__clkbuf_1
X_3598_ VDD VSS _3600_/A2 wire75/Z _4081_/Q VDD VSS gf180mcu_fd_sc_mcu7t5v0__nand2_1
X_2549_ wire29/I VDD VSS _4172_/D _4446_/Q _4172_/Q VDD VSS gf180mcu_fd_sc_mcu7t5v0__mux2_2
XFILLER_87_212 VDD VSS VDD VSS gf180mcu_fd_sc_mcu7t5v0__fillcap_64
XFILLER_248_527 VDD VSS VDD VSS gf180mcu_fd_sc_mcu7t5v0__fillcap_64
X_4219_ VSS _4521_/CLK VDD _4219_/D _4219_/Q wire199/Z VDD VSS gf180mcu_fd_sc_mcu7t5v0__dffsnq_1
XFILLER_102_589 VDD VSS VDD VSS gf180mcu_fd_sc_mcu7t5v0__fillcap_4
XFILLER_55_142 VDD VSS VDD VSS gf180mcu_fd_sc_mcu7t5v0__fillcap_64
XFILLER_216_457 VDD VSS VDD VSS gf180mcu_fd_sc_mcu7t5v0__fillcap_16
XFILLER_70_101 VDD VSS VDD VSS gf180mcu_fd_sc_mcu7t5v0__fillcap_4
XFILLER_243_276 VDD VSS VDD VSS gf180mcu_fd_sc_mcu7t5v0__fillcap_4
XFILLER_231_416 VDD VSS VDD VSS gf180mcu_fd_sc_mcu7t5v0__fillcap_4
XFILLER_197_821 VDD VSS VDD VSS gf180mcu_fd_sc_mcu7t5v0__fillcap_16
XFILLER_52_871 VDD VSS VDD VSS gf180mcu_fd_sc_mcu7t5v0__fillcap_4
Xspi_opentarget_i3c_top_226 scl_pad_i_PD VDD VSS VDD VSS gf180mcu_fd_sc_mcu7t5v0__tiel
Xspi_opentarget_i3c_top_237 spi_miso_o_IE VDD VSS VDD VSS gf180mcu_fd_sc_mcu7t5v0__tiel
XFILLER_11_212 VDD VSS VDD VSS gf180mcu_fd_sc_mcu7t5v0__fillcap_64
Xspi_opentarget_i3c_top_215 host_clk_i_PD VDD VSS VDD VSS gf180mcu_fd_sc_mcu7t5v0__tiel
Xspi_opentarget_i3c_top_248 sda_pad_IE VDD VSS VDD VSS gf180mcu_fd_sc_mcu7t5v0__tieh
Xwire114 VDD _4451_/Q VSS wire114/Z VDD VSS gf180mcu_fd_sc_mcu7t5v0__dlyb_1
Xwire125 VSS wire125/Z wire125/I VDD VDD VSS gf180mcu_fd_sc_mcu7t5v0__buf_1
XFILLER_200_869 VDD VSS VDD VSS gf180mcu_fd_sc_mcu7t5v0__fillcap_4
Xwire147 _2883_/C VSS VDD _4326_/Q VDD VSS gf180mcu_fd_sc_mcu7t5v0__clkbuf_3
XFILLER_126_2 VDD VSS VDD VSS gf180mcu_fd_sc_mcu7t5v0__fillcap_32
Xwire158 VSS wire158/Z wire160/Z VDD VDD VSS gf180mcu_fd_sc_mcu7t5v0__buf_2
XFILLER_3_422 VDD VSS VDD VSS gf180mcu_fd_sc_mcu7t5v0__fillcap_64
XFILLER_180_754 VDD VSS VDD VSS gf180mcu_fd_sc_mcu7t5v0__fillcap_4
XFILLER_124_169 VDD VSS VDD VSS gf180mcu_fd_sc_mcu7t5v0__fillcap_4
XFILLER_79_702 VDD VSS VDD VSS gf180mcu_fd_sc_mcu7t5v0__fillcap_64
XFILLER_133_670 VDD VSS VDD VSS gf180mcu_fd_sc_mcu7t5v0__fillcap_8
XFILLER_267_836 VDD VSS VDD VSS gf180mcu_fd_sc_mcu7t5v0__fillcap_4
XFILLER_59_492 VDD VSS VDD VSS gf180mcu_fd_sc_mcu7t5v0__fillcap_64
XFILLER_47_632 VDD VSS VDD VSS gf180mcu_fd_sc_mcu7t5v0__fillcap_64
XFILLER_74_451 VDD VSS VDD VSS gf180mcu_fd_sc_mcu7t5v0__fillcap_4
XFILLER_207_446 VDD VSS VDD VSS gf180mcu_fd_sc_mcu7t5v0__fillcap_4
XFILLER_235_755 VDD VSS VDD VSS gf180mcu_fd_sc_mcu7t5v0__fillcap_8
XFILLER_235_788 VDD VSS VDD VSS gf180mcu_fd_sc_mcu7t5v0__fillcap_8
XFILLER_15_562 VDD VSS VDD VSS gf180mcu_fd_sc_mcu7t5v0__fillcap_64
X_1920_ VDD VSS _4551_/Q _3157_/A1 VDD VSS gf180mcu_fd_sc_mcu7t5v0__clkinv_1
XFILLER_91_72 VDD VSS VDD VSS gf180mcu_fd_sc_mcu7t5v0__fillcap_64
XFILLER_30_521 VDD VSS VDD VSS gf180mcu_fd_sc_mcu7t5v0__fillcap_4
XFILLER_42_381 VDD VSS VDD VSS gf180mcu_fd_sc_mcu7t5v0__fillcap_4
X_4570_ _4570_/D _4570_/Q _4616_/RN VSS _4595_/CLK VDD VDD VSS gf180mcu_fd_sc_mcu7t5v0__dffrnq_1
X_3521_ VDD VSS _3523_/A2 _4154_/Q _2040_/Z VDD VSS gf180mcu_fd_sc_mcu7t5v0__nand2_1
XFILLER_171_710 VDD VSS VDD VSS gf180mcu_fd_sc_mcu7t5v0__fillcap_8
XFILLER_115_114 VDD VSS VDD VSS gf180mcu_fd_sc_mcu7t5v0__fillcap_4
XFILLER_7_772 VDD VSS VDD VSS gf180mcu_fd_sc_mcu7t5v0__fillcap_64
XFILLER_171_765 VDD VSS VDD VSS gf180mcu_fd_sc_mcu7t5v0__fillcap_4
X_3452_ wire145/Z _3452_/C VDD VSS _3454_/A3 _4151_/Q _2040_/Z _3633_/C1 VDD VSS gf180mcu_fd_sc_mcu7t5v0__aoi221_1
XFILLER_115_158 VDD VSS VDD VSS gf180mcu_fd_sc_mcu7t5v0__fillcap_8
X_3383_ _3383_/B VDD VSS _4429_/D _3383_/A1 wire56/Z VDD VSS gf180mcu_fd_sc_mcu7t5v0__aoi21_1
X_2403_ _2403_/S VDD VSS _4041_/D _4041_/Q _2454_/I0 VDD VSS gf180mcu_fd_sc_mcu7t5v0__mux2_2
XFILLER_41_2 VDD VSS VDD VSS gf180mcu_fd_sc_mcu7t5v0__fillcap_64
X_2334_ _3018_/B2 _2883_/C VDD VSS _2984_/A4 _3008_/B2 _3015_/C VDD VSS gf180mcu_fd_sc_mcu7t5v0__nand4_1
XFILLER_69_212 VDD VSS VDD VSS gf180mcu_fd_sc_mcu7t5v0__fillcap_64
XFILLER_97_521 VDD VSS VDD VSS gf180mcu_fd_sc_mcu7t5v0__fillcap_8
XFILLER_257_346 VDD VSS VDD VSS gf180mcu_fd_sc_mcu7t5v0__fillcap_4
X_2265_ VDD VSS _2265_/Z _4600_/Q _4595_/D VDD VSS gf180mcu_fd_sc_mcu7t5v0__xor2_1
X_2196_ _4239_/Q _4240_/Q VDD VSS _2205_/A2 _4238_/Q _4237_/Q VDD VSS gf180mcu_fd_sc_mcu7t5v0__nor4_1
X_4004_ VDD _4004_/Q _4028_/CLK VSS _4004_/D VDD VSS gf180mcu_fd_sc_mcu7t5v0__dffq_1
XFILLER_37_142 VDD VSS VDD VSS gf180mcu_fd_sc_mcu7t5v0__fillcap_64
XFILLER_52_101 VDD VSS VDD VSS gf180mcu_fd_sc_mcu7t5v0__fillcap_4
XFILLER_198_629 VDD VSS VDD VSS gf180mcu_fd_sc_mcu7t5v0__fillcap_8
XFILLER_225_276 VDD VSS VDD VSS gf180mcu_fd_sc_mcu7t5v0__fillcap_4
XFILLER_213_416 VDD VSS VDD VSS gf180mcu_fd_sc_mcu7t5v0__fillcap_4
XFILLER_111_38 VDD VSS VDD VSS gf180mcu_fd_sc_mcu7t5v0__fillcap_4
XFILLER_179_832 VDD VSS VDD VSS gf180mcu_fd_sc_mcu7t5v0__fillcap_8
XFILLER_34_871 VDD VSS VDD VSS gf180mcu_fd_sc_mcu7t5v0__fillcap_4
XFILLER_147_751 VDD VSS VDD VSS gf180mcu_fd_sc_mcu7t5v0__fillcap_4
X_3719_ _3719_/A3 VDD VSS _3759_/A1 _4538_/Q _4539_/Q VDD VSS gf180mcu_fd_sc_mcu7t5v0__nor3_1
XFILLER_107_648 VDD VSS VDD VSS gf180mcu_fd_sc_mcu7t5v0__fillcap_4
XFILLER_249_836 VDD VSS VDD VSS gf180mcu_fd_sc_mcu7t5v0__fillcap_4
XFILLER_88_521 VDD VSS VDD VSS gf180mcu_fd_sc_mcu7t5v0__fillcap_4
XFILLER_29_66 VDD VSS VDD VSS gf180mcu_fd_sc_mcu7t5v0__fillcap_4
XFILLER_29_632 VDD VSS VDD VSS gf180mcu_fd_sc_mcu7t5v0__fillcap_64
XFILLER_56_451 VDD VSS VDD VSS gf180mcu_fd_sc_mcu7t5v0__fillcap_4
XFILLER_243_2 VDD VSS VDD VSS gf180mcu_fd_sc_mcu7t5v0__fillcap_64
XFILLER_12_521 VDD VSS VDD VSS gf180mcu_fd_sc_mcu7t5v0__fillcap_4
XFILLER_24_381 VDD VSS VDD VSS gf180mcu_fd_sc_mcu7t5v0__fillcap_4
XFILLER_129_228 VDD VSS VDD VSS gf180mcu_fd_sc_mcu7t5v0__fillcap_4
XFILLER_40_885 VDD VSS VDD VSS gf180mcu_fd_sc_mcu7t5v0__fillcap_4
XFILLER_6_37 VDD VSS VDD VSS gf180mcu_fd_sc_mcu7t5v0__fillcap_64
XFILLER_4_731 VDD VSS VDD VSS gf180mcu_fd_sc_mcu7t5v0__fillcap_4
XFILLER_180_573 VDD VSS VDD VSS gf180mcu_fd_sc_mcu7t5v0__fillcap_16
XFILLER_239_346 VDD VSS VDD VSS gf180mcu_fd_sc_mcu7t5v0__fillcap_4
XFILLER_121_673 VDD VSS VDD VSS gf180mcu_fd_sc_mcu7t5v0__fillcap_16
X_2050_ VDD VSS _4592_/D _4592_/Q _2086_/A1 VDD VSS gf180mcu_fd_sc_mcu7t5v0__xor2_1
XFILLER_208_755 VDD VSS VDD VSS gf180mcu_fd_sc_mcu7t5v0__fillcap_16
XFILLER_212_37 VDD VSS VDD VSS gf180mcu_fd_sc_mcu7t5v0__fillcap_64
Xclkbuf_leaf_40_clk_i _4346_/CLK VSS VDD clkload4/I VDD VSS gf180mcu_fd_sc_mcu7t5v0__clkbuf_2
XFILLER_19_142 VDD VSS VDD VSS gf180mcu_fd_sc_mcu7t5v0__fillcap_64
XFILLER_207_265 VDD VSS VDD VSS gf180mcu_fd_sc_mcu7t5v0__fillcap_8
XFILLER_34_101 VDD VSS VDD VSS gf180mcu_fd_sc_mcu7t5v0__fillcap_4
XFILLER_16_871 VDD VSS VDD VSS gf180mcu_fd_sc_mcu7t5v0__fillcap_4
XFILLER_188_651 VDD VSS VDD VSS gf180mcu_fd_sc_mcu7t5v0__fillcap_8
Xclkbuf_leaf_55_clk_i _4531_/CLK VSS VDD clkload5/I VDD VSS gf180mcu_fd_sc_mcu7t5v0__clkbuf_2
X_2952_ VDD VSS _2953_/A4 _3497_/C1 _3212_/A2 VDD VSS gf180mcu_fd_sc_mcu7t5v0__nor2_1
XFILLER_231_780 VDD VSS VDD VSS gf180mcu_fd_sc_mcu7t5v0__fillcap_4
X_2883_ _2883_/B _2883_/C VDD VSS _2884_/A2 _2883_/A1 _2883_/A2 VDD VSS gf180mcu_fd_sc_mcu7t5v0__aoi211_1
XFILLER_31_874 VDD VSS VDD VSS gf180mcu_fd_sc_mcu7t5v0__fillcap_16
XFILLER_89_2 VDD VSS VDD VSS gf180mcu_fd_sc_mcu7t5v0__fillcap_64
XFILLER_191_827 VDD VSS VDD VSS gf180mcu_fd_sc_mcu7t5v0__fillcap_4
X_4553_ _4553_/D wire96/I _4573_/RN VSS _4553_/CLK VDD VDD VSS gf180mcu_fd_sc_mcu7t5v0__dffrnq_1
X_4484_ _4484_/D _4484_/Q wire186/Z VSS _4498_/CLK VDD VDD VSS gf180mcu_fd_sc_mcu7t5v0__dffrnq_1
X_3504_ _3564_/S VDD VSS _3504_/Z _4029_/Q _4021_/Q VDD VSS gf180mcu_fd_sc_mcu7t5v0__mux2_2
XFILLER_171_562 VDD VSS VDD VSS gf180mcu_fd_sc_mcu7t5v0__fillcap_16
XFILLER_131_404 VDD VSS VDD VSS gf180mcu_fd_sc_mcu7t5v0__fillcap_16
X_3435_ VDD VSS _3440_/A2 _3596_/A1 _3434_/Z VDD VSS gf180mcu_fd_sc_mcu7t5v0__nand2_1
X_3366_ wire20/Z VDD VSS _4413_/D _4405_/Q _4413_/Q VDD VSS gf180mcu_fd_sc_mcu7t5v0__mux2_2
XFILLER_98_885 VDD VSS VDD VSS gf180mcu_fd_sc_mcu7t5v0__fillcap_4
XFILLER_253_66 VDD VSS VDD VSS gf180mcu_fd_sc_mcu7t5v0__fillcap_4
X_2317_ VDD VSS wire45/I _2987_/B _3213_/B VDD VSS gf180mcu_fd_sc_mcu7t5v0__nor2_2
X_3297_ _3297_/A3 VDD VSS _3298_/B _4380_/Q _3297_/A2 VDD VSS gf180mcu_fd_sc_mcu7t5v0__nand3_1
X_2248_ VDD VSS _2249_/A3 _4558_/Q _4549_/D VDD VSS gf180mcu_fd_sc_mcu7t5v0__xnor2_1
XFILLER_122_37 VDD VSS VDD VSS gf180mcu_fd_sc_mcu7t5v0__fillcap_8
XFILLER_38_451 VDD VSS VDD VSS gf180mcu_fd_sc_mcu7t5v0__fillcap_4
X_2179_ _2666_/B1 _2653_/A1 VDD VSS _2182_/B _2168_/Z _2664_/A2 VDD VSS gf180mcu_fd_sc_mcu7t5v0__or4_1
XFILLER_222_791 VDD VSS VDD VSS gf180mcu_fd_sc_mcu7t5v0__fillcap_8
XFILLER_139_548 VDD VSS VDD VSS gf180mcu_fd_sc_mcu7t5v0__fillcap_8
XFILLER_22_885 VDD VSS VDD VSS gf180mcu_fd_sc_mcu7t5v0__fillcap_4
XFILLER_166_367 VDD VSS VDD VSS gf180mcu_fd_sc_mcu7t5v0__fillcap_16
XFILLER_134_220 VDD VSS VDD VSS gf180mcu_fd_sc_mcu7t5v0__fillcap_16
XFILLER_107_456 VDD VSS VDD VSS gf180mcu_fd_sc_mcu7t5v0__fillcap_32
XFILLER_122_448 VDD VSS VDD VSS gf180mcu_fd_sc_mcu7t5v0__fillcap_4
XFILLER_193_2 VDD VSS VDD VSS gf180mcu_fd_sc_mcu7t5v0__fillcap_16
XFILLER_130_492 VDD VSS VDD VSS gf180mcu_fd_sc_mcu7t5v0__fillcap_32
XFILLER_16_101 VDD VSS VDD VSS gf180mcu_fd_sc_mcu7t5v0__fillcap_4
XFILLER_185_632 VDD VSS VDD VSS gf180mcu_fd_sc_mcu7t5v0__fillcap_64
XFILLER_13_874 VDD VSS VDD VSS gf180mcu_fd_sc_mcu7t5v0__fillcap_16
XFILLER_8_311 VDD VSS VDD VSS gf180mcu_fd_sc_mcu7t5v0__fillcap_4
XFILLER_153_562 VDD VSS VDD VSS gf180mcu_fd_sc_mcu7t5v0__fillcap_32
XFILLER_113_448 VDD VSS VDD VSS gf180mcu_fd_sc_mcu7t5v0__fillcap_8
X_3220_ VDD VSS _3222_/A1 _4348_/Q _4347_/Q VDD VSS gf180mcu_fd_sc_mcu7t5v0__nor2_1
X_3151_ VDD VSS _3152_/A3 wire143/Z _3170_/B VDD VSS gf180mcu_fd_sc_mcu7t5v0__nor2_1
X_2102_ _2087_/Z _2102_/A4 VDD VSS _2102_/Z _4538_/Q _4539_/Q VDD VSS gf180mcu_fd_sc_mcu7t5v0__and4_1
XFILLER_121_492 VDD VSS VDD VSS gf180mcu_fd_sc_mcu7t5v0__fillcap_8
XFILLER_94_387 VDD VSS VDD VSS gf180mcu_fd_sc_mcu7t5v0__fillcap_64
X_3082_ _3122_/S VDD VSS _3082_/Z _3947_/Q _3939_/Q VDD VSS gf180mcu_fd_sc_mcu7t5v0__mux2_2
XFILLER_82_527 VDD VSS VDD VSS gf180mcu_fd_sc_mcu7t5v0__fillcap_8
X_2033_ VDD VSS _2511_/A3 _4428_/Q _4427_/Q VDD VSS gf180mcu_fd_sc_mcu7t5v0__nor2_1
XFILLER_251_842 VDD VSS VDD VSS gf180mcu_fd_sc_mcu7t5v0__fillcap_32
XFILLER_211_717 VDD VSS VDD VSS gf180mcu_fd_sc_mcu7t5v0__fillcap_16
XFILLER_223_577 VDD VSS VDD VSS gf180mcu_fd_sc_mcu7t5v0__fillcap_32
X_3984_ VDD _3984_/Q _3998_/CLK VSS _3984_/D VDD VSS gf180mcu_fd_sc_mcu7t5v0__dffq_1
XFILLER_210_227 VDD VSS VDD VSS gf180mcu_fd_sc_mcu7t5v0__fillcap_16
XFILLER_50_457 VDD VSS VDD VSS gf180mcu_fd_sc_mcu7t5v0__fillcap_64
X_2935_ VDD VSS _2936_/A2 _2935_/A1 _2935_/A2 VDD VSS gf180mcu_fd_sc_mcu7t5v0__nand2_1
XFILLER_175_142 VDD VSS VDD VSS gf180mcu_fd_sc_mcu7t5v0__fillcap_16
X_2866_ VDD VSS _3204_/A2 _3214_/A1 _4232_/Q VDD VSS gf180mcu_fd_sc_mcu7t5v0__nor2_1
X_4605_ _4605_/D _4605_/Q _4616_/RN VSS _4605_/CLK VDD VDD VSS gf180mcu_fd_sc_mcu7t5v0__dffrnq_1
X_2797_ VDD VSS _2989_/A1 _4524_/D _2995_/A2 VDD VSS gf180mcu_fd_sc_mcu7t5v0__nor2_1
XFILLER_190_123 VDD VSS VDD VSS gf180mcu_fd_sc_mcu7t5v0__fillcap_8
X_4536_ _4536_/D _4536_/Q _4536_/RN VSS _4536_/CLK VDD VDD VSS gf180mcu_fd_sc_mcu7t5v0__dffrnq_1
X_4467_ _4467_/D _4467_/Q wire210/Z VSS _4467_/CLK VDD VDD VSS gf180mcu_fd_sc_mcu7t5v0__dffrnq_1
XFILLER_131_212 VDD VSS VDD VSS gf180mcu_fd_sc_mcu7t5v0__fillcap_8
X_3418_ _3424_/S VDD VSS _4461_/D _4419_/Q _4461_/Q VDD VSS gf180mcu_fd_sc_mcu7t5v0__mux2_2
X_4398_ _4398_/D _4398_/Q wire186/Z VSS _4402_/CLK VDD VDD VSS gf180mcu_fd_sc_mcu7t5v0__dffrnq_1
XFILLER_98_660 VDD VSS VDD VSS gf180mcu_fd_sc_mcu7t5v0__fillcap_4
X_3349_ wire21/Z VDD VSS _4396_/D _4373_/Q _4396_/Q VDD VSS gf180mcu_fd_sc_mcu7t5v0__mux2_2
XFILLER_218_305 VDD VSS VDD VSS gf180mcu_fd_sc_mcu7t5v0__fillcap_8
XFILLER_112_481 VDD VSS VDD VSS gf180mcu_fd_sc_mcu7t5v0__fillcap_4
XFILLER_86_877 VDD VSS VDD VSS gf180mcu_fd_sc_mcu7t5v0__fillcap_8
XFILLER_93_18 VDD VSS VDD VSS gf180mcu_fd_sc_mcu7t5v0__fillcap_8
XFILLER_241_352 VDD VSS VDD VSS gf180mcu_fd_sc_mcu7t5v0__fillcap_64
XFILLER_202_728 VDD VSS VDD VSS gf180mcu_fd_sc_mcu7t5v0__fillcap_4
XFILLER_167_632 VDD VSS VDD VSS gf180mcu_fd_sc_mcu7t5v0__fillcap_16
Xmax_length40 _3831_/A1 VSS VDD _3707_/Z VDD VSS gf180mcu_fd_sc_mcu7t5v0__clkbuf_2
Xmax_length62 _3813_/A1 VSS VDD _2102_/Z VDD VSS gf180mcu_fd_sc_mcu7t5v0__clkbuf_2
Xmax_length95 VSS _3159_/C wire96/Z VDD VDD VSS gf180mcu_fd_sc_mcu7t5v0__buf_2
XFILLER_10_877 VDD VSS VDD VSS gf180mcu_fd_sc_mcu7t5v0__fillcap_8
Xmax_length73 VSS _3596_/A1 wire74/Z VDD VDD VSS gf180mcu_fd_sc_mcu7t5v0__buf_2
Xmax_length84 wire83/I wire82/I VDD VSS VDD VSS gf180mcu_fd_sc_mcu7t5v0__buf_4
Xclkbuf_4_13_0_host_clk_i _3937_/CLK VSS VDD clkbuf_0_host_clk_i/Z VDD VSS gf180mcu_fd_sc_mcu7t5v0__clkbuf_2
XFILLER_166_197 VDD VSS VDD VSS gf180mcu_fd_sc_mcu7t5v0__fillcap_16
XFILLER_135_562 VDD VSS VDD VSS gf180mcu_fd_sc_mcu7t5v0__fillcap_8
XFILLER_206_2 VDD VSS VDD VSS gf180mcu_fd_sc_mcu7t5v0__fillcap_32
XFILLER_123_702 VDD VSS VDD VSS gf180mcu_fd_sc_mcu7t5v0__fillcap_16
XFILLER_108_798 VDD VSS VDD VSS gf180mcu_fd_sc_mcu7t5v0__fillcap_4
XFILLER_103_492 VDD VSS VDD VSS gf180mcu_fd_sc_mcu7t5v0__fillcap_8
XFILLER_76_387 VDD VSS VDD VSS gf180mcu_fd_sc_mcu7t5v0__fillcap_64
XFILLER_123_80 VDD VSS VDD VSS gf180mcu_fd_sc_mcu7t5v0__fillcap_4
XFILLER_64_527 VDD VSS VDD VSS gf180mcu_fd_sc_mcu7t5v0__fillcap_64
XFILLER_233_842 VDD VSS VDD VSS gf180mcu_fd_sc_mcu7t5v0__fillcap_32
XFILLER_91_346 VDD VSS VDD VSS gf180mcu_fd_sc_mcu7t5v0__fillcap_4
XFILLER_260_661 VDD VSS VDD VSS gf180mcu_fd_sc_mcu7t5v0__fillcap_4
XFILLER_32_457 VDD VSS VDD VSS gf180mcu_fd_sc_mcu7t5v0__fillcap_64
XFILLER_201_772 VDD VSS VDD VSS gf180mcu_fd_sc_mcu7t5v0__fillcap_8
X_2720_ VDD VSS _2720_/I _4254_/D VDD VSS gf180mcu_fd_sc_mcu7t5v0__clkinv_1
XFILLER_157_142 VDD VSS VDD VSS gf180mcu_fd_sc_mcu7t5v0__fillcap_8
X_2651_ VDD VSS _2652_/B2 _2646_/C _2650_/Z VDD VSS gf180mcu_fd_sc_mcu7t5v0__nor2_1
XFILLER_154_871 VDD VSS VDD VSS gf180mcu_fd_sc_mcu7t5v0__fillcap_4
X_2582_ _2582_/B VDD VSS _4200_/D _2934_/B1 wire27/Z VDD VSS gf180mcu_fd_sc_mcu7t5v0__aoi21_1
X_4321_ _4321_/D _4321_/Q wire206/Z VSS _4345_/CLK VDD VDD VSS gf180mcu_fd_sc_mcu7t5v0__dffrnq_1
XFILLER_141_554 VDD VSS VDD VSS gf180mcu_fd_sc_mcu7t5v0__fillcap_4
X_4252_ _4252_/D _4252_/Q _4284_/RN VSS _4466_/CLK VDD VDD VSS gf180mcu_fd_sc_mcu7t5v0__dffrnq_1
XFILLER_268_750 VDD VSS VDD VSS gf180mcu_fd_sc_mcu7t5v0__fillcap_32
X_3203_ VDD _4341_/Q _3205_/A1 _3205_/B _3213_/B VSS VDD VSS gf180mcu_fd_sc_mcu7t5v0__oai21_1
XFILLER_86_107 VDD VSS VDD VSS gf180mcu_fd_sc_mcu7t5v0__fillcap_64
X_4183_ _4183_/D _4183_/Q wire209/Z VSS clkload8/I VDD VDD VSS gf180mcu_fd_sc_mcu7t5v0__dffrnq_1
XFILLER_255_422 VDD VSS VDD VSS gf180mcu_fd_sc_mcu7t5v0__fillcap_64
X_3134_ VDD VSS _3138_/A1 _4551_/Q _3886_/Q VDD VSS gf180mcu_fd_sc_mcu7t5v0__nor2_1
XFILLER_267_282 VDD VSS VDD VSS gf180mcu_fd_sc_mcu7t5v0__fillcap_64
XFILLER_68_877 VDD VSS VDD VSS gf180mcu_fd_sc_mcu7t5v0__fillcap_8
X_3065_ _4508_/Q VDD VSS wire68/I _4247_/Q _4255_/Q VDD VSS gf180mcu_fd_sc_mcu7t5v0__mux2_2
X_2016_ VDD VSS _3925_/Q _3753_/A1 VDD VSS gf180mcu_fd_sc_mcu7t5v0__clkinv_1
XFILLER_223_352 VDD VSS VDD VSS gf180mcu_fd_sc_mcu7t5v0__fillcap_64
XFILLER_250_171 VDD VSS VDD VSS gf180mcu_fd_sc_mcu7t5v0__fillcap_4
XFILLER_51_766 VDD VSS VDD VSS gf180mcu_fd_sc_mcu7t5v0__fillcap_4
X_3967_ VDD _3967_/Q _3967_/CLK VSS _3967_/D VDD VSS gf180mcu_fd_sc_mcu7t5v0__dffq_1
XFILLER_10_107 VDD VSS VDD VSS gf180mcu_fd_sc_mcu7t5v0__fillcap_64
X_2918_ VDD _2918_/B _2919_/S _4310_/D _2944_/A1 VSS VDD VSS gf180mcu_fd_sc_mcu7t5v0__oai21_1
X_3898_ VDD _3898_/Q _3969_/CLK VSS _3898_/D VDD VSS gf180mcu_fd_sc_mcu7t5v0__dffq_1
X_2849_ wire71/Z VDD VSS _2850_/A2 wire97/Z _2838_/Z VDD VSS gf180mcu_fd_sc_mcu7t5v0__aoi21_1
XFILLER_117_562 VDD VSS VDD VSS gf180mcu_fd_sc_mcu7t5v0__fillcap_16
XFILLER_105_702 VDD VSS VDD VSS gf180mcu_fd_sc_mcu7t5v0__fillcap_4
X_4519_ VSS _4522_/CLK VDD _4519_/D _4520_/D wire199/I VDD VSS gf180mcu_fd_sc_mcu7t5v0__dffsnq_1
XFILLER_144_381 VDD VSS VDD VSS gf180mcu_fd_sc_mcu7t5v0__fillcap_4
XFILLER_132_521 VDD VSS VDD VSS gf180mcu_fd_sc_mcu7t5v0__fillcap_4
XFILLER_2_317 VDD VSS VDD VSS gf180mcu_fd_sc_mcu7t5v0__fillcap_64
XFILLER_160_885 VDD VSS VDD VSS gf180mcu_fd_sc_mcu7t5v0__fillcap_4
XFILLER_259_772 VDD VSS VDD VSS gf180mcu_fd_sc_mcu7t5v0__fillcap_64
XFILLER_219_647 VDD VSS VDD VSS gf180mcu_fd_sc_mcu7t5v0__fillcap_16
XFILLER_58_387 VDD VSS VDD VSS gf180mcu_fd_sc_mcu7t5v0__fillcap_64
XFILLER_46_527 VDD VSS VDD VSS gf180mcu_fd_sc_mcu7t5v0__fillcap_64
XFILLER_73_346 VDD VSS VDD VSS gf180mcu_fd_sc_mcu7t5v0__fillcap_4
XFILLER_215_842 VDD VSS VDD VSS gf180mcu_fd_sc_mcu7t5v0__fillcap_32
XFILLER_242_661 VDD VSS VDD VSS gf180mcu_fd_sc_mcu7t5v0__fillcap_4
XFILLER_156_2 VDD VSS VDD VSS gf180mcu_fd_sc_mcu7t5v0__fillcap_16
XFILLER_14_457 VDD VSS VDD VSS gf180mcu_fd_sc_mcu7t5v0__fillcap_64
XFILLER_41_276 VDD VSS VDD VSS gf180mcu_fd_sc_mcu7t5v0__fillcap_4
XFILLER_139_142 VDD VSS VDD VSS gf180mcu_fd_sc_mcu7t5v0__fillcap_16
XFILLER_155_679 VDD VSS VDD VSS gf180mcu_fd_sc_mcu7t5v0__fillcap_4
XFILLER_6_667 VDD VSS VDD VSS gf180mcu_fd_sc_mcu7t5v0__fillcap_64
XFILLER_170_649 VDD VSS VDD VSS gf180mcu_fd_sc_mcu7t5v0__fillcap_16
XFILLER_68_107 VDD VSS VDD VSS gf180mcu_fd_sc_mcu7t5v0__fillcap_64
XFILLER_110_226 VDD VSS VDD VSS gf180mcu_fd_sc_mcu7t5v0__fillcap_16
XFILLER_237_422 VDD VSS VDD VSS gf180mcu_fd_sc_mcu7t5v0__fillcap_64
XFILLER_249_282 VDD VSS VDD VSS gf180mcu_fd_sc_mcu7t5v0__fillcap_64
XFILLER_264_241 VDD VSS VDD VSS gf180mcu_fd_sc_mcu7t5v0__fillcap_4
XFILLER_65_836 VDD VSS VDD VSS gf180mcu_fd_sc_mcu7t5v0__fillcap_4
XFILLER_77_696 VDD VSS VDD VSS gf180mcu_fd_sc_mcu7t5v0__fillcap_4
XFILLER_220_37 VDD VSS VDD VSS gf180mcu_fd_sc_mcu7t5v0__fillcap_64
XFILLER_178_716 VDD VSS VDD VSS gf180mcu_fd_sc_mcu7t5v0__fillcap_16
XFILLER_205_352 VDD VSS VDD VSS gf180mcu_fd_sc_mcu7t5v0__fillcap_16
X_3821_ _3821_/S VDD VSS _3977_/D _3848_/I0 _3977_/Q VDD VSS gf180mcu_fd_sc_mcu7t5v0__mux2_2
XFILLER_220_311 VDD VSS VDD VSS gf180mcu_fd_sc_mcu7t5v0__fillcap_4
XFILLER_232_171 VDD VSS VDD VSS gf180mcu_fd_sc_mcu7t5v0__fillcap_4
XFILLER_33_766 VDD VSS VDD VSS gf180mcu_fd_sc_mcu7t5v0__fillcap_4
X_3752_ VDD VSS _3753_/B _3763_/I0 _3758_/S VDD VSS gf180mcu_fd_sc_mcu7t5v0__nor2_1
XFILLER_146_613 VDD VSS VDD VSS gf180mcu_fd_sc_mcu7t5v0__fillcap_8
XFILLER_71_2 VDD VSS VDD VSS gf180mcu_fd_sc_mcu7t5v0__fillcap_16
X_2703_ VDD VSS _2713_/B1 _4288_/Q _2226_/B VDD VSS gf180mcu_fd_sc_mcu7t5v0__nor2_1
XFILLER_145_101 VDD VSS VDD VSS gf180mcu_fd_sc_mcu7t5v0__fillcap_4
X_3683_ VDD VSS _3683_/I _4499_/D VDD VSS gf180mcu_fd_sc_mcu7t5v0__clkinv_1
X_2634_ _2634_/A3 _2634_/A4 VDD VSS _2635_/B _4216_/Q _2276_/B VDD VSS gf180mcu_fd_sc_mcu7t5v0__or4_1
X_2565_ wire29/Z VDD VSS _4188_/D _4462_/Q _4188_/Q VDD VSS gf180mcu_fd_sc_mcu7t5v0__mux2_2
XFILLER_133_329 VDD VSS VDD VSS gf180mcu_fd_sc_mcu7t5v0__fillcap_16
X_4304_ _4304_/D _4304_/Q wire199/Z VSS _4354_/CLK VDD VDD VSS gf180mcu_fd_sc_mcu7t5v0__dffrnq_1
XFILLER_114_543 VDD VSS VDD VSS gf180mcu_fd_sc_mcu7t5v0__fillcap_8
XFILLER_142_885 VDD VSS VDD VSS gf180mcu_fd_sc_mcu7t5v0__fillcap_4
XFILLER_87_416 VDD VSS VDD VSS gf180mcu_fd_sc_mcu7t5v0__fillcap_4
X_2496_ _2500_/S VDD VSS _4117_/D _2505_/I0 _4117_/Q VDD VSS gf180mcu_fd_sc_mcu7t5v0__mux2_2
X_4235_ _4235_/D _4235_/Q _4534_/RN VSS _4614_/CLK VDD VDD VSS gf180mcu_fd_sc_mcu7t5v0__dffrnq_1
XFILLER_256_731 VDD VSS VDD VSS gf180mcu_fd_sc_mcu7t5v0__fillcap_4
XFILLER_268_580 VDD VSS VDD VSS gf180mcu_fd_sc_mcu7t5v0__fillcap_32
X_4166_ _4166_/D _4166_/Q _4527_/RN VSS _4468_/CLK VDD VDD VSS gf180mcu_fd_sc_mcu7t5v0__dffrnq_1
X_3117_ VDD _3117_/B _3885_/Q _3118_/B _3176_/S VSS VDD VSS gf180mcu_fd_sc_mcu7t5v0__oai21_1
XFILLER_261_66 VDD VSS VDD VSS gf180mcu_fd_sc_mcu7t5v0__fillcap_4
XFILLER_28_527 VDD VSS VDD VSS gf180mcu_fd_sc_mcu7t5v0__fillcap_64
X_4097_ VDD _4097_/Q _4270_/CLK VSS _4097_/D VDD VSS gf180mcu_fd_sc_mcu7t5v0__dffq_1
XFILLER_55_346 VDD VSS VDD VSS gf180mcu_fd_sc_mcu7t5v0__fillcap_4
X_3048_ VDD _3048_/B _3048_/A2 _4331_/D wire13/I VSS VDD VSS gf180mcu_fd_sc_mcu7t5v0__oai21_1
XFILLER_130_37 VDD VSS VDD VSS gf180mcu_fd_sc_mcu7t5v0__fillcap_16
XFILLER_168_215 VDD VSS VDD VSS gf180mcu_fd_sc_mcu7t5v0__fillcap_4
XFILLER_11_416 VDD VSS VDD VSS gf180mcu_fd_sc_mcu7t5v0__fillcap_4
XFILLER_23_276 VDD VSS VDD VSS gf180mcu_fd_sc_mcu7t5v0__fillcap_4
XFILLER_164_410 VDD VSS VDD VSS gf180mcu_fd_sc_mcu7t5v0__fillcap_32
XFILLER_3_626 VDD VSS VDD VSS gf180mcu_fd_sc_mcu7t5v0__fillcap_4
XFILLER_132_340 VDD VSS VDD VSS gf180mcu_fd_sc_mcu7t5v0__fillcap_4
XFILLER_219_422 VDD VSS VDD VSS gf180mcu_fd_sc_mcu7t5v0__fillcap_32
XFILLER_246_241 VDD VSS VDD VSS gf180mcu_fd_sc_mcu7t5v0__fillcap_4
XFILLER_47_836 VDD VSS VDD VSS gf180mcu_fd_sc_mcu7t5v0__fillcap_4
XFILLER_59_696 VDD VSS VDD VSS gf180mcu_fd_sc_mcu7t5v0__fillcap_4
XFILLER_15_766 VDD VSS VDD VSS gf180mcu_fd_sc_mcu7t5v0__fillcap_4
XFILLER_182_240 VDD VSS VDD VSS gf180mcu_fd_sc_mcu7t5v0__fillcap_4
XFILLER_170_457 VDD VSS VDD VSS gf180mcu_fd_sc_mcu7t5v0__fillcap_32
XFILLER_89_72 VDD VSS VDD VSS gf180mcu_fd_sc_mcu7t5v0__fillcap_64
X_2350_ VDD VSS _4530_/D _2671_/A1 _2213_/Z VDD VSS gf180mcu_fd_sc_mcu7t5v0__nor2_1
XFILLER_123_340 VDD VSS VDD VSS gf180mcu_fd_sc_mcu7t5v0__fillcap_8
XFILLER_69_416 VDD VSS VDD VSS gf180mcu_fd_sc_mcu7t5v0__fillcap_4
X_2281_ VDD VSS _3338_/A2 _4384_/Q _4385_/Q VDD VSS gf180mcu_fd_sc_mcu7t5v0__nor2_1
XFILLER_238_731 VDD VSS VDD VSS gf180mcu_fd_sc_mcu7t5v0__fillcap_4
X_4020_ VDD _4020_/Q _4028_/CLK VSS _4020_/D VDD VSS gf180mcu_fd_sc_mcu7t5v0__dffq_1
XFILLER_37_346 VDD VSS VDD VSS gf180mcu_fd_sc_mcu7t5v0__fillcap_4
XFILLER_221_620 VDD VSS VDD VSS gf180mcu_fd_sc_mcu7t5v0__fillcap_8
X_3804_ wire15/I VDD VSS _3962_/D _4289_/Q _3962_/Q VDD VSS gf180mcu_fd_sc_mcu7t5v0__mux2_2
X_1996_ VDD VSS _4012_/Q _3492_/A2 VDD VSS gf180mcu_fd_sc_mcu7t5v0__clkinv_1
X_3735_ _3738_/S VDD VSS _3910_/D wire174/Z _3910_/Q VDD VSS gf180mcu_fd_sc_mcu7t5v0__mux2_2
XFILLER_134_605 VDD VSS VDD VSS gf180mcu_fd_sc_mcu7t5v0__fillcap_4
XFILLER_109_38 VDD VSS VDD VSS gf180mcu_fd_sc_mcu7t5v0__fillcap_32
XFILLER_146_487 VDD VSS VDD VSS gf180mcu_fd_sc_mcu7t5v0__fillcap_32
Xclkload61 VSS clkload61/Z _4283_/CLK VDD VDD VSS gf180mcu_fd_sc_mcu7t5v0__clkbuf_1
Xclkload50 VSS clkload50/Z _4462_/CLK VDD VDD VSS gf180mcu_fd_sc_mcu7t5v0__clkbuf_1
XFILLER_161_413 VDD VSS VDD VSS gf180mcu_fd_sc_mcu7t5v0__fillcap_4
X_3666_ _3679_/A2 _4186_/Q VDD VSS _3667_/I _4492_/Q _3479_/C VDD VSS gf180mcu_fd_sc_mcu7t5v0__aoi22_1
Xclkload94 VSS clkload94/ZN _4604_/CLK VDD VDD VSS gf180mcu_fd_sc_mcu7t5v0__inv_8
X_2617_ VDD VSS _2622_/A2 _2637_/A2 _2621_/A3 VDD VSS gf180mcu_fd_sc_mcu7t5v0__nor2_1
Xclkload72 VDD VSS _4346_/CLK clkload72/ZN VDD VSS gf180mcu_fd_sc_mcu7t5v0__clkinv_2
Xclkload83 VDD VSS _4525_/CLK clkload83/ZN VDD VSS gf180mcu_fd_sc_mcu7t5v0__clkinv_2
X_3597_ _3597_/S VDD VSS _3597_/Z _4097_/Q _4089_/Q VDD VSS gf180mcu_fd_sc_mcu7t5v0__mux2_2
X_2548_ wire29/I VDD VSS _4171_/D wire117/Z _4171_/Q VDD VSS gf180mcu_fd_sc_mcu7t5v0__mux2_2
XFILLER_114_373 VDD VSS VDD VSS gf180mcu_fd_sc_mcu7t5v0__fillcap_4
XFILLER_88_769 VDD VSS VDD VSS gf180mcu_fd_sc_mcu7t5v0__fillcap_4
XFILLER_130_855 VDD VSS VDD VSS gf180mcu_fd_sc_mcu7t5v0__fillcap_16
X_4218_ _4218_/D _4218_/Q wire199/Z VSS _4521_/CLK VDD VDD VSS gf180mcu_fd_sc_mcu7t5v0__dffrnq_1
X_2479_ _2482_/S VDD VSS _4102_/D _4102_/Q _2506_/I0 VDD VSS gf180mcu_fd_sc_mcu7t5v0__mux2_2
XFILLER_130_877 VDD VSS VDD VSS gf180mcu_fd_sc_mcu7t5v0__fillcap_8
XFILLER_228_241 VDD VSS VDD VSS gf180mcu_fd_sc_mcu7t5v0__fillcap_4
XFILLER_29_836 VDD VSS VDD VSS gf180mcu_fd_sc_mcu7t5v0__fillcap_4
XFILLER_96_791 VDD VSS VDD VSS gf180mcu_fd_sc_mcu7t5v0__fillcap_8
X_4149_ _4149_/D _4149_/Q wire192/Z VSS _4364_/CLK VDD VDD VSS gf180mcu_fd_sc_mcu7t5v0__dffrnq_1
XFILLER_157_708 VDD VSS VDD VSS gf180mcu_fd_sc_mcu7t5v0__fillcap_8
Xspi_opentarget_i3c_top_227 scl_pad_i_PU VDD VSS VDD VSS gf180mcu_fd_sc_mcu7t5v0__tiel
Xspi_opentarget_i3c_top_238 spi_miso_o_PD VDD VSS VDD VSS gf180mcu_fd_sc_mcu7t5v0__tiel
Xspi_opentarget_i3c_top_216 host_clk_i_PU VDD VSS VDD VSS gf180mcu_fd_sc_mcu7t5v0__tiel
XFILLER_184_527 VDD VSS VDD VSS gf180mcu_fd_sc_mcu7t5v0__fillcap_16
XFILLER_200_837 VDD VSS VDD VSS gf180mcu_fd_sc_mcu7t5v0__fillcap_32
Xwire104 _3122_/S _4551_/Q VDD VSS VDD VSS gf180mcu_fd_sc_mcu7t5v0__buf_4
XFILLER_211_174 VDD VSS VDD VSS gf180mcu_fd_sc_mcu7t5v0__fillcap_16
Xspi_opentarget_i3c_top_249 spi_miso_o_OE VDD VSS VDD VSS gf180mcu_fd_sc_mcu7t5v0__tieh
XFILLER_196_387 VDD VSS VDD VSS gf180mcu_fd_sc_mcu7t5v0__fillcap_32
XFILLER_196_376 VDD VSS VDD VSS gf180mcu_fd_sc_mcu7t5v0__fillcap_8
Xwire137 VSS wire137/Z wire138/Z VDD VDD VSS gf180mcu_fd_sc_mcu7t5v0__clkbuf_1
XFILLER_165_741 VDD VSS VDD VSS gf180mcu_fd_sc_mcu7t5v0__fillcap_16
Xwire115 VSS wire115/Z wire116/Z VDD VDD VSS gf180mcu_fd_sc_mcu7t5v0__clkbuf_1
Xclkload0 VSS clkload0/ZN clkload0/I VDD VDD VSS gf180mcu_fd_sc_mcu7t5v0__inv_3
XFILLER_7_206 VDD VSS VDD VSS gf180mcu_fd_sc_mcu7t5v0__fillcap_4
XFILLER_166_22 VDD VSS VDD VSS gf180mcu_fd_sc_mcu7t5v0__fillcap_8
XFILLER_109_134 VDD VSS VDD VSS gf180mcu_fd_sc_mcu7t5v0__fillcap_4
XFILLER_152_402 VDD VSS VDD VSS gf180mcu_fd_sc_mcu7t5v0__fillcap_4
XFILLER_124_115 VDD VSS VDD VSS gf180mcu_fd_sc_mcu7t5v0__fillcap_16
XFILLER_109_189 VDD VSS VDD VSS gf180mcu_fd_sc_mcu7t5v0__fillcap_4
XFILLER_119_2 VDD VSS VDD VSS gf180mcu_fd_sc_mcu7t5v0__fillcap_8
XFILLER_180_744 VDD VSS VDD VSS gf180mcu_fd_sc_mcu7t5v0__fillcap_4
XFILLER_166_77 VDD VSS VDD VSS gf180mcu_fd_sc_mcu7t5v0__fillcap_16
XFILLER_106_885 VDD VSS VDD VSS gf180mcu_fd_sc_mcu7t5v0__fillcap_4
XFILLER_160_490 VDD VSS VDD VSS gf180mcu_fd_sc_mcu7t5v0__fillcap_32
XFILLER_19_346 VDD VSS VDD VSS gf180mcu_fd_sc_mcu7t5v0__fillcap_4
XFILLER_250_737 VDD VSS VDD VSS gf180mcu_fd_sc_mcu7t5v0__fillcap_64
XFILLER_262_597 VDD VSS VDD VSS gf180mcu_fd_sc_mcu7t5v0__fillcap_64
XFILLER_131_80 VDD VSS VDD VSS gf180mcu_fd_sc_mcu7t5v0__fillcap_4
XFILLER_188_877 VDD VSS VDD VSS gf180mcu_fd_sc_mcu7t5v0__fillcap_8
X_3520_ VSS VDD _3633_/C1 _4330_/Q _4366_/Q _3685_/C2 _3685_/A2 _4166_/Q _3523_/A1
+ VDD VSS gf180mcu_fd_sc_mcu7t5v0__aoi222_1
XFILLER_156_796 VDD VSS VDD VSS gf180mcu_fd_sc_mcu7t5v0__fillcap_8
X_3451_ VDD _3451_/B _3499_/A2 _3452_/C _3451_/A1 VSS VDD VSS gf180mcu_fd_sc_mcu7t5v0__oai21_1
X_3382_ VDD VSS _3383_/B _4389_/Q wire56/Z VDD VSS gf180mcu_fd_sc_mcu7t5v0__nor2_1
XFILLER_130_107 VDD VSS VDD VSS gf180mcu_fd_sc_mcu7t5v0__fillcap_4
X_2402_ _2403_/S VDD VSS _4040_/D _4040_/Q wire152/Z VDD VSS gf180mcu_fd_sc_mcu7t5v0__mux2_2
X_2333_ _4325_/Q _2885_/C VDD VSS _2898_/A3 _3015_/B _4324_/Q VDD VSS gf180mcu_fd_sc_mcu7t5v0__nor4_1
XFILLER_124_682 VDD VSS VDD VSS gf180mcu_fd_sc_mcu7t5v0__fillcap_16
XFILLER_34_2 VDD VSS VDD VSS gf180mcu_fd_sc_mcu7t5v0__fillcap_32
X_2264_ VDD VSS _2264_/Z _4599_/Q _4590_/D VDD VSS gf180mcu_fd_sc_mcu7t5v0__xor2_1
XFILLER_111_398 VDD VSS VDD VSS gf180mcu_fd_sc_mcu7t5v0__fillcap_8
X_2195_ _4240_/Q VDD VSS _2199_/A2 _4237_/Q _4239_/Q VDD VSS gf180mcu_fd_sc_mcu7t5v0__nor3_1
X_4003_ VDD _4003_/Q _4612_/CLK VSS _4003_/D VDD VSS gf180mcu_fd_sc_mcu7t5v0__dffq_1
XFILLER_226_745 VDD VSS VDD VSS gf180mcu_fd_sc_mcu7t5v0__fillcap_4
XFILLER_93_772 VDD VSS VDD VSS gf180mcu_fd_sc_mcu7t5v0__fillcap_8
XFILLER_240_247 VDD VSS VDD VSS gf180mcu_fd_sc_mcu7t5v0__fillcap_64
XFILLER_166_505 VDD VSS VDD VSS gf180mcu_fd_sc_mcu7t5v0__fillcap_16
XFILLER_166_527 VDD VSS VDD VSS gf180mcu_fd_sc_mcu7t5v0__fillcap_16
XFILLER_193_324 VDD VSS VDD VSS gf180mcu_fd_sc_mcu7t5v0__fillcap_16
XFILLER_178_387 VDD VSS VDD VSS gf180mcu_fd_sc_mcu7t5v0__fillcap_8
XFILLER_193_346 VDD VSS VDD VSS gf180mcu_fd_sc_mcu7t5v0__fillcap_4
X_1979_ VDD VSS _3852_/Q _2285_/A2 VDD VSS gf180mcu_fd_sc_mcu7t5v0__clkinv_1
X_3718_ _3718_/S VDD VSS _3897_/D _3897_/Q _4296_/Q VDD VSS gf180mcu_fd_sc_mcu7t5v0__mux2_2
XFILLER_134_435 VDD VSS VDD VSS gf180mcu_fd_sc_mcu7t5v0__fillcap_4
X_3649_ VDD VSS _3650_/A3 _4485_/Q _3682_/A2 VDD VSS gf180mcu_fd_sc_mcu7t5v0__nand2_1
XFILLER_102_310 VDD VSS VDD VSS gf180mcu_fd_sc_mcu7t5v0__fillcap_4
XFILLER_130_641 VDD VSS VDD VSS gf180mcu_fd_sc_mcu7t5v0__fillcap_16
XFILLER_264_807 VDD VSS VDD VSS gf180mcu_fd_sc_mcu7t5v0__fillcap_64
XFILLER_71_422 VDD VSS VDD VSS gf180mcu_fd_sc_mcu7t5v0__fillcap_64
XFILLER_232_726 VDD VSS VDD VSS gf180mcu_fd_sc_mcu7t5v0__fillcap_8
XFILLER_83_282 VDD VSS VDD VSS gf180mcu_fd_sc_mcu7t5v0__fillcap_64
XFILLER_244_597 VDD VSS VDD VSS gf180mcu_fd_sc_mcu7t5v0__fillcap_64
XFILLER_188_107 VDD VSS VDD VSS gf180mcu_fd_sc_mcu7t5v0__fillcap_64
XFILLER_45_66 VDD VSS VDD VSS gf180mcu_fd_sc_mcu7t5v0__fillcap_4
XFILLER_197_685 VDD VSS VDD VSS gf180mcu_fd_sc_mcu7t5v0__fillcap_4
XFILLER_236_2 VDD VSS VDD VSS gf180mcu_fd_sc_mcu7t5v0__fillcap_32
XFILLER_101_72 VDD VSS VDD VSS gf180mcu_fd_sc_mcu7t5v0__fillcap_64
XFILLER_185_836 VDD VSS VDD VSS gf180mcu_fd_sc_mcu7t5v0__fillcap_4
XFILLER_184_335 VDD VSS VDD VSS gf180mcu_fd_sc_mcu7t5v0__fillcap_32
XFILLER_165_571 VDD VSS VDD VSS gf180mcu_fd_sc_mcu7t5v0__fillcap_16
XFILLER_180_541 VDD VSS VDD VSS gf180mcu_fd_sc_mcu7t5v0__fillcap_32
XFILLER_112_107 VDD VSS VDD VSS gf180mcu_fd_sc_mcu7t5v0__fillcap_16
XFILLER_106_682 VDD VSS VDD VSS gf180mcu_fd_sc_mcu7t5v0__fillcap_16
XFILLER_266_177 VDD VSS VDD VSS gf180mcu_fd_sc_mcu7t5v0__fillcap_64
XFILLER_254_317 VDD VSS VDD VSS gf180mcu_fd_sc_mcu7t5v0__fillcap_64
XFILLER_75_772 VDD VSS VDD VSS gf180mcu_fd_sc_mcu7t5v0__fillcap_64
XFILLER_222_247 VDD VSS VDD VSS gf180mcu_fd_sc_mcu7t5v0__fillcap_64
X_2951_ _2951_/B VDD VSS _2953_/A3 _4342_/Q _2831_/B VDD VSS gf180mcu_fd_sc_mcu7t5v0__aoi21_1
XFILLER_31_842 VDD VSS VDD VSS gf180mcu_fd_sc_mcu7t5v0__fillcap_32
XFILLER_148_527 VDD VSS VDD VSS gf180mcu_fd_sc_mcu7t5v0__fillcap_32
XFILLER_188_696 VDD VSS VDD VSS gf180mcu_fd_sc_mcu7t5v0__fillcap_4
X_2882_ _2871_/Z _4343_/Q VDD VSS _2883_/B _3015_/C _2870_/Z _2303_/Z VDD VSS gf180mcu_fd_sc_mcu7t5v0__oai221_1
XFILLER_175_346 VDD VSS VDD VSS gf180mcu_fd_sc_mcu7t5v0__fillcap_4
X_4552_ _4552_/D wire97/I _4573_/RN VSS _4553_/CLK VDD VDD VSS gf180mcu_fd_sc_mcu7t5v0__dffrnq_1
X_3503_ _3503_/B1 _3503_/B2 VDD VSS _4471_/D _3503_/A1 _3546_/B VDD VSS gf180mcu_fd_sc_mcu7t5v0__aoi22_1
X_4483_ _4483_/D _4483_/Q _4498_/RN VSS _4494_/CLK VDD VDD VSS gf180mcu_fd_sc_mcu7t5v0__dffrnq_1
X_3434_ _4122_/Q VSS VDD _4106_/Q _4114_/Q _3597_/S _4098_/Q wire82/Z _3434_/Z VDD
+ VSS gf180mcu_fd_sc_mcu7t5v0__mux4_1
XFILLER_116_457 VDD VSS VDD VSS gf180mcu_fd_sc_mcu7t5v0__fillcap_64
XFILLER_143_298 VDD VSS VDD VSS gf180mcu_fd_sc_mcu7t5v0__fillcap_8
X_3365_ wire20/Z VDD VSS _4412_/D _4404_/Q _4412_/Q VDD VSS gf180mcu_fd_sc_mcu7t5v0__mux2_2
XFILLER_97_352 VDD VSS VDD VSS gf180mcu_fd_sc_mcu7t5v0__fillcap_64
XFILLER_258_667 VDD VSS VDD VSS gf180mcu_fd_sc_mcu7t5v0__fillcap_64
XFILLER_246_807 VDD VSS VDD VSS gf180mcu_fd_sc_mcu7t5v0__fillcap_64
X_2316_ _4529_/D VDD VSS _3209_/B _4524_/Q _3271_/A1 VDD VSS gf180mcu_fd_sc_mcu7t5v0__nand3_1
X_3296_ VDD VSS _3298_/A2 _3296_/A1 _3296_/A2 VDD VSS gf180mcu_fd_sc_mcu7t5v0__nand2_1
X_2247_ VDD VSS _2249_/A2 _4557_/Q _4548_/D VDD VSS gf180mcu_fd_sc_mcu7t5v0__xnor2_1
XFILLER_53_422 VDD VSS VDD VSS gf180mcu_fd_sc_mcu7t5v0__fillcap_64
X_2178_ _2200_/A3 VDD VSS _2644_/A1 _2169_/Z _2170_/Z VDD VSS gf180mcu_fd_sc_mcu7t5v0__nand3_1
XFILLER_65_282 VDD VSS VDD VSS gf180mcu_fd_sc_mcu7t5v0__fillcap_64
XFILLER_214_737 VDD VSS VDD VSS gf180mcu_fd_sc_mcu7t5v0__fillcap_8
XFILLER_226_597 VDD VSS VDD VSS gf180mcu_fd_sc_mcu7t5v0__fillcap_8
XFILLER_80_241 VDD VSS VDD VSS gf180mcu_fd_sc_mcu7t5v0__fillcap_4
XFILLER_241_556 VDD VSS VDD VSS gf180mcu_fd_sc_mcu7t5v0__fillcap_4
XFILLER_139_516 VDD VSS VDD VSS gf180mcu_fd_sc_mcu7t5v0__fillcap_8
XFILLER_194_622 VDD VSS VDD VSS gf180mcu_fd_sc_mcu7t5v0__fillcap_8
XFILLER_179_696 VDD VSS VDD VSS gf180mcu_fd_sc_mcu7t5v0__fillcap_4
XFILLER_21_352 VDD VSS VDD VSS gf180mcu_fd_sc_mcu7t5v0__fillcap_64
XFILLER_194_677 VDD VSS VDD VSS gf180mcu_fd_sc_mcu7t5v0__fillcap_4
XFILLER_147_593 VDD VSS VDD VSS gf180mcu_fd_sc_mcu7t5v0__fillcap_32
XFILLER_1_702 VDD VSS VDD VSS gf180mcu_fd_sc_mcu7t5v0__fillcap_64
XFILLER_89_842 VDD VSS VDD VSS gf180mcu_fd_sc_mcu7t5v0__fillcap_16
XFILLER_248_177 VDD VSS VDD VSS gf180mcu_fd_sc_mcu7t5v0__fillcap_64
XFILLER_236_317 VDD VSS VDD VSS gf180mcu_fd_sc_mcu7t5v0__fillcap_64
XFILLER_263_136 VDD VSS VDD VSS gf180mcu_fd_sc_mcu7t5v0__fillcap_4
XFILLER_186_2 VDD VSS VDD VSS gf180mcu_fd_sc_mcu7t5v0__fillcap_32
XFILLER_57_772 VDD VSS VDD VSS gf180mcu_fd_sc_mcu7t5v0__fillcap_64
XFILLER_72_731 VDD VSS VDD VSS gf180mcu_fd_sc_mcu7t5v0__fillcap_4
XFILLER_189_416 VDD VSS VDD VSS gf180mcu_fd_sc_mcu7t5v0__fillcap_4
XFILLER_189_438 VDD VSS VDD VSS gf180mcu_fd_sc_mcu7t5v0__fillcap_8
XFILLER_13_842 VDD VSS VDD VSS gf180mcu_fd_sc_mcu7t5v0__fillcap_32
XFILLER_157_324 VDD VSS VDD VSS gf180mcu_fd_sc_mcu7t5v0__fillcap_16
XFILLER_40_661 VDD VSS VDD VSS gf180mcu_fd_sc_mcu7t5v0__fillcap_4
XFILLER_158_869 VDD VSS VDD VSS gf180mcu_fd_sc_mcu7t5v0__fillcap_4
XFILLER_157_368 VDD VSS VDD VSS gf180mcu_fd_sc_mcu7t5v0__fillcap_4
XFILLER_126_755 VDD VSS VDD VSS gf180mcu_fd_sc_mcu7t5v0__fillcap_8
XFILLER_126_799 VDD VSS VDD VSS gf180mcu_fd_sc_mcu7t5v0__fillcap_4
XFILLER_97_50 VDD VSS VDD VSS gf180mcu_fd_sc_mcu7t5v0__fillcap_16
XFILLER_79_352 VDD VSS VDD VSS gf180mcu_fd_sc_mcu7t5v0__fillcap_64
XFILLER_97_72 VDD VSS VDD VSS gf180mcu_fd_sc_mcu7t5v0__fillcap_16
XFILLER_228_807 VDD VSS VDD VSS gf180mcu_fd_sc_mcu7t5v0__fillcap_64
X_3150_ _3150_/B VDD VSS _3152_/A2 _2854_/B _3150_/A2 VDD VSS gf180mcu_fd_sc_mcu7t5v0__aoi21_1
XFILLER_255_626 VDD VSS VDD VSS gf180mcu_fd_sc_mcu7t5v0__fillcap_4
XFILLER_267_486 VDD VSS VDD VSS gf180mcu_fd_sc_mcu7t5v0__fillcap_4
X_3081_ _3081_/B wire97/Z VDD VSS _3083_/B _3124_/A1 _3791_/A1 VDD VSS gf180mcu_fd_sc_mcu7t5v0__aoi211_1
X_2101_ VDD VSS _4543_/D _3707_/A1 _2101_/A2 VDD VSS gf180mcu_fd_sc_mcu7t5v0__xor2_1
XFILLER_208_542 VDD VSS VDD VSS gf180mcu_fd_sc_mcu7t5v0__fillcap_16
X_2032_ VDD VSS _3441_/A3 _4432_/Q _2035_/A3 VDD VSS gf180mcu_fd_sc_mcu7t5v0__nand2_1
XFILLER_94_366 VDD VSS VDD VSS gf180mcu_fd_sc_mcu7t5v0__fillcap_16
XFILLER_35_422 VDD VSS VDD VSS gf180mcu_fd_sc_mcu7t5v0__fillcap_64
XFILLER_47_282 VDD VSS VDD VSS gf180mcu_fd_sc_mcu7t5v0__fillcap_64
XFILLER_208_597 VDD VSS VDD VSS gf180mcu_fd_sc_mcu7t5v0__fillcap_16
XFILLER_62_241 VDD VSS VDD VSS gf180mcu_fd_sc_mcu7t5v0__fillcap_4
X_3983_ VDD _3983_/Q _3998_/CLK VSS _3983_/D VDD VSS gf180mcu_fd_sc_mcu7t5v0__dffq_1
X_2934_ _1945_/I _2934_/C VDD VSS _2935_/A2 _4332_/Q _2934_/A2 _2934_/B1 VDD VSS gf180mcu_fd_sc_mcu7t5v0__aoi221_1
XFILLER_149_858 VDD VSS VDD VSS gf180mcu_fd_sc_mcu7t5v0__fillcap_4
X_2865_ _2865_/B _2865_/C VDD VSS _2869_/A1 _4353_/Q _2865_/A2 VDD VSS gf180mcu_fd_sc_mcu7t5v0__aoi211_1
XFILLER_148_357 VDD VSS VDD VSS gf180mcu_fd_sc_mcu7t5v0__fillcap_16
XFILLER_30_171 VDD VSS VDD VSS gf180mcu_fd_sc_mcu7t5v0__fillcap_4
X_4604_ _4604_/D _4604_/Q _4616_/RN VSS _4604_/CLK VDD VDD VSS gf180mcu_fd_sc_mcu7t5v0__dffrnq_1
X_2796_ VDD VSS _3044_/A1 _4529_/D _2796_/A2 VDD VSS gf180mcu_fd_sc_mcu7t5v0__nand2_1
X_4535_ _4535_/D _4535_/Q _4535_/RN VSS _4535_/CLK VDD VDD VSS gf180mcu_fd_sc_mcu7t5v0__dffrnq_1
X_4466_ _4466_/D _4466_/Q wire206/Z VSS _4466_/CLK VDD VDD VSS gf180mcu_fd_sc_mcu7t5v0__dffrnq_1
XFILLER_117_38 VDD VSS VDD VSS gf180mcu_fd_sc_mcu7t5v0__fillcap_32
X_3417_ _3425_/S VDD VSS _4460_/D _4418_/Q _4460_/Q VDD VSS gf180mcu_fd_sc_mcu7t5v0__mux2_2
X_4397_ _4397_/D _4397_/Q wire186/Z VSS _4430_/CLK VDD VDD VSS gf180mcu_fd_sc_mcu7t5v0__dffrnq_1
X_3348_ wire20/Z VDD VSS _4395_/D _3856_/Q _4395_/Q VDD VSS gf180mcu_fd_sc_mcu7t5v0__mux2_2
XFILLER_86_801 VDD VSS VDD VSS gf180mcu_fd_sc_mcu7t5v0__fillcap_4
XFILLER_218_317 VDD VSS VDD VSS gf180mcu_fd_sc_mcu7t5v0__fillcap_64
XFILLER_245_136 VDD VSS VDD VSS gf180mcu_fd_sc_mcu7t5v0__fillcap_4
XFILLER_39_772 VDD VSS VDD VSS gf180mcu_fd_sc_mcu7t5v0__fillcap_64
X_3279_ VDD VSS _3331_/A2 _4384_/Q _4383_/Q VDD VSS gf180mcu_fd_sc_mcu7t5v0__nand2_1
XFILLER_66_591 VDD VSS VDD VSS gf180mcu_fd_sc_mcu7t5v0__fillcap_4
XFILLER_54_731 VDD VSS VDD VSS gf180mcu_fd_sc_mcu7t5v0__fillcap_4
XFILLER_199_714 VDD VSS VDD VSS gf180mcu_fd_sc_mcu7t5v0__fillcap_16
XFILLER_22_661 VDD VSS VDD VSS gf180mcu_fd_sc_mcu7t5v0__fillcap_4
XFILLER_10_801 VDD VSS VDD VSS gf180mcu_fd_sc_mcu7t5v0__fillcap_4
XFILLER_194_441 VDD VSS VDD VSS gf180mcu_fd_sc_mcu7t5v0__fillcap_8
Xmax_length41 _3822_/A1 VSS VDD _3739_/A1 VDD VSS gf180mcu_fd_sc_mcu7t5v0__clkbuf_2
Xmax_length52 VSS _2896_/B _2829_/C VDD VDD VSS gf180mcu_fd_sc_mcu7t5v0__buf_2
Xmax_length30 wire29/I wire28/I VDD VSS VDD VSS gf180mcu_fd_sc_mcu7t5v0__buf_4
XFILLER_210_784 VDD VSS VDD VSS gf180mcu_fd_sc_mcu7t5v0__fillcap_16
XFILLER_182_625 VDD VSS VDD VSS gf180mcu_fd_sc_mcu7t5v0__fillcap_8
Xmax_length85 wire82/I _4592_/Q VDD VSS VDD VSS gf180mcu_fd_sc_mcu7t5v0__buf_4
XFILLER_101_2 VDD VSS VDD VSS gf180mcu_fd_sc_mcu7t5v0__fillcap_8
XFILLER_108_766 VDD VSS VDD VSS gf180mcu_fd_sc_mcu7t5v0__fillcap_32
XFILLER_268_206 VDD VSS VDD VSS gf180mcu_fd_sc_mcu7t5v0__fillcap_32
XFILLER_162_360 VDD VSS VDD VSS gf180mcu_fd_sc_mcu7t5v0__fillcap_16
Xclkbuf_leaf_54_clk_i _4530_/CLK VSS VDD clkload5/I VDD VSS gf180mcu_fd_sc_mcu7t5v0__clkbuf_2
XFILLER_150_588 VDD VSS VDD VSS gf180mcu_fd_sc_mcu7t5v0__fillcap_4
XFILLER_122_279 VDD VSS VDD VSS gf180mcu_fd_sc_mcu7t5v0__fillcap_16
XFILLER_237_626 VDD VSS VDD VSS gf180mcu_fd_sc_mcu7t5v0__fillcap_4
XFILLER_249_486 VDD VSS VDD VSS gf180mcu_fd_sc_mcu7t5v0__fillcap_4
XFILLER_209_306 VDD VSS VDD VSS gf180mcu_fd_sc_mcu7t5v0__fillcap_4
XFILLER_76_311 VDD VSS VDD VSS gf180mcu_fd_sc_mcu7t5v0__fillcap_4
XFILLER_131_780 VDD VSS VDD VSS gf180mcu_fd_sc_mcu7t5v0__fillcap_4
XFILLER_88_171 VDD VSS VDD VSS gf180mcu_fd_sc_mcu7t5v0__fillcap_4
XFILLER_17_422 VDD VSS VDD VSS gf180mcu_fd_sc_mcu7t5v0__fillcap_64
Xclkbuf_leaf_69_clk_i _4047_/CLK VSS VDD clkbuf_3_2__f_clk_i/Z VDD VSS gf180mcu_fd_sc_mcu7t5v0__clkbuf_2
XFILLER_29_282 VDD VSS VDD VSS gf180mcu_fd_sc_mcu7t5v0__fillcap_64
XFILLER_44_241 VDD VSS VDD VSS gf180mcu_fd_sc_mcu7t5v0__fillcap_4
XFILLER_189_268 VDD VSS VDD VSS gf180mcu_fd_sc_mcu7t5v0__fillcap_8
XFILLER_220_559 VDD VSS VDD VSS gf180mcu_fd_sc_mcu7t5v0__fillcap_4
XFILLER_9_632 VDD VSS VDD VSS gf180mcu_fd_sc_mcu7t5v0__fillcap_64
XFILLER_12_171 VDD VSS VDD VSS gf180mcu_fd_sc_mcu7t5v0__fillcap_4
X_2650_ _2699_/A1 _2653_/A1 VDD VSS _2650_/Z _4242_/Q _2695_/B VDD VSS gf180mcu_fd_sc_mcu7t5v0__and4_1
XFILLER_218_37 VDD VSS VDD VSS gf180mcu_fd_sc_mcu7t5v0__fillcap_64
XFILLER_200_294 VDD VSS VDD VSS gf180mcu_fd_sc_mcu7t5v0__fillcap_8
X_2581_ VDD VSS _2582_/B wire123/I wire27/Z VDD VSS gf180mcu_fd_sc_mcu7t5v0__nor2_1
X_4320_ _4320_/D _4320_/Q wire206/Z VSS _4345_/CLK VDD VDD VSS gf180mcu_fd_sc_mcu7t5v0__dffrnq_1
XFILLER_259_206 VDD VSS VDD VSS gf180mcu_fd_sc_mcu7t5v0__fillcap_4
X_4251_ _4251_/D _4251_/Q _4284_/RN VSS _4283_/CLK VDD VDD VSS gf180mcu_fd_sc_mcu7t5v0__dffrnq_1
XFILLER_113_246 VDD VSS VDD VSS gf180mcu_fd_sc_mcu7t5v0__fillcap_16
XFILLER_4_381 VDD VSS VDD VSS gf180mcu_fd_sc_mcu7t5v0__fillcap_4
X_3202_ VDD VSS _3205_/A1 _2958_/C _3202_/A2 VDD VSS gf180mcu_fd_sc_mcu7t5v0__nand2_1
XFILLER_68_801 VDD VSS VDD VSS gf180mcu_fd_sc_mcu7t5v0__fillcap_4
XFILLER_268_784 VDD VSS VDD VSS gf180mcu_fd_sc_mcu7t5v0__fillcap_32
X_4182_ _4182_/D _4182_/Q wire209/Z VSS _4496_/CLK VDD VDD VSS gf180mcu_fd_sc_mcu7t5v0__dffrnq_1
XFILLER_122_780 VDD VSS VDD VSS gf180mcu_fd_sc_mcu7t5v0__fillcap_4
X_3133_ _3934_/Q VSS VDD _3918_/Q _3926_/Q _2846_/S _3910_/Q _3180_/B _3133_/Z VDD
+ VSS gf180mcu_fd_sc_mcu7t5v0__mux4_1
XFILLER_227_136 VDD VSS VDD VSS gf180mcu_fd_sc_mcu7t5v0__fillcap_4
X_3064_ VDD VSS _3170_/B _3064_/A1 _3064_/A2 VDD VSS gf180mcu_fd_sc_mcu7t5v0__nor2_1
XFILLER_95_686 VDD VSS VDD VSS gf180mcu_fd_sc_mcu7t5v0__fillcap_8
X_2015_ VDD VSS _3957_/Q _3795_/A1 VDD VSS gf180mcu_fd_sc_mcu7t5v0__clkinv_1
XFILLER_48_591 VDD VSS VDD VSS gf180mcu_fd_sc_mcu7t5v0__fillcap_4
XFILLER_36_731 VDD VSS VDD VSS gf180mcu_fd_sc_mcu7t5v0__fillcap_4
X_3966_ VDD _3966_/Q _3998_/CLK VSS _3966_/D VDD VSS gf180mcu_fd_sc_mcu7t5v0__dffq_1
XFILLER_176_441 VDD VSS VDD VSS gf180mcu_fd_sc_mcu7t5v0__fillcap_8
X_2917_ VDD VSS _2918_/B _4310_/Q _2919_/S VDD VSS gf180mcu_fd_sc_mcu7t5v0__nand2_1
XFILLER_259_66 VDD VSS VDD VSS gf180mcu_fd_sc_mcu7t5v0__fillcap_4
X_3897_ VDD _3897_/Q _4574_/CLK VSS _3897_/D VDD VSS gf180mcu_fd_sc_mcu7t5v0__dffq_1
X_2848_ VDD VSS _2850_/B wire94/Z _2847_/Z VDD VSS gf180mcu_fd_sc_mcu7t5v0__nor2_1
XFILLER_176_496 VDD VSS VDD VSS gf180mcu_fd_sc_mcu7t5v0__fillcap_8
XFILLER_191_422 VDD VSS VDD VSS gf180mcu_fd_sc_mcu7t5v0__fillcap_8
XFILLER_136_349 VDD VSS VDD VSS gf180mcu_fd_sc_mcu7t5v0__fillcap_16
XFILLER_12_37 VDD VSS VDD VSS gf180mcu_fd_sc_mcu7t5v0__fillcap_64
XFILLER_145_850 VDD VSS VDD VSS gf180mcu_fd_sc_mcu7t5v0__fillcap_4
X_2779_ _3213_/B _2779_/B1 _2779_/B2 VDD VSS _2803_/A2 _2898_/A2 _3032_/A1 VDD VSS
+ gf180mcu_fd_sc_mcu7t5v0__oai32_1
X_4518_ VSS _4518_/CLK VDD _4518_/D _4518_/Q wire207/Z VDD VSS gf180mcu_fd_sc_mcu7t5v0__dffsnq_1
X_4449_ _4449_/D _4449_/Q wire196/I VSS _4449_/CLK VDD VDD VSS gf180mcu_fd_sc_mcu7t5v0__dffrnq_1
XFILLER_113_780 VDD VSS VDD VSS gf180mcu_fd_sc_mcu7t5v0__fillcap_4
XFILLER_58_311 VDD VSS VDD VSS gf180mcu_fd_sc_mcu7t5v0__fillcap_4
XFILLER_215_832 VDD VSS VDD VSS gf180mcu_fd_sc_mcu7t5v0__fillcap_8
XFILLER_26_241 VDD VSS VDD VSS gf180mcu_fd_sc_mcu7t5v0__fillcap_4
XFILLER_53_66 VDD VSS VDD VSS gf180mcu_fd_sc_mcu7t5v0__fillcap_4
XFILLER_210_581 VDD VSS VDD VSS gf180mcu_fd_sc_mcu7t5v0__fillcap_8
XFILLER_155_625 VDD VSS VDD VSS gf180mcu_fd_sc_mcu7t5v0__fillcap_4
XFILLER_195_794 VDD VSS VDD VSS gf180mcu_fd_sc_mcu7t5v0__fillcap_8
XFILLER_151_842 VDD VSS VDD VSS gf180mcu_fd_sc_mcu7t5v0__fillcap_8
XFILLER_2_885 VDD VSS VDD VSS gf180mcu_fd_sc_mcu7t5v0__fillcap_4
XFILLER_225_618 VDD VSS VDD VSS gf180mcu_fd_sc_mcu7t5v0__fillcap_8
XFILLER_18_731 VDD VSS VDD VSS gf180mcu_fd_sc_mcu7t5v0__fillcap_4
XFILLER_80_807 VDD VSS VDD VSS gf180mcu_fd_sc_mcu7t5v0__fillcap_64
X_3820_ _3821_/S VDD VSS _3976_/D wire172/Z _3976_/Q VDD VSS gf180mcu_fd_sc_mcu7t5v0__mux2_2
X_3751_ _3758_/S VDD VSS _3924_/D wire177/Z _3924_/Q VDD VSS gf180mcu_fd_sc_mcu7t5v0__mux2_2
XFILLER_60_597 VDD VSS VDD VSS gf180mcu_fd_sc_mcu7t5v0__fillcap_64
XFILLER_186_761 VDD VSS VDD VSS gf180mcu_fd_sc_mcu7t5v0__fillcap_4
X_2702_ _2728_/S VDD VSS _4246_/D _4246_/Q _4287_/Q VDD VSS gf180mcu_fd_sc_mcu7t5v0__mux2_2
XFILLER_173_422 VDD VSS VDD VSS gf180mcu_fd_sc_mcu7t5v0__fillcap_16
X_3682_ _3682_/B1 _4193_/Q VDD VSS _3683_/I _4499_/Q _3682_/A2 VDD VSS gf180mcu_fd_sc_mcu7t5v0__aoi22_1
XFILLER_146_658 VDD VSS VDD VSS gf180mcu_fd_sc_mcu7t5v0__fillcap_4
X_2633_ _2633_/A3 VDD VSS _4215_/D _2606_/C _2635_/A3 VDD VSS gf180mcu_fd_sc_mcu7t5v0__nor3_1
XFILLER_64_2 VDD VSS VDD VSS gf180mcu_fd_sc_mcu7t5v0__fillcap_32
X_2564_ wire29/Z VDD VSS _4187_/D _4461_/Q _4187_/Q VDD VSS gf180mcu_fd_sc_mcu7t5v0__mux2_2
XFILLER_154_691 VDD VSS VDD VSS gf180mcu_fd_sc_mcu7t5v0__fillcap_4
X_4303_ VSS _4529_/CLK VDD _4303_/D _4303_/Q wire199/Z VDD VSS gf180mcu_fd_sc_mcu7t5v0__dffsnq_1
XFILLER_141_352 VDD VSS VDD VSS gf180mcu_fd_sc_mcu7t5v0__fillcap_64
XFILLER_101_205 VDD VSS VDD VSS gf180mcu_fd_sc_mcu7t5v0__fillcap_4
XFILLER_102_717 VDD VSS VDD VSS gf180mcu_fd_sc_mcu7t5v0__fillcap_16
X_2495_ _2500_/S VDD VSS _4116_/D wire161/Z _4116_/Q VDD VSS gf180mcu_fd_sc_mcu7t5v0__mux2_2
X_4234_ _4234_/D _4234_/Q _4534_/RN VSS _4586_/CLK VDD VDD VSS gf180mcu_fd_sc_mcu7t5v0__dffrnq_1
X_4165_ _4165_/D _4165_/Q wire184/Z VSS _4500_/CLK VDD VDD VSS gf180mcu_fd_sc_mcu7t5v0__dffrnq_1
X_3116_ _3116_/B _3187_/C VDD VSS _3119_/A2 _3176_/S _3713_/A1 VDD VSS gf180mcu_fd_sc_mcu7t5v0__aoi211_1
X_4096_ VDD _4096_/Q _4096_/CLK VSS _4096_/D VDD VSS gf180mcu_fd_sc_mcu7t5v0__dffq_1
X_3047_ VDD VSS _3048_/B _4331_/Q wire13/Z VDD VSS gf180mcu_fd_sc_mcu7t5v0__nand2_1
XFILLER_82_177 VDD VSS VDD VSS gf180mcu_fd_sc_mcu7t5v0__fillcap_64
XFILLER_70_317 VDD VSS VDD VSS gf180mcu_fd_sc_mcu7t5v0__fillcap_64
XFILLER_251_492 VDD VSS VDD VSS gf180mcu_fd_sc_mcu7t5v0__fillcap_64
XFILLER_196_558 VDD VSS VDD VSS gf180mcu_fd_sc_mcu7t5v0__fillcap_8
X_3949_ VDD _3949_/Q _3965_/CLK VSS _3949_/D VDD VSS gf180mcu_fd_sc_mcu7t5v0__dffq_1
XFILLER_177_772 VDD VSS VDD VSS gf180mcu_fd_sc_mcu7t5v0__fillcap_64
XFILLER_192_731 VDD VSS VDD VSS gf180mcu_fd_sc_mcu7t5v0__fillcap_4
XFILLER_133_842 VDD VSS VDD VSS gf180mcu_fd_sc_mcu7t5v0__fillcap_16
XFILLER_105_577 VDD VSS VDD VSS gf180mcu_fd_sc_mcu7t5v0__fillcap_16
XFILLER_171_34 VDD VSS VDD VSS gf180mcu_fd_sc_mcu7t5v0__fillcap_8
XFILLER_101_750 VDD VSS VDD VSS gf180mcu_fd_sc_mcu7t5v0__fillcap_8
XFILLER_101_772 VDD VSS VDD VSS gf180mcu_fd_sc_mcu7t5v0__fillcap_8
XFILLER_261_212 VDD VSS VDD VSS gf180mcu_fd_sc_mcu7t5v0__fillcap_64
XFILLER_100_293 VDD VSS VDD VSS gf180mcu_fd_sc_mcu7t5v0__fillcap_4
XFILLER_62_807 VDD VSS VDD VSS gf180mcu_fd_sc_mcu7t5v0__fillcap_64
XFILLER_74_667 VDD VSS VDD VSS gf180mcu_fd_sc_mcu7t5v0__fillcap_64
XFILLER_266_2 VDD VSS VDD VSS gf180mcu_fd_sc_mcu7t5v0__fillcap_32
XFILLER_203_857 VDD VSS VDD VSS gf180mcu_fd_sc_mcu7t5v0__fillcap_32
XFILLER_42_597 VDD VSS VDD VSS gf180mcu_fd_sc_mcu7t5v0__fillcap_64
XFILLER_30_737 VDD VSS VDD VSS gf180mcu_fd_sc_mcu7t5v0__fillcap_64
XFILLER_167_282 VDD VSS VDD VSS gf180mcu_fd_sc_mcu7t5v0__fillcap_16
XFILLER_155_422 VDD VSS VDD VSS gf180mcu_fd_sc_mcu7t5v0__fillcap_8
XFILLER_127_113 VDD VSS VDD VSS gf180mcu_fd_sc_mcu7t5v0__fillcap_16
XFILLER_170_436 VDD VSS VDD VSS gf180mcu_fd_sc_mcu7t5v0__fillcap_16
XFILLER_124_853 VDD VSS VDD VSS gf180mcu_fd_sc_mcu7t5v0__fillcap_8
XFILLER_151_694 VDD VSS VDD VSS gf180mcu_fd_sc_mcu7t5v0__fillcap_4
X_2280_ VDD VSS _2280_/I _2290_/A2 VDD VSS gf180mcu_fd_sc_mcu7t5v0__clkinv_1
XFILLER_96_247 VDD VSS VDD VSS gf180mcu_fd_sc_mcu7t5v0__fillcap_8
XFILLER_253_702 VDD VSS VDD VSS gf180mcu_fd_sc_mcu7t5v0__fillcap_64
XFILLER_265_562 VDD VSS VDD VSS gf180mcu_fd_sc_mcu7t5v0__fillcap_64
XFILLER_64_177 VDD VSS VDD VSS gf180mcu_fd_sc_mcu7t5v0__fillcap_64
XFILLER_52_317 VDD VSS VDD VSS gf180mcu_fd_sc_mcu7t5v0__fillcap_64
XFILLER_221_632 VDD VSS VDD VSS gf180mcu_fd_sc_mcu7t5v0__fillcap_64
XFILLER_233_492 VDD VSS VDD VSS gf180mcu_fd_sc_mcu7t5v0__fillcap_16
X_3803_ VDD VSS wire15/I _3840_/A1 _3768_/Z VDD VSS gf180mcu_fd_sc_mcu7t5v0__nand2_1
XFILLER_159_772 VDD VSS VDD VSS gf180mcu_fd_sc_mcu7t5v0__fillcap_16
X_1995_ VDD VSS _4076_/Q _3485_/A2 VDD VSS gf180mcu_fd_sc_mcu7t5v0__clkinv_1
XFILLER_20_247 VDD VSS VDD VSS gf180mcu_fd_sc_mcu7t5v0__fillcap_64
X_3734_ _3738_/S VDD VSS _3909_/D _3763_/I0 _3909_/Q VDD VSS gf180mcu_fd_sc_mcu7t5v0__mux2_2
XFILLER_186_591 VDD VSS VDD VSS gf180mcu_fd_sc_mcu7t5v0__fillcap_4
X_3665_ VDD VSS _3665_/I _4491_/D VDD VSS gf180mcu_fd_sc_mcu7t5v0__clkinv_1
X_2616_ VDD VSS _2621_/A3 _4211_/Q _2618_/A2 VDD VSS gf180mcu_fd_sc_mcu7t5v0__nand2_1
Xclkload62 VSS clkload62/Z _4271_/CLK VDD VDD VSS gf180mcu_fd_sc_mcu7t5v0__clkbuf_1
Xclkload51 VSS clkload51/Z _4451_/CLK VDD VDD VSS gf180mcu_fd_sc_mcu7t5v0__clkbuf_1
Xclkload40 VSS clkload40/Z _4532_/CLK VDD VDD VSS gf180mcu_fd_sc_mcu7t5v0__clkbuf_1
Xclkload73 VSS clkload73/Z _4305_/CLK VDD VDD VSS gf180mcu_fd_sc_mcu7t5v0__clkbuf_1
Xclkload95 VDD VSS clkload95/ZN _4595_/CLK VDD VSS gf180mcu_fd_sc_mcu7t5v0__clkinv_8
Xclkload84 VSS clkload84/Z _4371_/CLK VDD VDD VSS gf180mcu_fd_sc_mcu7t5v0__clkbuf_1
X_3596_ VDD VSS _3602_/A2 _3596_/A1 _3595_/Z VDD VSS gf180mcu_fd_sc_mcu7t5v0__nand2_1
XFILLER_115_842 VDD VSS VDD VSS gf180mcu_fd_sc_mcu7t5v0__fillcap_16
X_2547_ wire28/I VDD VSS _4170_/D wire119/Z _4170_/Q VDD VSS gf180mcu_fd_sc_mcu7t5v0__mux2_2
XFILLER_115_875 VDD VSS VDD VSS gf180mcu_fd_sc_mcu7t5v0__fillcap_8
X_2478_ _2482_/S VDD VSS _4101_/D _4101_/Q _2505_/I0 VDD VSS gf180mcu_fd_sc_mcu7t5v0__mux2_2
XFILLER_88_737 VDD VSS VDD VSS gf180mcu_fd_sc_mcu7t5v0__fillcap_32
X_4217_ _4217_/D _4217_/Q wire199/Z VSS _4521_/CLK VDD VDD VSS gf180mcu_fd_sc_mcu7t5v0__dffrnq_1
X_4148_ _4148_/D _4148_/Q wire192/Z VSS _4531_/CLK VDD VDD VSS gf180mcu_fd_sc_mcu7t5v0__dffrnq_1
XFILLER_243_212 VDD VSS VDD VSS gf180mcu_fd_sc_mcu7t5v0__fillcap_64
XFILLER_44_807 VDD VSS VDD VSS gf180mcu_fd_sc_mcu7t5v0__fillcap_64
XFILLER_110_591 VDD VSS VDD VSS gf180mcu_fd_sc_mcu7t5v0__fillcap_4
XFILLER_71_626 VDD VSS VDD VSS gf180mcu_fd_sc_mcu7t5v0__fillcap_4
X_4079_ VDD _4079_/Q _4096_/CLK VSS _4079_/D VDD VSS gf180mcu_fd_sc_mcu7t5v0__dffq_1
XFILLER_56_667 VDD VSS VDD VSS gf180mcu_fd_sc_mcu7t5v0__fillcap_64
XFILLER_83_486 VDD VSS VDD VSS gf180mcu_fd_sc_mcu7t5v0__fillcap_4
XFILLER_196_300 VDD VSS VDD VSS gf180mcu_fd_sc_mcu7t5v0__fillcap_4
Xspi_opentarget_i3c_top_217 irq_o_CS VDD VSS VDD VSS gf180mcu_fd_sc_mcu7t5v0__tiel
Xspi_opentarget_i3c_top_228 sda_pad_CS VDD VSS VDD VSS gf180mcu_fd_sc_mcu7t5v0__tiel
XFILLER_211_142 VDD VSS VDD VSS gf180mcu_fd_sc_mcu7t5v0__fillcap_32
XFILLER_24_597 VDD VSS VDD VSS gf180mcu_fd_sc_mcu7t5v0__fillcap_64
XFILLER_12_737 VDD VSS VDD VSS gf180mcu_fd_sc_mcu7t5v0__fillcap_64
Xspi_opentarget_i3c_top_239 spi_miso_o_PDRV0 VDD VSS VDD VSS gf180mcu_fd_sc_mcu7t5v0__tiel
Xwire138 VSS wire138/Z _4437_/Q VDD VDD VSS gf180mcu_fd_sc_mcu7t5v0__buf_2
XFILLER_149_282 VDD VSS VDD VSS gf180mcu_fd_sc_mcu7t5v0__fillcap_8
XFILLER_137_422 VDD VSS VDD VSS gf180mcu_fd_sc_mcu7t5v0__fillcap_4
Xwire127 wire127/Z VSS VDD _4441_/Q VDD VSS gf180mcu_fd_sc_mcu7t5v0__clkbuf_2
XFILLER_109_102 VDD VSS VDD VSS gf180mcu_fd_sc_mcu7t5v0__fillcap_32
Xclkload1 VSS clkload1/ZN clkload1/I VDD VDD VSS gf180mcu_fd_sc_mcu7t5v0__inv_4
Xwire116 VSS wire116/Z _4449_/Q VDD VDD VSS gf180mcu_fd_sc_mcu7t5v0__clkbuf_1
XFILLER_109_168 VDD VSS VDD VSS gf180mcu_fd_sc_mcu7t5v0__fillcap_4
XFILLER_105_352 VDD VSS VDD VSS gf180mcu_fd_sc_mcu7t5v0__fillcap_16
XFILLER_120_311 VDD VSS VDD VSS gf180mcu_fd_sc_mcu7t5v0__fillcap_4
XFILLER_121_834 VDD VSS VDD VSS gf180mcu_fd_sc_mcu7t5v0__fillcap_4
XFILLER_78_247 VDD VSS VDD VSS gf180mcu_fd_sc_mcu7t5v0__fillcap_64
XFILLER_132_193 VDD VSS VDD VSS gf180mcu_fd_sc_mcu7t5v0__fillcap_8
XFILLER_93_206 VDD VSS VDD VSS gf180mcu_fd_sc_mcu7t5v0__fillcap_4
XFILLER_115_60 VDD VSS VDD VSS gf180mcu_fd_sc_mcu7t5v0__fillcap_8
XFILLER_247_562 VDD VSS VDD VSS gf180mcu_fd_sc_mcu7t5v0__fillcap_64
Xload_slew24 _2763_/S wire25/Z VDD VSS VDD VSS gf180mcu_fd_sc_mcu7t5v0__buf_4
XFILLER_262_521 VDD VSS VDD VSS gf180mcu_fd_sc_mcu7t5v0__fillcap_4
XFILLER_201_18 VDD VSS VDD VSS gf180mcu_fd_sc_mcu7t5v0__fillcap_32
XFILLER_46_177 VDD VSS VDD VSS gf180mcu_fd_sc_mcu7t5v0__fillcap_64
XFILLER_34_317 VDD VSS VDD VSS gf180mcu_fd_sc_mcu7t5v0__fillcap_64
XFILLER_215_492 VDD VSS VDD VSS gf180mcu_fd_sc_mcu7t5v0__fillcap_64
XFILLER_131_92 VDD VSS VDD VSS gf180mcu_fd_sc_mcu7t5v0__fillcap_16
XFILLER_61_136 VDD VSS VDD VSS gf180mcu_fd_sc_mcu7t5v0__fillcap_4
XFILLER_230_451 VDD VSS VDD VSS gf180mcu_fd_sc_mcu7t5v0__fillcap_4
XFILLER_187_377 VDD VSS VDD VSS gf180mcu_fd_sc_mcu7t5v0__fillcap_16
X_3450_ VDD VSS _3622_/C _3451_/A1 _3499_/A2 VDD VSS gf180mcu_fd_sc_mcu7t5v0__nor2_1
XFILLER_226_37 VDD VSS VDD VSS gf180mcu_fd_sc_mcu7t5v0__fillcap_64
X_3381_ wire56/Z VDD VSS _4428_/D _4388_/Q _4428_/Q VDD VSS gf180mcu_fd_sc_mcu7t5v0__mux2_2
XFILLER_124_650 VDD VSS VDD VSS gf180mcu_fd_sc_mcu7t5v0__fillcap_4
X_2401_ _2403_/S VDD VSS _4039_/D _4039_/Q wire154/Z VDD VSS gf180mcu_fd_sc_mcu7t5v0__mux2_2
X_2332_ VDD VSS _2346_/A1 _2975_/A1 _3035_/A2 VDD VSS gf180mcu_fd_sc_mcu7t5v0__nand2_1
XFILLER_111_322 VDD VSS VDD VSS gf180mcu_fd_sc_mcu7t5v0__fillcap_16
XFILLER_27_2 VDD VSS VDD VSS gf180mcu_fd_sc_mcu7t5v0__fillcap_64
X_2263_ _2263_/A3 VDD VSS _2266_/A1 _2263_/A1 _2263_/A2 VDD VSS gf180mcu_fd_sc_mcu7t5v0__nand3_1
X_4002_ VDD _4002_/Q _4047_/CLK VSS _4002_/D VDD VSS gf180mcu_fd_sc_mcu7t5v0__dffq_1
XFILLER_266_871 VDD VSS VDD VSS gf180mcu_fd_sc_mcu7t5v0__fillcap_4
X_2194_ VDD VSS _2194_/I _2203_/A2 VDD VSS gf180mcu_fd_sc_mcu7t5v0__clkinv_1
XFILLER_225_212 VDD VSS VDD VSS gf180mcu_fd_sc_mcu7t5v0__fillcap_64
XFILLER_26_807 VDD VSS VDD VSS gf180mcu_fd_sc_mcu7t5v0__fillcap_64
XFILLER_38_667 VDD VSS VDD VSS gf180mcu_fd_sc_mcu7t5v0__fillcap_64
XFILLER_1_72 VDD VSS VDD VSS gf180mcu_fd_sc_mcu7t5v0__fillcap_64
XFILLER_53_626 VDD VSS VDD VSS gf180mcu_fd_sc_mcu7t5v0__fillcap_4
XFILLER_65_486 VDD VSS VDD VSS gf180mcu_fd_sc_mcu7t5v0__fillcap_4
XFILLER_21_556 VDD VSS VDD VSS gf180mcu_fd_sc_mcu7t5v0__fillcap_4
XFILLER_119_422 VDD VSS VDD VSS gf180mcu_fd_sc_mcu7t5v0__fillcap_16
X_3717_ VDD _3717_/B _3718_/S _3896_/D _3717_/A1 VSS VDD VSS gf180mcu_fd_sc_mcu7t5v0__oai21_1
XFILLER_267_66 VDD VSS VDD VSS gf180mcu_fd_sc_mcu7t5v0__fillcap_4
X_1978_ VDD VSS _3852_/D _3318_/A1 VDD VSS gf180mcu_fd_sc_mcu7t5v0__clkinv_1
X_3648_ VDD VSS _3650_/A2 _4179_/Q _3682_/B1 VDD VSS gf180mcu_fd_sc_mcu7t5v0__nand2_1
XFILLER_20_37 VDD VSS VDD VSS gf180mcu_fd_sc_mcu7t5v0__fillcap_64
X_3579_ VDD VSS _3581_/A2 wire75/I _4016_/Q VDD VSS gf180mcu_fd_sc_mcu7t5v0__nand2_1
XFILLER_115_683 VDD VSS VDD VSS gf180mcu_fd_sc_mcu7t5v0__fillcap_16
XFILLER_114_193 VDD VSS VDD VSS gf180mcu_fd_sc_mcu7t5v0__fillcap_8
XFILLER_75_206 VDD VSS VDD VSS gf180mcu_fd_sc_mcu7t5v0__fillcap_4
XFILLER_229_562 VDD VSS VDD VSS gf180mcu_fd_sc_mcu7t5v0__fillcap_64
XFILLER_152_69 VDD VSS VDD VSS gf180mcu_fd_sc_mcu7t5v0__fillcap_8
XFILLER_244_521 VDD VSS VDD VSS gf180mcu_fd_sc_mcu7t5v0__fillcap_4
XFILLER_256_381 VDD VSS VDD VSS gf180mcu_fd_sc_mcu7t5v0__fillcap_4
XFILLER_28_177 VDD VSS VDD VSS gf180mcu_fd_sc_mcu7t5v0__fillcap_64
XFILLER_16_317 VDD VSS VDD VSS gf180mcu_fd_sc_mcu7t5v0__fillcap_64
XFILLER_43_136 VDD VSS VDD VSS gf180mcu_fd_sc_mcu7t5v0__fillcap_4
XFILLER_212_484 VDD VSS VDD VSS gf180mcu_fd_sc_mcu7t5v0__fillcap_32
XFILLER_212_451 VDD VSS VDD VSS gf180mcu_fd_sc_mcu7t5v0__fillcap_4
XFILLER_196_185 VDD VSS VDD VSS gf180mcu_fd_sc_mcu7t5v0__fillcap_32
XFILLER_184_303 VDD VSS VDD VSS gf180mcu_fd_sc_mcu7t5v0__fillcap_8
XFILLER_131_2 VDD VSS VDD VSS gf180mcu_fd_sc_mcu7t5v0__fillcap_16
XFILLER_8_527 VDD VSS VDD VSS gf180mcu_fd_sc_mcu7t5v0__fillcap_64
XFILLER_61_66 VDD VSS VDD VSS gf180mcu_fd_sc_mcu7t5v0__fillcap_4
XFILLER_138_731 VDD VSS VDD VSS gf180mcu_fd_sc_mcu7t5v0__fillcap_4
XFILLER_229_2 VDD VSS VDD VSS gf180mcu_fd_sc_mcu7t5v0__fillcap_64
XFILLER_193_881 VDD VSS VDD VSS gf180mcu_fd_sc_mcu7t5v0__fillcap_8
XFILLER_153_745 VDD VSS VDD VSS gf180mcu_fd_sc_mcu7t5v0__fillcap_16
XFILLER_180_597 VDD VSS VDD VSS gf180mcu_fd_sc_mcu7t5v0__fillcap_64
XFILLER_3_276 VDD VSS VDD VSS gf180mcu_fd_sc_mcu7t5v0__fillcap_4
XFILLER_266_101 VDD VSS VDD VSS gf180mcu_fd_sc_mcu7t5v0__fillcap_4
XFILLER_79_556 VDD VSS VDD VSS gf180mcu_fd_sc_mcu7t5v0__fillcap_4
XFILLER_248_871 VDD VSS VDD VSS gf180mcu_fd_sc_mcu7t5v0__fillcap_4
XFILLER_207_201 VDD VSS VDD VSS gf180mcu_fd_sc_mcu7t5v0__fillcap_8
XFILLER_207_212 VDD VSS VDD VSS gf180mcu_fd_sc_mcu7t5v0__fillcap_32
XFILLER_263_874 VDD VSS VDD VSS gf180mcu_fd_sc_mcu7t5v0__fillcap_16
XFILLER_35_626 VDD VSS VDD VSS gf180mcu_fd_sc_mcu7t5v0__fillcap_4
XFILLER_47_486 VDD VSS VDD VSS gf180mcu_fd_sc_mcu7t5v0__fillcap_4
XFILLER_90_721 VDD VSS VDD VSS gf180mcu_fd_sc_mcu7t5v0__fillcap_8
X_2950_ _2963_/A2 _2950_/C VDD VSS _2954_/A2 _2950_/A1 _2950_/A2 _4341_/Q VDD VSS
+ gf180mcu_fd_sc_mcu7t5v0__oai221_1
X_2881_ _4343_/Q VDD VSS _2885_/B2 _3008_/B2 _3015_/C VDD VSS gf180mcu_fd_sc_mcu7t5v0__nand3_1
X_4551_ _4551_/D _4551_/Q _4573_/RN VDD VSS _4553_/CLK VDD VSS gf180mcu_fd_sc_mcu7t5v0__dffrnq_2
XFILLER_190_317 VDD VSS VDD VSS gf180mcu_fd_sc_mcu7t5v0__fillcap_4
XFILLER_129_786 VDD VSS VDD VSS gf180mcu_fd_sc_mcu7t5v0__fillcap_32
XFILLER_156_583 VDD VSS VDD VSS gf180mcu_fd_sc_mcu7t5v0__fillcap_4
XFILLER_144_745 VDD VSS VDD VSS gf180mcu_fd_sc_mcu7t5v0__fillcap_4
X_4482_ _4482_/D _4482_/Q wire186/Z VSS _4498_/CLK VDD VDD VSS gf180mcu_fd_sc_mcu7t5v0__dffrnq_1
X_3502_ VDD VSS _3503_/B2 _3619_/B1 _3502_/A2 VDD VSS gf180mcu_fd_sc_mcu7t5v0__nand2_1
XFILLER_171_553 VDD VSS VDD VSS gf180mcu_fd_sc_mcu7t5v0__fillcap_4
XFILLER_143_244 VDD VSS VDD VSS gf180mcu_fd_sc_mcu7t5v0__fillcap_8
X_3433_ _3433_/A3 VDD VSS _3442_/A1 wire78/Z _3433_/A2 VDD VSS gf180mcu_fd_sc_mcu7t5v0__nand3_1
X_3364_ wire20/Z VDD VSS _4411_/D _4403_/Q _4411_/Q VDD VSS gf180mcu_fd_sc_mcu7t5v0__mux2_2
XFILLER_112_631 VDD VSS VDD VSS gf180mcu_fd_sc_mcu7t5v0__fillcap_16
X_2315_ VDD VSS _3213_/B _4524_/D _2318_/B1 VDD VSS gf180mcu_fd_sc_mcu7t5v0__nor2_1
X_3295_ _3334_/A2 _4486_/Q VDD VSS _3296_/A2 _4478_/Q _3278_/Z VDD VSS gf180mcu_fd_sc_mcu7t5v0__aoi22_1
XFILLER_57_206 VDD VSS VDD VSS gf180mcu_fd_sc_mcu7t5v0__fillcap_4
X_2246_ VDD VSS _2249_/A1 _4556_/Q _4547_/D VDD VSS gf180mcu_fd_sc_mcu7t5v0__xnor2_1
XFILLER_238_381 VDD VSS VDD VSS gf180mcu_fd_sc_mcu7t5v0__fillcap_4
XFILLER_254_885 VDD VSS VDD VSS gf180mcu_fd_sc_mcu7t5v0__fillcap_4
X_2177_ VDD VSS _2653_/A1 _2684_/A2 _2684_/A3 VDD VSS gf180mcu_fd_sc_mcu7t5v0__nor2_1
XFILLER_25_136 VDD VSS VDD VSS gf180mcu_fd_sc_mcu7t5v0__fillcap_4
XFILLER_182_807 VDD VSS VDD VSS gf180mcu_fd_sc_mcu7t5v0__fillcap_32
XFILLER_193_166 VDD VSS VDD VSS gf180mcu_fd_sc_mcu7t5v0__fillcap_4
XFILLER_107_414 VDD VSS VDD VSS gf180mcu_fd_sc_mcu7t5v0__fillcap_4
XFILLER_162_542 VDD VSS VDD VSS gf180mcu_fd_sc_mcu7t5v0__fillcap_8
XFILLER_162_597 VDD VSS VDD VSS gf180mcu_fd_sc_mcu7t5v0__fillcap_32
XFILLER_150_737 VDD VSS VDD VSS gf180mcu_fd_sc_mcu7t5v0__fillcap_16
XFILLER_150_726 VDD VSS VDD VSS gf180mcu_fd_sc_mcu7t5v0__fillcap_8
XFILLER_248_101 VDD VSS VDD VSS gf180mcu_fd_sc_mcu7t5v0__fillcap_4
XFILLER_245_874 VDD VSS VDD VSS gf180mcu_fd_sc_mcu7t5v0__fillcap_16
XFILLER_179_2 VDD VSS VDD VSS gf180mcu_fd_sc_mcu7t5v0__fillcap_16
XFILLER_29_486 VDD VSS VDD VSS gf180mcu_fd_sc_mcu7t5v0__fillcap_4
XFILLER_17_626 VDD VSS VDD VSS gf180mcu_fd_sc_mcu7t5v0__fillcap_4
XFILLER_260_877 VDD VSS VDD VSS gf180mcu_fd_sc_mcu7t5v0__fillcap_8
XFILLER_220_719 VDD VSS VDD VSS gf180mcu_fd_sc_mcu7t5v0__fillcap_16
XFILLER_185_612 VDD VSS VDD VSS gf180mcu_fd_sc_mcu7t5v0__fillcap_8
XFILLER_197_483 VDD VSS VDD VSS gf180mcu_fd_sc_mcu7t5v0__fillcap_4
XFILLER_212_281 VDD VSS VDD VSS gf180mcu_fd_sc_mcu7t5v0__fillcap_32
XFILLER_9_836 VDD VSS VDD VSS gf180mcu_fd_sc_mcu7t5v0__fillcap_4
XFILLER_172_317 VDD VSS VDD VSS gf180mcu_fd_sc_mcu7t5v0__fillcap_8
XFILLER_180_372 VDD VSS VDD VSS gf180mcu_fd_sc_mcu7t5v0__fillcap_8
XFILLER_98_139 VDD VSS VDD VSS gf180mcu_fd_sc_mcu7t5v0__fillcap_4
XFILLER_121_450 VDD VSS VDD VSS gf180mcu_fd_sc_mcu7t5v0__fillcap_4
XFILLER_39_206 VDD VSS VDD VSS gf180mcu_fd_sc_mcu7t5v0__fillcap_4
X_3080_ VDD VSS _3081_/B _3124_/A1 _3963_/Q VDD VSS gf180mcu_fd_sc_mcu7t5v0__nor2_1
X_2100_ VDD VSS _4590_/D _4616_/D _2100_/A2 VDD VSS gf180mcu_fd_sc_mcu7t5v0__xnor2_1
X_2031_ VDD VSS _2035_/A3 _4433_/Q _4434_/Q VDD VSS gf180mcu_fd_sc_mcu7t5v0__nor2_1
XFILLER_236_885 VDD VSS VDD VSS gf180mcu_fd_sc_mcu7t5v0__fillcap_4
X_3982_ VDD _3982_/Q _3998_/CLK VSS _3982_/D VDD VSS gf180mcu_fd_sc_mcu7t5v0__dffq_1
XFILLER_250_387 VDD VSS VDD VSS gf180mcu_fd_sc_mcu7t5v0__fillcap_64
X_2933_ VDD VSS _2934_/C _4334_/Q _4198_/Q VDD VSS gf180mcu_fd_sc_mcu7t5v0__xor2_1
XFILLER_94_2 VDD VSS VDD VSS gf180mcu_fd_sc_mcu7t5v0__fillcap_32
XFILLER_176_667 VDD VSS VDD VSS gf180mcu_fd_sc_mcu7t5v0__fillcap_8
XFILLER_164_807 VDD VSS VDD VSS gf180mcu_fd_sc_mcu7t5v0__fillcap_8
X_2864_ _2864_/A2 _2864_/B1 _4354_/Q VDD VSS _2865_/B _4353_/Q VDD VSS gf180mcu_fd_sc_mcu7t5v0__oai22_1
XFILLER_191_626 VDD VSS VDD VSS gf180mcu_fd_sc_mcu7t5v0__fillcap_4
XFILLER_136_509 VDD VSS VDD VSS gf180mcu_fd_sc_mcu7t5v0__fillcap_4
X_4603_ _4603_/D _4603_/Q _4616_/RN VSS _4605_/CLK VDD VDD VSS gf180mcu_fd_sc_mcu7t5v0__dffrnq_1
X_2795_ VDD VSS _3212_/A2 _2795_/A1 _4529_/Q VDD VSS gf180mcu_fd_sc_mcu7t5v0__nor2_1
X_4534_ _4534_/D _4534_/Q _4534_/RN VSS _4614_/CLK VDD VDD VSS gf180mcu_fd_sc_mcu7t5v0__dffrnq_1
XFILLER_175_199 VDD VSS VDD VSS gf180mcu_fd_sc_mcu7t5v0__fillcap_8
XFILLER_156_380 VDD VSS VDD VSS gf180mcu_fd_sc_mcu7t5v0__fillcap_4
XFILLER_144_586 VDD VSS VDD VSS gf180mcu_fd_sc_mcu7t5v0__fillcap_8
X_4465_ _4465_/D _4465_/Q wire212/Z VSS clkload7/I VDD VDD VSS gf180mcu_fd_sc_mcu7t5v0__dffrnq_1
X_3416_ _3425_/S VDD VSS _4459_/D _4417_/Q _4459_/Q VDD VSS gf180mcu_fd_sc_mcu7t5v0__mux2_2
X_4396_ _4396_/D _4396_/Q _4536_/RN VSS _4446_/CLK VDD VDD VSS gf180mcu_fd_sc_mcu7t5v0__dffrnq_1
XFILLER_132_759 VDD VSS VDD VSS gf180mcu_fd_sc_mcu7t5v0__fillcap_8
X_3347_ _4385_/Q wire21/I _4384_/Q VSS _3347_/B VDD VDD VSS gf180mcu_fd_sc_mcu7t5v0__oai21_2
XFILLER_133_38 VDD VSS VDD VSS gf180mcu_fd_sc_mcu7t5v0__fillcap_32
X_3278_ _4385_/Q VDD VSS _3278_/Z _3333_/A1 _3336_/A1 VDD VSS gf180mcu_fd_sc_mcu7t5v0__and3_1
XFILLER_227_874 VDD VSS VDD VSS gf180mcu_fd_sc_mcu7t5v0__fillcap_16
X_2229_ VDD _4319_/Q _2975_/A3 _2233_/A2 _2220_/Z VSS VDD VSS gf180mcu_fd_sc_mcu7t5v0__oai21_1
XFILLER_260_107 VDD VSS VDD VSS gf180mcu_fd_sc_mcu7t5v0__fillcap_64
XFILLER_242_877 VDD VSS VDD VSS gf180mcu_fd_sc_mcu7t5v0__fillcap_8
XFILLER_214_535 VDD VSS VDD VSS gf180mcu_fd_sc_mcu7t5v0__fillcap_4
XFILLER_81_562 VDD VSS VDD VSS gf180mcu_fd_sc_mcu7t5v0__fillcap_16
XFILLER_81_551 VDD VSS VDD VSS gf180mcu_fd_sc_mcu7t5v0__fillcap_8
XFILLER_198_247 VDD VSS VDD VSS gf180mcu_fd_sc_mcu7t5v0__fillcap_16
XFILLER_167_623 VDD VSS VDD VSS gf180mcu_fd_sc_mcu7t5v0__fillcap_4
Xmax_length31 _2546_/S wire28/I VDD VSS VDD VSS gf180mcu_fd_sc_mcu7t5v0__buf_4
Xmax_length86 _3597_/S _3586_/S VDD VSS VDD VSS gf180mcu_fd_sc_mcu7t5v0__buf_4
XFILLER_182_648 VDD VSS VDD VSS gf180mcu_fd_sc_mcu7t5v0__fillcap_16
XFILLER_166_177 VDD VSS VDD VSS gf180mcu_fd_sc_mcu7t5v0__fillcap_8
XFILLER_122_247 VDD VSS VDD VSS gf180mcu_fd_sc_mcu7t5v0__fillcap_32
XFILLER_89_640 VDD VSS VDD VSS gf180mcu_fd_sc_mcu7t5v0__fillcap_4
XFILLER_190_22 VDD VSS VDD VSS gf180mcu_fd_sc_mcu7t5v0__fillcap_8
XFILLER_264_457 VDD VSS VDD VSS gf180mcu_fd_sc_mcu7t5v0__fillcap_64
XFILLER_218_885 VDD VSS VDD VSS gf180mcu_fd_sc_mcu7t5v0__fillcap_4
XFILLER_232_387 VDD VSS VDD VSS gf180mcu_fd_sc_mcu7t5v0__fillcap_64
XFILLER_220_527 VDD VSS VDD VSS gf180mcu_fd_sc_mcu7t5v0__fillcap_32
XFILLER_198_792 VDD VSS VDD VSS gf180mcu_fd_sc_mcu7t5v0__fillcap_4
XFILLER_158_634 VDD VSS VDD VSS gf180mcu_fd_sc_mcu7t5v0__fillcap_16
XFILLER_157_133 VDD VSS VDD VSS gf180mcu_fd_sc_mcu7t5v0__fillcap_4
XFILLER_146_807 VDD VSS VDD VSS gf180mcu_fd_sc_mcu7t5v0__fillcap_8
XFILLER_173_626 VDD VSS VDD VSS gf180mcu_fd_sc_mcu7t5v0__fillcap_4
XFILLER_145_339 VDD VSS VDD VSS gf180mcu_fd_sc_mcu7t5v0__fillcap_4
X_2580_ wire27/Z VDD VSS _4199_/D wire125/I _4199_/Q VDD VSS gf180mcu_fd_sc_mcu7t5v0__mux2_2
XFILLER_126_597 VDD VSS VDD VSS gf180mcu_fd_sc_mcu7t5v0__fillcap_16
XFILLER_114_737 VDD VSS VDD VSS gf180mcu_fd_sc_mcu7t5v0__fillcap_8
XFILLER_181_692 VDD VSS VDD VSS gf180mcu_fd_sc_mcu7t5v0__fillcap_4
X_4250_ _4250_/D _4250_/Q _4284_/RN VSS _4271_/CLK VDD VDD VSS gf180mcu_fd_sc_mcu7t5v0__dffrnq_1
XFILLER_234_37 VDD VSS VDD VSS gf180mcu_fd_sc_mcu7t5v0__fillcap_64
X_3201_ _3201_/A3 VDD VSS _3202_/A2 wire58/I _3201_/A2 VDD VSS gf180mcu_fd_sc_mcu7t5v0__nand3_1
X_4181_ _4181_/D _4181_/Q wire212/Z VSS clkload8/I VDD VDD VSS gf180mcu_fd_sc_mcu7t5v0__dffrnq_1
X_3132_ VDD VSS _3152_/B _4336_/Q wire13/Z VDD VSS gf180mcu_fd_sc_mcu7t5v0__nand2_1
XFILLER_95_632 VDD VSS VDD VSS gf180mcu_fd_sc_mcu7t5v0__fillcap_32
XFILLER_94_153 VDD VSS VDD VSS gf180mcu_fd_sc_mcu7t5v0__fillcap_8
XFILLER_209_874 VDD VSS VDD VSS gf180mcu_fd_sc_mcu7t5v0__fillcap_16
X_3063_ VDD _3067_/A2 _3063_/B wire93/Z _3063_/A2 VSS _3063_/A3 VDD VSS gf180mcu_fd_sc_mcu7t5v0__oai31_1
X_2014_ VDD VSS _4226_/Q _3106_/A2 VDD VSS gf180mcu_fd_sc_mcu7t5v0__clkinv_1
XFILLER_208_373 VDD VSS VDD VSS gf180mcu_fd_sc_mcu7t5v0__fillcap_4
XFILLER_242_107 VDD VSS VDD VSS gf180mcu_fd_sc_mcu7t5v0__fillcap_64
XFILLER_63_562 VDD VSS VDD VSS gf180mcu_fd_sc_mcu7t5v0__fillcap_64
XFILLER_51_702 VDD VSS VDD VSS gf180mcu_fd_sc_mcu7t5v0__fillcap_64
XFILLER_91_882 VDD VSS VDD VSS gf180mcu_fd_sc_mcu7t5v0__fillcap_8
XFILLER_224_877 VDD VSS VDD VSS gf180mcu_fd_sc_mcu7t5v0__fillcap_8
XFILLER_90_381 VDD VSS VDD VSS gf180mcu_fd_sc_mcu7t5v0__fillcap_4
XFILLER_251_696 VDD VSS VDD VSS gf180mcu_fd_sc_mcu7t5v0__fillcap_4
X_3965_ VDD _3965_/Q _3965_/CLK VSS _3965_/D VDD VSS gf180mcu_fd_sc_mcu7t5v0__dffq_1
XFILLER_204_590 VDD VSS VDD VSS gf180mcu_fd_sc_mcu7t5v0__fillcap_4
XFILLER_195_206 VDD VSS VDD VSS gf180mcu_fd_sc_mcu7t5v0__fillcap_4
X_3896_ VDD _3896_/Q _3937_/CLK VSS _3896_/D VDD VSS gf180mcu_fd_sc_mcu7t5v0__dffq_1
X_2916_ VDD _2916_/B _2919_/S _4309_/D _3244_/A1 VSS VDD VSS gf180mcu_fd_sc_mcu7t5v0__oai21_1
XFILLER_195_239 VDD VSS VDD VSS gf180mcu_fd_sc_mcu7t5v0__fillcap_32
X_2847_ _4001_/Q VSS VDD _3985_/Q _3993_/Q _3185_/S _3977_/Q _3187_/C _2847_/Z VDD
+ VSS gf180mcu_fd_sc_mcu7t5v0__mux4_1
XFILLER_31_492 VDD VSS VDD VSS gf180mcu_fd_sc_mcu7t5v0__fillcap_64
XFILLER_136_317 VDD VSS VDD VSS gf180mcu_fd_sc_mcu7t5v0__fillcap_32
X_2778_ VDD _2778_/B _2304_/Z _2779_/B2 _2883_/C VSS VDD VSS gf180mcu_fd_sc_mcu7t5v0__oai21_1
X_4517_ VSS _4518_/CLK VDD _4517_/D _4518_/D wire207/Z VDD VSS gf180mcu_fd_sc_mcu7t5v0__dffsnq_1
XFILLER_117_597 VDD VSS VDD VSS gf180mcu_fd_sc_mcu7t5v0__fillcap_32
XFILLER_117_586 VDD VSS VDD VSS gf180mcu_fd_sc_mcu7t5v0__fillcap_4
XFILLER_105_715 VDD VSS VDD VSS gf180mcu_fd_sc_mcu7t5v0__fillcap_16
XFILLER_160_865 VDD VSS VDD VSS gf180mcu_fd_sc_mcu7t5v0__fillcap_8
X_4448_ _4448_/D _4448_/Q _4527_/RN VSS _4448_/CLK VDD VDD VSS gf180mcu_fd_sc_mcu7t5v0__dffrnq_1
XFILLER_104_247 VDD VSS VDD VSS gf180mcu_fd_sc_mcu7t5v0__fillcap_4
XFILLER_144_37 VDD VSS VDD VSS gf180mcu_fd_sc_mcu7t5v0__fillcap_64
X_4379_ _4379_/D _4379_/Q wire193/I VSS _4441_/CLK VDD VDD VSS gf180mcu_fd_sc_mcu7t5v0__dffrnq_1
XFILLER_100_442 VDD VSS VDD VSS gf180mcu_fd_sc_mcu7t5v0__fillcap_8
XFILLER_85_142 VDD VSS VDD VSS gf180mcu_fd_sc_mcu7t5v0__fillcap_64
XFILLER_246_457 VDD VSS VDD VSS gf180mcu_fd_sc_mcu7t5v0__fillcap_64
XFILLER_261_416 VDD VSS VDD VSS gf180mcu_fd_sc_mcu7t5v0__fillcap_4
XFILLER_214_310 VDD VSS VDD VSS gf180mcu_fd_sc_mcu7t5v0__fillcap_4
XFILLER_41_212 VDD VSS VDD VSS gf180mcu_fd_sc_mcu7t5v0__fillcap_64
XFILLER_214_387 VDD VSS VDD VSS gf180mcu_fd_sc_mcu7t5v0__fillcap_64
XFILLER_169_34 VDD VSS VDD VSS gf180mcu_fd_sc_mcu7t5v0__fillcap_8
XFILLER_167_431 VDD VSS VDD VSS gf180mcu_fd_sc_mcu7t5v0__fillcap_8
XFILLER_128_807 VDD VSS VDD VSS gf180mcu_fd_sc_mcu7t5v0__fillcap_64
XFILLER_167_486 VDD VSS VDD VSS gf180mcu_fd_sc_mcu7t5v0__fillcap_4
XFILLER_155_648 VDD VSS VDD VSS gf180mcu_fd_sc_mcu7t5v0__fillcap_4
XFILLER_211_2 VDD VSS VDD VSS gf180mcu_fd_sc_mcu7t5v0__fillcap_64
XFILLER_127_339 VDD VSS VDD VSS gf180mcu_fd_sc_mcu7t5v0__fillcap_8
XFILLER_185_66 VDD VSS VDD VSS gf180mcu_fd_sc_mcu7t5v0__fillcap_4
XFILLER_108_597 VDD VSS VDD VSS gf180mcu_fd_sc_mcu7t5v0__fillcap_4
XFILLER_1_352 VDD VSS VDD VSS gf180mcu_fd_sc_mcu7t5v0__fillcap_64
XFILLER_89_492 VDD VSS VDD VSS gf180mcu_fd_sc_mcu7t5v0__fillcap_16
XFILLER_77_632 VDD VSS VDD VSS gf180mcu_fd_sc_mcu7t5v0__fillcap_64
XFILLER_209_104 VDD VSS VDD VSS gf180mcu_fd_sc_mcu7t5v0__fillcap_8
XFILLER_265_766 VDD VSS VDD VSS gf180mcu_fd_sc_mcu7t5v0__fillcap_4
XFILLER_224_107 VDD VSS VDD VSS gf180mcu_fd_sc_mcu7t5v0__fillcap_64
XFILLER_217_192 VDD VSS VDD VSS gf180mcu_fd_sc_mcu7t5v0__fillcap_4
XFILLER_45_562 VDD VSS VDD VSS gf180mcu_fd_sc_mcu7t5v0__fillcap_64
XFILLER_33_702 VDD VSS VDD VSS gf180mcu_fd_sc_mcu7t5v0__fillcap_64
XFILLER_233_663 VDD VSS VDD VSS gf180mcu_fd_sc_mcu7t5v0__fillcap_8
XFILLER_206_877 VDD VSS VDD VSS gf180mcu_fd_sc_mcu7t5v0__fillcap_8
XFILLER_205_343 VDD VSS VDD VSS gf180mcu_fd_sc_mcu7t5v0__fillcap_4
XFILLER_72_381 VDD VSS VDD VSS gf180mcu_fd_sc_mcu7t5v0__fillcap_4
XFILLER_60_521 VDD VSS VDD VSS gf180mcu_fd_sc_mcu7t5v0__fillcap_4
XFILLER_221_836 VDD VSS VDD VSS gf180mcu_fd_sc_mcu7t5v0__fillcap_4
XFILLER_205_376 VDD VSS VDD VSS gf180mcu_fd_sc_mcu7t5v0__fillcap_4
X_3750_ _3758_/S VDD VSS _3923_/D wire178/Z _3923_/Q VDD VSS gf180mcu_fd_sc_mcu7t5v0__mux2_2
XFILLER_158_442 VDD VSS VDD VSS gf180mcu_fd_sc_mcu7t5v0__fillcap_8
XFILLER_186_773 VDD VSS VDD VSS gf180mcu_fd_sc_mcu7t5v0__fillcap_32
XFILLER_192_209 VDD VSS VDD VSS gf180mcu_fd_sc_mcu7t5v0__fillcap_16
X_2701_ VDD _2701_/B _2728_/S _4245_/D _2701_/A1 VSS VDD VSS gf180mcu_fd_sc_mcu7t5v0__oai21_1
XFILLER_13_492 VDD VSS VDD VSS gf180mcu_fd_sc_mcu7t5v0__fillcap_64
XFILLER_118_317 VDD VSS VDD VSS gf180mcu_fd_sc_mcu7t5v0__fillcap_16
X_3681_ _3681_/A3 VDD VSS _4498_/D _3681_/A1 _3681_/A2 VDD VSS gf180mcu_fd_sc_mcu7t5v0__nand3_1
X_2632_ VDD VSS _2633_/A3 _4215_/Q _2632_/A2 VDD VSS gf180mcu_fd_sc_mcu7t5v0__nor2_1
X_2563_ wire29/Z VDD VSS _4186_/D _4460_/Q _4186_/Q VDD VSS gf180mcu_fd_sc_mcu7t5v0__mux2_2
XFILLER_57_2 VDD VSS VDD VSS gf180mcu_fd_sc_mcu7t5v0__fillcap_64
XFILLER_142_832 VDD VSS VDD VSS gf180mcu_fd_sc_mcu7t5v0__fillcap_16
X_4302_ _4302_/D _4302_/Q wire199/Z VSS _4354_/CLK VDD VDD VSS gf180mcu_fd_sc_mcu7t5v0__dffrnq_1
X_4233_ _4233_/D _4233_/Q _4534_/RN VSS _4531_/CLK VDD VDD VSS gf180mcu_fd_sc_mcu7t5v0__dffrnq_1
XFILLER_142_865 VDD VSS VDD VSS gf180mcu_fd_sc_mcu7t5v0__fillcap_8
X_2494_ _2500_/S VDD VSS _4115_/D wire164/Z _4115_/Q VDD VSS gf180mcu_fd_sc_mcu7t5v0__mux2_2
X_4164_ _4164_/D _4164_/Q _4527_/RN VSS _4528_/CLK VDD VDD VSS gf180mcu_fd_sc_mcu7t5v0__dffrnq_1
XFILLER_67_142 VDD VSS VDD VSS gf180mcu_fd_sc_mcu7t5v0__fillcap_64
X_3115_ VDD VSS _3116_/B _3176_/S _3901_/Q VDD VSS gf180mcu_fd_sc_mcu7t5v0__nor2_1
XFILLER_228_457 VDD VSS VDD VSS gf180mcu_fd_sc_mcu7t5v0__fillcap_8
X_4095_ VDD _4095_/Q _4532_/CLK VSS _4095_/D VDD VSS gf180mcu_fd_sc_mcu7t5v0__dffq_1
XFILLER_110_773 VDD VSS VDD VSS gf180mcu_fd_sc_mcu7t5v0__fillcap_32
XFILLER_82_101 VDD VSS VDD VSS gf180mcu_fd_sc_mcu7t5v0__fillcap_4
X_3046_ VDD VSS _3048_/A2 _4524_/D _3064_/A2 VDD VSS gf180mcu_fd_sc_mcu7t5v0__nand2_1
XFILLER_243_416 VDD VSS VDD VSS gf180mcu_fd_sc_mcu7t5v0__fillcap_4
XFILLER_255_276 VDD VSS VDD VSS gf180mcu_fd_sc_mcu7t5v0__fillcap_4
XFILLER_64_871 VDD VSS VDD VSS gf180mcu_fd_sc_mcu7t5v0__fillcap_4
XFILLER_23_212 VDD VSS VDD VSS gf180mcu_fd_sc_mcu7t5v0__fillcap_64
Xclkbuf_leaf_53_clk_i _4554_/CLK VSS VDD clkload5/I VDD VSS gf180mcu_fd_sc_mcu7t5v0__clkbuf_2
XFILLER_211_346 VDD VSS VDD VSS gf180mcu_fd_sc_mcu7t5v0__fillcap_4
X_3948_ VDD _3948_/Q _3967_/CLK VSS _3948_/D VDD VSS gf180mcu_fd_sc_mcu7t5v0__dffq_1
X_3879_ VDD _3879_/Q _3937_/CLK VSS _3879_/D VDD VSS gf180mcu_fd_sc_mcu7t5v0__dffq_1
XFILLER_149_486 VDD VSS VDD VSS gf180mcu_fd_sc_mcu7t5v0__fillcap_4
XFILLER_149_475 VDD VSS VDD VSS gf180mcu_fd_sc_mcu7t5v0__fillcap_4
XFILLER_137_626 VDD VSS VDD VSS gf180mcu_fd_sc_mcu7t5v0__fillcap_4
XFILLER_137_659 VDD VSS VDD VSS gf180mcu_fd_sc_mcu7t5v0__fillcap_32
XFILLER_191_220 VDD VSS VDD VSS gf180mcu_fd_sc_mcu7t5v0__fillcap_4
XFILLER_164_489 VDD VSS VDD VSS gf180mcu_fd_sc_mcu7t5v0__fillcap_8
XFILLER_152_629 VDD VSS VDD VSS gf180mcu_fd_sc_mcu7t5v0__fillcap_16
Xclkbuf_leaf_68_clk_i _4033_/CLK VSS VDD clkbuf_3_2__f_clk_i/Z VDD VSS gf180mcu_fd_sc_mcu7t5v0__clkbuf_2
XFILLER_155_47 VDD VSS VDD VSS gf180mcu_fd_sc_mcu7t5v0__fillcap_16
XFILLER_105_534 VDD VSS VDD VSS gf180mcu_fd_sc_mcu7t5v0__fillcap_4
XFILLER_59_632 VDD VSS VDD VSS gf180mcu_fd_sc_mcu7t5v0__fillcap_64
XFILLER_86_451 VDD VSS VDD VSS gf180mcu_fd_sc_mcu7t5v0__fillcap_4
XFILLER_247_766 VDD VSS VDD VSS gf180mcu_fd_sc_mcu7t5v0__fillcap_4
XFILLER_101_795 VDD VSS VDD VSS gf180mcu_fd_sc_mcu7t5v0__fillcap_32
XFILLER_27_562 VDD VSS VDD VSS gf180mcu_fd_sc_mcu7t5v0__fillcap_64
XFILLER_15_702 VDD VSS VDD VSS gf180mcu_fd_sc_mcu7t5v0__fillcap_64
XFILLER_104_95 VDD VSS VDD VSS gf180mcu_fd_sc_mcu7t5v0__fillcap_8
XFILLER_259_2 VDD VSS VDD VSS gf180mcu_fd_sc_mcu7t5v0__fillcap_64
XFILLER_161_2 VDD VSS VDD VSS gf180mcu_fd_sc_mcu7t5v0__fillcap_32
XFILLER_42_521 VDD VSS VDD VSS gf180mcu_fd_sc_mcu7t5v0__fillcap_4
XFILLER_54_381 VDD VSS VDD VSS gf180mcu_fd_sc_mcu7t5v0__fillcap_4
XFILLER_70_885 VDD VSS VDD VSS gf180mcu_fd_sc_mcu7t5v0__fillcap_4
XFILLER_10_451 VDD VSS VDD VSS gf180mcu_fd_sc_mcu7t5v0__fillcap_4
XFILLER_196_87 VDD VSS VDD VSS gf180mcu_fd_sc_mcu7t5v0__fillcap_16
XFILLER_127_136 VDD VSS VDD VSS gf180mcu_fd_sc_mcu7t5v0__fillcap_4
XFILLER_128_659 VDD VSS VDD VSS gf180mcu_fd_sc_mcu7t5v0__fillcap_4
XFILLER_155_478 VDD VSS VDD VSS gf180mcu_fd_sc_mcu7t5v0__fillcap_4
XFILLER_170_415 VDD VSS VDD VSS gf180mcu_fd_sc_mcu7t5v0__fillcap_4
XFILLER_129_81 VDD VSS VDD VSS gf180mcu_fd_sc_mcu7t5v0__fillcap_8
XFILLER_151_684 VDD VSS VDD VSS gf180mcu_fd_sc_mcu7t5v0__fillcap_4
XFILLER_145_80 VDD VSS VDD VSS gf180mcu_fd_sc_mcu7t5v0__fillcap_4
XFILLER_2_661 VDD VSS VDD VSS gf180mcu_fd_sc_mcu7t5v0__fillcap_4
XFILLER_111_526 VDD VSS VDD VSS gf180mcu_fd_sc_mcu7t5v0__fillcap_32
XFILLER_64_101 VDD VSS VDD VSS gf180mcu_fd_sc_mcu7t5v0__fillcap_4
XFILLER_49_142 VDD VSS VDD VSS gf180mcu_fd_sc_mcu7t5v0__fillcap_64
XFILLER_237_276 VDD VSS VDD VSS gf180mcu_fd_sc_mcu7t5v0__fillcap_4
XFILLER_225_416 VDD VSS VDD VSS gf180mcu_fd_sc_mcu7t5v0__fillcap_4
XFILLER_46_871 VDD VSS VDD VSS gf180mcu_fd_sc_mcu7t5v0__fillcap_4
X_3802_ wire16/I VDD VSS _3961_/D _4296_/Q _3961_/Q VDD VSS gf180mcu_fd_sc_mcu7t5v0__mux2_2
XFILLER_61_874 VDD VSS VDD VSS gf180mcu_fd_sc_mcu7t5v0__fillcap_16
X_1994_ VDD VSS _4011_/Q _3471_/A2 VDD VSS gf180mcu_fd_sc_mcu7t5v0__clkinv_1
X_3733_ _3738_/S VDD VSS _3908_/D wire177/Z _3908_/Q VDD VSS gf180mcu_fd_sc_mcu7t5v0__mux2_2
XFILLER_119_626 VDD VSS VDD VSS gf180mcu_fd_sc_mcu7t5v0__fillcap_4
X_3664_ _3679_/A2 _4185_/Q VDD VSS _3665_/I _4491_/Q _3682_/A2 VDD VSS gf180mcu_fd_sc_mcu7t5v0__aoi22_1
XFILLER_9_282 VDD VSS VDD VSS gf180mcu_fd_sc_mcu7t5v0__fillcap_64
X_2615_ VDD VSS _2618_/A2 _2623_/A1 _2623_/A3 VDD VSS gf180mcu_fd_sc_mcu7t5v0__nor2_1
Xclkload52 VSS clkload52/Z _4536_/CLK VDD VDD VSS gf180mcu_fd_sc_mcu7t5v0__clkbuf_1
Xclkload41 VDD VSS _4580_/CLK clkload41/ZN VDD VSS gf180mcu_fd_sc_mcu7t5v0__clkinv_1
Xclkload30 VSS clkload30/Z _4058_/CLK VDD VDD VSS gf180mcu_fd_sc_mcu7t5v0__clkbuf_1
Xclkload96 VSS clkload96/ZN _3965_/CLK VDD VDD VSS gf180mcu_fd_sc_mcu7t5v0__inv_4
Xclkload85 VSS clkload85/Z _4369_/CLK VDD VDD VSS gf180mcu_fd_sc_mcu7t5v0__clkbuf_1
Xclkload74 VSS clkload74/Z _4562_/CLK VDD VDD VSS gf180mcu_fd_sc_mcu7t5v0__clkbuf_1
Xclkload63 VSS clkload63/Z _4330_/CLK VDD VDD VSS gf180mcu_fd_sc_mcu7t5v0__clkbuf_1
X_3595_ _4129_/Q VSS VDD _4113_/Q _4121_/Q wire88/Z _4105_/Q wire83/Z _3595_/Z VDD
+ VSS gf180mcu_fd_sc_mcu7t5v0__mux4_1
X_2546_ _2546_/S VDD VSS _4169_/D wire121/Z _4169_/Q VDD VSS gf180mcu_fd_sc_mcu7t5v0__mux2_2
XFILLER_141_150 VDD VSS VDD VSS gf180mcu_fd_sc_mcu7t5v0__fillcap_4
X_2477_ _2482_/S VDD VSS _4100_/D _4100_/Q wire161/Z VDD VSS gf180mcu_fd_sc_mcu7t5v0__mux2_2
X_4216_ _4216_/D _4216_/Q wire199/Z VSS _4521_/CLK VDD VDD VSS gf180mcu_fd_sc_mcu7t5v0__dffrnq_1
X_4147_ _4147_/D _4147_/Q _4534_/RN VSS _4269_/CLK VDD VDD VSS gf180mcu_fd_sc_mcu7t5v0__dffrnq_1
XFILLER_205_72 VDD VSS VDD VSS gf180mcu_fd_sc_mcu7t5v0__fillcap_16
XFILLER_68_451 VDD VSS VDD VSS gf180mcu_fd_sc_mcu7t5v0__fillcap_4
XFILLER_18_37 VDD VSS VDD VSS gf180mcu_fd_sc_mcu7t5v0__fillcap_64
X_4078_ VDD _4078_/Q _4081_/CLK VSS _4078_/D VDD VSS gf180mcu_fd_sc_mcu7t5v0__dffq_1
X_3029_ VDD _3038_/B _3038_/C _3029_/A1 _3029_/A2 VSS _3029_/A3 VDD VSS gf180mcu_fd_sc_mcu7t5v0__oai31_1
XFILLER_24_521 VDD VSS VDD VSS gf180mcu_fd_sc_mcu7t5v0__fillcap_4
XFILLER_36_381 VDD VSS VDD VSS gf180mcu_fd_sc_mcu7t5v0__fillcap_4
XFILLER_169_526 VDD VSS VDD VSS gf180mcu_fd_sc_mcu7t5v0__fillcap_16
Xspi_opentarget_i3c_top_218 irq_o_IE VDD VSS VDD VSS gf180mcu_fd_sc_mcu7t5v0__tiel
Xspi_opentarget_i3c_top_229 sda_pad_PD VDD VSS VDD VSS gf180mcu_fd_sc_mcu7t5v0__tiel
XFILLER_52_885 VDD VSS VDD VSS gf180mcu_fd_sc_mcu7t5v0__fillcap_4
Xwire117 wire117/Z VSS VDD _4445_/Q VDD VSS gf180mcu_fd_sc_mcu7t5v0__clkbuf_2
Xwire128 VSS wire128/Z _4440_/Q VDD VDD VSS gf180mcu_fd_sc_mcu7t5v0__clkbuf_1
Xclkload2 VDD VSS clkload2/I clkload2/ZN VDD VSS gf180mcu_fd_sc_mcu7t5v0__clkinv_2
XFILLER_164_253 VDD VSS VDD VSS gf180mcu_fd_sc_mcu7t5v0__fillcap_4
XFILLER_109_158 VDD VSS VDD VSS gf180mcu_fd_sc_mcu7t5v0__fillcap_4
XFILLER_124_139 VDD VSS VDD VSS gf180mcu_fd_sc_mcu7t5v0__fillcap_4
XFILLER_105_342 VDD VSS VDD VSS gf180mcu_fd_sc_mcu7t5v0__fillcap_8
XFILLER_121_802 VDD VSS VDD VSS gf180mcu_fd_sc_mcu7t5v0__fillcap_32
XFILLER_59_66 VDD VSS VDD VSS gf180mcu_fd_sc_mcu7t5v0__fillcap_4
XFILLER_94_719 VDD VSS VDD VSS gf180mcu_fd_sc_mcu7t5v0__fillcap_16
XFILLER_115_72 VDD VSS VDD VSS gf180mcu_fd_sc_mcu7t5v0__fillcap_32
XFILLER_219_276 VDD VSS VDD VSS gf180mcu_fd_sc_mcu7t5v0__fillcap_4
XFILLER_46_101 VDD VSS VDD VSS gf180mcu_fd_sc_mcu7t5v0__fillcap_4
XFILLER_207_438 VDD VSS VDD VSS gf180mcu_fd_sc_mcu7t5v0__fillcap_8
XFILLER_28_871 VDD VSS VDD VSS gf180mcu_fd_sc_mcu7t5v0__fillcap_4
XFILLER_199_150 VDD VSS VDD VSS gf180mcu_fd_sc_mcu7t5v0__fillcap_4
XFILLER_187_334 VDD VSS VDD VSS gf180mcu_fd_sc_mcu7t5v0__fillcap_16
XFILLER_43_874 VDD VSS VDD VSS gf180mcu_fd_sc_mcu7t5v0__fillcap_16
XFILLER_168_581 VDD VSS VDD VSS gf180mcu_fd_sc_mcu7t5v0__fillcap_8
XFILLER_6_241 VDD VSS VDD VSS gf180mcu_fd_sc_mcu7t5v0__fillcap_4
XFILLER_171_757 VDD VSS VDD VSS gf180mcu_fd_sc_mcu7t5v0__fillcap_8
X_2400_ _2403_/S VDD VSS _4038_/D _4038_/Q _2506_/I0 VDD VSS gf180mcu_fd_sc_mcu7t5v0__mux2_2
X_3380_ wire56/Z VDD VSS _4427_/D _4387_/Q _4427_/Q VDD VSS gf180mcu_fd_sc_mcu7t5v0__mux2_2
X_2331_ _2926_/A3 _2926_/A4 VDD VSS _2331_/Z _4332_/Q _2868_/A1 VDD VSS gf180mcu_fd_sc_mcu7t5v0__or4_1
XFILLER_151_492 VDD VSS VDD VSS gf180mcu_fd_sc_mcu7t5v0__fillcap_8
X_2262_ VDD VSS _2263_/A3 _4598_/Q _4589_/D VDD VSS gf180mcu_fd_sc_mcu7t5v0__xnor2_1
X_4001_ VDD _4001_/Q _4001_/CLK VSS _4001_/D VDD VSS gf180mcu_fd_sc_mcu7t5v0__dffq_1
XFILLER_242_37 VDD VSS VDD VSS gf180mcu_fd_sc_mcu7t5v0__fillcap_64
XFILLER_242_26 VDD VSS VDD VSS gf180mcu_fd_sc_mcu7t5v0__fillcap_8
X_2193_ VDD _2205_/B _2193_/A2 _2194_/I _2169_/Z VSS VDD VSS gf180mcu_fd_sc_mcu7t5v0__oai21_1
XFILLER_1_40 VDD VSS VDD VSS gf180mcu_fd_sc_mcu7t5v0__fillcap_16
XFILLER_93_752 VDD VSS VDD VSS gf180mcu_fd_sc_mcu7t5v0__fillcap_16
XFILLER_80_457 VDD VSS VDD VSS gf180mcu_fd_sc_mcu7t5v0__fillcap_64
XFILLER_18_381 VDD VSS VDD VSS gf180mcu_fd_sc_mcu7t5v0__fillcap_4
XFILLER_34_885 VDD VSS VDD VSS gf180mcu_fd_sc_mcu7t5v0__fillcap_4
X_3716_ VDD VSS _3717_/B _3766_/I0 _3718_/S VDD VSS gf180mcu_fd_sc_mcu7t5v0__nand2_1
X_1977_ VDD VSS _4525_/Q _3270_/A2 VDD VSS gf180mcu_fd_sc_mcu7t5v0__clkinv_1
XFILLER_147_743 VDD VSS VDD VSS gf180mcu_fd_sc_mcu7t5v0__fillcap_8
XFILLER_146_220 VDD VSS VDD VSS gf180mcu_fd_sc_mcu7t5v0__fillcap_16
XFILLER_134_448 VDD VSS VDD VSS gf180mcu_fd_sc_mcu7t5v0__fillcap_4
X_3647_ VDD VSS _3647_/I _4484_/D VDD VSS gf180mcu_fd_sc_mcu7t5v0__clkinv_1
XFILLER_106_128 VDD VSS VDD VSS gf180mcu_fd_sc_mcu7t5v0__fillcap_16
X_3578_ _4591_/Q VDD VSS _3578_/Z _4032_/Q _4024_/Q VDD VSS gf180mcu_fd_sc_mcu7t5v0__mux2_2
X_2529_ _2535_/S VDD VSS _4155_/D _4155_/Q wire125/I VDD VSS gf180mcu_fd_sc_mcu7t5v0__mux2_2
XFILLER_152_37 VDD VSS VDD VSS gf180mcu_fd_sc_mcu7t5v0__fillcap_32
XFILLER_28_101 VDD VSS VDD VSS gf180mcu_fd_sc_mcu7t5v0__fillcap_4
XFILLER_217_747 VDD VSS VDD VSS gf180mcu_fd_sc_mcu7t5v0__fillcap_8
XFILLER_197_632 VDD VSS VDD VSS gf180mcu_fd_sc_mcu7t5v0__fillcap_8
XFILLER_25_874 VDD VSS VDD VSS gf180mcu_fd_sc_mcu7t5v0__fillcap_16
XFILLER_40_877 VDD VSS VDD VSS gf180mcu_fd_sc_mcu7t5v0__fillcap_8
Xclkbuf_3_6__f_clk_i VDD VSS clkload5/I clkbuf_0_clk_i/Z VDD VSS gf180mcu_fd_sc_mcu7t5v0__clkbuf_16
XFILLER_124_2 VDD VSS VDD VSS gf180mcu_fd_sc_mcu7t5v0__fillcap_32
XFILLER_138_776 VDD VSS VDD VSS gf180mcu_fd_sc_mcu7t5v0__fillcap_16
XFILLER_153_713 VDD VSS VDD VSS gf180mcu_fd_sc_mcu7t5v0__fillcap_32
XFILLER_193_88 VDD VSS VDD VSS gf180mcu_fd_sc_mcu7t5v0__fillcap_4
XFILLER_133_492 VDD VSS VDD VSS gf180mcu_fd_sc_mcu7t5v0__fillcap_4
XFILLER_121_632 VDD VSS VDD VSS gf180mcu_fd_sc_mcu7t5v0__fillcap_16
XFILLER_94_527 VDD VSS VDD VSS gf180mcu_fd_sc_mcu7t5v0__fillcap_16
XFILLER_263_842 VDD VSS VDD VSS gf180mcu_fd_sc_mcu7t5v0__fillcap_32
XFILLER_62_457 VDD VSS VDD VSS gf180mcu_fd_sc_mcu7t5v0__fillcap_64
XFILLER_203_441 VDD VSS VDD VSS gf180mcu_fd_sc_mcu7t5v0__fillcap_32
XFILLER_16_885 VDD VSS VDD VSS gf180mcu_fd_sc_mcu7t5v0__fillcap_4
XFILLER_231_772 VDD VSS VDD VSS gf180mcu_fd_sc_mcu7t5v0__fillcap_8
XFILLER_187_142 VDD VSS VDD VSS gf180mcu_fd_sc_mcu7t5v0__fillcap_64
X_2880_ VDD _2880_/B _2934_/A2 _2885_/B1 _4370_/Q VSS VDD VSS gf180mcu_fd_sc_mcu7t5v0__oai21_1
XFILLER_30_387 VDD VSS VDD VSS gf180mcu_fd_sc_mcu7t5v0__fillcap_64
X_4550_ _4550_/D _4575_/D _4616_/RN VSS _4615_/CLK VDD VDD VSS gf180mcu_fd_sc_mcu7t5v0__dffrnq_1
XFILLER_143_212 VDD VSS VDD VSS gf180mcu_fd_sc_mcu7t5v0__fillcap_32
X_3501_ _3501_/A3 VDD VSS _3502_/A2 _3501_/A1 _3501_/A2 VDD VSS gf180mcu_fd_sc_mcu7t5v0__nand3_1
X_4481_ _4481_/D _4481_/Q wire196/I VSS clkload9/I VDD VDD VSS gf180mcu_fd_sc_mcu7t5v0__dffrnq_1
X_3432_ _3432_/B _3609_/C VDD VSS _3433_/A3 wire82/I _3429_/Z VDD VSS gf180mcu_fd_sc_mcu7t5v0__oai211_1
XFILLER_143_267 VDD VSS VDD VSS gf180mcu_fd_sc_mcu7t5v0__fillcap_4
X_3363_ wire21/Z VDD VSS _4410_/D _4402_/Q _4410_/Q VDD VSS gf180mcu_fd_sc_mcu7t5v0__mux2_2
X_2314_ VDD VSS _2318_/B1 _4524_/Q _4529_/D VDD VSS gf180mcu_fd_sc_mcu7t5v0__nand2_1
X_3294_ _3302_/A2 _4494_/Q VDD VSS _3296_/A1 _4470_/Q _2280_/I VDD VSS gf180mcu_fd_sc_mcu7t5v0__aoi22_1
XFILLER_98_877 VDD VSS VDD VSS gf180mcu_fd_sc_mcu7t5v0__fillcap_8
XFILLER_226_500 VDD VSS VDD VSS gf180mcu_fd_sc_mcu7t5v0__fillcap_16
X_2245_ VDD VSS _2245_/Z _4559_/Q _4550_/D VDD VSS gf180mcu_fd_sc_mcu7t5v0__xor2_1
XFILLER_112_698 VDD VSS VDD VSS gf180mcu_fd_sc_mcu7t5v0__fillcap_8
X_2176_ VDD VSS _2684_/A3 _4233_/Q _2673_/A1 VDD VSS gf180mcu_fd_sc_mcu7t5v0__nand2_1
XFILLER_253_352 VDD VSS VDD VSS gf180mcu_fd_sc_mcu7t5v0__fillcap_64
XFILLER_179_632 VDD VSS VDD VSS gf180mcu_fd_sc_mcu7t5v0__fillcap_64
XFILLER_40_107 VDD VSS VDD VSS gf180mcu_fd_sc_mcu7t5v0__fillcap_64
XFILLER_221_282 VDD VSS VDD VSS gf180mcu_fd_sc_mcu7t5v0__fillcap_64
XFILLER_22_877 VDD VSS VDD VSS gf180mcu_fd_sc_mcu7t5v0__fillcap_8
XFILLER_134_289 VDD VSS VDD VSS gf180mcu_fd_sc_mcu7t5v0__fillcap_16
XFILLER_190_885 VDD VSS VDD VSS gf180mcu_fd_sc_mcu7t5v0__fillcap_4
XFILLER_115_492 VDD VSS VDD VSS gf180mcu_fd_sc_mcu7t5v0__fillcap_16
XFILLER_103_632 VDD VSS VDD VSS gf180mcu_fd_sc_mcu7t5v0__fillcap_16
XFILLER_88_387 VDD VSS VDD VSS gf180mcu_fd_sc_mcu7t5v0__fillcap_64
XFILLER_76_527 VDD VSS VDD VSS gf180mcu_fd_sc_mcu7t5v0__fillcap_64
XFILLER_245_842 VDD VSS VDD VSS gf180mcu_fd_sc_mcu7t5v0__fillcap_32
XFILLER_260_801 VDD VSS VDD VSS gf180mcu_fd_sc_mcu7t5v0__fillcap_4
XFILLER_217_544 VDD VSS VDD VSS gf180mcu_fd_sc_mcu7t5v0__fillcap_16
Xclkbuf_4_4_0_host_clk_i _4605_/CLK VSS VDD clkbuf_0_host_clk_i/Z VDD VSS gf180mcu_fd_sc_mcu7t5v0__clkbuf_2
XFILLER_232_514 VDD VSS VDD VSS gf180mcu_fd_sc_mcu7t5v0__fillcap_8
XFILLER_44_457 VDD VSS VDD VSS gf180mcu_fd_sc_mcu7t5v0__fillcap_64
XFILLER_71_276 VDD VSS VDD VSS gf180mcu_fd_sc_mcu7t5v0__fillcap_4
XFILLER_213_772 VDD VSS VDD VSS gf180mcu_fd_sc_mcu7t5v0__fillcap_64
XFILLER_169_142 VDD VSS VDD VSS gf180mcu_fd_sc_mcu7t5v0__fillcap_16
XFILLER_240_591 VDD VSS VDD VSS gf180mcu_fd_sc_mcu7t5v0__fillcap_4
XFILLER_12_387 VDD VSS VDD VSS gf180mcu_fd_sc_mcu7t5v0__fillcap_64
XFILLER_125_212 VDD VSS VDD VSS gf180mcu_fd_sc_mcu7t5v0__fillcap_4
XFILLER_126_724 VDD VSS VDD VSS gf180mcu_fd_sc_mcu7t5v0__fillcap_4
XFILLER_99_619 VDD VSS VDD VSS gf180mcu_fd_sc_mcu7t5v0__fillcap_8
XFILLER_98_107 VDD VSS VDD VSS gf180mcu_fd_sc_mcu7t5v0__fillcap_32
XFILLER_4_597 VDD VSS VDD VSS gf180mcu_fd_sc_mcu7t5v0__fillcap_64
XFILLER_267_422 VDD VSS VDD VSS gf180mcu_fd_sc_mcu7t5v0__fillcap_64
XFILLER_95_836 VDD VSS VDD VSS gf180mcu_fd_sc_mcu7t5v0__fillcap_4
X_2030_ VDD VSS _4522_/D _2774_/A1 VDD VSS gf180mcu_fd_sc_mcu7t5v0__clkinv_1
XFILLER_11_6 VDD VSS VDD VSS gf180mcu_fd_sc_mcu7t5v0__fillcap_64
XFILLER_235_352 VDD VSS VDD VSS gf180mcu_fd_sc_mcu7t5v0__fillcap_64
XFILLER_250_311 VDD VSS VDD VSS gf180mcu_fd_sc_mcu7t5v0__fillcap_4
X_3981_ VDD _3981_/Q _3989_/CLK VSS _3981_/D VDD VSS gf180mcu_fd_sc_mcu7t5v0__dffq_1
XFILLER_262_171 VDD VSS VDD VSS gf180mcu_fd_sc_mcu7t5v0__fillcap_4
XFILLER_63_766 VDD VSS VDD VSS gf180mcu_fd_sc_mcu7t5v0__fillcap_4
XFILLER_22_107 VDD VSS VDD VSS gf180mcu_fd_sc_mcu7t5v0__fillcap_64
X_2932_ VSS VDD _2939_/A1 _4201_/Q _2932_/B2 _4200_/Q _4197_/Q _3244_/A1 _2935_/A1
+ VDD VSS gf180mcu_fd_sc_mcu7t5v0__aoi222_1
XFILLER_90_585 VDD VSS VDD VSS gf180mcu_fd_sc_mcu7t5v0__fillcap_8
XFILLER_203_260 VDD VSS VDD VSS gf180mcu_fd_sc_mcu7t5v0__fillcap_8
XFILLER_203_282 VDD VSS VDD VSS gf180mcu_fd_sc_mcu7t5v0__fillcap_16
X_2863_ _2863_/B VDD VSS _2864_/B1 _3236_/A1 _4349_/Q VDD VSS gf180mcu_fd_sc_mcu7t5v0__aoi21_1
XFILLER_31_696 VDD VSS VDD VSS gf180mcu_fd_sc_mcu7t5v0__fillcap_4
X_4602_ _4602_/D _4602_/Q _4613_/RN VSS _4605_/CLK VDD VDD VSS gf180mcu_fd_sc_mcu7t5v0__dffrnq_1
X_2794_ _2832_/B1 VDD VSS _2802_/B _3201_/A2 _2788_/Z VDD VSS gf180mcu_fd_sc_mcu7t5v0__nand3_1
XFILLER_117_702 VDD VSS VDD VSS gf180mcu_fd_sc_mcu7t5v0__fillcap_16
X_4533_ _4533_/D _4533_/Q wire193/Z VSS _4580_/CLK VDD VDD VSS gf180mcu_fd_sc_mcu7t5v0__dffrnq_1
XFILLER_7_72 VDD VSS VDD VSS gf180mcu_fd_sc_mcu7t5v0__fillcap_64
XFILLER_172_841 VDD VSS VDD VSS gf180mcu_fd_sc_mcu7t5v0__fillcap_8
XFILLER_172_885 VDD VSS VDD VSS gf180mcu_fd_sc_mcu7t5v0__fillcap_4
X_4464_ _4464_/D _4464_/Q wire210/Z VSS _4496_/CLK VDD VDD VSS gf180mcu_fd_sc_mcu7t5v0__dffrnq_1
X_3415_ _3425_/S VDD VSS _4458_/D _4416_/Q _4458_/Q VDD VSS gf180mcu_fd_sc_mcu7t5v0__mux2_2
X_4395_ _4395_/D _4395_/Q wire209/Z VSS _4485_/CLK VDD VDD VSS gf180mcu_fd_sc_mcu7t5v0__dffrnq_1
X_3346_ _3346_/S VDD VSS _4394_/D _4379_/Q _4394_/Q VDD VSS gf180mcu_fd_sc_mcu7t5v0__mux2_2
XFILLER_98_652 VDD VSS VDD VSS gf180mcu_fd_sc_mcu7t5v0__fillcap_8
XFILLER_58_527 VDD VSS VDD VSS gf180mcu_fd_sc_mcu7t5v0__fillcap_64
XFILLER_112_473 VDD VSS VDD VSS gf180mcu_fd_sc_mcu7t5v0__fillcap_8
XFILLER_86_858 VDD VSS VDD VSS gf180mcu_fd_sc_mcu7t5v0__fillcap_16
XFILLER_227_831 VDD VSS VDD VSS gf180mcu_fd_sc_mcu7t5v0__fillcap_8
XFILLER_85_346 VDD VSS VDD VSS gf180mcu_fd_sc_mcu7t5v0__fillcap_4
X_3277_ _4380_/Q VDD VSS _3285_/A1 _4500_/Q _3302_/A2 VDD VSS gf180mcu_fd_sc_mcu7t5v0__aoi21_1
XFILLER_227_842 VDD VSS VDD VSS gf180mcu_fd_sc_mcu7t5v0__fillcap_32
X_2228_ _2230_/A2 _4245_/Q _2232_/B1 VDD VSS _4506_/D _4322_/Q VDD VSS gf180mcu_fd_sc_mcu7t5v0__oai22_1
XFILLER_242_801 VDD VSS VDD VSS gf180mcu_fd_sc_mcu7t5v0__fillcap_4
XFILLER_254_661 VDD VSS VDD VSS gf180mcu_fd_sc_mcu7t5v0__fillcap_4
XFILLER_213_72 VDD VSS VDD VSS gf180mcu_fd_sc_mcu7t5v0__fillcap_16
X_2159_ VDD VSS _2226_/A2 _2159_/A1 _4507_/Q VDD VSS gf180mcu_fd_sc_mcu7t5v0__nand2_1
XFILLER_26_37 VDD VSS VDD VSS gf180mcu_fd_sc_mcu7t5v0__fillcap_64
XFILLER_26_457 VDD VSS VDD VSS gf180mcu_fd_sc_mcu7t5v0__fillcap_64
XFILLER_53_276 VDD VSS VDD VSS gf180mcu_fd_sc_mcu7t5v0__fillcap_4
XFILLER_41_416 VDD VSS VDD VSS gf180mcu_fd_sc_mcu7t5v0__fillcap_4
XFILLER_222_580 VDD VSS VDD VSS gf180mcu_fd_sc_mcu7t5v0__fillcap_8
XFILLER_179_484 VDD VSS VDD VSS gf180mcu_fd_sc_mcu7t5v0__fillcap_4
XFILLER_210_764 VDD VSS VDD VSS gf180mcu_fd_sc_mcu7t5v0__fillcap_8
Xmax_length43 VSS _3685_/A2 _3616_/A2 VDD VDD VSS gf180mcu_fd_sc_mcu7t5v0__buf_2
XFILLER_182_605 VDD VSS VDD VSS gf180mcu_fd_sc_mcu7t5v0__fillcap_4
XFILLER_155_819 VDD VSS VDD VSS gf180mcu_fd_sc_mcu7t5v0__fillcap_16
XFILLER_158_69 VDD VSS VDD VSS gf180mcu_fd_sc_mcu7t5v0__fillcap_16
XFILLER_139_359 VDD VSS VDD VSS gf180mcu_fd_sc_mcu7t5v0__fillcap_4
Xmax_length54 _3424_/S wire56/Z VDD VSS VDD VSS gf180mcu_fd_sc_mcu7t5v0__buf_4
XFILLER_6_807 VDD VSS VDD VSS gf180mcu_fd_sc_mcu7t5v0__fillcap_64
Xmax_length98 VSS _3143_/C _3187_/C VDD VDD VSS gf180mcu_fd_sc_mcu7t5v0__buf_2
XFILLER_107_212 VDD VSS VDD VSS gf180mcu_fd_sc_mcu7t5v0__fillcap_16
Xmax_length87 _3586_/S _4591_/Q VDD VSS VDD VSS gf180mcu_fd_sc_mcu7t5v0__buf_4
XFILLER_108_724 VDD VSS VDD VSS gf180mcu_fd_sc_mcu7t5v0__fillcap_8
XFILLER_135_554 VDD VSS VDD VSS gf180mcu_fd_sc_mcu7t5v0__fillcap_4
XFILLER_162_395 VDD VSS VDD VSS gf180mcu_fd_sc_mcu7t5v0__fillcap_4
XFILLER_123_749 VDD VSS VDD VSS gf180mcu_fd_sc_mcu7t5v0__fillcap_16
XFILLER_249_422 VDD VSS VDD VSS gf180mcu_fd_sc_mcu7t5v0__fillcap_64
XFILLER_1_556 VDD VSS VDD VSS gf180mcu_fd_sc_mcu7t5v0__fillcap_4
XFILLER_191_2 VDD VSS VDD VSS gf180mcu_fd_sc_mcu7t5v0__fillcap_64
XFILLER_67_66 VDD VSS VDD VSS gf180mcu_fd_sc_mcu7t5v0__fillcap_4
XFILLER_103_462 VDD VSS VDD VSS gf180mcu_fd_sc_mcu7t5v0__fillcap_16
XFILLER_77_836 VDD VSS VDD VSS gf180mcu_fd_sc_mcu7t5v0__fillcap_4
XFILLER_190_89 VDD VSS VDD VSS gf180mcu_fd_sc_mcu7t5v0__fillcap_16
XFILLER_217_352 VDD VSS VDD VSS gf180mcu_fd_sc_mcu7t5v0__fillcap_64
XFILLER_123_72 VDD VSS VDD VSS gf180mcu_fd_sc_mcu7t5v0__fillcap_8
XFILLER_232_311 VDD VSS VDD VSS gf180mcu_fd_sc_mcu7t5v0__fillcap_4
XFILLER_244_171 VDD VSS VDD VSS gf180mcu_fd_sc_mcu7t5v0__fillcap_4
XFILLER_45_766 VDD VSS VDD VSS gf180mcu_fd_sc_mcu7t5v0__fillcap_4
XFILLER_158_602 VDD VSS VDD VSS gf180mcu_fd_sc_mcu7t5v0__fillcap_32
XFILLER_201_742 VDD VSS VDD VSS gf180mcu_fd_sc_mcu7t5v0__fillcap_4
XFILLER_13_696 VDD VSS VDD VSS gf180mcu_fd_sc_mcu7t5v0__fillcap_4
XFILLER_200_263 VDD VSS VDD VSS gf180mcu_fd_sc_mcu7t5v0__fillcap_8
XFILLER_8_177 VDD VSS VDD VSS gf180mcu_fd_sc_mcu7t5v0__fillcap_64
XFILLER_154_885 VDD VSS VDD VSS gf180mcu_fd_sc_mcu7t5v0__fillcap_4
XFILLER_99_416 VDD VSS VDD VSS gf180mcu_fd_sc_mcu7t5v0__fillcap_4
XFILLER_141_546 VDD VSS VDD VSS gf180mcu_fd_sc_mcu7t5v0__fillcap_8
XFILLER_153_395 VDD VSS VDD VSS gf180mcu_fd_sc_mcu7t5v0__fillcap_8
X_4180_ _4180_/D _4180_/Q wire210/Z VSS _4462_/CLK VDD VDD VSS gf180mcu_fd_sc_mcu7t5v0__dffrnq_1
X_3200_ VDD _4340_/D _3200_/B _3200_/A1 _3200_/A2 VSS _3200_/A3 VDD VSS gf180mcu_fd_sc_mcu7t5v0__oai31_1
X_3131_ VDD _4335_/D _3131_/B wire13/Z _3131_/A2 VSS _3131_/A3 VDD VSS gf180mcu_fd_sc_mcu7t5v0__oai31_1
XFILLER_67_346 VDD VSS VDD VSS gf180mcu_fd_sc_mcu7t5v0__fillcap_4
XFILLER_209_842 VDD VSS VDD VSS gf180mcu_fd_sc_mcu7t5v0__fillcap_32
XFILLER_236_650 VDD VSS VDD VSS gf180mcu_fd_sc_mcu7t5v0__fillcap_8
X_3062_ _3062_/B wire71/Z VDD VSS _3063_/A3 wire97/Z _3061_/Z VDD VSS gf180mcu_fd_sc_mcu7t5v0__aoi211_1
X_2013_ VDD VSS _3956_/Q _3793_/A1 VDD VSS gf180mcu_fd_sc_mcu7t5v0__clkinv_1
XFILLER_250_37 VDD VSS VDD VSS gf180mcu_fd_sc_mcu7t5v0__fillcap_64
XFILLER_196_708 VDD VSS VDD VSS gf180mcu_fd_sc_mcu7t5v0__fillcap_16
XFILLER_23_416 VDD VSS VDD VSS gf180mcu_fd_sc_mcu7t5v0__fillcap_4
XFILLER_35_276 VDD VSS VDD VSS gf180mcu_fd_sc_mcu7t5v0__fillcap_4
X_3964_ VDD _3964_/Q _3965_/CLK VSS _3964_/D VDD VSS gf180mcu_fd_sc_mcu7t5v0__dffq_1
X_3895_ VDD _3895_/Q _3937_/CLK VSS _3895_/D VDD VSS gf180mcu_fd_sc_mcu7t5v0__dffq_1
X_2915_ VDD VSS _2916_/B _4309_/Q _2919_/S VDD VSS gf180mcu_fd_sc_mcu7t5v0__nand2_1
XFILLER_148_101 VDD VSS VDD VSS gf180mcu_fd_sc_mcu7t5v0__fillcap_4
X_2846_ _2846_/S VDD VSS _2846_/Z _3921_/Q _3913_/Q VDD VSS gf180mcu_fd_sc_mcu7t5v0__mux2_2
XFILLER_163_104 VDD VSS VDD VSS gf180mcu_fd_sc_mcu7t5v0__fillcap_16
X_2777_ VDD VSS _2985_/A2 _2883_/C _2304_/Z VDD VSS gf180mcu_fd_sc_mcu7t5v0__nor2_1
X_4516_ VSS _4518_/CLK VDD input2/Z _4517_/D wire207/Z VDD VSS gf180mcu_fd_sc_mcu7t5v0__dffsnq_1
X_4447_ _4447_/D _4447_/Q wire186/Z VSS _4478_/CLK VDD VDD VSS gf180mcu_fd_sc_mcu7t5v0__dffrnq_1
XFILLER_160_877 VDD VSS VDD VSS gf180mcu_fd_sc_mcu7t5v0__fillcap_8
XFILLER_258_241 VDD VSS VDD VSS gf180mcu_fd_sc_mcu7t5v0__fillcap_4
X_4378_ _4378_/D _4378_/Q wire193/I VSS _4400_/CLK VDD VDD VSS gf180mcu_fd_sc_mcu7t5v0__dffrnq_1
XFILLER_59_836 VDD VSS VDD VSS gf180mcu_fd_sc_mcu7t5v0__fillcap_4
X_3329_ _3329_/B VDD VSS _3333_/B1 _3329_/A1 _3318_/B VDD VSS gf180mcu_fd_sc_mcu7t5v0__aoi21_1
XFILLER_160_37 VDD VSS VDD VSS gf180mcu_fd_sc_mcu7t5v0__fillcap_16
XFILLER_199_524 VDD VSS VDD VSS gf180mcu_fd_sc_mcu7t5v0__fillcap_16
XFILLER_226_171 VDD VSS VDD VSS gf180mcu_fd_sc_mcu7t5v0__fillcap_4
XFILLER_163_6 VDD VSS VDD VSS gf180mcu_fd_sc_mcu7t5v0__fillcap_32
XFILLER_27_766 VDD VSS VDD VSS gf180mcu_fd_sc_mcu7t5v0__fillcap_4
XFILLER_182_457 VDD VSS VDD VSS gf180mcu_fd_sc_mcu7t5v0__fillcap_64
XFILLER_5_136 VDD VSS VDD VSS gf180mcu_fd_sc_mcu7t5v0__fillcap_4
XFILLER_136_885 VDD VSS VDD VSS gf180mcu_fd_sc_mcu7t5v0__fillcap_4
XFILLER_204_2 VDD VSS VDD VSS gf180mcu_fd_sc_mcu7t5v0__fillcap_32
XFILLER_150_387 VDD VSS VDD VSS gf180mcu_fd_sc_mcu7t5v0__fillcap_16
XFILLER_49_346 VDD VSS VDD VSS gf180mcu_fd_sc_mcu7t5v0__fillcap_4
XFILLER_17_276 VDD VSS VDD VSS gf180mcu_fd_sc_mcu7t5v0__fillcap_4
XFILLER_158_465 VDD VSS VDD VSS gf180mcu_fd_sc_mcu7t5v0__fillcap_4
X_2700_ VDD VSS _4244_/D _2700_/A1 _2699_/Z VDD VSS gf180mcu_fd_sc_mcu7t5v0__nor2_1
XFILLER_201_594 VDD VSS VDD VSS gf180mcu_fd_sc_mcu7t5v0__fillcap_4
X_3680_ VDD VSS _3681_/A3 _4498_/Q _3479_/C VDD VSS gf180mcu_fd_sc_mcu7t5v0__nand2_1
XFILLER_9_486 VDD VSS VDD VSS gf180mcu_fd_sc_mcu7t5v0__fillcap_4
XFILLER_161_608 VDD VSS VDD VSS gf180mcu_fd_sc_mcu7t5v0__fillcap_16
X_2631_ _2634_/A4 VDD VSS _2635_/A3 _2276_/B _2637_/A2 VDD VSS gf180mcu_fd_sc_mcu7t5v0__nor3_1
XFILLER_154_660 VDD VSS VDD VSS gf180mcu_fd_sc_mcu7t5v0__fillcap_4
X_2562_ wire29/Z VDD VSS _4185_/D _4459_/Q _4185_/Q VDD VSS gf180mcu_fd_sc_mcu7t5v0__mux2_2
X_4301_ VSS _4522_/CLK VDD _4301_/D _4522_/D _4512_/RN VDD VSS gf180mcu_fd_sc_mcu7t5v0__dffsnq_1
XFILLER_114_513 VDD VSS VDD VSS gf180mcu_fd_sc_mcu7t5v0__fillcap_4
X_4232_ _4232_/D _4232_/Q _4530_/RN VSS _4530_/CLK VDD VDD VSS gf180mcu_fd_sc_mcu7t5v0__dffrnq_1
XFILLER_142_877 VDD VSS VDD VSS gf180mcu_fd_sc_mcu7t5v0__fillcap_8
XFILLER_141_343 VDD VSS VDD VSS gf180mcu_fd_sc_mcu7t5v0__fillcap_4
X_2493_ _2500_/S VDD VSS _4114_/D wire168/Z _4114_/Q VDD VSS gf180mcu_fd_sc_mcu7t5v0__mux2_2
X_4163_ _4163_/D _4163_/Q _4527_/RN VSS _4198_/CLK VDD VDD VSS gf180mcu_fd_sc_mcu7t5v0__dffrnq_1
XFILLER_122_590 VDD VSS VDD VSS gf180mcu_fd_sc_mcu7t5v0__fillcap_4
X_3114_ _3114_/B wire94/Z VDD VSS _3126_/B1 _3117_/B _3113_/Z VDD VSS gf180mcu_fd_sc_mcu7t5v0__aoi211_1
X_4094_ VDD _4094_/Q _4096_/CLK VSS _4094_/D VDD VSS gf180mcu_fd_sc_mcu7t5v0__dffq_1
X_3045_ _3045_/B _3045_/C VDD VSS wire13/I _3004_/C _3064_/A2 VDD VSS gf180mcu_fd_sc_mcu7t5v0__oai211_1
XFILLER_208_193 VDD VSS VDD VSS gf180mcu_fd_sc_mcu7t5v0__fillcap_4
X_3947_ VDD _3947_/Q _3967_/CLK VSS _3947_/D VDD VSS gf180mcu_fd_sc_mcu7t5v0__dffq_1
X_3878_ VDD _3878_/Q _3937_/CLK VSS _3878_/D VDD VSS gf180mcu_fd_sc_mcu7t5v0__dffq_1
XFILLER_164_457 VDD VSS VDD VSS gf180mcu_fd_sc_mcu7t5v0__fillcap_32
X_2829_ _2829_/B _2829_/C VDD VSS _3045_/C _3024_/A2 _3024_/B VDD VSS gf180mcu_fd_sc_mcu7t5v0__aoi211_1
XFILLER_191_243 VDD VSS VDD VSS gf180mcu_fd_sc_mcu7t5v0__fillcap_4
XFILLER_176_295 VDD VSS VDD VSS gf180mcu_fd_sc_mcu7t5v0__fillcap_8
XFILLER_118_885 VDD VSS VDD VSS gf180mcu_fd_sc_mcu7t5v0__fillcap_4
XFILLER_132_332 VDD VSS VDD VSS gf180mcu_fd_sc_mcu7t5v0__fillcap_8
XFILLER_132_387 VDD VSS VDD VSS gf180mcu_fd_sc_mcu7t5v0__fillcap_32
XFILLER_120_527 VDD VSS VDD VSS gf180mcu_fd_sc_mcu7t5v0__fillcap_4
XFILLER_104_63 VDD VSS VDD VSS gf180mcu_fd_sc_mcu7t5v0__fillcap_32
XFILLER_262_737 VDD VSS VDD VSS gf180mcu_fd_sc_mcu7t5v0__fillcap_64
XFILLER_215_664 VDD VSS VDD VSS gf180mcu_fd_sc_mcu7t5v0__fillcap_16
XFILLER_199_332 VDD VSS VDD VSS gf180mcu_fd_sc_mcu7t5v0__fillcap_4
XFILLER_202_325 VDD VSS VDD VSS gf180mcu_fd_sc_mcu7t5v0__fillcap_16
XFILLER_154_2 VDD VSS VDD VSS gf180mcu_fd_sc_mcu7t5v0__fillcap_16
XFILLER_230_667 VDD VSS VDD VSS gf180mcu_fd_sc_mcu7t5v0__fillcap_64
XFILLER_187_549 VDD VSS VDD VSS gf180mcu_fd_sc_mcu7t5v0__fillcap_8
XFILLER_214_185 VDD VSS VDD VSS gf180mcu_fd_sc_mcu7t5v0__fillcap_4
XFILLER_128_605 VDD VSS VDD VSS gf180mcu_fd_sc_mcu7t5v0__fillcap_4
XFILLER_196_55 VDD VSS VDD VSS gf180mcu_fd_sc_mcu7t5v0__fillcap_32
XFILLER_155_446 VDD VSS VDD VSS gf180mcu_fd_sc_mcu7t5v0__fillcap_32
XFILLER_183_766 VDD VSS VDD VSS gf180mcu_fd_sc_mcu7t5v0__fillcap_4
XFILLER_183_788 VDD VSS VDD VSS gf180mcu_fd_sc_mcu7t5v0__fillcap_8
XFILLER_182_287 VDD VSS VDD VSS gf180mcu_fd_sc_mcu7t5v0__fillcap_4
XFILLER_96_238 VDD VSS VDD VSS gf180mcu_fd_sc_mcu7t5v0__fillcap_4
XFILLER_252_247 VDD VSS VDD VSS gf180mcu_fd_sc_mcu7t5v0__fillcap_64
XFILLER_206_675 VDD VSS VDD VSS gf180mcu_fd_sc_mcu7t5v0__fillcap_4
XFILLER_61_842 VDD VSS VDD VSS gf180mcu_fd_sc_mcu7t5v0__fillcap_32
X_3801_ _3801_/B VDD VSS _3960_/D _3801_/A1 wire16/Z VDD VSS gf180mcu_fd_sc_mcu7t5v0__aoi21_1
XFILLER_178_527 VDD VSS VDD VSS gf180mcu_fd_sc_mcu7t5v0__fillcap_16
XFILLER_220_177 VDD VSS VDD VSS gf180mcu_fd_sc_mcu7t5v0__fillcap_64
XFILLER_158_240 VDD VSS VDD VSS gf180mcu_fd_sc_mcu7t5v0__fillcap_4
X_1993_ VDD VSS _4043_/Q _3467_/A2 VDD VSS gf180mcu_fd_sc_mcu7t5v0__clkinv_1
X_3732_ _3738_/S VDD VSS _3907_/D wire178/Z _3907_/Q VDD VSS gf180mcu_fd_sc_mcu7t5v0__mux2_2
Xclkload20 VSS clkload20/Z _4485_/CLK VDD VDD VSS gf180mcu_fd_sc_mcu7t5v0__clkbuf_1
XFILLER_146_457 VDD VSS VDD VSS gf180mcu_fd_sc_mcu7t5v0__fillcap_16
X_3663_ _3663_/A3 VDD VSS _4490_/D _3681_/A1 _3663_/A2 VDD VSS gf180mcu_fd_sc_mcu7t5v0__nand3_1
XFILLER_174_799 VDD VSS VDD VSS gf180mcu_fd_sc_mcu7t5v0__fillcap_4
X_2614_ VDD _4210_/D _2614_/B _4210_/Q _2634_/A3 VSS _2623_/A3 VDD VSS gf180mcu_fd_sc_mcu7t5v0__oai31_1
XFILLER_173_254 VDD VSS VDD VSS gf180mcu_fd_sc_mcu7t5v0__fillcap_8
XFILLER_161_405 VDD VSS VDD VSS gf180mcu_fd_sc_mcu7t5v0__fillcap_8
Xclkload53 VSS clkload53/Z _4198_/CLK VDD VDD VSS gf180mcu_fd_sc_mcu7t5v0__clkbuf_1
Xclkload31 VSS clkload31/Z _4065_/CLK VDD VDD VSS gf180mcu_fd_sc_mcu7t5v0__clkbuf_1
Xclkload42 clkload42/Z VSS VDD _4583_/CLK VDD VSS gf180mcu_fd_sc_mcu7t5v0__clkbuf_2
X_3594_ _3594_/B1 _3594_/B2 VDD VSS _4475_/D _3594_/A1 _3619_/C VDD VSS gf180mcu_fd_sc_mcu7t5v0__aoi22_1
Xclkload86 VDD VSS _4355_/CLK clkload86/ZN VDD VSS gf180mcu_fd_sc_mcu7t5v0__clkinv_2
Xclkload75 VSS clkload75/Z _4565_/CLK VDD VDD VSS gf180mcu_fd_sc_mcu7t5v0__clkbuf_1
Xclkload64 VSS clkload64/Z _4523_/CLK VDD VDD VSS gf180mcu_fd_sc_mcu7t5v0__clkbuf_1
Xclkload97 VDD VSS _3967_/CLK clkload97/ZN VDD VSS gf180mcu_fd_sc_mcu7t5v0__clkinv_2
X_2545_ _2546_/S VDD VSS _4168_/D wire123/I _4168_/Q VDD VSS gf180mcu_fd_sc_mcu7t5v0__mux2_2
XFILLER_114_387 VDD VSS VDD VSS gf180mcu_fd_sc_mcu7t5v0__fillcap_16
XFILLER_114_365 VDD VSS VDD VSS gf180mcu_fd_sc_mcu7t5v0__fillcap_8
X_2476_ _2482_/S VDD VSS _4099_/D _4099_/Q wire164/Z VDD VSS gf180mcu_fd_sc_mcu7t5v0__mux2_2
XFILLER_102_527 VDD VSS VDD VSS gf180mcu_fd_sc_mcu7t5v0__fillcap_16
X_4215_ _4215_/D _4215_/Q wire199/Z VSS _4521_/CLK VDD VDD VSS gf180mcu_fd_sc_mcu7t5v0__dffrnq_1
X_4146_ _4146_/D _4146_/Q wire192/Z VSS _4510_/CLK VDD VDD VSS gf180mcu_fd_sc_mcu7t5v0__dffrnq_1
XFILLER_83_422 VDD VSS VDD VSS gf180mcu_fd_sc_mcu7t5v0__fillcap_64
XFILLER_95_282 VDD VSS VDD VSS gf180mcu_fd_sc_mcu7t5v0__fillcap_8
XFILLER_244_737 VDD VSS VDD VSS gf180mcu_fd_sc_mcu7t5v0__fillcap_64
XFILLER_256_597 VDD VSS VDD VSS gf180mcu_fd_sc_mcu7t5v0__fillcap_64
X_4077_ VDD _4077_/Q _4469_/CLK VSS _4077_/D VDD VSS gf180mcu_fd_sc_mcu7t5v0__dffq_1
Xclkbuf_4_9_0_host_clk_i _3967_/CLK VSS VDD clkbuf_0_host_clk_i/Z VDD VSS gf180mcu_fd_sc_mcu7t5v0__clkbuf_2
X_3028_ _3032_/A4 VDD VSS _3030_/A3 _2951_/B _3037_/A2 VDD VSS gf180mcu_fd_sc_mcu7t5v0__nand3_1
XFILLER_221_72 VDD VSS VDD VSS gf180mcu_fd_sc_mcu7t5v0__fillcap_64
XFILLER_34_37 VDD VSS VDD VSS gf180mcu_fd_sc_mcu7t5v0__fillcap_64
Xspi_opentarget_i3c_top_219 irq_o_PD VDD VSS VDD VSS gf180mcu_fd_sc_mcu7t5v0__tiel
XFILLER_51_352 VDD VSS VDD VSS gf180mcu_fd_sc_mcu7t5v0__fillcap_64
XFILLER_177_571 VDD VSS VDD VSS gf180mcu_fd_sc_mcu7t5v0__fillcap_4
Xwire129 VSS wire129/Z wire129/I VDD VDD VSS gf180mcu_fd_sc_mcu7t5v0__buf_1
Xwire118 VSS wire118/Z wire119/Z VDD VDD VSS gf180mcu_fd_sc_mcu7t5v0__buf_1
Xclkload3 clkload3/Z VSS VDD clkload3/I VDD VSS gf180mcu_fd_sc_mcu7t5v0__clkbuf_2
XFILLER_137_413 VDD VSS VDD VSS gf180mcu_fd_sc_mcu7t5v0__fillcap_4
XFILLER_164_210 VDD VSS VDD VSS gf180mcu_fd_sc_mcu7t5v0__fillcap_32
XFILLER_137_468 VDD VSS VDD VSS gf180mcu_fd_sc_mcu7t5v0__fillcap_16
XFILLER_117_192 VDD VSS VDD VSS gf180mcu_fd_sc_mcu7t5v0__fillcap_16
XFILLER_106_877 VDD VSS VDD VSS gf180mcu_fd_sc_mcu7t5v0__fillcap_8
XFILLER_266_317 VDD VSS VDD VSS gf180mcu_fd_sc_mcu7t5v0__fillcap_64
XFILLER_182_79 VDD VSS VDD VSS gf180mcu_fd_sc_mcu7t5v0__fillcap_8
XFILLER_120_357 VDD VSS VDD VSS gf180mcu_fd_sc_mcu7t5v0__fillcap_4
XFILLER_87_772 VDD VSS VDD VSS gf180mcu_fd_sc_mcu7t5v0__fillcap_64
XFILLER_75_66 VDD VSS VDD VSS gf180mcu_fd_sc_mcu7t5v0__fillcap_4
XFILLER_234_247 VDD VSS VDD VSS gf180mcu_fd_sc_mcu7t5v0__fillcap_64
XFILLER_131_72 VDD VSS VDD VSS gf180mcu_fd_sc_mcu7t5v0__fillcap_8
XFILLER_43_842 VDD VSS VDD VSS gf180mcu_fd_sc_mcu7t5v0__fillcap_32
XFILLER_188_847 VDD VSS VDD VSS gf180mcu_fd_sc_mcu7t5v0__fillcap_4
XFILLER_70_661 VDD VSS VDD VSS gf180mcu_fd_sc_mcu7t5v0__fillcap_4
XFILLER_202_177 VDD VSS VDD VSS gf180mcu_fd_sc_mcu7t5v0__fillcap_32
XFILLER_11_772 VDD VSS VDD VSS gf180mcu_fd_sc_mcu7t5v0__fillcap_64
XFILLER_183_552 VDD VSS VDD VSS gf180mcu_fd_sc_mcu7t5v0__fillcap_8
XFILLER_128_457 VDD VSS VDD VSS gf180mcu_fd_sc_mcu7t5v0__fillcap_4
XFILLER_155_298 VDD VSS VDD VSS gf180mcu_fd_sc_mcu7t5v0__fillcap_4
XFILLER_258_807 VDD VSS VDD VSS gf180mcu_fd_sc_mcu7t5v0__fillcap_64
X_2330_ _2926_/A3 _2926_/A4 VDD VSS _3035_/A2 _4332_/Q _2868_/A1 VDD VSS gf180mcu_fd_sc_mcu7t5v0__nor4_1
X_2261_ VDD VSS _2263_/A2 _4597_/Q _4588_/D VDD VSS gf180mcu_fd_sc_mcu7t5v0__xnor2_1
XFILLER_111_346 VDD VSS VDD VSS gf180mcu_fd_sc_mcu7t5v0__fillcap_4
X_4000_ VDD _4000_/Q _4001_/CLK VSS _4000_/D VDD VSS gf180mcu_fd_sc_mcu7t5v0__dffq_1
Xclkbuf_leaf_52_clk_i _4586_/CLK VSS VDD clkload5/I VDD VSS gf180mcu_fd_sc_mcu7t5v0__clkbuf_2
XFILLER_65_422 VDD VSS VDD VSS gf180mcu_fd_sc_mcu7t5v0__fillcap_64
X_2192_ VDD _2205_/B _2192_/B _4235_/Q _2677_/A1 VSS _2684_/A3 VDD VSS gf180mcu_fd_sc_mcu7t5v0__oai31_1
XFILLER_77_282 VDD VSS VDD VSS gf180mcu_fd_sc_mcu7t5v0__fillcap_64
XFILLER_226_737 VDD VSS VDD VSS gf180mcu_fd_sc_mcu7t5v0__fillcap_8
XFILLER_238_597 VDD VSS VDD VSS gf180mcu_fd_sc_mcu7t5v0__fillcap_64
XFILLER_92_241 VDD VSS VDD VSS gf180mcu_fd_sc_mcu7t5v0__fillcap_4
XFILLER_253_556 VDD VSS VDD VSS gf180mcu_fd_sc_mcu7t5v0__fillcap_4
Xclkbuf_leaf_67_clk_i _4032_/CLK VSS VDD clkload2/I VDD VSS gf180mcu_fd_sc_mcu7t5v0__clkbuf_2
XFILLER_33_352 VDD VSS VDD VSS gf180mcu_fd_sc_mcu7t5v0__fillcap_64
XFILLER_60_171 VDD VSS VDD VSS gf180mcu_fd_sc_mcu7t5v0__fillcap_4
XFILLER_221_486 VDD VSS VDD VSS gf180mcu_fd_sc_mcu7t5v0__fillcap_4
XFILLER_187_880 VDD VSS VDD VSS gf180mcu_fd_sc_mcu7t5v0__fillcap_8
XFILLER_147_711 VDD VSS VDD VSS gf180mcu_fd_sc_mcu7t5v0__fillcap_32
X_1976_ VDD VSS _4350_/Q _2863_/B VDD VSS gf180mcu_fd_sc_mcu7t5v0__clkinv_1
X_3715_ _3718_/S VDD VSS _3895_/D _3895_/Q _3765_/I0 VDD VSS gf180mcu_fd_sc_mcu7t5v0__mux2_2
XFILLER_146_298 VDD VSS VDD VSS gf180mcu_fd_sc_mcu7t5v0__fillcap_8
X_3646_ _3679_/A2 _4178_/Q VDD VSS _3647_/I _4484_/Q _3479_/C VDD VSS gf180mcu_fd_sc_mcu7t5v0__aoi22_1
XFILLER_161_235 VDD VSS VDD VSS gf180mcu_fd_sc_mcu7t5v0__fillcap_4
X_3577_ VDD VSS _3583_/A2 wire74/Z _3576_/Z VDD VSS gf180mcu_fd_sc_mcu7t5v0__nand2_1
X_2528_ _2536_/S VDD VSS _4154_/D _4154_/Q wire129/I VDD VSS gf180mcu_fd_sc_mcu7t5v0__mux2_2
XFILLER_103_836 VDD VSS VDD VSS gf180mcu_fd_sc_mcu7t5v0__fillcap_4
XFILLER_248_317 VDD VSS VDD VSS gf180mcu_fd_sc_mcu7t5v0__fillcap_64
X_2459_ _2463_/S VDD VSS _4085_/D wire160/Z _4085_/Q VDD VSS gf180mcu_fd_sc_mcu7t5v0__mux2_2
XFILLER_69_772 VDD VSS VDD VSS gf180mcu_fd_sc_mcu7t5v0__fillcap_64
X_4129_ VDD _4129_/Q _4129_/CLK VSS _4129_/D VDD VSS gf180mcu_fd_sc_mcu7t5v0__dffq_1
XFILLER_231_206 VDD VSS VDD VSS gf180mcu_fd_sc_mcu7t5v0__fillcap_4
XFILLER_25_842 VDD VSS VDD VSS gf180mcu_fd_sc_mcu7t5v0__fillcap_32
XFILLER_52_661 VDD VSS VDD VSS gf180mcu_fd_sc_mcu7t5v0__fillcap_4
XFILLER_40_801 VDD VSS VDD VSS gf180mcu_fd_sc_mcu7t5v0__fillcap_4
XFILLER_169_346 VDD VSS VDD VSS gf180mcu_fd_sc_mcu7t5v0__fillcap_4
XFILLER_101_64 VDD VSS VDD VSS gf180mcu_fd_sc_mcu7t5v0__fillcap_4
XFILLER_197_677 VDD VSS VDD VSS gf180mcu_fd_sc_mcu7t5v0__fillcap_8
XFILLER_165_541 VDD VSS VDD VSS gf180mcu_fd_sc_mcu7t5v0__fillcap_16
XFILLER_20_591 VDD VSS VDD VSS gf180mcu_fd_sc_mcu7t5v0__fillcap_4
XFILLER_137_298 VDD VSS VDD VSS gf180mcu_fd_sc_mcu7t5v0__fillcap_8
XFILLER_3_212 VDD VSS VDD VSS gf180mcu_fd_sc_mcu7t5v0__fillcap_64
XFILLER_267_626 VDD VSS VDD VSS gf180mcu_fd_sc_mcu7t5v0__fillcap_4
XFILLER_47_422 VDD VSS VDD VSS gf180mcu_fd_sc_mcu7t5v0__fillcap_64
XFILLER_59_282 VDD VSS VDD VSS gf180mcu_fd_sc_mcu7t5v0__fillcap_64
XFILLER_208_737 VDD VSS VDD VSS gf180mcu_fd_sc_mcu7t5v0__fillcap_8
XFILLER_74_241 VDD VSS VDD VSS gf180mcu_fd_sc_mcu7t5v0__fillcap_4
XFILLER_15_352 VDD VSS VDD VSS gf180mcu_fd_sc_mcu7t5v0__fillcap_64
XFILLER_30_311 VDD VSS VDD VSS gf180mcu_fd_sc_mcu7t5v0__fillcap_4
XFILLER_42_171 VDD VSS VDD VSS gf180mcu_fd_sc_mcu7t5v0__fillcap_4
X_3500_ _4165_/Q _3628_/C VDD VSS _3501_/A3 _4153_/Q _2040_/Z _3616_/A2 VDD VSS gf180mcu_fd_sc_mcu7t5v0__aoi221_1
X_4480_ _4480_/D _4480_/Q wire186/Z VSS _4500_/CLK VDD VDD VSS gf180mcu_fd_sc_mcu7t5v0__dffrnq_1
XFILLER_7_562 VDD VSS VDD VSS gf180mcu_fd_sc_mcu7t5v0__fillcap_64
X_3431_ _3431_/B wire82/I VDD VSS _3432_/B _3564_/S _3431_/A2 VDD VSS gf180mcu_fd_sc_mcu7t5v0__oai211_1
X_3362_ wire21/Z VDD VSS _4409_/D _4401_/Q _4409_/Q VDD VSS gf180mcu_fd_sc_mcu7t5v0__mux2_2
X_2313_ _2985_/C VDD VSS _4525_/D _4355_/Q _2831_/B VDD VSS gf180mcu_fd_sc_mcu7t5v0__and3_1
XFILLER_32_2 VDD VSS VDD VSS gf180mcu_fd_sc_mcu7t5v0__fillcap_32
XFILLER_257_136 VDD VSS VDD VSS gf180mcu_fd_sc_mcu7t5v0__fillcap_4
X_3293_ _3334_/A2 _4485_/Q VDD VSS _3297_/A3 _4493_/Q _3302_/A2 VDD VSS gf180mcu_fd_sc_mcu7t5v0__aoi22_1
X_2244_ VDD VSS _2244_/Z _4560_/Q _4555_/D VDD VSS gf180mcu_fd_sc_mcu7t5v0__xor2_1
XFILLER_78_591 VDD VSS VDD VSS gf180mcu_fd_sc_mcu7t5v0__fillcap_4
XFILLER_66_731 VDD VSS VDD VSS gf180mcu_fd_sc_mcu7t5v0__fillcap_4
XFILLER_100_839 VDD VSS VDD VSS gf180mcu_fd_sc_mcu7t5v0__fillcap_4
X_2175_ VDD VSS _2200_/A3 _2671_/A1 _4234_/Q VDD VSS gf180mcu_fd_sc_mcu7t5v0__nor2_1
XFILLER_214_718 VDD VSS VDD VSS gf180mcu_fd_sc_mcu7t5v0__fillcap_16
XFILLER_81_745 VDD VSS VDD VSS gf180mcu_fd_sc_mcu7t5v0__fillcap_16
XFILLER_34_661 VDD VSS VDD VSS gf180mcu_fd_sc_mcu7t5v0__fillcap_4
XFILLER_22_801 VDD VSS VDD VSS gf180mcu_fd_sc_mcu7t5v0__fillcap_4
X_1959_ VDD VSS _4233_/Q _2671_/A1 VDD VSS gf180mcu_fd_sc_mcu7t5v0__clkinv_1
XFILLER_190_831 VDD VSS VDD VSS gf180mcu_fd_sc_mcu7t5v0__fillcap_4
XFILLER_193_179 VDD VSS VDD VSS gf180mcu_fd_sc_mcu7t5v0__fillcap_16
X_3629_ VDD VSS _3630_/B2 _3629_/A1 _3629_/A2 VDD VSS gf180mcu_fd_sc_mcu7t5v0__nand2_1
XFILLER_122_419 VDD VSS VDD VSS gf180mcu_fd_sc_mcu7t5v0__fillcap_4
XFILLER_249_626 VDD VSS VDD VSS gf180mcu_fd_sc_mcu7t5v0__fillcap_4
XFILLER_88_311 VDD VSS VDD VSS gf180mcu_fd_sc_mcu7t5v0__fillcap_4
XFILLER_29_422 VDD VSS VDD VSS gf180mcu_fd_sc_mcu7t5v0__fillcap_64
XFILLER_102_165 VDD VSS VDD VSS gf180mcu_fd_sc_mcu7t5v0__fillcap_8
XFILLER_56_241 VDD VSS VDD VSS gf180mcu_fd_sc_mcu7t5v0__fillcap_4
XFILLER_112_63 VDD VSS VDD VSS gf180mcu_fd_sc_mcu7t5v0__fillcap_8
XFILLER_12_311 VDD VSS VDD VSS gf180mcu_fd_sc_mcu7t5v0__fillcap_4
XFILLER_24_171 VDD VSS VDD VSS gf180mcu_fd_sc_mcu7t5v0__fillcap_4
XFILLER_234_2 VDD VSS VDD VSS gf180mcu_fd_sc_mcu7t5v0__fillcap_32
XFILLER_200_489 VDD VSS VDD VSS gf180mcu_fd_sc_mcu7t5v0__fillcap_32
XFILLER_181_842 VDD VSS VDD VSS gf180mcu_fd_sc_mcu7t5v0__fillcap_4
XFILLER_180_330 VDD VSS VDD VSS gf180mcu_fd_sc_mcu7t5v0__fillcap_8
XFILLER_4_521 VDD VSS VDD VSS gf180mcu_fd_sc_mcu7t5v0__fillcap_4
XFILLER_239_136 VDD VSS VDD VSS gf180mcu_fd_sc_mcu7t5v0__fillcap_4
XFILLER_94_325 VDD VSS VDD VSS gf180mcu_fd_sc_mcu7t5v0__fillcap_4
XFILLER_121_485 VDD VSS VDD VSS gf180mcu_fd_sc_mcu7t5v0__fillcap_4
XFILLER_48_731 VDD VSS VDD VSS gf180mcu_fd_sc_mcu7t5v0__fillcap_4
XFILLER_208_589 VDD VSS VDD VSS gf180mcu_fd_sc_mcu7t5v0__fillcap_4
X_3980_ VDD _3980_/Q _3989_/CLK VSS _3980_/D VDD VSS gf180mcu_fd_sc_mcu7t5v0__dffq_1
XFILLER_223_526 VDD VSS VDD VSS gf180mcu_fd_sc_mcu7t5v0__fillcap_4
XFILLER_16_661 VDD VSS VDD VSS gf180mcu_fd_sc_mcu7t5v0__fillcap_4
X_2931_ _2929_/Z _2931_/A4 VDD VSS _2931_/Z _2931_/A1 _2931_/A2 VDD VSS gf180mcu_fd_sc_mcu7t5v0__or4_1
X_4601_ _4601_/D _4601_/Q _4613_/RN VSS _4606_/CLK VDD VDD VSS gf180mcu_fd_sc_mcu7t5v0__dffrnq_1
X_2862_ _2862_/B VDD VSS _2864_/A2 _3236_/A1 _4350_/Q VDD VSS gf180mcu_fd_sc_mcu7t5v0__aoi21_1
XFILLER_248_37 VDD VSS VDD VSS gf180mcu_fd_sc_mcu7t5v0__fillcap_64
X_2793_ _3040_/B VDD VSS _2886_/C _2793_/A1 _3023_/A2 VDD VSS gf180mcu_fd_sc_mcu7t5v0__or3_1
X_4532_ _4532_/D _4532_/Q _4534_/RN VSS _4532_/CLK VDD VDD VSS gf180mcu_fd_sc_mcu7t5v0__dffrnq_1
XFILLER_8_871 VDD VSS VDD VSS gf180mcu_fd_sc_mcu7t5v0__fillcap_4
XFILLER_171_341 VDD VSS VDD VSS gf180mcu_fd_sc_mcu7t5v0__fillcap_8
X_4463_ _4463_/D _4463_/Q wire212/Z VSS clkload7/I VDD VDD VSS gf180mcu_fd_sc_mcu7t5v0__dffrnq_1
XFILLER_171_352 VDD VSS VDD VSS gf180mcu_fd_sc_mcu7t5v0__fillcap_64
XFILLER_116_279 VDD VSS VDD VSS gf180mcu_fd_sc_mcu7t5v0__fillcap_16
X_3414_ wire53/Z VDD VSS _4457_/D _4415_/Q _4457_/Q VDD VSS gf180mcu_fd_sc_mcu7t5v0__mux2_2
X_4394_ _4394_/D _4394_/Q _4473_/RN VSS _4400_/CLK VDD VDD VSS gf180mcu_fd_sc_mcu7t5v0__dffrnq_1
X_3345_ _3346_/S VDD VSS _4393_/D _4378_/Q _4393_/Q VDD VSS gf180mcu_fd_sc_mcu7t5v0__mux2_2
XFILLER_86_826 VDD VSS VDD VSS gf180mcu_fd_sc_mcu7t5v0__fillcap_32
X_3276_ _4385_/Q VDD VSS _3302_/A2 _3333_/A1 _4383_/Q VDD VSS gf180mcu_fd_sc_mcu7t5v0__nor3_1
X_2227_ VDD VSS _2232_/B1 _4320_/Q _4507_/Q VDD VSS gf180mcu_fd_sc_mcu7t5v0__nand2_1
XFILLER_100_658 VDD VSS VDD VSS gf180mcu_fd_sc_mcu7t5v0__fillcap_4
XFILLER_38_241 VDD VSS VDD VSS gf180mcu_fd_sc_mcu7t5v0__fillcap_4
X_2158_ VDD VSS output7/I _2158_/A1 _2995_/A2 VDD VSS gf180mcu_fd_sc_mcu7t5v0__nor2_1
X_2089_ VDD VSS _3719_/A3 _2087_/Z _2102_/A4 VDD VSS gf180mcu_fd_sc_mcu7t5v0__nand2_1
XFILLER_198_205 VDD VSS VDD VSS gf180mcu_fd_sc_mcu7t5v0__fillcap_16
XFILLER_42_37 VDD VSS VDD VSS gf180mcu_fd_sc_mcu7t5v0__fillcap_64
Xmax_length22 wire20/I wire21/I VDD VSS VDD VSS gf180mcu_fd_sc_mcu7t5v0__buf_4
XFILLER_158_37 VDD VSS VDD VSS gf180mcu_fd_sc_mcu7t5v0__fillcap_32
Xmax_length44 _2535_/S _2536_/S VDD VSS VDD VSS gf180mcu_fd_sc_mcu7t5v0__buf_4
Xmax_length55 _3425_/S wire56/Z VDD VSS VDD VSS gf180mcu_fd_sc_mcu7t5v0__buf_4
Xmax_length99 VSS _3117_/B _3187_/C VDD VDD VSS gf180mcu_fd_sc_mcu7t5v0__buf_2
XFILLER_194_499 VDD VSS VDD VSS gf180mcu_fd_sc_mcu7t5v0__fillcap_16
XFILLER_147_360 VDD VSS VDD VSS gf180mcu_fd_sc_mcu7t5v0__fillcap_4
XFILLER_163_842 VDD VSS VDD VSS gf180mcu_fd_sc_mcu7t5v0__fillcap_8
XFILLER_190_661 VDD VSS VDD VSS gf180mcu_fd_sc_mcu7t5v0__fillcap_4
XFILLER_122_227 VDD VSS VDD VSS gf180mcu_fd_sc_mcu7t5v0__fillcap_16
XFILLER_103_430 VDD VSS VDD VSS gf180mcu_fd_sc_mcu7t5v0__fillcap_32
XFILLER_131_772 VDD VSS VDD VSS gf180mcu_fd_sc_mcu7t5v0__fillcap_8
XFILLER_92_807 VDD VSS VDD VSS gf180mcu_fd_sc_mcu7t5v0__fillcap_16
XFILLER_218_854 VDD VSS VDD VSS gf180mcu_fd_sc_mcu7t5v0__fillcap_16
XFILLER_184_2 VDD VSS VDD VSS gf180mcu_fd_sc_mcu7t5v0__fillcap_32
XFILLER_85_870 VDD VSS VDD VSS gf180mcu_fd_sc_mcu7t5v0__fillcap_16
XFILLER_233_835 VDD VSS VDD VSS gf180mcu_fd_sc_mcu7t5v0__fillcap_4
XFILLER_83_66 VDD VSS VDD VSS gf180mcu_fd_sc_mcu7t5v0__fillcap_4
XFILLER_199_66 VDD VSS VDD VSS gf180mcu_fd_sc_mcu7t5v0__fillcap_4
XFILLER_60_737 VDD VSS VDD VSS gf180mcu_fd_sc_mcu7t5v0__fillcap_64
XFILLER_72_597 VDD VSS VDD VSS gf180mcu_fd_sc_mcu7t5v0__fillcap_64
XFILLER_185_422 VDD VSS VDD VSS gf180mcu_fd_sc_mcu7t5v0__fillcap_4
XFILLER_197_282 VDD VSS VDD VSS gf180mcu_fd_sc_mcu7t5v0__fillcap_4
XFILLER_8_101 VDD VSS VDD VSS gf180mcu_fd_sc_mcu7t5v0__fillcap_4
XFILLER_201_765 VDD VSS VDD VSS gf180mcu_fd_sc_mcu7t5v0__fillcap_4
XFILLER_158_658 VDD VSS VDD VSS gf180mcu_fd_sc_mcu7t5v0__fillcap_4
XFILLER_139_850 VDD VSS VDD VSS gf180mcu_fd_sc_mcu7t5v0__fillcap_4
XFILLER_185_499 VDD VSS VDD VSS gf180mcu_fd_sc_mcu7t5v0__fillcap_32
XFILLER_157_168 VDD VSS VDD VSS gf180mcu_fd_sc_mcu7t5v0__fillcap_32
XFILLER_166_691 VDD VSS VDD VSS gf180mcu_fd_sc_mcu7t5v0__fillcap_32
XFILLER_153_330 VDD VSS VDD VSS gf180mcu_fd_sc_mcu7t5v0__fillcap_4
XFILLER_153_352 VDD VSS VDD VSS gf180mcu_fd_sc_mcu7t5v0__fillcap_8
XFILLER_113_205 VDD VSS VDD VSS gf180mcu_fd_sc_mcu7t5v0__fillcap_4
XFILLER_5_874 VDD VSS VDD VSS gf180mcu_fd_sc_mcu7t5v0__fillcap_16
X_3130_ VDD VSS _3131_/A3 _4334_/Q _3170_/B VDD VSS gf180mcu_fd_sc_mcu7t5v0__nor2_1
XFILLER_122_772 VDD VSS VDD VSS gf180mcu_fd_sc_mcu7t5v0__fillcap_8
XFILLER_209_821 VDD VSS VDD VSS gf180mcu_fd_sc_mcu7t5v0__fillcap_16
XFILLER_121_282 VDD VSS VDD VSS gf180mcu_fd_sc_mcu7t5v0__fillcap_16
X_3061_ _3122_/S VDD VSS _3061_/Z _3946_/Q _3938_/Q VDD VSS gf180mcu_fd_sc_mcu7t5v0__mux2_2
XFILLER_82_317 VDD VSS VDD VSS gf180mcu_fd_sc_mcu7t5v0__fillcap_64
XFILLER_94_177 VDD VSS VDD VSS gf180mcu_fd_sc_mcu7t5v0__fillcap_4
XFILLER_94_166 VDD VSS VDD VSS gf180mcu_fd_sc_mcu7t5v0__fillcap_8
X_2012_ VDD VSS _4225_/Q _3086_/A2 VDD VSS gf180mcu_fd_sc_mcu7t5v0__clkinv_1
XFILLER_251_632 VDD VSS VDD VSS gf180mcu_fd_sc_mcu7t5v0__fillcap_64
XFILLER_263_492 VDD VSS VDD VSS gf180mcu_fd_sc_mcu7t5v0__fillcap_64
X_3963_ VDD _3963_/Q _3965_/CLK VSS _3963_/D VDD VSS gf180mcu_fd_sc_mcu7t5v0__dffq_1
XFILLER_50_247 VDD VSS VDD VSS gf180mcu_fd_sc_mcu7t5v0__fillcap_64
X_3894_ VDD _3894_/Q _3937_/CLK VSS _3894_/D VDD VSS gf180mcu_fd_sc_mcu7t5v0__dffq_1
X_2914_ VDD _2914_/B _2919_/S _4308_/D _2942_/A1 VSS VDD VSS gf180mcu_fd_sc_mcu7t5v0__oai21_1
XFILLER_188_271 VDD VSS VDD VSS gf180mcu_fd_sc_mcu7t5v0__fillcap_4
X_2845_ _2845_/B _3158_/B VDD VSS _2853_/A1 _3157_/A1 _3929_/Q VDD VSS gf180mcu_fd_sc_mcu7t5v0__oai211_1
XFILLER_145_842 VDD VSS VDD VSS gf180mcu_fd_sc_mcu7t5v0__fillcap_8
X_4515_ VSS _4523_/CLK VDD _4515_/D _4515_/Q _4512_/RN VDD VSS gf180mcu_fd_sc_mcu7t5v0__dffsnq_1
X_2776_ VDD VSS _2778_/B _4355_/Q _2804_/A1 VDD VSS gf180mcu_fd_sc_mcu7t5v0__nand2_1
XFILLER_117_544 VDD VSS VDD VSS gf180mcu_fd_sc_mcu7t5v0__fillcap_16
XFILLER_160_801 VDD VSS VDD VSS gf180mcu_fd_sc_mcu7t5v0__fillcap_4
XFILLER_144_341 VDD VSS VDD VSS gf180mcu_fd_sc_mcu7t5v0__fillcap_4
XFILLER_160_823 VDD VSS VDD VSS gf180mcu_fd_sc_mcu7t5v0__fillcap_8
X_4446_ _4446_/D _4446_/Q _4536_/RN VSS _4446_/CLK VDD VDD VSS gf180mcu_fd_sc_mcu7t5v0__dffrnq_1
X_4377_ _4377_/D _4377_/Q wire193/I VSS _4400_/CLK VDD VDD VSS gf180mcu_fd_sc_mcu7t5v0__dffrnq_1
XFILLER_113_772 VDD VSS VDD VSS gf180mcu_fd_sc_mcu7t5v0__fillcap_8
X_3328_ VDD VSS _3330_/B _3336_/A1 _3347_/B VDD VSS gf180mcu_fd_sc_mcu7t5v0__nand2_1
XFILLER_74_807 VDD VSS VDD VSS gf180mcu_fd_sc_mcu7t5v0__fillcap_64
XFILLER_86_667 VDD VSS VDD VSS gf180mcu_fd_sc_mcu7t5v0__fillcap_64
X_3259_ VDD VSS _3259_/I _4364_/D VDD VSS gf180mcu_fd_sc_mcu7t5v0__clkinv_1
XFILLER_241_142 VDD VSS VDD VSS gf180mcu_fd_sc_mcu7t5v0__fillcap_64
XFILLER_54_597 VDD VSS VDD VSS gf180mcu_fd_sc_mcu7t5v0__fillcap_64
XFILLER_42_737 VDD VSS VDD VSS gf180mcu_fd_sc_mcu7t5v0__fillcap_64
XFILLER_202_518 VDD VSS VDD VSS gf180mcu_fd_sc_mcu7t5v0__fillcap_4
XFILLER_179_282 VDD VSS VDD VSS gf180mcu_fd_sc_mcu7t5v0__fillcap_16
XFILLER_167_422 VDD VSS VDD VSS gf180mcu_fd_sc_mcu7t5v0__fillcap_4
XFILLER_155_606 VDD VSS VDD VSS gf180mcu_fd_sc_mcu7t5v0__fillcap_4
XFILLER_195_742 VDD VSS VDD VSS gf180mcu_fd_sc_mcu7t5v0__fillcap_4
XFILLER_108_511 VDD VSS VDD VSS gf180mcu_fd_sc_mcu7t5v0__fillcap_8
XFILLER_10_667 VDD VSS VDD VSS gf180mcu_fd_sc_mcu7t5v0__fillcap_64
XFILLER_147_190 VDD VSS VDD VSS gf180mcu_fd_sc_mcu7t5v0__fillcap_4
XFILLER_135_352 VDD VSS VDD VSS gf180mcu_fd_sc_mcu7t5v0__fillcap_16
XFILLER_265_702 VDD VSS VDD VSS gf180mcu_fd_sc_mcu7t5v0__fillcap_64
XFILLER_150_366 VDD VSS VDD VSS gf180mcu_fd_sc_mcu7t5v0__fillcap_16
XFILLER_2_877 VDD VSS VDD VSS gf180mcu_fd_sc_mcu7t5v0__fillcap_8
XFILLER_103_282 VDD VSS VDD VSS gf180mcu_fd_sc_mcu7t5v0__fillcap_64
XFILLER_92_626 VDD VSS VDD VSS gf180mcu_fd_sc_mcu7t5v0__fillcap_8
XFILLER_64_317 VDD VSS VDD VSS gf180mcu_fd_sc_mcu7t5v0__fillcap_64
XFILLER_76_177 VDD VSS VDD VSS gf180mcu_fd_sc_mcu7t5v0__fillcap_64
XFILLER_91_136 VDD VSS VDD VSS gf180mcu_fd_sc_mcu7t5v0__fillcap_4
XFILLER_245_492 VDD VSS VDD VSS gf180mcu_fd_sc_mcu7t5v0__fillcap_64
XFILLER_260_451 VDD VSS VDD VSS gf180mcu_fd_sc_mcu7t5v0__fillcap_4
XFILLER_32_247 VDD VSS VDD VSS gf180mcu_fd_sc_mcu7t5v0__fillcap_64
XFILLER_198_591 VDD VSS VDD VSS gf180mcu_fd_sc_mcu7t5v0__fillcap_4
XFILLER_201_562 VDD VSS VDD VSS gf180mcu_fd_sc_mcu7t5v0__fillcap_32
XFILLER_186_753 VDD VSS VDD VSS gf180mcu_fd_sc_mcu7t5v0__fillcap_8
X_2630_ VDD VSS _2632_/A2 _2637_/A2 _2634_/A4 VDD VSS gf180mcu_fd_sc_mcu7t5v0__nor2_1
XFILLER_127_842 VDD VSS VDD VSS gf180mcu_fd_sc_mcu7t5v0__fillcap_16
X_2561_ wire29/Z VDD VSS _4184_/D _4458_/Q _4184_/Q VDD VSS gf180mcu_fd_sc_mcu7t5v0__mux2_2
XFILLER_154_683 VDD VSS VDD VSS gf180mcu_fd_sc_mcu7t5v0__fillcap_8
X_4300_ VSS _4518_/CLK VDD _4300_/D _4519_/D wire207/Z VDD VSS gf180mcu_fd_sc_mcu7t5v0__dffsnq_1
X_2492_ VDD VSS _2500_/S _2492_/A1 _2501_/A2 VDD VSS gf180mcu_fd_sc_mcu7t5v0__nand2_1
X_4231_ _4231_/D _4231_/Q _4530_/RN VSS _4531_/CLK VDD VDD VSS gf180mcu_fd_sc_mcu7t5v0__dffrnq_1
X_4162_ _4162_/D _4162_/Q _4527_/RN VSS _4448_/CLK VDD VDD VSS gf180mcu_fd_sc_mcu7t5v0__dffrnq_1
XFILLER_110_731 VDD VSS VDD VSS gf180mcu_fd_sc_mcu7t5v0__fillcap_4
X_3113_ _3113_/S VDD VSS _3113_/Z _3917_/Q _3909_/Q VDD VSS gf180mcu_fd_sc_mcu7t5v0__mux2_2
XFILLER_255_212 VDD VSS VDD VSS gf180mcu_fd_sc_mcu7t5v0__fillcap_64
XFILLER_56_807 VDD VSS VDD VSS gf180mcu_fd_sc_mcu7t5v0__fillcap_64
X_4093_ VDD _4093_/Q _4270_/CLK VSS _4093_/D VDD VSS gf180mcu_fd_sc_mcu7t5v0__dffq_1
XFILLER_68_667 VDD VSS VDD VSS gf180mcu_fd_sc_mcu7t5v0__fillcap_64
X_3044_ VDD VSS _3045_/B _3044_/A1 _3064_/A2 VDD VSS gf180mcu_fd_sc_mcu7t5v0__nand2_1
XFILLER_95_486 VDD VSS VDD VSS gf180mcu_fd_sc_mcu7t5v0__fillcap_4
XFILLER_223_142 VDD VSS VDD VSS gf180mcu_fd_sc_mcu7t5v0__fillcap_64
XFILLER_36_597 VDD VSS VDD VSS gf180mcu_fd_sc_mcu7t5v0__fillcap_64
XFILLER_24_737 VDD VSS VDD VSS gf180mcu_fd_sc_mcu7t5v0__fillcap_64
XFILLER_224_687 VDD VSS VDD VSS gf180mcu_fd_sc_mcu7t5v0__fillcap_32
XFILLER_212_838 VDD VSS VDD VSS gf180mcu_fd_sc_mcu7t5v0__fillcap_32
XFILLER_196_517 VDD VSS VDD VSS gf180mcu_fd_sc_mcu7t5v0__fillcap_8
XFILLER_51_556 VDD VSS VDD VSS gf180mcu_fd_sc_mcu7t5v0__fillcap_4
X_3946_ VDD _3946_/Q _3967_/CLK VSS _3946_/D VDD VSS gf180mcu_fd_sc_mcu7t5v0__dffq_1
XFILLER_149_422 VDD VSS VDD VSS gf180mcu_fd_sc_mcu7t5v0__fillcap_8
XFILLER_220_871 VDD VSS VDD VSS gf180mcu_fd_sc_mcu7t5v0__fillcap_4
X_3877_ VDD _3877_/Q _3968_/CLK VSS _3877_/D VDD VSS gf180mcu_fd_sc_mcu7t5v0__dffq_1
X_2828_ _2828_/S VDD VSS _4302_/D _4302_/Q _2828_/I1 VDD VSS gf180mcu_fd_sc_mcu7t5v0__mux2_2
X_2759_ _2763_/S VDD VSS _4292_/D wire129/Z _4292_/Q VDD VSS gf180mcu_fd_sc_mcu7t5v0__mux2_2
XFILLER_219_72 VDD VSS VDD VSS gf180mcu_fd_sc_mcu7t5v0__fillcap_64
XFILLER_117_330 VDD VSS VDD VSS gf180mcu_fd_sc_mcu7t5v0__fillcap_8
XFILLER_2_107 VDD VSS VDD VSS gf180mcu_fd_sc_mcu7t5v0__fillcap_64
X_4429_ _4429_/D _4429_/Q wire196/Z VSS _4500_/CLK VDD VDD VSS gf180mcu_fd_sc_mcu7t5v0__dffrnq_1
XFILLER_247_702 VDD VSS VDD VSS gf180mcu_fd_sc_mcu7t5v0__fillcap_64
XFILLER_259_562 VDD VSS VDD VSS gf180mcu_fd_sc_mcu7t5v0__fillcap_64
XFILLER_58_177 VDD VSS VDD VSS gf180mcu_fd_sc_mcu7t5v0__fillcap_64
XFILLER_46_317 VDD VSS VDD VSS gf180mcu_fd_sc_mcu7t5v0__fillcap_64
XFILLER_227_470 VDD VSS VDD VSS gf180mcu_fd_sc_mcu7t5v0__fillcap_4
XFILLER_215_632 VDD VSS VDD VSS gf180mcu_fd_sc_mcu7t5v0__fillcap_32
XFILLER_73_136 VDD VSS VDD VSS gf180mcu_fd_sc_mcu7t5v0__fillcap_4
XFILLER_242_451 VDD VSS VDD VSS gf180mcu_fd_sc_mcu7t5v0__fillcap_4
XFILLER_214_131 VDD VSS VDD VSS gf180mcu_fd_sc_mcu7t5v0__fillcap_4
XFILLER_14_247 VDD VSS VDD VSS gf180mcu_fd_sc_mcu7t5v0__fillcap_64
XFILLER_147_2 VDD VSS VDD VSS gf180mcu_fd_sc_mcu7t5v0__fillcap_4
XFILLER_210_381 VDD VSS VDD VSS gf180mcu_fd_sc_mcu7t5v0__fillcap_4
XFILLER_109_842 VDD VSS VDD VSS gf180mcu_fd_sc_mcu7t5v0__fillcap_4
XFILLER_13_72 VDD VSS VDD VSS gf180mcu_fd_sc_mcu7t5v0__fillcap_64
XFILLER_108_352 VDD VSS VDD VSS gf180mcu_fd_sc_mcu7t5v0__fillcap_8
XFILLER_6_457 VDD VSS VDD VSS gf180mcu_fd_sc_mcu7t5v0__fillcap_64
XFILLER_136_683 VDD VSS VDD VSS gf180mcu_fd_sc_mcu7t5v0__fillcap_4
XFILLER_96_206 VDD VSS VDD VSS gf180mcu_fd_sc_mcu7t5v0__fillcap_32
XFILLER_237_212 VDD VSS VDD VSS gf180mcu_fd_sc_mcu7t5v0__fillcap_64
XFILLER_38_807 VDD VSS VDD VSS gf180mcu_fd_sc_mcu7t5v0__fillcap_64
XFILLER_65_626 VDD VSS VDD VSS gf180mcu_fd_sc_mcu7t5v0__fillcap_4
XFILLER_77_486 VDD VSS VDD VSS gf180mcu_fd_sc_mcu7t5v0__fillcap_4
XFILLER_220_101 VDD VSS VDD VSS gf180mcu_fd_sc_mcu7t5v0__fillcap_4
XFILLER_205_142 VDD VSS VDD VSS gf180mcu_fd_sc_mcu7t5v0__fillcap_64
XFILLER_18_597 VDD VSS VDD VSS gf180mcu_fd_sc_mcu7t5v0__fillcap_64
X_3800_ VDD VSS _3801_/B wire172/Z wire16/Z VDD VSS gf180mcu_fd_sc_mcu7t5v0__nor2_1
XFILLER_33_556 VDD VSS VDD VSS gf180mcu_fd_sc_mcu7t5v0__fillcap_4
X_3731_ _3738_/S VDD VSS _3906_/D _3841_/I0 _3906_/Q VDD VSS gf180mcu_fd_sc_mcu7t5v0__mux2_2
X_1992_ VDD VSS _4075_/Q _3462_/A2 VDD VSS gf180mcu_fd_sc_mcu7t5v0__clkinv_1
XFILLER_174_745 VDD VSS VDD VSS gf180mcu_fd_sc_mcu7t5v0__fillcap_4
XFILLER_173_222 VDD VSS VDD VSS gf180mcu_fd_sc_mcu7t5v0__fillcap_32
X_3662_ VDD VSS _3663_/A3 _4490_/Q _3682_/A2 VDD VSS gf180mcu_fd_sc_mcu7t5v0__nand2_1
Xclkload10 VSS clkload10/Z _4427_/CLK VDD VDD VSS gf180mcu_fd_sc_mcu7t5v0__clkbuf_1
Xclkload43 VSS clkload43/Z _4616_/CLK VDD VDD VSS gf180mcu_fd_sc_mcu7t5v0__clkbuf_1
XFILLER_256_37 VDD VSS VDD VSS gf180mcu_fd_sc_mcu7t5v0__fillcap_64
X_2613_ _2620_/B _4210_/Q VDD VSS _2614_/B _2637_/A2 _2623_/A3 VDD VSS gf180mcu_fd_sc_mcu7t5v0__oai211_1
Xclkload21 VSS clkload21/Z _4492_/CLK VDD VDD VSS gf180mcu_fd_sc_mcu7t5v0__clkbuf_1
X_3593_ _3619_/C VDD VSS _3594_/B2 _3619_/B1 _3593_/A2 VDD VSS gf180mcu_fd_sc_mcu7t5v0__aoi21_1
Xclkload32 VSS clkload32/Z _4123_/CLK VDD VDD VSS gf180mcu_fd_sc_mcu7t5v0__clkbuf_1
Xclkload87 VSS clkload87/Z _4363_/CLK VDD VDD VSS gf180mcu_fd_sc_mcu7t5v0__clkbuf_1
Xclkload76 VSS clkload76/Z _4615_/CLK VDD VDD VSS gf180mcu_fd_sc_mcu7t5v0__clkbuf_1
Xclkload65 VSS clkload65/Z _4522_/CLK VDD VDD VSS gf180mcu_fd_sc_mcu7t5v0__clkbuf_1
Xclkload54 VSS clkload54/Z _4528_/CLK VDD VDD VSS gf180mcu_fd_sc_mcu7t5v0__clkbuf_1
X_2544_ _2546_/S VDD VSS _4167_/D wire125/I _4167_/Q VDD VSS gf180mcu_fd_sc_mcu7t5v0__mux2_2
XFILLER_114_311 VDD VSS VDD VSS gf180mcu_fd_sc_mcu7t5v0__fillcap_4
XFILLER_133_119 VDD VSS VDD VSS gf180mcu_fd_sc_mcu7t5v0__fillcap_16
Xclkload98 VSS clkload98/ZN _3989_/CLK VDD VDD VSS gf180mcu_fd_sc_mcu7t5v0__inv_4
X_2475_ _2482_/S VDD VSS _4098_/D _4098_/Q wire168/Z VDD VSS gf180mcu_fd_sc_mcu7t5v0__mux2_2
XFILLER_87_206 VDD VSS VDD VSS gf180mcu_fd_sc_mcu7t5v0__fillcap_4
X_4214_ _4214_/D _4214_/Q wire199/I VSS _4214_/CLK VDD VDD VSS gf180mcu_fd_sc_mcu7t5v0__dffrnq_1
XFILLER_256_521 VDD VSS VDD VSS gf180mcu_fd_sc_mcu7t5v0__fillcap_4
X_4145_ _4145_/D _4145_/Q wire192/Z VSS _4363_/CLK VDD VDD VSS gf180mcu_fd_sc_mcu7t5v0__dffrnq_1
XFILLER_28_317 VDD VSS VDD VSS gf180mcu_fd_sc_mcu7t5v0__fillcap_64
X_4076_ VDD _4076_/Q _4076_/CLK VSS _4076_/D VDD VSS gf180mcu_fd_sc_mcu7t5v0__dffq_1
XFILLER_55_136 VDD VSS VDD VSS gf180mcu_fd_sc_mcu7t5v0__fillcap_4
XFILLER_209_492 VDD VSS VDD VSS gf180mcu_fd_sc_mcu7t5v0__fillcap_16
X_3027_ _3027_/A3 _3027_/A4 VDD VSS _3032_/A4 _4340_/Q _3036_/B VDD VSS gf180mcu_fd_sc_mcu7t5v0__nand4_1
XFILLER_224_451 VDD VSS VDD VSS gf180mcu_fd_sc_mcu7t5v0__fillcap_4
XFILLER_224_473 VDD VSS VDD VSS gf180mcu_fd_sc_mcu7t5v0__fillcap_8
XFILLER_211_112 VDD VSS VDD VSS gf180mcu_fd_sc_mcu7t5v0__fillcap_4
XFILLER_11_206 VDD VSS VDD VSS gf180mcu_fd_sc_mcu7t5v0__fillcap_4
X_3929_ VDD _3929_/Q _3937_/CLK VSS _3929_/D VDD VSS gf180mcu_fd_sc_mcu7t5v0__dffq_1
Xclkload4 VSS clkload4/ZN clkload4/I VDD VDD VSS gf180mcu_fd_sc_mcu7t5v0__inv_3
Xwire108 VSS _1926_/I _4524_/D VDD VDD VSS gf180mcu_fd_sc_mcu7t5v0__buf_2
Xwire119 VSS wire119/Z _4444_/Q VDD VDD VSS gf180mcu_fd_sc_mcu7t5v0__buf_1
XFILLER_50_37 VDD VSS VDD VSS gf180mcu_fd_sc_mcu7t5v0__fillcap_64
XFILLER_180_715 VDD VSS VDD VSS gf180mcu_fd_sc_mcu7t5v0__fillcap_8
XFILLER_166_37 VDD VSS VDD VSS gf180mcu_fd_sc_mcu7t5v0__fillcap_16
XFILLER_118_661 VDD VSS VDD VSS gf180mcu_fd_sc_mcu7t5v0__fillcap_4
XFILLER_106_801 VDD VSS VDD VSS gf180mcu_fd_sc_mcu7t5v0__fillcap_4
XFILLER_192_597 VDD VSS VDD VSS gf180mcu_fd_sc_mcu7t5v0__fillcap_8
XFILLER_117_160 VDD VSS VDD VSS gf180mcu_fd_sc_mcu7t5v0__fillcap_32
XFILLER_106_823 VDD VSS VDD VSS gf180mcu_fd_sc_mcu7t5v0__fillcap_16
XFILLER_3_416 VDD VSS VDD VSS gf180mcu_fd_sc_mcu7t5v0__fillcap_4
XFILLER_132_163 VDD VSS VDD VSS gf180mcu_fd_sc_mcu7t5v0__fillcap_4
XFILLER_219_212 VDD VSS VDD VSS gf180mcu_fd_sc_mcu7t5v0__fillcap_64
XFILLER_47_626 VDD VSS VDD VSS gf180mcu_fd_sc_mcu7t5v0__fillcap_4
XFILLER_59_486 VDD VSS VDD VSS gf180mcu_fd_sc_mcu7t5v0__fillcap_4
XFILLER_264_2 VDD VSS VDD VSS gf180mcu_fd_sc_mcu7t5v0__fillcap_32
XFILLER_188_815 VDD VSS VDD VSS gf180mcu_fd_sc_mcu7t5v0__fillcap_32
XFILLER_202_101 VDD VSS VDD VSS gf180mcu_fd_sc_mcu7t5v0__fillcap_4
XFILLER_15_556 VDD VSS VDD VSS gf180mcu_fd_sc_mcu7t5v0__fillcap_4
XFILLER_230_465 VDD VSS VDD VSS gf180mcu_fd_sc_mcu7t5v0__fillcap_4
XFILLER_128_403 VDD VSS VDD VSS gf180mcu_fd_sc_mcu7t5v0__fillcap_4
XFILLER_155_200 VDD VSS VDD VSS gf180mcu_fd_sc_mcu7t5v0__fillcap_8
XFILLER_7_766 VDD VSS VDD VSS gf180mcu_fd_sc_mcu7t5v0__fillcap_4
XFILLER_124_642 VDD VSS VDD VSS gf180mcu_fd_sc_mcu7t5v0__fillcap_8
XFILLER_69_206 VDD VSS VDD VSS gf180mcu_fd_sc_mcu7t5v0__fillcap_4
X_2260_ VDD VSS _2263_/A1 _4596_/Q _4587_/D VDD VSS gf180mcu_fd_sc_mcu7t5v0__xnor2_1
XFILLER_123_174 VDD VSS VDD VSS gf180mcu_fd_sc_mcu7t5v0__fillcap_16
XFILLER_238_521 VDD VSS VDD VSS gf180mcu_fd_sc_mcu7t5v0__fillcap_4
X_2191_ VDD _2191_/B _2203_/A1 _4504_/D _2213_/A1 VSS VDD VSS gf180mcu_fd_sc_mcu7t5v0__oai21_1
XFILLER_266_885 VDD VSS VDD VSS gf180mcu_fd_sc_mcu7t5v0__fillcap_4
XFILLER_226_716 VDD VSS VDD VSS gf180mcu_fd_sc_mcu7t5v0__fillcap_16
XFILLER_1_64 VDD VSS VDD VSS gf180mcu_fd_sc_mcu7t5v0__fillcap_4
XFILLER_37_136 VDD VSS VDD VSS gf180mcu_fd_sc_mcu7t5v0__fillcap_4
XFILLER_194_807 VDD VSS VDD VSS gf180mcu_fd_sc_mcu7t5v0__fillcap_4
X_1975_ VDD VSS _4349_/Q _2862_/B VDD VSS gf180mcu_fd_sc_mcu7t5v0__clkinv_1
X_3714_ _3718_/S VDD VSS _3894_/D _3894_/Q wire174/Z VDD VSS gf180mcu_fd_sc_mcu7t5v0__mux2_2
XFILLER_174_597 VDD VSS VDD VSS gf180mcu_fd_sc_mcu7t5v0__fillcap_64
XFILLER_174_575 VDD VSS VDD VSS gf180mcu_fd_sc_mcu7t5v0__fillcap_4
X_3645_ _3681_/A1 VDD VSS _4483_/D _3645_/A1 _3645_/A2 VDD VSS gf180mcu_fd_sc_mcu7t5v0__nand3_1
X_3576_ _4064_/Q VSS VDD _4048_/Q _4056_/Q wire88/I _4040_/Q wire83/I _3576_/Z VDD
+ VSS gf180mcu_fd_sc_mcu7t5v0__mux4_1
X_2527_ _2535_/S VDD VSS _4153_/D _4153_/Q wire133/Z VDD VSS gf180mcu_fd_sc_mcu7t5v0__mux2_2
XFILLER_114_141 VDD VSS VDD VSS gf180mcu_fd_sc_mcu7t5v0__fillcap_16
X_2458_ _2463_/S VDD VSS _4084_/D wire163/Z _4084_/Q VDD VSS gf180mcu_fd_sc_mcu7t5v0__mux2_2
XFILLER_130_667 VDD VSS VDD VSS gf180mcu_fd_sc_mcu7t5v0__fillcap_16
XFILLER_257_874 VDD VSS VDD VSS gf180mcu_fd_sc_mcu7t5v0__fillcap_16
XFILLER_96_581 VDD VSS VDD VSS gf180mcu_fd_sc_mcu7t5v0__fillcap_8
XFILLER_29_626 VDD VSS VDD VSS gf180mcu_fd_sc_mcu7t5v0__fillcap_4
X_2389_ _2393_/S VDD VSS _4029_/D wire158/Z _4029_/Q VDD VSS gf180mcu_fd_sc_mcu7t5v0__mux2_2
XFILLER_110_380 VDD VSS VDD VSS gf180mcu_fd_sc_mcu7t5v0__fillcap_4
X_4128_ VDD _4128_/Q _4128_/CLK VSS _4128_/D VDD VSS gf180mcu_fd_sc_mcu7t5v0__dffq_1
X_4059_ VDD _4059_/Q _4061_/CLK VSS _4059_/D VDD VSS gf180mcu_fd_sc_mcu7t5v0__dffq_1
XFILLER_197_623 VDD VSS VDD VSS gf180mcu_fd_sc_mcu7t5v0__fillcap_4
XFILLER_169_314 VDD VSS VDD VSS gf180mcu_fd_sc_mcu7t5v0__fillcap_32
XFILLER_101_10 VDD VSS VDD VSS gf180mcu_fd_sc_mcu7t5v0__fillcap_4
XFILLER_212_465 VDD VSS VDD VSS gf180mcu_fd_sc_mcu7t5v0__fillcap_4
XFILLER_178_870 VDD VSS VDD VSS gf180mcu_fd_sc_mcu7t5v0__fillcap_4
XFILLER_184_317 VDD VSS VDD VSS gf180mcu_fd_sc_mcu7t5v0__fillcap_8
XFILLER_180_589 VDD VSS VDD VSS gf180mcu_fd_sc_mcu7t5v0__fillcap_4
XFILLER_120_144 VDD VSS VDD VSS gf180mcu_fd_sc_mcu7t5v0__fillcap_4
XFILLER_120_177 VDD VSS VDD VSS gf180mcu_fd_sc_mcu7t5v0__fillcap_8
XFILLER_121_689 VDD VSS VDD VSS gf180mcu_fd_sc_mcu7t5v0__fillcap_8
XFILLER_248_885 VDD VSS VDD VSS gf180mcu_fd_sc_mcu7t5v0__fillcap_4
XFILLER_19_136 VDD VSS VDD VSS gf180mcu_fd_sc_mcu7t5v0__fillcap_4
XFILLER_235_535 VDD VSS VDD VSS gf180mcu_fd_sc_mcu7t5v0__fillcap_16
XFILLER_262_387 VDD VSS VDD VSS gf180mcu_fd_sc_mcu7t5v0__fillcap_64
XFILLER_250_527 VDD VSS VDD VSS gf180mcu_fd_sc_mcu7t5v0__fillcap_64
XFILLER_203_410 VDD VSS VDD VSS gf180mcu_fd_sc_mcu7t5v0__fillcap_8
XFILLER_176_807 VDD VSS VDD VSS gf180mcu_fd_sc_mcu7t5v0__fillcap_16
XFILLER_203_498 VDD VSS VDD VSS gf180mcu_fd_sc_mcu7t5v0__fillcap_8
XFILLER_129_745 VDD VSS VDD VSS gf180mcu_fd_sc_mcu7t5v0__fillcap_16
XFILLER_156_597 VDD VSS VDD VSS gf180mcu_fd_sc_mcu7t5v0__fillcap_32
XFILLER_156_575 VDD VSS VDD VSS gf180mcu_fd_sc_mcu7t5v0__fillcap_8
XFILLER_144_737 VDD VSS VDD VSS gf180mcu_fd_sc_mcu7t5v0__fillcap_8
X_3430_ VDD VSS _3431_/B _3564_/S _4002_/Q VDD VSS gf180mcu_fd_sc_mcu7t5v0__nand2_1
XFILLER_171_578 VDD VSS VDD VSS gf180mcu_fd_sc_mcu7t5v0__fillcap_4
X_3361_ wire21/Z VDD VSS _4408_/D _4400_/Q _4408_/Q VDD VSS gf180mcu_fd_sc_mcu7t5v0__mux2_2
X_2312_ VDD VSS _3032_/A1 _4330_/Q _2783_/A2 VDD VSS gf180mcu_fd_sc_mcu7t5v0__nand2_1
X_3292_ _3278_/Z _4477_/Q VDD VSS _3297_/A2 _4469_/Q _2280_/I VDD VSS gf180mcu_fd_sc_mcu7t5v0__aoi22_1
XFILLER_100_807 VDD VSS VDD VSS gf180mcu_fd_sc_mcu7t5v0__fillcap_32
XFILLER_239_874 VDD VSS VDD VSS gf180mcu_fd_sc_mcu7t5v0__fillcap_16
X_2243_ VDD VSS wire48/I _2243_/A1 _2242_/Z VDD VSS gf180mcu_fd_sc_mcu7t5v0__nand2_1
XFILLER_25_2 VDD VSS VDD VSS gf180mcu_fd_sc_mcu7t5v0__fillcap_64
X_2174_ _2181_/A1 _2174_/A4 VDD VSS _2666_/B1 _4233_/Q _4234_/Q VDD VSS gf180mcu_fd_sc_mcu7t5v0__nor4_2
XFILLER_81_702 VDD VSS VDD VSS gf180mcu_fd_sc_mcu7t5v0__fillcap_8
XFILLER_254_877 VDD VSS VDD VSS gf180mcu_fd_sc_mcu7t5v0__fillcap_8
XFILLER_61_492 VDD VSS VDD VSS gf180mcu_fd_sc_mcu7t5v0__fillcap_64
XFILLER_166_317 VDD VSS VDD VSS gf180mcu_fd_sc_mcu7t5v0__fillcap_16
X_1958_ VDD VSS _4219_/Q _2638_/A1 VDD VSS gf180mcu_fd_sc_mcu7t5v0__clkinv_1
XFILLER_119_255 VDD VSS VDD VSS gf180mcu_fd_sc_mcu7t5v0__fillcap_16
XFILLER_135_737 VDD VSS VDD VSS gf180mcu_fd_sc_mcu7t5v0__fillcap_32
XFILLER_134_236 VDD VSS VDD VSS gf180mcu_fd_sc_mcu7t5v0__fillcap_8
XFILLER_134_247 VDD VSS VDD VSS gf180mcu_fd_sc_mcu7t5v0__fillcap_16
X_3628_ wire141/Z _3628_/C VDD VSS _3629_/A2 _4173_/Q _3685_/A2 _3633_/C1 VDD VSS
+ gf180mcu_fd_sc_mcu7t5v0__aoi221_1
XFILLER_162_589 VDD VSS VDD VSS gf180mcu_fd_sc_mcu7t5v0__fillcap_4
XFILLER_227_72 VDD VSS VDD VSS gf180mcu_fd_sc_mcu7t5v0__fillcap_64
XFILLER_163_38 VDD VSS VDD VSS gf180mcu_fd_sc_mcu7t5v0__fillcap_8
X_3559_ _4591_/Q VDD VSS _3559_/Z _4031_/Q _4023_/Q VDD VSS gf180mcu_fd_sc_mcu7t5v0__mux2_2
XFILLER_103_678 VDD VSS VDD VSS gf180mcu_fd_sc_mcu7t5v0__fillcap_4
XFILLER_102_177 VDD VSS VDD VSS gf180mcu_fd_sc_mcu7t5v0__fillcap_64
XFILLER_84_562 VDD VSS VDD VSS gf180mcu_fd_sc_mcu7t5v0__fillcap_4
XFILLER_205_708 VDD VSS VDD VSS gf180mcu_fd_sc_mcu7t5v0__fillcap_16
XFILLER_71_212 VDD VSS VDD VSS gf180mcu_fd_sc_mcu7t5v0__fillcap_64
XFILLER_244_387 VDD VSS VDD VSS gf180mcu_fd_sc_mcu7t5v0__fillcap_64
XFILLER_232_527 VDD VSS VDD VSS gf180mcu_fd_sc_mcu7t5v0__fillcap_16
XFILLER_158_807 VDD VSS VDD VSS gf180mcu_fd_sc_mcu7t5v0__fillcap_4
XFILLER_200_446 VDD VSS VDD VSS gf180mcu_fd_sc_mcu7t5v0__fillcap_8
XFILLER_185_626 VDD VSS VDD VSS gf180mcu_fd_sc_mcu7t5v0__fillcap_4
XFILLER_200_457 VDD VSS VDD VSS gf180mcu_fd_sc_mcu7t5v0__fillcap_16
Xclkbuf_leaf_51_clk_i _4615_/CLK VSS VDD clkload5/I VDD VSS gf180mcu_fd_sc_mcu7t5v0__clkbuf_2
XFILLER_227_2 VDD VSS VDD VSS gf180mcu_fd_sc_mcu7t5v0__fillcap_64
XFILLER_138_597 VDD VSS VDD VSS gf180mcu_fd_sc_mcu7t5v0__fillcap_64
XFILLER_126_737 VDD VSS VDD VSS gf180mcu_fd_sc_mcu7t5v0__fillcap_4
XFILLER_21_72 VDD VSS VDD VSS gf180mcu_fd_sc_mcu7t5v0__fillcap_64
XFILLER_137_72 VDD VSS VDD VSS gf180mcu_fd_sc_mcu7t5v0__fillcap_16
Xclkbuf_leaf_66_clk_i _4612_/CLK VSS VDD clkload2/I VDD VSS gf180mcu_fd_sc_mcu7t5v0__clkbuf_2
XFILLER_0_750 VDD VSS VDD VSS gf180mcu_fd_sc_mcu7t5v0__fillcap_32
XFILLER_254_107 VDD VSS VDD VSS gf180mcu_fd_sc_mcu7t5v0__fillcap_64
XFILLER_63_702 VDD VSS VDD VSS gf180mcu_fd_sc_mcu7t5v0__fillcap_64
XFILLER_75_562 VDD VSS VDD VSS gf180mcu_fd_sc_mcu7t5v0__fillcap_64
XFILLER_236_877 VDD VSS VDD VSS gf180mcu_fd_sc_mcu7t5v0__fillcap_8
XFILLER_90_521 VDD VSS VDD VSS gf180mcu_fd_sc_mcu7t5v0__fillcap_4
XFILLER_251_836 VDD VSS VDD VSS gf180mcu_fd_sc_mcu7t5v0__fillcap_4
XFILLER_263_696 VDD VSS VDD VSS gf180mcu_fd_sc_mcu7t5v0__fillcap_4
X_2930_ VDD _4202_/Q _4195_/Q _2931_/A4 _3244_/A2 VSS VDD VSS gf180mcu_fd_sc_mcu7t5v0__oai21_1
XFILLER_188_420 VDD VSS VDD VSS gf180mcu_fd_sc_mcu7t5v0__fillcap_32
XFILLER_203_273 VDD VSS VDD VSS gf180mcu_fd_sc_mcu7t5v0__fillcap_4
XFILLER_43_492 VDD VSS VDD VSS gf180mcu_fd_sc_mcu7t5v0__fillcap_64
XFILLER_31_632 VDD VSS VDD VSS gf180mcu_fd_sc_mcu7t5v0__fillcap_64
XFILLER_176_648 VDD VSS VDD VSS gf180mcu_fd_sc_mcu7t5v0__fillcap_16
X_4600_ _4600_/D _4600_/Q _4616_/RN VSS _4604_/CLK VDD VDD VSS gf180mcu_fd_sc_mcu7t5v0__dffrnq_1
X_2861_ _2861_/A3 _4352_/Q _4350_/Q VDD VSS _2865_/A2 _3241_/B2 _2861_/A2 VDD VSS
+ gf180mcu_fd_sc_mcu7t5v0__oai32_1
Xclkbuf_leaf_19_clk_i _4468_/CLK VSS VDD clkload3/I VDD VSS gf180mcu_fd_sc_mcu7t5v0__clkbuf_2
XFILLER_148_317 VDD VSS VDD VSS gf180mcu_fd_sc_mcu7t5v0__fillcap_16
XFILLER_175_158 VDD VSS VDD VSS gf180mcu_fd_sc_mcu7t5v0__fillcap_8
X_2792_ _3040_/B VDD VSS _2832_/B1 _2793_/A1 _3023_/A2 VDD VSS gf180mcu_fd_sc_mcu7t5v0__nor3_1
XFILLER_129_553 VDD VSS VDD VSS gf180mcu_fd_sc_mcu7t5v0__fillcap_4
X_4531_ _4531_/D _4531_/Q wire192/Z VSS _4531_/CLK VDD VDD VSS gf180mcu_fd_sc_mcu7t5v0__dffrnq_1
XFILLER_156_372 VDD VSS VDD VSS gf180mcu_fd_sc_mcu7t5v0__fillcap_8
XFILLER_183_191 VDD VSS VDD VSS gf180mcu_fd_sc_mcu7t5v0__fillcap_16
X_4462_ _4462_/D _4462_/Q wire210/Z VSS _4462_/CLK VDD VDD VSS gf180mcu_fd_sc_mcu7t5v0__dffrnq_1
XFILLER_264_37 VDD VSS VDD VSS gf180mcu_fd_sc_mcu7t5v0__fillcap_64
XFILLER_116_247 VDD VSS VDD VSS gf180mcu_fd_sc_mcu7t5v0__fillcap_32
X_3413_ wire53/Z VDD VSS _4456_/D _4414_/Q _4456_/Q VDD VSS gf180mcu_fd_sc_mcu7t5v0__mux2_2
X_4393_ _4393_/D _4393_/Q _4473_/RN VSS _4400_/CLK VDD VDD VSS gf180mcu_fd_sc_mcu7t5v0__dffrnq_1
X_3344_ _3346_/S VDD VSS _4392_/D _4377_/Q _4392_/Q VDD VSS gf180mcu_fd_sc_mcu7t5v0__mux2_2
XFILLER_258_457 VDD VSS VDD VSS gf180mcu_fd_sc_mcu7t5v0__fillcap_64
X_3275_ VDD _4372_/Q _3307_/A3 _3309_/B _3852_/D VSS VDD VSS gf180mcu_fd_sc_mcu7t5v0__oai21_1
XFILLER_100_626 VDD VSS VDD VSS gf180mcu_fd_sc_mcu7t5v0__fillcap_32
X_2226_ _2226_/B _2701_/B VDD VSS _4507_/D _4321_/Q _2226_/A2 VDD VSS gf180mcu_fd_sc_mcu7t5v0__oai211_1
XFILLER_94_871 VDD VSS VDD VSS gf180mcu_fd_sc_mcu7t5v0__fillcap_4
X_2157_ VDD VSS _2995_/A2 _4303_/Q _4302_/Q VDD VSS gf180mcu_fd_sc_mcu7t5v0__nand2_1
XFILLER_53_212 VDD VSS VDD VSS gf180mcu_fd_sc_mcu7t5v0__fillcap_64
XFILLER_226_387 VDD VSS VDD VSS gf180mcu_fd_sc_mcu7t5v0__fillcap_64
XFILLER_214_527 VDD VSS VDD VSS gf180mcu_fd_sc_mcu7t5v0__fillcap_8
X_2088_ _4537_/Q VDD VSS _2102_/A4 _3862_/Q _3863_/Q VDD VSS gf180mcu_fd_sc_mcu7t5v0__aoi21_1
XFILLER_241_346 VDD VSS VDD VSS gf180mcu_fd_sc_mcu7t5v0__fillcap_4
XFILLER_210_711 VDD VSS VDD VSS gf180mcu_fd_sc_mcu7t5v0__fillcap_16
XFILLER_167_615 VDD VSS VDD VSS gf180mcu_fd_sc_mcu7t5v0__fillcap_8
XFILLER_21_142 VDD VSS VDD VSS gf180mcu_fd_sc_mcu7t5v0__fillcap_64
XFILLER_194_489 VDD VSS VDD VSS gf180mcu_fd_sc_mcu7t5v0__fillcap_4
Xmax_length89 wire88/I _3564_/S VDD VSS VDD VSS gf180mcu_fd_sc_mcu7t5v0__buf_4
XFILLER_107_236 VDD VSS VDD VSS gf180mcu_fd_sc_mcu7t5v0__fillcap_4
XFILLER_108_737 VDD VSS VDD VSS gf180mcu_fd_sc_mcu7t5v0__fillcap_16
XFILLER_174_37 VDD VSS VDD VSS gf180mcu_fd_sc_mcu7t5v0__fillcap_16
XFILLER_89_632 VDD VSS VDD VSS gf180mcu_fd_sc_mcu7t5v0__fillcap_8
XFILLER_150_559 VDD VSS VDD VSS gf180mcu_fd_sc_mcu7t5v0__fillcap_8
XFILLER_103_486 VDD VSS VDD VSS gf180mcu_fd_sc_mcu7t5v0__fillcap_4
XFILLER_131_762 VDD VSS VDD VSS gf180mcu_fd_sc_mcu7t5v0__fillcap_8
XFILLER_218_822 VDD VSS VDD VSS gf180mcu_fd_sc_mcu7t5v0__fillcap_32
XFILLER_236_107 VDD VSS VDD VSS gf180mcu_fd_sc_mcu7t5v0__fillcap_64
XFILLER_130_272 VDD VSS VDD VSS gf180mcu_fd_sc_mcu7t5v0__fillcap_32
XFILLER_190_69 VDD VSS VDD VSS gf180mcu_fd_sc_mcu7t5v0__fillcap_4
XFILLER_57_562 VDD VSS VDD VSS gf180mcu_fd_sc_mcu7t5v0__fillcap_64
XFILLER_45_702 VDD VSS VDD VSS gf180mcu_fd_sc_mcu7t5v0__fillcap_64
XFILLER_218_877 VDD VSS VDD VSS gf180mcu_fd_sc_mcu7t5v0__fillcap_8
XFILLER_177_2 VDD VSS VDD VSS gf180mcu_fd_sc_mcu7t5v0__fillcap_16
XFILLER_84_381 VDD VSS VDD VSS gf180mcu_fd_sc_mcu7t5v0__fillcap_4
XFILLER_72_521 VDD VSS VDD VSS gf180mcu_fd_sc_mcu7t5v0__fillcap_4
XFILLER_245_696 VDD VSS VDD VSS gf180mcu_fd_sc_mcu7t5v0__fillcap_4
XFILLER_25_492 VDD VSS VDD VSS gf180mcu_fd_sc_mcu7t5v0__fillcap_64
XFILLER_13_632 VDD VSS VDD VSS gf180mcu_fd_sc_mcu7t5v0__fillcap_64
XFILLER_198_784 VDD VSS VDD VSS gf180mcu_fd_sc_mcu7t5v0__fillcap_8
XFILLER_40_451 VDD VSS VDD VSS gf180mcu_fd_sc_mcu7t5v0__fillcap_4
XFILLER_138_394 VDD VSS VDD VSS gf180mcu_fd_sc_mcu7t5v0__fillcap_16
XFILLER_5_842 VDD VSS VDD VSS gf180mcu_fd_sc_mcu7t5v0__fillcap_32
XFILLER_148_93 VDD VSS VDD VSS gf180mcu_fd_sc_mcu7t5v0__fillcap_8
XFILLER_79_142 VDD VSS VDD VSS gf180mcu_fd_sc_mcu7t5v0__fillcap_64
X_3060_ _3060_/B wire97/Z VDD VSS _3062_/B _3124_/A1 _3789_/A1 VDD VSS gf180mcu_fd_sc_mcu7t5v0__aoi211_1
XFILLER_255_416 VDD VSS VDD VSS gf180mcu_fd_sc_mcu7t5v0__fillcap_4
XFILLER_267_276 VDD VSS VDD VSS gf180mcu_fd_sc_mcu7t5v0__fillcap_4
XFILLER_0_580 VDD VSS VDD VSS gf180mcu_fd_sc_mcu7t5v0__fillcap_32
X_2011_ VDD VSS _3955_/Q _3791_/A1 VDD VSS gf180mcu_fd_sc_mcu7t5v0__clkinv_1
XFILLER_76_871 VDD VSS VDD VSS gf180mcu_fd_sc_mcu7t5v0__fillcap_4
XFILLER_35_212 VDD VSS VDD VSS gf180mcu_fd_sc_mcu7t5v0__fillcap_64
XFILLER_224_869 VDD VSS VDD VSS gf180mcu_fd_sc_mcu7t5v0__fillcap_4
XFILLER_211_508 VDD VSS VDD VSS gf180mcu_fd_sc_mcu7t5v0__fillcap_8
XFILLER_223_346 VDD VSS VDD VSS gf180mcu_fd_sc_mcu7t5v0__fillcap_4
X_3962_ VDD _3962_/Q _3965_/CLK VSS _3962_/D VDD VSS gf180mcu_fd_sc_mcu7t5v0__dffq_1
XFILLER_92_2 VDD VSS VDD VSS gf180mcu_fd_sc_mcu7t5v0__fillcap_32
X_3893_ VDD _3893_/Q _3968_/CLK VSS _3893_/D VDD VSS gf180mcu_fd_sc_mcu7t5v0__dffq_1
X_2913_ VDD VSS _2914_/B _4308_/Q _2919_/S VDD VSS gf180mcu_fd_sc_mcu7t5v0__nand2_1
XFILLER_149_637 VDD VSS VDD VSS gf180mcu_fd_sc_mcu7t5v0__fillcap_16
X_2844_ VDD VSS _2845_/B _2846_/S _3937_/Q VDD VSS gf180mcu_fd_sc_mcu7t5v0__or2_1
XFILLER_164_629 VDD VSS VDD VSS gf180mcu_fd_sc_mcu7t5v0__fillcap_16
XFILLER_191_415 VDD VSS VDD VSS gf180mcu_fd_sc_mcu7t5v0__fillcap_4
X_4514_ VSS _4514_/CLK VDD _4514_/D _4515_/D _4512_/RN VDD VSS gf180mcu_fd_sc_mcu7t5v0__dffsnq_1
X_2775_ _2984_/A4 VDD VSS _2779_/B1 _2985_/C _3209_/B VDD VSS gf180mcu_fd_sc_mcu7t5v0__nand3_1
XFILLER_117_578 VDD VSS VDD VSS gf180mcu_fd_sc_mcu7t5v0__fillcap_8
X_4445_ _4445_/D _4445_/Q _4536_/RN VSS _4492_/CLK VDD VDD VSS gf180mcu_fd_sc_mcu7t5v0__dffrnq_1
X_4376_ _4376_/D _4376_/Q wire196/Z VSS _4402_/CLK VDD VDD VSS gf180mcu_fd_sc_mcu7t5v0__dffrnq_1
XFILLER_104_239 VDD VSS VDD VSS gf180mcu_fd_sc_mcu7t5v0__fillcap_4
XFILLER_259_766 VDD VSS VDD VSS gf180mcu_fd_sc_mcu7t5v0__fillcap_4
X_3327_ VDD VSS _3327_/I _4382_/D VDD VSS gf180mcu_fd_sc_mcu7t5v0__clkinv_1
XFILLER_98_451 VDD VSS VDD VSS gf180mcu_fd_sc_mcu7t5v0__fillcap_4
XFILLER_218_107 VDD VSS VDD VSS gf180mcu_fd_sc_mcu7t5v0__fillcap_64
X_3258_ _3268_/B1 _4364_/Q VDD VSS _3259_/I _4357_/Q _4526_/D VDD VSS gf180mcu_fd_sc_mcu7t5v0__aoi22_1
XFILLER_39_562 VDD VSS VDD VSS gf180mcu_fd_sc_mcu7t5v0__fillcap_64
XFILLER_27_702 VDD VSS VDD VSS gf180mcu_fd_sc_mcu7t5v0__fillcap_64
X_2209_ VDD VSS _2210_/A3 _4503_/Q _2194_/I VDD VSS gf180mcu_fd_sc_mcu7t5v0__nand2_1
X_3189_ _3189_/A3 _3189_/B1 _3189_/B2 VDD VSS _3191_/B2 _3182_/B _3189_/A2 VDD VSS
+ gf180mcu_fd_sc_mcu7t5v0__oai32_1
XFILLER_54_521 VDD VSS VDD VSS gf180mcu_fd_sc_mcu7t5v0__fillcap_4
XFILLER_66_381 VDD VSS VDD VSS gf180mcu_fd_sc_mcu7t5v0__fillcap_4
XFILLER_82_885 VDD VSS VDD VSS gf180mcu_fd_sc_mcu7t5v0__fillcap_4
XFILLER_22_451 VDD VSS VDD VSS gf180mcu_fd_sc_mcu7t5v0__fillcap_4
XFILLER_194_220 VDD VSS VDD VSS gf180mcu_fd_sc_mcu7t5v0__fillcap_16
XFILLER_139_136 VDD VSS VDD VSS gf180mcu_fd_sc_mcu7t5v0__fillcap_4
XFILLER_148_681 VDD VSS VDD VSS gf180mcu_fd_sc_mcu7t5v0__fillcap_16
XFILLER_154_139 VDD VSS VDD VSS gf180mcu_fd_sc_mcu7t5v0__fillcap_8
XFILLER_118_74 VDD VSS VDD VSS gf180mcu_fd_sc_mcu7t5v0__fillcap_16
XFILLER_2_801 VDD VSS VDD VSS gf180mcu_fd_sc_mcu7t5v0__fillcap_4
XFILLER_150_334 VDD VSS VDD VSS gf180mcu_fd_sc_mcu7t5v0__fillcap_32
XFILLER_237_416 VDD VSS VDD VSS gf180mcu_fd_sc_mcu7t5v0__fillcap_4
XFILLER_249_276 VDD VSS VDD VSS gf180mcu_fd_sc_mcu7t5v0__fillcap_4
XFILLER_76_101 VDD VSS VDD VSS gf180mcu_fd_sc_mcu7t5v0__fillcap_4
XFILLER_58_871 VDD VSS VDD VSS gf180mcu_fd_sc_mcu7t5v0__fillcap_4
XFILLER_17_212 VDD VSS VDD VSS gf180mcu_fd_sc_mcu7t5v0__fillcap_64
XFILLER_217_184 VDD VSS VDD VSS gf180mcu_fd_sc_mcu7t5v0__fillcap_8
XFILLER_73_874 VDD VSS VDD VSS gf180mcu_fd_sc_mcu7t5v0__fillcap_16
XFILLER_205_368 VDD VSS VDD VSS gf180mcu_fd_sc_mcu7t5v0__fillcap_8
XFILLER_9_422 VDD VSS VDD VSS gf180mcu_fd_sc_mcu7t5v0__fillcap_64
XFILLER_139_692 VDD VSS VDD VSS gf180mcu_fd_sc_mcu7t5v0__fillcap_8
X_2560_ wire28/Z VDD VSS _4183_/D wire112/Z _4183_/Q VDD VSS gf180mcu_fd_sc_mcu7t5v0__mux2_2
XFILLER_153_150 VDD VSS VDD VSS gf180mcu_fd_sc_mcu7t5v0__fillcap_4
XFILLER_126_375 VDD VSS VDD VSS gf180mcu_fd_sc_mcu7t5v0__fillcap_8
X_2491_ _2491_/S VDD VSS _4113_/D wire150/Z _4113_/Q VDD VSS gf180mcu_fd_sc_mcu7t5v0__mux2_2
X_4230_ _4230_/D _4230_/Q _4530_/RN VSS _4530_/CLK VDD VDD VSS gf180mcu_fd_sc_mcu7t5v0__dffrnq_1
XFILLER_181_492 VDD VSS VDD VSS gf180mcu_fd_sc_mcu7t5v0__fillcap_32
XFILLER_4_171 VDD VSS VDD VSS gf180mcu_fd_sc_mcu7t5v0__fillcap_4
X_4161_ _4161_/D _4161_/Q wire193/Z VSS _4476_/CLK VDD VDD VSS gf180mcu_fd_sc_mcu7t5v0__dffrnq_1
X_3112_ _3112_/B _3117_/B VDD VSS _3114_/B _3113_/S _3753_/A1 VDD VSS gf180mcu_fd_sc_mcu7t5v0__aoi211_1
X_4092_ VDD _4092_/Q _4580_/CLK VSS _4092_/D VDD VSS gf180mcu_fd_sc_mcu7t5v0__dffq_1
X_3043_ VDD _3043_/B _3038_/B _4330_/D _3043_/A1 VSS VDD VSS gf180mcu_fd_sc_mcu7t5v0__oai21_1
XFILLER_36_521 VDD VSS VDD VSS gf180mcu_fd_sc_mcu7t5v0__fillcap_4
XFILLER_48_381 VDD VSS VDD VSS gf180mcu_fd_sc_mcu7t5v0__fillcap_4
XFILLER_224_644 VDD VSS VDD VSS gf180mcu_fd_sc_mcu7t5v0__fillcap_16
XFILLER_64_885 VDD VSS VDD VSS gf180mcu_fd_sc_mcu7t5v0__fillcap_4
X_3945_ VDD _3945_/Q _3967_/CLK VSS _3945_/D VDD VSS gf180mcu_fd_sc_mcu7t5v0__dffq_1
XFILLER_149_467 VDD VSS VDD VSS gf180mcu_fd_sc_mcu7t5v0__fillcap_8
X_3876_ VDD _3876_/Q _3969_/CLK VSS _3876_/D VDD VSS gf180mcu_fd_sc_mcu7t5v0__dffq_1
X_2827_ _2827_/B VDD VSS _2828_/I1 _2827_/A1 _3225_/A1 VDD VSS gf180mcu_fd_sc_mcu7t5v0__aoi21_1
XFILLER_191_212 VDD VSS VDD VSS gf180mcu_fd_sc_mcu7t5v0__fillcap_8
X_2758_ wire25/Z VDD VSS _4291_/D wire132/Z _4291_/Q VDD VSS gf180mcu_fd_sc_mcu7t5v0__mux2_2
XFILLER_191_256 VDD VSS VDD VSS gf180mcu_fd_sc_mcu7t5v0__fillcap_4
XFILLER_105_526 VDD VSS VDD VSS gf180mcu_fd_sc_mcu7t5v0__fillcap_8
X_2689_ VDD VSS _2689_/Z _4241_/Q _4242_/Q VDD VSS gf180mcu_fd_sc_mcu7t5v0__or2_1
X_4428_ _4428_/D _4428_/Q wire196/Z VSS _4430_/CLK VDD VDD VSS gf180mcu_fd_sc_mcu7t5v0__dffrnq_1
XFILLER_160_676 VDD VSS VDD VSS gf180mcu_fd_sc_mcu7t5v0__fillcap_32
XFILLER_235_72 VDD VSS VDD VSS gf180mcu_fd_sc_mcu7t5v0__fillcap_64
X_4359_ _4359_/D _4359_/Q wire183/Z VSS _4366_/CLK VDD VDD VSS gf180mcu_fd_sc_mcu7t5v0__dffrnq_1
XFILLER_219_416 VDD VSS VDD VSS gf180mcu_fd_sc_mcu7t5v0__fillcap_4
XFILLER_58_101 VDD VSS VDD VSS gf180mcu_fd_sc_mcu7t5v0__fillcap_4
XFILLER_48_37 VDD VSS VDD VSS gf180mcu_fd_sc_mcu7t5v0__fillcap_64
XFILLER_55_874 VDD VSS VDD VSS gf180mcu_fd_sc_mcu7t5v0__fillcap_16
XFILLER_82_682 VDD VSS VDD VSS gf180mcu_fd_sc_mcu7t5v0__fillcap_4
XFILLER_70_877 VDD VSS VDD VSS gf180mcu_fd_sc_mcu7t5v0__fillcap_8
XFILLER_195_562 VDD VSS VDD VSS gf180mcu_fd_sc_mcu7t5v0__fillcap_16
XFILLER_183_702 VDD VSS VDD VSS gf180mcu_fd_sc_mcu7t5v0__fillcap_16
XFILLER_167_253 VDD VSS VDD VSS gf180mcu_fd_sc_mcu7t5v0__fillcap_16
XFILLER_155_415 VDD VSS VDD VSS gf180mcu_fd_sc_mcu7t5v0__fillcap_4
XFILLER_170_407 VDD VSS VDD VSS gf180mcu_fd_sc_mcu7t5v0__fillcap_8
XFILLER_151_610 VDD VSS VDD VSS gf180mcu_fd_sc_mcu7t5v0__fillcap_4
XFILLER_89_66 VDD VSS VDD VSS gf180mcu_fd_sc_mcu7t5v0__fillcap_4
XFILLER_163_492 VDD VSS VDD VSS gf180mcu_fd_sc_mcu7t5v0__fillcap_4
XFILLER_151_632 VDD VSS VDD VSS gf180mcu_fd_sc_mcu7t5v0__fillcap_16
XFILLER_145_72 VDD VSS VDD VSS gf180mcu_fd_sc_mcu7t5v0__fillcap_8
XFILLER_150_164 VDD VSS VDD VSS gf180mcu_fd_sc_mcu7t5v0__fillcap_8
XFILLER_18_521 VDD VSS VDD VSS gf180mcu_fd_sc_mcu7t5v0__fillcap_4
XFILLER_92_457 VDD VSS VDD VSS gf180mcu_fd_sc_mcu7t5v0__fillcap_32
XFILLER_46_885 VDD VSS VDD VSS gf180mcu_fd_sc_mcu7t5v0__fillcap_4
XFILLER_261_772 VDD VSS VDD VSS gf180mcu_fd_sc_mcu7t5v0__fillcap_64
XFILLER_178_507 VDD VSS VDD VSS gf180mcu_fd_sc_mcu7t5v0__fillcap_4
XFILLER_60_387 VDD VSS VDD VSS gf180mcu_fd_sc_mcu7t5v0__fillcap_64
X_3730_ VDD VSS _3738_/S _2102_/Z _3759_/A2 VDD VSS gf180mcu_fd_sc_mcu7t5v0__nand2_1
X_1991_ VDD VSS _4010_/Q _3431_/A2 VDD VSS gf180mcu_fd_sc_mcu7t5v0__clkinv_1
XFILLER_173_212 VDD VSS VDD VSS gf180mcu_fd_sc_mcu7t5v0__fillcap_4
X_3661_ VDD VSS _3663_/A2 _4184_/Q _3679_/A2 VDD VSS gf180mcu_fd_sc_mcu7t5v0__nand2_1
XFILLER_118_139 VDD VSS VDD VSS gf180mcu_fd_sc_mcu7t5v0__fillcap_16
X_2612_ VDD VSS _2612_/I _4209_/D VDD VSS gf180mcu_fd_sc_mcu7t5v0__clkinv_1
Xclkload11 VDD VSS _4436_/CLK clkload11/ZN VDD VSS gf180mcu_fd_sc_mcu7t5v0__clkinv_2
Xclkload22 VSS clkload22/Z _4478_/CLK VDD VDD VSS gf180mcu_fd_sc_mcu7t5v0__clkbuf_1
X_3592_ _3592_/A3 VDD VSS _3594_/B1 wire42/Z _3592_/A2 VDD VSS gf180mcu_fd_sc_mcu7t5v0__nand3_1
Xclkload44 VSS clkload44/Z _4612_/CLK VDD VDD VSS gf180mcu_fd_sc_mcu7t5v0__clkbuf_1
Xclkload33 VSS clkload33/Z _4076_/CLK VDD VDD VSS gf180mcu_fd_sc_mcu7t5v0__clkbuf_1
Xclkload77 VDD VSS _4586_/CLK clkload77/ZN VDD VSS gf180mcu_fd_sc_mcu7t5v0__clkinv_2
Xclkload66 VSS clkload66/Z _4514_/CLK VDD VDD VSS gf180mcu_fd_sc_mcu7t5v0__clkbuf_1
X_2543_ _2546_/S VDD VSS _4166_/D wire129/I _4166_/Q VDD VSS gf180mcu_fd_sc_mcu7t5v0__mux2_2
Xclkload55 VDD VSS _4278_/CLK clkload55/ZN VDD VSS gf180mcu_fd_sc_mcu7t5v0__clkinv_2
XFILLER_55_2 VDD VSS VDD VSS gf180mcu_fd_sc_mcu7t5v0__fillcap_64
Xclkload99 VDD VSS _3998_/CLK clkload99/ZN VDD VSS gf180mcu_fd_sc_mcu7t5v0__clkinv_2
Xclkload88 VDD VSS clkload88/ZN _4574_/CLK VDD VSS gf180mcu_fd_sc_mcu7t5v0__clkinv_8
XFILLER_141_131 VDD VSS VDD VSS gf180mcu_fd_sc_mcu7t5v0__fillcap_8
XFILLER_141_142 VDD VSS VDD VSS gf180mcu_fd_sc_mcu7t5v0__fillcap_8
XFILLER_102_518 VDD VSS VDD VSS gf180mcu_fd_sc_mcu7t5v0__fillcap_4
X_2474_ VDD VSS _2482_/S _2061_/Z _2501_/A2 VDD VSS gf180mcu_fd_sc_mcu7t5v0__and2_1
X_4213_ _4213_/D _4213_/Q wire199/I VSS _4214_/CLK VDD VDD VSS gf180mcu_fd_sc_mcu7t5v0__dffrnq_1
X_4144_ _4144_/D _4144_/Q wire192/Z VSS _4364_/CLK VDD VDD VSS gf180mcu_fd_sc_mcu7t5v0__dffrnq_1
X_4075_ VDD _4075_/Q _4096_/CLK VSS _4075_/D VDD VSS gf180mcu_fd_sc_mcu7t5v0__dffq_1
X_3026_ VDD _4339_/Q _2331_/Z _3027_/A4 _4371_/Q VSS VDD VSS gf180mcu_fd_sc_mcu7t5v0__oai21_1
XFILLER_70_107 VDD VSS VDD VSS gf180mcu_fd_sc_mcu7t5v0__fillcap_64
XFILLER_37_874 VDD VSS VDD VSS gf180mcu_fd_sc_mcu7t5v0__fillcap_16
XFILLER_251_282 VDD VSS VDD VSS gf180mcu_fd_sc_mcu7t5v0__fillcap_64
XFILLER_211_124 VDD VSS VDD VSS gf180mcu_fd_sc_mcu7t5v0__fillcap_16
XFILLER_52_877 VDD VSS VDD VSS gf180mcu_fd_sc_mcu7t5v0__fillcap_8
X_3928_ VDD _3928_/Q _3936_/CLK VSS _3928_/D VDD VSS gf180mcu_fd_sc_mcu7t5v0__dffq_1
Xclkload5 VSS clkload5/ZN clkload5/I VDD VDD VSS gf180mcu_fd_sc_mcu7t5v0__inv_4
Xwire109 VSS _4524_/D _4523_/Q VDD VDD VSS gf180mcu_fd_sc_mcu7t5v0__buf_2
XFILLER_149_264 VDD VSS VDD VSS gf180mcu_fd_sc_mcu7t5v0__fillcap_16
X_3859_ _3859_/D _3859_/Q _4473_/RN VSS _4477_/CLK VDD VDD VSS gf180mcu_fd_sc_mcu7t5v0__dffrnq_1
XFILLER_145_492 VDD VSS VDD VSS gf180mcu_fd_sc_mcu7t5v0__fillcap_32
XFILLER_133_632 VDD VSS VDD VSS gf180mcu_fd_sc_mcu7t5v0__fillcap_4
XFILLER_182_37 VDD VSS VDD VSS gf180mcu_fd_sc_mcu7t5v0__fillcap_4
XFILLER_101_562 VDD VSS VDD VSS gf180mcu_fd_sc_mcu7t5v0__fillcap_64
XFILLER_74_457 VDD VSS VDD VSS gf180mcu_fd_sc_mcu7t5v0__fillcap_64
XFILLER_28_885 VDD VSS VDD VSS gf180mcu_fd_sc_mcu7t5v0__fillcap_4
XFILLER_243_772 VDD VSS VDD VSS gf180mcu_fd_sc_mcu7t5v0__fillcap_64
XFILLER_257_2 VDD VSS VDD VSS gf180mcu_fd_sc_mcu7t5v0__fillcap_64
XFILLER_199_142 VDD VSS VDD VSS gf180mcu_fd_sc_mcu7t5v0__fillcap_8
XFILLER_187_315 VDD VSS VDD VSS gf180mcu_fd_sc_mcu7t5v0__fillcap_4
XFILLER_42_387 VDD VSS VDD VSS gf180mcu_fd_sc_mcu7t5v0__fillcap_64
XFILLER_30_527 VDD VSS VDD VSS gf180mcu_fd_sc_mcu7t5v0__fillcap_64
XFILLER_156_713 VDD VSS VDD VSS gf180mcu_fd_sc_mcu7t5v0__fillcap_8
XFILLER_123_142 VDD VSS VDD VSS gf180mcu_fd_sc_mcu7t5v0__fillcap_32
XFILLER_124_698 VDD VSS VDD VSS gf180mcu_fd_sc_mcu7t5v0__fillcap_4
X_2190_ VDD VSS _2666_/C _2211_/B VDD VSS gf180mcu_fd_sc_mcu7t5v0__clkinv_1
XFILLER_265_352 VDD VSS VDD VSS gf180mcu_fd_sc_mcu7t5v0__fillcap_64
XFILLER_120_871 VDD VSS VDD VSS gf180mcu_fd_sc_mcu7t5v0__fillcap_4
XFILLER_19_874 VDD VSS VDD VSS gf180mcu_fd_sc_mcu7t5v0__fillcap_16
XFILLER_52_107 VDD VSS VDD VSS gf180mcu_fd_sc_mcu7t5v0__fillcap_64
XFILLER_221_422 VDD VSS VDD VSS gf180mcu_fd_sc_mcu7t5v0__fillcap_64
XFILLER_233_282 VDD VSS VDD VSS gf180mcu_fd_sc_mcu7t5v0__fillcap_64
XFILLER_34_877 VDD VSS VDD VSS gf180mcu_fd_sc_mcu7t5v0__fillcap_8
XFILLER_61_696 VDD VSS VDD VSS gf180mcu_fd_sc_mcu7t5v0__fillcap_4
XFILLER_159_562 VDD VSS VDD VSS gf180mcu_fd_sc_mcu7t5v0__fillcap_8
XFILLER_147_702 VDD VSS VDD VSS gf180mcu_fd_sc_mcu7t5v0__fillcap_4
X_1974_ VDD VSS _4351_/Q _2859_/B VDD VSS gf180mcu_fd_sc_mcu7t5v0__clkinv_1
X_3713_ VDD _3713_/B _3718_/S _3893_/D _3713_/A1 VSS VDD VSS gf180mcu_fd_sc_mcu7t5v0__oai21_1
Xclkload100 VDD VSS clkload100/ZN _3968_/CLK VDD VSS gf180mcu_fd_sc_mcu7t5v0__clkinv_8
X_3644_ VDD VSS _3681_/A1 _3628_/C _3644_/A2 VDD VSS gf180mcu_fd_sc_mcu7t5v0__nand2_1
X_3575_ _3575_/A3 VDD VSS _3593_/A2 _3575_/A1 _3575_/A2 VDD VSS gf180mcu_fd_sc_mcu7t5v0__nand3_1
XFILLER_127_492 VDD VSS VDD VSS gf180mcu_fd_sc_mcu7t5v0__fillcap_8
XFILLER_115_632 VDD VSS VDD VSS gf180mcu_fd_sc_mcu7t5v0__fillcap_16
X_2526_ _2536_/S VDD VSS _4152_/D _4152_/Q wire134/I VDD VSS gf180mcu_fd_sc_mcu7t5v0__mux2_2
XFILLER_88_527 VDD VSS VDD VSS gf180mcu_fd_sc_mcu7t5v0__fillcap_64
XFILLER_103_849 VDD VSS VDD VSS gf180mcu_fd_sc_mcu7t5v0__fillcap_4
X_2457_ _2463_/S VDD VSS _4083_/D wire166/Z _4083_/Q VDD VSS gf180mcu_fd_sc_mcu7t5v0__mux2_2
XFILLER_257_842 VDD VSS VDD VSS gf180mcu_fd_sc_mcu7t5v0__fillcap_32
XFILLER_130_657 VDD VSS VDD VSS gf180mcu_fd_sc_mcu7t5v0__fillcap_8
X_2388_ _2393_/S VDD VSS _4028_/D _2467_/I0 _4028_/Q VDD VSS gf180mcu_fd_sc_mcu7t5v0__mux2_2
XFILLER_56_457 VDD VSS VDD VSS gf180mcu_fd_sc_mcu7t5v0__fillcap_64
X_4127_ VDD _4127_/Q _4128_/CLK VSS _4127_/D VDD VSS gf180mcu_fd_sc_mcu7t5v0__dffq_1
XFILLER_216_227 VDD VSS VDD VSS gf180mcu_fd_sc_mcu7t5v0__fillcap_4
XFILLER_83_276 VDD VSS VDD VSS gf180mcu_fd_sc_mcu7t5v0__fillcap_4
XFILLER_71_416 VDD VSS VDD VSS gf180mcu_fd_sc_mcu7t5v0__fillcap_4
X_4058_ VDD _4058_/Q _4058_/CLK VSS _4058_/D VDD VSS gf180mcu_fd_sc_mcu7t5v0__dffq_1
XFILLER_225_772 VDD VSS VDD VSS gf180mcu_fd_sc_mcu7t5v0__fillcap_4
X_3009_ VDD VSS _3009_/Z _3003_/Z _3009_/A2 VDD VSS gf180mcu_fd_sc_mcu7t5v0__and2_1
XFILLER_240_731 VDD VSS VDD VSS gf180mcu_fd_sc_mcu7t5v0__fillcap_4
XFILLER_252_591 VDD VSS VDD VSS gf180mcu_fd_sc_mcu7t5v0__fillcap_4
XFILLER_24_387 VDD VSS VDD VSS gf180mcu_fd_sc_mcu7t5v0__fillcap_64
XFILLER_12_527 VDD VSS VDD VSS gf180mcu_fd_sc_mcu7t5v0__fillcap_64
XFILLER_165_532 VDD VSS VDD VSS gf180mcu_fd_sc_mcu7t5v0__fillcap_4
XFILLER_192_340 VDD VSS VDD VSS gf180mcu_fd_sc_mcu7t5v0__fillcap_8
XFILLER_165_587 VDD VSS VDD VSS gf180mcu_fd_sc_mcu7t5v0__fillcap_8
XFILLER_4_737 VDD VSS VDD VSS gf180mcu_fd_sc_mcu7t5v0__fillcap_64
XFILLER_106_621 VDD VSS VDD VSS gf180mcu_fd_sc_mcu7t5v0__fillcap_32
XFILLER_105_142 VDD VSS VDD VSS gf180mcu_fd_sc_mcu7t5v0__fillcap_4
XFILLER_105_120 VDD VSS VDD VSS gf180mcu_fd_sc_mcu7t5v0__fillcap_16
XFILLER_106_698 VDD VSS VDD VSS gf180mcu_fd_sc_mcu7t5v0__fillcap_8
XFILLER_126_85 VDD VSS VDD VSS gf180mcu_fd_sc_mcu7t5v0__fillcap_4
XFILLER_102_871 VDD VSS VDD VSS gf180mcu_fd_sc_mcu7t5v0__fillcap_4
XFILLER_247_352 VDD VSS VDD VSS gf180mcu_fd_sc_mcu7t5v0__fillcap_64
XFILLER_19_72 VDD VSS VDD VSS gf180mcu_fd_sc_mcu7t5v0__fillcap_64
XFILLER_262_311 VDD VSS VDD VSS gf180mcu_fd_sc_mcu7t5v0__fillcap_4
XFILLER_75_766 VDD VSS VDD VSS gf180mcu_fd_sc_mcu7t5v0__fillcap_4
XFILLER_34_107 VDD VSS VDD VSS gf180mcu_fd_sc_mcu7t5v0__fillcap_64
XFILLER_215_282 VDD VSS VDD VSS gf180mcu_fd_sc_mcu7t5v0__fillcap_64
XFILLER_203_422 VDD VSS VDD VSS gf180mcu_fd_sc_mcu7t5v0__fillcap_4
XFILLER_16_877 VDD VSS VDD VSS gf180mcu_fd_sc_mcu7t5v0__fillcap_8
XFILLER_188_635 VDD VSS VDD VSS gf180mcu_fd_sc_mcu7t5v0__fillcap_16
XFILLER_230_241 VDD VSS VDD VSS gf180mcu_fd_sc_mcu7t5v0__fillcap_4
XFILLER_43_696 VDD VSS VDD VSS gf180mcu_fd_sc_mcu7t5v0__fillcap_4
XFILLER_31_836 VDD VSS VDD VSS gf180mcu_fd_sc_mcu7t5v0__fillcap_4
XFILLER_129_702 VDD VSS VDD VSS gf180mcu_fd_sc_mcu7t5v0__fillcap_16
XFILLER_184_885 VDD VSS VDD VSS gf180mcu_fd_sc_mcu7t5v0__fillcap_4
XFILLER_143_204 VDD VSS VDD VSS gf180mcu_fd_sc_mcu7t5v0__fillcap_4
XFILLER_183_384 VDD VSS VDD VSS gf180mcu_fd_sc_mcu7t5v0__fillcap_16
XFILLER_109_481 VDD VSS VDD VSS gf180mcu_fd_sc_mcu7t5v0__fillcap_8
XFILLER_109_492 VDD VSS VDD VSS gf180mcu_fd_sc_mcu7t5v0__fillcap_64
X_3360_ wire20/I VDD VSS _4407_/D _4399_/Q _4407_/Q VDD VSS gf180mcu_fd_sc_mcu7t5v0__mux2_2
X_2311_ _3043_/A1 _3497_/C1 VDD VSS _2985_/C _4328_/Q _2991_/C VDD VSS gf180mcu_fd_sc_mcu7t5v0__nor4_2
X_3291_ _3291_/B _3305_/C VDD VSS _3308_/A3 _3291_/A1 _3291_/A2 VDD VSS gf180mcu_fd_sc_mcu7t5v0__aoi211_1
XFILLER_85_508 VDD VSS VDD VSS gf180mcu_fd_sc_mcu7t5v0__fillcap_4
XFILLER_239_842 VDD VSS VDD VSS gf180mcu_fd_sc_mcu7t5v0__fillcap_32
X_2242_ _2242_/A3 _2242_/A4 VDD VSS _2242_/Z _2242_/A1 _2242_/A2 VDD VSS gf180mcu_fd_sc_mcu7t5v0__and4_1
XFILLER_254_801 VDD VSS VDD VSS gf180mcu_fd_sc_mcu7t5v0__fillcap_4
XFILLER_266_661 VDD VSS VDD VSS gf180mcu_fd_sc_mcu7t5v0__fillcap_4
X_2173_ VDD VSS _2174_/A4 _4235_/Q _2677_/A1 VDD VSS gf180mcu_fd_sc_mcu7t5v0__nand2_1
XFILLER_18_2 VDD VSS VDD VSS gf180mcu_fd_sc_mcu7t5v0__fillcap_32
XFILLER_38_457 VDD VSS VDD VSS gf180mcu_fd_sc_mcu7t5v0__fillcap_64
XFILLER_207_772 VDD VSS VDD VSS gf180mcu_fd_sc_mcu7t5v0__fillcap_16
XFILLER_65_276 VDD VSS VDD VSS gf180mcu_fd_sc_mcu7t5v0__fillcap_4
XFILLER_53_416 VDD VSS VDD VSS gf180mcu_fd_sc_mcu7t5v0__fillcap_4
XFILLER_222_731 VDD VSS VDD VSS gf180mcu_fd_sc_mcu7t5v0__fillcap_4
XFILLER_222_775 VDD VSS VDD VSS gf180mcu_fd_sc_mcu7t5v0__fillcap_16
XFILLER_21_346 VDD VSS VDD VSS gf180mcu_fd_sc_mcu7t5v0__fillcap_4
XFILLER_119_212 VDD VSS VDD VSS gf180mcu_fd_sc_mcu7t5v0__fillcap_16
X_1957_ VDD VSS _4210_/Q _2623_/A1 VDD VSS gf180mcu_fd_sc_mcu7t5v0__clkinv_1
X_3627_ _2040_/Z _4161_/Q VDD VSS _3629_/A1 _4140_/Q _2039_/Z VDD VSS gf180mcu_fd_sc_mcu7t5v0__aoi22_1
XFILLER_174_395 VDD VSS VDD VSS gf180mcu_fd_sc_mcu7t5v0__fillcap_4
XFILLER_190_877 VDD VSS VDD VSS gf180mcu_fd_sc_mcu7t5v0__fillcap_8
X_3558_ _3558_/A3 VDD VSS _3570_/A2 wire72/Z _3558_/A2 VDD VSS gf180mcu_fd_sc_mcu7t5v0__nand3_1
XFILLER_89_814 VDD VSS VDD VSS gf180mcu_fd_sc_mcu7t5v0__fillcap_4
XFILLER_142_270 VDD VSS VDD VSS gf180mcu_fd_sc_mcu7t5v0__fillcap_8
XFILLER_0_206 VDD VSS VDD VSS gf180mcu_fd_sc_mcu7t5v0__fillcap_32
X_2509_ _2509_/S VDD VSS _4129_/D wire150/Z _4129_/Q VDD VSS gf180mcu_fd_sc_mcu7t5v0__mux2_2
XFILLER_89_836 VDD VSS VDD VSS gf180mcu_fd_sc_mcu7t5v0__fillcap_4
XFILLER_102_101 VDD VSS VDD VSS gf180mcu_fd_sc_mcu7t5v0__fillcap_4
X_3489_ VDD VSS _3494_/A2 wire74/Z _3488_/Z VDD VSS gf180mcu_fd_sc_mcu7t5v0__nand2_1
XFILLER_229_352 VDD VSS VDD VSS gf180mcu_fd_sc_mcu7t5v0__fillcap_64
XFILLER_243_72 VDD VSS VDD VSS gf180mcu_fd_sc_mcu7t5v0__fillcap_64
XFILLER_56_37 VDD VSS VDD VSS gf180mcu_fd_sc_mcu7t5v0__fillcap_64
XFILLER_244_311 VDD VSS VDD VSS gf180mcu_fd_sc_mcu7t5v0__fillcap_4
XFILLER_256_171 VDD VSS VDD VSS gf180mcu_fd_sc_mcu7t5v0__fillcap_4
XFILLER_57_766 VDD VSS VDD VSS gf180mcu_fd_sc_mcu7t5v0__fillcap_4
XFILLER_16_107 VDD VSS VDD VSS gf180mcu_fd_sc_mcu7t5v0__fillcap_64
XFILLER_212_263 VDD VSS VDD VSS gf180mcu_fd_sc_mcu7t5v0__fillcap_8
XFILLER_200_403 VDD VSS VDD VSS gf180mcu_fd_sc_mcu7t5v0__fillcap_8
XFILLER_13_836 VDD VSS VDD VSS gf180mcu_fd_sc_mcu7t5v0__fillcap_4
XFILLER_25_696 VDD VSS VDD VSS gf180mcu_fd_sc_mcu7t5v0__fillcap_4
XFILLER_8_317 VDD VSS VDD VSS gf180mcu_fd_sc_mcu7t5v0__fillcap_64
XFILLER_166_885 VDD VSS VDD VSS gf180mcu_fd_sc_mcu7t5v0__fillcap_4
XFILLER_126_716 VDD VSS VDD VSS gf180mcu_fd_sc_mcu7t5v0__fillcap_8
XFILLER_181_833 VDD VSS VDD VSS gf180mcu_fd_sc_mcu7t5v0__fillcap_4
XFILLER_137_62 VDD VSS VDD VSS gf180mcu_fd_sc_mcu7t5v0__fillcap_8
XFILLER_133_270 VDD VSS VDD VSS gf180mcu_fd_sc_mcu7t5v0__fillcap_8
XFILLER_79_346 VDD VSS VDD VSS gf180mcu_fd_sc_mcu7t5v0__fillcap_4
XFILLER_97_66 VDD VSS VDD VSS gf180mcu_fd_sc_mcu7t5v0__fillcap_4
XFILLER_248_661 VDD VSS VDD VSS gf180mcu_fd_sc_mcu7t5v0__fillcap_4
XFILLER_153_72 VDD VSS VDD VSS gf180mcu_fd_sc_mcu7t5v0__fillcap_8
XFILLER_0_784 VDD VSS VDD VSS gf180mcu_fd_sc_mcu7t5v0__fillcap_32
XFILLER_208_558 VDD VSS VDD VSS gf180mcu_fd_sc_mcu7t5v0__fillcap_8
XFILLER_47_276 VDD VSS VDD VSS gf180mcu_fd_sc_mcu7t5v0__fillcap_4
XFILLER_35_416 VDD VSS VDD VSS gf180mcu_fd_sc_mcu7t5v0__fillcap_4
XFILLER_176_605 VDD VSS VDD VSS gf180mcu_fd_sc_mcu7t5v0__fillcap_4
X_2860_ _4350_/Q VDD VSS _2861_/A3 _4351_/Q _2862_/B VDD VSS gf180mcu_fd_sc_mcu7t5v0__nor3_1
XFILLER_175_104 VDD VSS VDD VSS gf180mcu_fd_sc_mcu7t5v0__fillcap_4
X_2791_ VDD VSS _2892_/A1 _3023_/A2 _3040_/B VDD VSS gf180mcu_fd_sc_mcu7t5v0__nor2_1
X_4530_ _4530_/D _4530_/Q _4530_/RN VSS _4530_/CLK VDD VDD VSS gf180mcu_fd_sc_mcu7t5v0__dffrnq_1
XFILLER_144_513 VDD VSS VDD VSS gf180mcu_fd_sc_mcu7t5v0__fillcap_4
XFILLER_190_107 VDD VSS VDD VSS gf180mcu_fd_sc_mcu7t5v0__fillcap_16
XFILLER_156_340 VDD VSS VDD VSS gf180mcu_fd_sc_mcu7t5v0__fillcap_32
X_4461_ _4461_/D _4461_/Q wire210/Z VSS _4485_/CLK VDD VDD VSS gf180mcu_fd_sc_mcu7t5v0__dffrnq_1
XFILLER_172_877 VDD VSS VDD VSS gf180mcu_fd_sc_mcu7t5v0__fillcap_8
X_3412_ wire53/Z VDD VSS _4455_/D _4413_/Q _4455_/Q VDD VSS gf180mcu_fd_sc_mcu7t5v0__mux2_2
X_4392_ _4392_/D _4392_/Q wire193/I VSS _4400_/CLK VDD VDD VSS gf180mcu_fd_sc_mcu7t5v0__dffrnq_1
X_3343_ _3346_/S VDD VSS _4391_/D _4376_/Q _4391_/Q VDD VSS gf180mcu_fd_sc_mcu7t5v0__mux2_2
X_3274_ VDD VSS _3307_/A3 _3852_/Q _3318_/B VDD VSS gf180mcu_fd_sc_mcu7t5v0__nand2_1
XFILLER_227_812 VDD VSS VDD VSS gf180mcu_fd_sc_mcu7t5v0__fillcap_4
X_2225_ _2975_/A3 VDD VSS _2701_/B _4319_/Q _4505_/Q VDD VSS gf180mcu_fd_sc_mcu7t5v0__nand3_1
XFILLER_226_311 VDD VSS VDD VSS gf180mcu_fd_sc_mcu7t5v0__fillcap_4
XFILLER_238_171 VDD VSS VDD VSS gf180mcu_fd_sc_mcu7t5v0__fillcap_4
XFILLER_39_766 VDD VSS VDD VSS gf180mcu_fd_sc_mcu7t5v0__fillcap_4
X_2156_ _2156_/B VDD VSS output8/I _4303_/Q _2158_/A1 VDD VSS gf180mcu_fd_sc_mcu7t5v0__aoi21_1
X_2087_ VDD VSS _2087_/Z _3862_/Q _3863_/Q VDD VSS gf180mcu_fd_sc_mcu7t5v0__or2_1
XFILLER_198_229 VDD VSS VDD VSS gf180mcu_fd_sc_mcu7t5v0__fillcap_4
XFILLER_210_745 VDD VSS VDD VSS gf180mcu_fd_sc_mcu7t5v0__fillcap_4
XFILLER_194_457 VDD VSS VDD VSS gf180mcu_fd_sc_mcu7t5v0__fillcap_32
Xmax_length57 VSS _2146_/A2 wire58/Z VDD VDD VSS gf180mcu_fd_sc_mcu7t5v0__buf_2
Xmax_length46 VSS _3038_/C wire45/I VDD VDD VSS gf180mcu_fd_sc_mcu7t5v0__buf_2
X_2989_ VDD VSS _2992_/C _2989_/A1 _3223_/B VDD VSS gf180mcu_fd_sc_mcu7t5v0__nand2_1
XFILLER_148_885 VDD VSS VDD VSS gf180mcu_fd_sc_mcu7t5v0__fillcap_4
Xmax_length79 VSS _3609_/C _4593_/Q VDD VDD VSS gf180mcu_fd_sc_mcu7t5v0__buf_2
XFILLER_135_546 VDD VSS VDD VSS gf180mcu_fd_sc_mcu7t5v0__fillcap_8
XFILLER_150_527 VDD VSS VDD VSS gf180mcu_fd_sc_mcu7t5v0__fillcap_32
XFILLER_162_387 VDD VSS VDD VSS gf180mcu_fd_sc_mcu7t5v0__fillcap_8
XFILLER_162_376 VDD VSS VDD VSS gf180mcu_fd_sc_mcu7t5v0__fillcap_8
XFILLER_131_730 VDD VSS VDD VSS gf180mcu_fd_sc_mcu7t5v0__fillcap_32
XFILLER_190_37 VDD VSS VDD VSS gf180mcu_fd_sc_mcu7t5v0__fillcap_32
XFILLER_85_850 VDD VSS VDD VSS gf180mcu_fd_sc_mcu7t5v0__fillcap_4
XFILLER_17_416 VDD VSS VDD VSS gf180mcu_fd_sc_mcu7t5v0__fillcap_4
XFILLER_29_276 VDD VSS VDD VSS gf180mcu_fd_sc_mcu7t5v0__fillcap_4
XFILLER_260_667 VDD VSS VDD VSS gf180mcu_fd_sc_mcu7t5v0__fillcap_64
XFILLER_201_734 VDD VSS VDD VSS gf180mcu_fd_sc_mcu7t5v0__fillcap_8
XFILLER_185_413 VDD VSS VDD VSS gf180mcu_fd_sc_mcu7t5v0__fillcap_4
XFILLER_9_626 VDD VSS VDD VSS gf180mcu_fd_sc_mcu7t5v0__fillcap_4
XFILLER_197_295 VDD VSS VDD VSS gf180mcu_fd_sc_mcu7t5v0__fillcap_16
XFILLER_172_107 VDD VSS VDD VSS gf180mcu_fd_sc_mcu7t5v0__fillcap_64
XFILLER_138_351 VDD VSS VDD VSS gf180mcu_fd_sc_mcu7t5v0__fillcap_16
XFILLER_154_855 VDD VSS VDD VSS gf180mcu_fd_sc_mcu7t5v0__fillcap_16
XFILLER_154_877 VDD VSS VDD VSS gf180mcu_fd_sc_mcu7t5v0__fillcap_8
XFILLER_99_408 VDD VSS VDD VSS gf180mcu_fd_sc_mcu7t5v0__fillcap_8
XFILLER_114_719 VDD VSS VDD VSS gf180mcu_fd_sc_mcu7t5v0__fillcap_16
XFILLER_141_516 VDD VSS VDD VSS gf180mcu_fd_sc_mcu7t5v0__fillcap_4
XFILLER_164_93 VDD VSS VDD VSS gf180mcu_fd_sc_mcu7t5v0__fillcap_4
X_2010_ VDD VSS _4224_/Q _3066_/A2 VDD VSS gf180mcu_fd_sc_mcu7t5v0__clkinv_1
XFILLER_224_837 VDD VSS VDD VSS gf180mcu_fd_sc_mcu7t5v0__fillcap_32
X_3961_ VDD _3961_/Q _3969_/CLK VSS _3961_/D VDD VSS gf180mcu_fd_sc_mcu7t5v0__dffq_1
X_2912_ VDD _2912_/B _2919_/S _4307_/D _3244_/A2 VSS VDD VSS gf180mcu_fd_sc_mcu7t5v0__oai21_1
XFILLER_250_177 VDD VSS VDD VSS gf180mcu_fd_sc_mcu7t5v0__fillcap_64
XFILLER_188_240 VDD VSS VDD VSS gf180mcu_fd_sc_mcu7t5v0__fillcap_4
X_3892_ VDD _3892_/Q _3969_/CLK VSS _3892_/D VDD VSS gf180mcu_fd_sc_mcu7t5v0__dffq_1
XFILLER_176_457 VDD VSS VDD VSS gf180mcu_fd_sc_mcu7t5v0__fillcap_4
X_2843_ _4551_/Q VDD VSS _2843_/Z _3889_/Q _3881_/Q VDD VSS gf180mcu_fd_sc_mcu7t5v0__mux2_2
XFILLER_85_2 VDD VSS VDD VSS gf180mcu_fd_sc_mcu7t5v0__fillcap_64
X_2774_ _2774_/B VDD VSS _4301_/D _2774_/A1 _2774_/A2 VDD VSS gf180mcu_fd_sc_mcu7t5v0__aoi21_1
X_4513_ VSS _4514_/CLK VDD input3/Z _4514_/D _4512_/RN VDD VSS gf180mcu_fd_sc_mcu7t5v0__dffsnq_1
XFILLER_144_387 VDD VSS VDD VSS gf180mcu_fd_sc_mcu7t5v0__fillcap_4
X_4444_ _4444_/D _4444_/Q wire186/Z VSS _4498_/CLK VDD VDD VSS gf180mcu_fd_sc_mcu7t5v0__dffrnq_1
XFILLER_132_527 VDD VSS VDD VSS gf180mcu_fd_sc_mcu7t5v0__fillcap_64
X_4375_ _4375_/D _4375_/Q wire196/Z VSS _4402_/CLK VDD VDD VSS gf180mcu_fd_sc_mcu7t5v0__dffrnq_1
X_3326_ _3326_/B1 _3329_/A1 VDD VSS _3327_/I _4382_/Q _3329_/B VDD VSS gf180mcu_fd_sc_mcu7t5v0__aoi22_1
XFILLER_224_30 VDD VSS VDD VSS gf180mcu_fd_sc_mcu7t5v0__fillcap_4
X_3257_ VDD VSS _3257_/I _4363_/D VDD VSS gf180mcu_fd_sc_mcu7t5v0__clkinv_1
Xclkbuf_leaf_50_clk_i _4565_/CLK VSS VDD clkload5/I VDD VSS gf180mcu_fd_sc_mcu7t5v0__clkbuf_2
XFILLER_100_457 VDD VSS VDD VSS gf180mcu_fd_sc_mcu7t5v0__fillcap_64
XFILLER_215_804 VDD VSS VDD VSS gf180mcu_fd_sc_mcu7t5v0__fillcap_4
X_3188_ _3188_/B _3188_/C VDD VSS _3189_/A3 _3187_/C _3185_/Z VDD VSS gf180mcu_fd_sc_mcu7t5v0__aoi211_1
X_2208_ _2208_/A2 _2206_/Z _2208_/B2 VDD VSS _4502_/D _2213_/A1 VDD VSS gf180mcu_fd_sc_mcu7t5v0__oai22_1
X_2139_ _4534_/Q _4532_/Q VDD VSS _2140_/I _4137_/Q _2139_/A2 VDD VSS gf180mcu_fd_sc_mcu7t5v0__aoi211_1
XFILLER_242_667 VDD VSS VDD VSS gf180mcu_fd_sc_mcu7t5v0__fillcap_64
XFILLER_230_807 VDD VSS VDD VSS gf180mcu_fd_sc_mcu7t5v0__fillcap_64
XFILLER_81_352 VDD VSS VDD VSS gf180mcu_fd_sc_mcu7t5v0__fillcap_64
Xclkbuf_leaf_65_clk_i _4616_/CLK VSS VDD clkload2/I VDD VSS gf180mcu_fd_sc_mcu7t5v0__clkbuf_2
XFILLER_210_597 VDD VSS VDD VSS gf180mcu_fd_sc_mcu7t5v0__fillcap_8
XFILLER_154_107 VDD VSS VDD VSS gf180mcu_fd_sc_mcu7t5v0__fillcap_32
XFILLER_135_321 VDD VSS VDD VSS gf180mcu_fd_sc_mcu7t5v0__fillcap_16
XFILLER_108_535 VDD VSS VDD VSS gf180mcu_fd_sc_mcu7t5v0__fillcap_4
XFILLER_136_877 VDD VSS VDD VSS gf180mcu_fd_sc_mcu7t5v0__fillcap_8
XFILLER_163_674 VDD VSS VDD VSS gf180mcu_fd_sc_mcu7t5v0__fillcap_16
XFILLER_118_53 VDD VSS VDD VSS gf180mcu_fd_sc_mcu7t5v0__fillcap_4
XFILLER_116_590 VDD VSS VDD VSS gf180mcu_fd_sc_mcu7t5v0__fillcap_4
Xclkbuf_leaf_18_clk_i _4528_/CLK VSS VDD clkload3/I VDD VSS gf180mcu_fd_sc_mcu7t5v0__clkbuf_2
XFILLER_264_247 VDD VSS VDD VSS gf180mcu_fd_sc_mcu7t5v0__fillcap_64
XFILLER_233_601 VDD VSS VDD VSS gf180mcu_fd_sc_mcu7t5v0__fillcap_8
XFILLER_73_842 VDD VSS VDD VSS gf180mcu_fd_sc_mcu7t5v0__fillcap_32
XFILLER_27_72 VDD VSS VDD VSS gf180mcu_fd_sc_mcu7t5v0__fillcap_64
XFILLER_220_317 VDD VSS VDD VSS gf180mcu_fd_sc_mcu7t5v0__fillcap_64
XFILLER_232_177 VDD VSS VDD VSS gf180mcu_fd_sc_mcu7t5v0__fillcap_64
XFILLER_41_772 VDD VSS VDD VSS gf180mcu_fd_sc_mcu7t5v0__fillcap_64
XFILLER_158_457 VDD VSS VDD VSS gf180mcu_fd_sc_mcu7t5v0__fillcap_8
XFILLER_173_416 VDD VSS VDD VSS gf180mcu_fd_sc_mcu7t5v0__fillcap_4
XFILLER_173_438 VDD VSS VDD VSS gf180mcu_fd_sc_mcu7t5v0__fillcap_4
XFILLER_126_310 VDD VSS VDD VSS gf180mcu_fd_sc_mcu7t5v0__fillcap_4
XFILLER_127_833 VDD VSS VDD VSS gf180mcu_fd_sc_mcu7t5v0__fillcap_4
XFILLER_166_490 VDD VSS VDD VSS gf180mcu_fd_sc_mcu7t5v0__fillcap_4
XFILLER_154_652 VDD VSS VDD VSS gf180mcu_fd_sc_mcu7t5v0__fillcap_8
XFILLER_138_192 VDD VSS VDD VSS gf180mcu_fd_sc_mcu7t5v0__fillcap_32
XFILLER_126_387 VDD VSS VDD VSS gf180mcu_fd_sc_mcu7t5v0__fillcap_8
XFILLER_99_227 VDD VSS VDD VSS gf180mcu_fd_sc_mcu7t5v0__fillcap_32
X_2490_ _2491_/S VDD VSS _4112_/D wire152/Z _4112_/Q VDD VSS gf180mcu_fd_sc_mcu7t5v0__mux2_2
XFILLER_114_527 VDD VSS VDD VSS gf180mcu_fd_sc_mcu7t5v0__fillcap_16
XFILLER_114_505 VDD VSS VDD VSS gf180mcu_fd_sc_mcu7t5v0__fillcap_8
XFILLER_99_205 VDD VSS VDD VSS gf180mcu_fd_sc_mcu7t5v0__fillcap_4
X_4160_ _4160_/D _4160_/Q _4527_/RN VSS _4448_/CLK VDD VDD VSS gf180mcu_fd_sc_mcu7t5v0__dffrnq_1
XFILLER_95_422 VDD VSS VDD VSS gf180mcu_fd_sc_mcu7t5v0__fillcap_64
X_3111_ VDD VSS _3112_/B _3113_/S _3933_/Q VDD VSS gf180mcu_fd_sc_mcu7t5v0__nor2_1
XFILLER_256_737 VDD VSS VDD VSS gf180mcu_fd_sc_mcu7t5v0__fillcap_64
X_4091_ VDD _4091_/Q _4580_/CLK VSS _4091_/D VDD VSS gf180mcu_fd_sc_mcu7t5v0__dffq_1
X_3042_ VDD VSS _3043_/B _3038_/B _3042_/A2 VDD VSS gf180mcu_fd_sc_mcu7t5v0__nand2_1
XFILLER_224_612 VDD VSS VDD VSS gf180mcu_fd_sc_mcu7t5v0__fillcap_32
XFILLER_63_352 VDD VSS VDD VSS gf180mcu_fd_sc_mcu7t5v0__fillcap_64
XFILLER_224_667 VDD VSS VDD VSS gf180mcu_fd_sc_mcu7t5v0__fillcap_4
XFILLER_90_171 VDD VSS VDD VSS gf180mcu_fd_sc_mcu7t5v0__fillcap_4
XFILLER_251_486 VDD VSS VDD VSS gf180mcu_fd_sc_mcu7t5v0__fillcap_4
X_3944_ VDD _3944_/Q _3968_/CLK VSS _3944_/D VDD VSS gf180mcu_fd_sc_mcu7t5v0__dffq_1
XFILLER_149_413 VDD VSS VDD VSS gf180mcu_fd_sc_mcu7t5v0__fillcap_4
X_3875_ VDD _3875_/Q _4541_/CLK VSS _3875_/D VDD VSS gf180mcu_fd_sc_mcu7t5v0__dffq_1
XFILLER_177_766 VDD VSS VDD VSS gf180mcu_fd_sc_mcu7t5v0__fillcap_4
X_2826_ VDD _2827_/B _3038_/C _2988_/A1 _2886_/C VSS _2826_/A3 VDD VSS gf180mcu_fd_sc_mcu7t5v0__oai31_1
XFILLER_31_282 VDD VSS VDD VSS gf180mcu_fd_sc_mcu7t5v0__fillcap_64
X_2757_ _2763_/S VDD VSS _4290_/D wire134/Z wire179/Z VDD VSS gf180mcu_fd_sc_mcu7t5v0__mux2_2
XFILLER_118_877 VDD VSS VDD VSS gf180mcu_fd_sc_mcu7t5v0__fillcap_8
XFILLER_118_866 VDD VSS VDD VSS gf180mcu_fd_sc_mcu7t5v0__fillcap_8
X_2688_ VDD VSS _4241_/D _2686_/Z _2688_/A2 VDD VSS gf180mcu_fd_sc_mcu7t5v0__nand2_1
XFILLER_133_836 VDD VSS VDD VSS gf180mcu_fd_sc_mcu7t5v0__fillcap_4
X_4427_ _4427_/D _4427_/Q wire186/Z VSS _4427_/CLK VDD VDD VSS gf180mcu_fd_sc_mcu7t5v0__dffrnq_1
XFILLER_117_398 VDD VSS VDD VSS gf180mcu_fd_sc_mcu7t5v0__fillcap_16
XFILLER_133_858 VDD VSS VDD VSS gf180mcu_fd_sc_mcu7t5v0__fillcap_4
XFILLER_132_379 VDD VSS VDD VSS gf180mcu_fd_sc_mcu7t5v0__fillcap_4
X_4358_ _4358_/D _4358_/Q wire183/Z VSS _4365_/CLK VDD VDD VSS gf180mcu_fd_sc_mcu7t5v0__dffrnq_1
X_4289_ _4289_/D _4289_/Q _4525_/RN VSS _4338_/CLK VDD VDD VSS gf180mcu_fd_sc_mcu7t5v0__dffrnq_1
X_3309_ VDD _3309_/B _3309_/A2 _4372_/D _3306_/Z VSS VDD VSS gf180mcu_fd_sc_mcu7t5v0__oai21_1
XFILLER_246_247 VDD VSS VDD VSS gf180mcu_fd_sc_mcu7t5v0__fillcap_64
XFILLER_251_72 VDD VSS VDD VSS gf180mcu_fd_sc_mcu7t5v0__fillcap_64
XFILLER_261_206 VDD VSS VDD VSS gf180mcu_fd_sc_mcu7t5v0__fillcap_4
XFILLER_55_842 VDD VSS VDD VSS gf180mcu_fd_sc_mcu7t5v0__fillcap_32
XFILLER_70_801 VDD VSS VDD VSS gf180mcu_fd_sc_mcu7t5v0__fillcap_4
XFILLER_64_37 VDD VSS VDD VSS gf180mcu_fd_sc_mcu7t5v0__fillcap_64
XFILLER_214_177 VDD VSS VDD VSS gf180mcu_fd_sc_mcu7t5v0__fillcap_8
XFILLER_120_98 VDD VSS VDD VSS gf180mcu_fd_sc_mcu7t5v0__fillcap_4
XFILLER_23_772 VDD VSS VDD VSS gf180mcu_fd_sc_mcu7t5v0__fillcap_64
XFILLER_50_591 VDD VSS VDD VSS gf180mcu_fd_sc_mcu7t5v0__fillcap_4
XFILLER_128_619 VDD VSS VDD VSS gf180mcu_fd_sc_mcu7t5v0__fillcap_32
XFILLER_182_224 VDD VSS VDD VSS gf180mcu_fd_sc_mcu7t5v0__fillcap_16
XFILLER_167_298 VDD VSS VDD VSS gf180mcu_fd_sc_mcu7t5v0__fillcap_4
XFILLER_108_310 VDD VSS VDD VSS gf180mcu_fd_sc_mcu7t5v0__fillcap_4
XFILLER_202_2 VDD VSS VDD VSS gf180mcu_fd_sc_mcu7t5v0__fillcap_32
XFILLER_182_279 VDD VSS VDD VSS gf180mcu_fd_sc_mcu7t5v0__fillcap_8
XFILLER_151_622 VDD VSS VDD VSS gf180mcu_fd_sc_mcu7t5v0__fillcap_8
XFILLER_123_324 VDD VSS VDD VSS gf180mcu_fd_sc_mcu7t5v0__fillcap_16
XFILLER_108_387 VDD VSS VDD VSS gf180mcu_fd_sc_mcu7t5v0__fillcap_16
XFILLER_1_142 VDD VSS VDD VSS gf180mcu_fd_sc_mcu7t5v0__fillcap_64
XFILLER_77_422 VDD VSS VDD VSS gf180mcu_fd_sc_mcu7t5v0__fillcap_64
XFILLER_89_282 VDD VSS VDD VSS gf180mcu_fd_sc_mcu7t5v0__fillcap_64
XFILLER_238_737 VDD VSS VDD VSS gf180mcu_fd_sc_mcu7t5v0__fillcap_64
XFILLER_265_556 VDD VSS VDD VSS gf180mcu_fd_sc_mcu7t5v0__fillcap_4
XFILLER_45_352 VDD VSS VDD VSS gf180mcu_fd_sc_mcu7t5v0__fillcap_64
XFILLER_206_667 VDD VSS VDD VSS gf180mcu_fd_sc_mcu7t5v0__fillcap_8
XFILLER_221_604 VDD VSS VDD VSS gf180mcu_fd_sc_mcu7t5v0__fillcap_16
XFILLER_60_311 VDD VSS VDD VSS gf180mcu_fd_sc_mcu7t5v0__fillcap_4
XFILLER_72_171 VDD VSS VDD VSS gf180mcu_fd_sc_mcu7t5v0__fillcap_4
XFILLER_233_486 VDD VSS VDD VSS gf180mcu_fd_sc_mcu7t5v0__fillcap_4
X_1990_ VDD VSS _4074_/Q _3438_/A2 VDD VSS gf180mcu_fd_sc_mcu7t5v0__clkinv_1
XFILLER_159_766 VDD VSS VDD VSS gf180mcu_fd_sc_mcu7t5v0__fillcap_4
XFILLER_159_788 VDD VSS VDD VSS gf180mcu_fd_sc_mcu7t5v0__fillcap_4
XFILLER_13_282 VDD VSS VDD VSS gf180mcu_fd_sc_mcu7t5v0__fillcap_64
X_3660_ _3660_/A3 VDD VSS _4489_/D _3681_/A1 _3660_/A2 VDD VSS gf180mcu_fd_sc_mcu7t5v0__nand3_1
XFILLER_118_107 VDD VSS VDD VSS gf180mcu_fd_sc_mcu7t5v0__fillcap_32
X_2611_ _2623_/A3 _2620_/B VDD VSS _2612_/I _4209_/Q _2609_/Z _2637_/A2 VDD VSS gf180mcu_fd_sc_mcu7t5v0__oai221_1
Xclkload23 VDD VSS _4526_/CLK clkload23/ZN VDD VSS gf180mcu_fd_sc_mcu7t5v0__clkinv_2
Xclkload12 VSS clkload12/Z _4477_/CLK VDD VDD VSS gf180mcu_fd_sc_mcu7t5v0__clkbuf_1
Xclkload34 VSS clkload34/Z _4473_/CLK VDD VDD VSS gf180mcu_fd_sc_mcu7t5v0__clkbuf_1
X_3591_ _3591_/A3 VDD VSS _3592_/A3 wire72/Z _3591_/A2 VDD VSS gf180mcu_fd_sc_mcu7t5v0__nand3_1
Xclkload78 VDD VSS _4554_/CLK clkload78/ZN VDD VSS gf180mcu_fd_sc_mcu7t5v0__clkinv_2
Xclkload67 VSS clkload67/Z _4210_/CLK VDD VDD VSS gf180mcu_fd_sc_mcu7t5v0__clkbuf_1
Xclkload56 VSS clkload56/Z _4345_/CLK VDD VDD VSS gf180mcu_fd_sc_mcu7t5v0__clkbuf_1
X_2542_ wire28/I VDD VSS _4165_/D wire133/Z _4165_/Q VDD VSS gf180mcu_fd_sc_mcu7t5v0__mux2_2
Xclkload45 VDD VSS _4032_/CLK clkload45/ZN VDD VSS gf180mcu_fd_sc_mcu7t5v0__clkinv_1
Xclkload89 VSS clkload89/ZN _4573_/CLK VDD VDD VSS gf180mcu_fd_sc_mcu7t5v0__inv_4
XFILLER_5_492 VDD VSS VDD VSS gf180mcu_fd_sc_mcu7t5v0__fillcap_64
XFILLER_127_696 VDD VSS VDD VSS gf180mcu_fd_sc_mcu7t5v0__fillcap_4
XFILLER_115_858 VDD VSS VDD VSS gf180mcu_fd_sc_mcu7t5v0__fillcap_4
X_4212_ _4212_/D _4212_/Q _4212_/RN VSS _4214_/CLK VDD VDD VSS gf180mcu_fd_sc_mcu7t5v0__dffrnq_1
X_2473_ VDD VSS _2501_/A2 _4580_/Q _4581_/Q VDD VSS gf180mcu_fd_sc_mcu7t5v0__nor2_1
XFILLER_48_2 VDD VSS VDD VSS gf180mcu_fd_sc_mcu7t5v0__fillcap_32
X_4143_ _4143_/D _4143_/Q wire192/Z VSS _4364_/CLK VDD VDD VSS gf180mcu_fd_sc_mcu7t5v0__dffrnq_1
XFILLER_229_759 VDD VSS VDD VSS gf180mcu_fd_sc_mcu7t5v0__fillcap_8
XFILLER_228_247 VDD VSS VDD VSS gf180mcu_fd_sc_mcu7t5v0__fillcap_64
X_4074_ VDD _4074_/Q _4473_/CLK VSS _4074_/D VDD VSS gf180mcu_fd_sc_mcu7t5v0__dffq_1
XFILLER_243_206 VDD VSS VDD VSS gf180mcu_fd_sc_mcu7t5v0__fillcap_4
X_3025_ _3025_/B1 _3025_/C VDD VSS _3029_/A3 _3025_/A1 _3271_/B _3208_/A2 VDD VSS
+ gf180mcu_fd_sc_mcu7t5v0__oai221_1
XFILLER_37_842 VDD VSS VDD VSS gf180mcu_fd_sc_mcu7t5v0__fillcap_32
XFILLER_64_661 VDD VSS VDD VSS gf180mcu_fd_sc_mcu7t5v0__fillcap_4
XFILLER_52_801 VDD VSS VDD VSS gf180mcu_fd_sc_mcu7t5v0__fillcap_4
X_3927_ VDD _3927_/Q _3936_/CLK VSS _3927_/D VDD VSS gf180mcu_fd_sc_mcu7t5v0__dffq_1
XFILLER_137_405 VDD VSS VDD VSS gf180mcu_fd_sc_mcu7t5v0__fillcap_8
XFILLER_32_591 VDD VSS VDD VSS gf180mcu_fd_sc_mcu7t5v0__fillcap_4
XFILLER_20_731 VDD VSS VDD VSS gf180mcu_fd_sc_mcu7t5v0__fillcap_4
Xclkload6 VDD VSS clkload6/ZN clkload6/I VDD VSS gf180mcu_fd_sc_mcu7t5v0__clkinv_8
X_3858_ VSS _4449_/CLK VDD _3858_/D _3858_/Q wire196/I VDD VSS gf180mcu_fd_sc_mcu7t5v0__dffsnq_1
X_3789_ _3789_/B VDD VSS _3954_/D _3789_/A1 wire16/I VDD VSS gf180mcu_fd_sc_mcu7t5v0__aoi21_1
X_2809_ _3043_/A1 VDD VSS _3032_/A2 _3226_/A1 _4327_/Q VDD VSS gf180mcu_fd_sc_mcu7t5v0__nand3_1
XFILLER_105_368 VDD VSS VDD VSS gf180mcu_fd_sc_mcu7t5v0__fillcap_4
XFILLER_59_422 VDD VSS VDD VSS gf180mcu_fd_sc_mcu7t5v0__fillcap_64
XFILLER_120_349 VDD VSS VDD VSS gf180mcu_fd_sc_mcu7t5v0__fillcap_8
XFILLER_86_241 VDD VSS VDD VSS gf180mcu_fd_sc_mcu7t5v0__fillcap_4
XFILLER_247_556 VDD VSS VDD VSS gf180mcu_fd_sc_mcu7t5v0__fillcap_4
XFILLER_228_792 VDD VSS VDD VSS gf180mcu_fd_sc_mcu7t5v0__fillcap_8
XFILLER_27_352 VDD VSS VDD VSS gf180mcu_fd_sc_mcu7t5v0__fillcap_64
XFILLER_42_311 VDD VSS VDD VSS gf180mcu_fd_sc_mcu7t5v0__fillcap_4
XFILLER_54_171 VDD VSS VDD VSS gf180mcu_fd_sc_mcu7t5v0__fillcap_4
XFILLER_152_2 VDD VSS VDD VSS gf180mcu_fd_sc_mcu7t5v0__fillcap_16
XFILLER_7_702 VDD VSS VDD VSS gf180mcu_fd_sc_mcu7t5v0__fillcap_64
XFILLER_10_241 VDD VSS VDD VSS gf180mcu_fd_sc_mcu7t5v0__fillcap_4
XFILLER_128_449 VDD VSS VDD VSS gf180mcu_fd_sc_mcu7t5v0__fillcap_4
XFILLER_109_696 VDD VSS VDD VSS gf180mcu_fd_sc_mcu7t5v0__fillcap_4
XFILLER_2_451 VDD VSS VDD VSS gf180mcu_fd_sc_mcu7t5v0__fillcap_4
XFILLER_78_731 VDD VSS VDD VSS gf180mcu_fd_sc_mcu7t5v0__fillcap_4
XFILLER_111_338 VDD VSS VDD VSS gf180mcu_fd_sc_mcu7t5v0__fillcap_8
XFILLER_172_71 VDD VSS VDD VSS gf180mcu_fd_sc_mcu7t5v0__fillcap_16
XFILLER_225_206 VDD VSS VDD VSS gf180mcu_fd_sc_mcu7t5v0__fillcap_4
XFILLER_19_842 VDD VSS VDD VSS gf180mcu_fd_sc_mcu7t5v0__fillcap_32
XFILLER_46_661 VDD VSS VDD VSS gf180mcu_fd_sc_mcu7t5v0__fillcap_4
XFILLER_34_801 VDD VSS VDD VSS gf180mcu_fd_sc_mcu7t5v0__fillcap_4
XFILLER_187_850 VDD VSS VDD VSS gf180mcu_fd_sc_mcu7t5v0__fillcap_4
X_1973_ VDD VSS _4352_/Q _3236_/A1 VDD VSS gf180mcu_fd_sc_mcu7t5v0__clkinv_1
XFILLER_14_591 VDD VSS VDD VSS gf180mcu_fd_sc_mcu7t5v0__fillcap_4
X_3712_ VDD VSS _3713_/B _3763_/I0 _3718_/S VDD VSS gf180mcu_fd_sc_mcu7t5v0__nand2_1
XFILLER_119_438 VDD VSS VDD VSS gf180mcu_fd_sc_mcu7t5v0__fillcap_8
Xclkload101 VSS clkload101/ZN _3937_/CLK VDD VDD VSS gf180mcu_fd_sc_mcu7t5v0__inv_3
X_3643_ VDD VSS _3645_/A2 _4483_/Q _3682_/A2 VDD VSS gf180mcu_fd_sc_mcu7t5v0__nand2_1
XFILLER_134_419 VDD VSS VDD VSS gf180mcu_fd_sc_mcu7t5v0__fillcap_16
XFILLER_162_717 VDD VSS VDD VSS gf180mcu_fd_sc_mcu7t5v0__fillcap_16
XFILLER_161_227 VDD VSS VDD VSS gf180mcu_fd_sc_mcu7t5v0__fillcap_8
X_3574_ VSS VDD _3685_/C2 _4369_/Q _4201_/Q _3685_/B1 _3685_/A2 _4169_/Q _3575_/A3
+ VDD VSS gf180mcu_fd_sc_mcu7t5v0__aoi222_1
X_2525_ _2536_/S VDD VSS _4151_/D _4151_/Q wire138/Z VDD VSS gf180mcu_fd_sc_mcu7t5v0__mux2_2
X_2456_ _2463_/S VDD VSS _4082_/D wire168/I _4082_/Q VDD VSS gf180mcu_fd_sc_mcu7t5v0__mux2_2
XFILLER_103_828 VDD VSS VDD VSS gf180mcu_fd_sc_mcu7t5v0__fillcap_8
XFILLER_68_241 VDD VSS VDD VSS gf180mcu_fd_sc_mcu7t5v0__fillcap_4
X_4126_ VDD _4126_/Q _4126_/CLK VSS _4126_/D VDD VSS gf180mcu_fd_sc_mcu7t5v0__dffq_1
X_2387_ _2393_/S VDD VSS _4027_/D _2466_/I0 _4027_/Q VDD VSS gf180mcu_fd_sc_mcu7t5v0__mux2_2
X_4057_ VDD _4057_/Q _4065_/CLK VSS _4057_/D VDD VSS gf180mcu_fd_sc_mcu7t5v0__dffq_1
X_3008_ _3007_/Z _2831_/B _3008_/B2 VDD VSS _3009_/A2 _3218_/B1 _3006_/Z VDD VSS gf180mcu_fd_sc_mcu7t5v0__oai32_1
XFILLER_24_311 VDD VSS VDD VSS gf180mcu_fd_sc_mcu7t5v0__fillcap_4
XFILLER_36_171 VDD VSS VDD VSS gf180mcu_fd_sc_mcu7t5v0__fillcap_4
XFILLER_193_842 VDD VSS VDD VSS gf180mcu_fd_sc_mcu7t5v0__fillcap_4
XFILLER_193_26 VDD VSS VDD VSS gf180mcu_fd_sc_mcu7t5v0__fillcap_4
XFILLER_145_290 VDD VSS VDD VSS gf180mcu_fd_sc_mcu7t5v0__fillcap_4
XFILLER_161_772 VDD VSS VDD VSS gf180mcu_fd_sc_mcu7t5v0__fillcap_16
XFILLER_133_474 VDD VSS VDD VSS gf180mcu_fd_sc_mcu7t5v0__fillcap_16
XFILLER_121_625 VDD VSS VDD VSS gf180mcu_fd_sc_mcu7t5v0__fillcap_4
XFILLER_120_168 VDD VSS VDD VSS gf180mcu_fd_sc_mcu7t5v0__fillcap_4
XFILLER_28_661 VDD VSS VDD VSS gf180mcu_fd_sc_mcu7t5v0__fillcap_4
XFILLER_16_801 VDD VSS VDD VSS gf180mcu_fd_sc_mcu7t5v0__fillcap_4
XFILLER_35_72 VDD VSS VDD VSS gf180mcu_fd_sc_mcu7t5v0__fillcap_64
XFILLER_183_352 VDD VSS VDD VSS gf180mcu_fd_sc_mcu7t5v0__fillcap_32
X_2310_ _4329_/Q VDD VSS _2783_/A2 _4328_/Q _2991_/C VDD VSS gf180mcu_fd_sc_mcu7t5v0__nor3_1
X_3290_ _3290_/A3 VDD VSS _3291_/B _4380_/Q _3290_/A2 VDD VSS gf180mcu_fd_sc_mcu7t5v0__and3_1
XFILLER_151_282 VDD VSS VDD VSS gf180mcu_fd_sc_mcu7t5v0__fillcap_8
X_2241_ _4152_/Q _4131_/Q VDD VSS _2242_/A4 _4130_/Q _4151_/Q VDD VSS gf180mcu_fd_sc_mcu7t5v0__aoi22_1
XFILLER_111_124 VDD VSS VDD VSS gf180mcu_fd_sc_mcu7t5v0__fillcap_16
XFILLER_112_647 VDD VSS VDD VSS gf180mcu_fd_sc_mcu7t5v0__fillcap_4
X_2172_ VDD VSS _2664_/A2 _2673_/A1 _2684_/A2 VDD VSS gf180mcu_fd_sc_mcu7t5v0__nor2_1
XFILLER_80_247 VDD VSS VDD VSS gf180mcu_fd_sc_mcu7t5v0__fillcap_64
XFILLER_18_171 VDD VSS VDD VSS gf180mcu_fd_sc_mcu7t5v0__fillcap_4
XFILLER_206_294 VDD VSS VDD VSS gf180mcu_fd_sc_mcu7t5v0__fillcap_16
XFILLER_187_680 VDD VSS VDD VSS gf180mcu_fd_sc_mcu7t5v0__fillcap_4
X_1956_ VDD VSS _4214_/Q _2276_/C VDD VSS gf180mcu_fd_sc_mcu7t5v0__clkinv_1
XFILLER_147_533 VDD VSS VDD VSS gf180mcu_fd_sc_mcu7t5v0__fillcap_16
XFILLER_147_577 VDD VSS VDD VSS gf180mcu_fd_sc_mcu7t5v0__fillcap_4
XFILLER_190_823 VDD VSS VDD VSS gf180mcu_fd_sc_mcu7t5v0__fillcap_8
XFILLER_174_374 VDD VSS VDD VSS gf180mcu_fd_sc_mcu7t5v0__fillcap_8
X_3626_ VDD VSS _3626_/I _4478_/D VDD VSS gf180mcu_fd_sc_mcu7t5v0__clkinv_1
X_3557_ _3557_/B _3590_/C VDD VSS _3558_/A3 _3515_/C _3553_/Z VDD VSS gf180mcu_fd_sc_mcu7t5v0__oai211_1
XFILLER_143_772 VDD VSS VDD VSS gf180mcu_fd_sc_mcu7t5v0__fillcap_4
X_2508_ _2509_/S VDD VSS _4128_/D wire152/Z _4128_/Q VDD VSS gf180mcu_fd_sc_mcu7t5v0__mux2_2
X_3488_ _4060_/Q VSS VDD _4044_/Q _4052_/Q wire88/Z _4036_/Q wire83/Z _3488_/Z VDD
+ VSS gf180mcu_fd_sc_mcu7t5v0__mux4_1
X_2439_ _2441_/S VDD VSS _4071_/D _4071_/Q wire154/Z VDD VSS gf180mcu_fd_sc_mcu7t5v0__mux2_2
X_4109_ VDD _4109_/Q _4129_/CLK VSS _4109_/D VDD VSS gf180mcu_fd_sc_mcu7t5v0__dffq_1
XFILLER_72_737 VDD VSS VDD VSS gf180mcu_fd_sc_mcu7t5v0__fillcap_64
XFILLER_212_231 VDD VSS VDD VSS gf180mcu_fd_sc_mcu7t5v0__fillcap_8
XFILLER_72_37 VDD VSS VDD VSS gf180mcu_fd_sc_mcu7t5v0__fillcap_64
XFILLER_169_135 VDD VSS VDD VSS gf180mcu_fd_sc_mcu7t5v0__fillcap_4
XFILLER_188_37 VDD VSS VDD VSS gf180mcu_fd_sc_mcu7t5v0__fillcap_64
XFILLER_138_500 VDD VSS VDD VSS gf180mcu_fd_sc_mcu7t5v0__fillcap_16
XFILLER_40_667 VDD VSS VDD VSS gf180mcu_fd_sc_mcu7t5v0__fillcap_64
XFILLER_268_70 VDD VSS VDD VSS gf180mcu_fd_sc_mcu7t5v0__fillcap_32
XFILLER_138_555 VDD VSS VDD VSS gf180mcu_fd_sc_mcu7t5v0__fillcap_8
XFILLER_165_352 VDD VSS VDD VSS gf180mcu_fd_sc_mcu7t5v0__fillcap_64
XFILLER_153_525 VDD VSS VDD VSS gf180mcu_fd_sc_mcu7t5v0__fillcap_4
XFILLER_192_171 VDD VSS VDD VSS gf180mcu_fd_sc_mcu7t5v0__fillcap_4
XFILLER_180_300 VDD VSS VDD VSS gf180mcu_fd_sc_mcu7t5v0__fillcap_8
XFILLER_115_2 VDD VSS VDD VSS gf180mcu_fd_sc_mcu7t5v0__fillcap_8
XFILLER_137_96 VDD VSS VDD VSS gf180mcu_fd_sc_mcu7t5v0__fillcap_4
XFILLER_133_282 VDD VSS VDD VSS gf180mcu_fd_sc_mcu7t5v0__fillcap_8
XFILLER_94_317 VDD VSS VDD VSS gf180mcu_fd_sc_mcu7t5v0__fillcap_8
XFILLER_263_632 VDD VSS VDD VSS gf180mcu_fd_sc_mcu7t5v0__fillcap_64
XFILLER_62_247 VDD VSS VDD VSS gf180mcu_fd_sc_mcu7t5v0__fillcap_64
XFILLER_231_562 VDD VSS VDD VSS gf180mcu_fd_sc_mcu7t5v0__fillcap_4
XFILLER_87_6 VDD VSS VDD VSS gf180mcu_fd_sc_mcu7t5v0__fillcap_64
XFILLER_157_842 VDD VSS VDD VSS gf180mcu_fd_sc_mcu7t5v0__fillcap_16
X_2790_ _3497_/C1 VDD VSS _3040_/B _4328_/Q _3043_/A1 VDD VSS gf180mcu_fd_sc_mcu7t5v0__nor3_1
XFILLER_30_177 VDD VSS VDD VSS gf180mcu_fd_sc_mcu7t5v0__fillcap_64
XFILLER_129_577 VDD VSS VDD VSS gf180mcu_fd_sc_mcu7t5v0__fillcap_32
X_4460_ _4460_/D _4460_/Q _4536_/RN VSS _4535_/CLK VDD VDD VSS gf180mcu_fd_sc_mcu7t5v0__dffrnq_1
XFILLER_8_885 VDD VSS VDD VSS gf180mcu_fd_sc_mcu7t5v0__fillcap_4
X_3411_ _3424_/S VDD VSS _4454_/D _4412_/Q _4454_/Q VDD VSS gf180mcu_fd_sc_mcu7t5v0__mux2_2
X_4391_ _4391_/D _4391_/Q wire193/I VSS _4430_/CLK VDD VDD VSS gf180mcu_fd_sc_mcu7t5v0__dffrnq_1
X_3342_ _3346_/S VDD VSS _4390_/D _4375_/Q _4390_/Q VDD VSS gf180mcu_fd_sc_mcu7t5v0__mux2_2
XFILLER_86_807 VDD VSS VDD VSS gf180mcu_fd_sc_mcu7t5v0__fillcap_8
XFILLER_98_667 VDD VSS VDD VSS gf180mcu_fd_sc_mcu7t5v0__fillcap_16
XFILLER_30_2 VDD VSS VDD VSS gf180mcu_fd_sc_mcu7t5v0__fillcap_32
X_3273_ VDD VSS _3273_/I _4371_/D VDD VSS gf180mcu_fd_sc_mcu7t5v0__clkinv_1
XFILLER_98_689 VDD VSS VDD VSS gf180mcu_fd_sc_mcu7t5v0__fillcap_16
X_2224_ VDD VSS _2975_/A3 _4370_/Q wire69/Z VDD VSS gf180mcu_fd_sc_mcu7t5v0__nor2_1
X_2155_ VDD VSS _2682_/S _4503_/D VDD VSS gf180mcu_fd_sc_mcu7t5v0__clkinv_1
XFILLER_253_142 VDD VSS VDD VSS gf180mcu_fd_sc_mcu7t5v0__fillcap_64
XFILLER_66_597 VDD VSS VDD VSS gf180mcu_fd_sc_mcu7t5v0__fillcap_64
XFILLER_54_737 VDD VSS VDD VSS gf180mcu_fd_sc_mcu7t5v0__fillcap_64
X_2086_ VDD VSS _4591_/D _2086_/A1 _2097_/A2 VDD VSS gf180mcu_fd_sc_mcu7t5v0__nor2_1
XFILLER_179_422 VDD VSS VDD VSS gf180mcu_fd_sc_mcu7t5v0__fillcap_32
XFILLER_81_578 VDD VSS VDD VSS gf180mcu_fd_sc_mcu7t5v0__fillcap_8
XFILLER_250_871 VDD VSS VDD VSS gf180mcu_fd_sc_mcu7t5v0__fillcap_4
XFILLER_10_807 VDD VSS VDD VSS gf180mcu_fd_sc_mcu7t5v0__fillcap_64
XFILLER_22_667 VDD VSS VDD VSS gf180mcu_fd_sc_mcu7t5v0__fillcap_64
X_2988_ _3212_/A2 VDD VSS _2997_/A1 _2988_/A1 _2886_/C VDD VSS gf180mcu_fd_sc_mcu7t5v0__nor3_1
X_1939_ VDD VSS _4346_/Q _2983_/A1 VDD VSS gf180mcu_fd_sc_mcu7t5v0__clkinv_1
XFILLER_147_352 VDD VSS VDD VSS gf180mcu_fd_sc_mcu7t5v0__fillcap_8
XFILLER_175_694 VDD VSS VDD VSS gf180mcu_fd_sc_mcu7t5v0__fillcap_4
X_3609_ _3609_/B _3609_/C VDD VSS _3610_/A3 wire82/Z _3605_/Z VDD VSS gf180mcu_fd_sc_mcu7t5v0__oai211_1
X_4589_ _4589_/D _4614_/D _4616_/RN VSS _4605_/CLK VDD VDD VSS gf180mcu_fd_sc_mcu7t5v0__dffrnq_1
XFILLER_103_422 VDD VSS VDD VSS gf180mcu_fd_sc_mcu7t5v0__fillcap_4
XFILLER_115_282 VDD VSS VDD VSS gf180mcu_fd_sc_mcu7t5v0__fillcap_16
XFILLER_88_177 VDD VSS VDD VSS gf180mcu_fd_sc_mcu7t5v0__fillcap_64
XFILLER_76_317 VDD VSS VDD VSS gf180mcu_fd_sc_mcu7t5v0__fillcap_64
XFILLER_245_632 VDD VSS VDD VSS gf180mcu_fd_sc_mcu7t5v0__fillcap_64
XFILLER_257_492 VDD VSS VDD VSS gf180mcu_fd_sc_mcu7t5v0__fillcap_64
XFILLER_44_247 VDD VSS VDD VSS gf180mcu_fd_sc_mcu7t5v0__fillcap_64
XFILLER_201_702 VDD VSS VDD VSS gf180mcu_fd_sc_mcu7t5v0__fillcap_32
XFILLER_213_573 VDD VSS VDD VSS gf180mcu_fd_sc_mcu7t5v0__fillcap_16
XFILLER_240_381 VDD VSS VDD VSS gf180mcu_fd_sc_mcu7t5v0__fillcap_4
XFILLER_232_2 VDD VSS VDD VSS gf180mcu_fd_sc_mcu7t5v0__fillcap_32
XFILLER_197_274 VDD VSS VDD VSS gf180mcu_fd_sc_mcu7t5v0__fillcap_4
XFILLER_201_757 VDD VSS VDD VSS gf180mcu_fd_sc_mcu7t5v0__fillcap_8
XFILLER_139_820 VDD VSS VDD VSS gf180mcu_fd_sc_mcu7t5v0__fillcap_4
XFILLER_139_842 VDD VSS VDD VSS gf180mcu_fd_sc_mcu7t5v0__fillcap_8
XFILLER_12_177 VDD VSS VDD VSS gf180mcu_fd_sc_mcu7t5v0__fillcap_64
XFILLER_193_480 VDD VSS VDD VSS gf180mcu_fd_sc_mcu7t5v0__fillcap_8
XFILLER_107_772 VDD VSS VDD VSS gf180mcu_fd_sc_mcu7t5v0__fillcap_16
XFILLER_4_387 VDD VSS VDD VSS gf180mcu_fd_sc_mcu7t5v0__fillcap_64
XFILLER_267_212 VDD VSS VDD VSS gf180mcu_fd_sc_mcu7t5v0__fillcap_64
XFILLER_68_807 VDD VSS VDD VSS gf180mcu_fd_sc_mcu7t5v0__fillcap_64
XFILLER_122_753 VDD VSS VDD VSS gf180mcu_fd_sc_mcu7t5v0__fillcap_4
XFILLER_235_142 VDD VSS VDD VSS gf180mcu_fd_sc_mcu7t5v0__fillcap_64
XFILLER_48_597 VDD VSS VDD VSS gf180mcu_fd_sc_mcu7t5v0__fillcap_64
XFILLER_36_737 VDD VSS VDD VSS gf180mcu_fd_sc_mcu7t5v0__fillcap_64
XFILLER_250_101 VDD VSS VDD VSS gf180mcu_fd_sc_mcu7t5v0__fillcap_4
XFILLER_63_556 VDD VSS VDD VSS gf180mcu_fd_sc_mcu7t5v0__fillcap_4
X_3960_ VDD _3960_/Q _3968_/CLK VSS _3960_/D VDD VSS gf180mcu_fd_sc_mcu7t5v0__dffq_1
X_2911_ VDD VSS _2912_/B _4307_/Q _2919_/S VDD VSS gf180mcu_fd_sc_mcu7t5v0__nand2_1
X_3891_ VDD _3891_/Q _4541_/CLK VSS _3891_/D VDD VSS gf180mcu_fd_sc_mcu7t5v0__dffq_1
XFILLER_176_403 VDD VSS VDD VSS gf180mcu_fd_sc_mcu7t5v0__fillcap_4
XFILLER_188_263 VDD VSS VDD VSS gf180mcu_fd_sc_mcu7t5v0__fillcap_8
X_2842_ _2842_/B _3158_/B VDD VSS _2853_/B2 _3157_/A1 _3897_/Q VDD VSS gf180mcu_fd_sc_mcu7t5v0__oai211_1
XFILLER_31_486 VDD VSS VDD VSS gf180mcu_fd_sc_mcu7t5v0__fillcap_4
X_2773_ _4515_/Q VDD VSS _2774_/B _4515_/D _4514_/D VDD VSS gf180mcu_fd_sc_mcu7t5v0__nor3_1
XFILLER_129_330 VDD VSS VDD VSS gf180mcu_fd_sc_mcu7t5v0__fillcap_4
XFILLER_129_352 VDD VSS VDD VSS gf180mcu_fd_sc_mcu7t5v0__fillcap_4
XFILLER_78_2 VDD VSS VDD VSS gf180mcu_fd_sc_mcu7t5v0__fillcap_32
X_4512_ wire47/Z _4512_/Q _4512_/RN VSS _4514_/CLK VDD VDD VSS gf180mcu_fd_sc_mcu7t5v0__dffrnq_1
XFILLER_172_642 VDD VSS VDD VSS gf180mcu_fd_sc_mcu7t5v0__fillcap_16
X_4443_ _4443_/D _4443_/Q wire209/Z VSS _4451_/CLK VDD VDD VSS gf180mcu_fd_sc_mcu7t5v0__dffrnq_1
XFILLER_259_702 VDD VSS VDD VSS gf180mcu_fd_sc_mcu7t5v0__fillcap_64
X_4374_ _4374_/D _4374_/Q wire196/Z VSS _4430_/CLK VDD VDD VSS gf180mcu_fd_sc_mcu7t5v0__dffrnq_1
X_3325_ _3325_/B VDD VSS _3326_/B1 _3305_/C _3325_/A2 VDD VSS gf180mcu_fd_sc_mcu7t5v0__aoi21_1
X_3256_ _3268_/B1 _4363_/Q VDD VSS _3257_/I _4356_/Q _4526_/D VDD VSS gf180mcu_fd_sc_mcu7t5v0__aoi22_1
XFILLER_58_317 VDD VSS VDD VSS gf180mcu_fd_sc_mcu7t5v0__fillcap_64
X_2207_ VDD VSS _2208_/B2 _4502_/Q wire58/Z VDD VSS gf180mcu_fd_sc_mcu7t5v0__nand2_1
XFILLER_86_659 VDD VSS VDD VSS gf180mcu_fd_sc_mcu7t5v0__fillcap_4
XFILLER_85_136 VDD VSS VDD VSS gf180mcu_fd_sc_mcu7t5v0__fillcap_4
XFILLER_239_492 VDD VSS VDD VSS gf180mcu_fd_sc_mcu7t5v0__fillcap_64
X_3187_ _3187_/B _3187_/C VDD VSS _3188_/B _3185_/S _3801_/A1 VDD VSS gf180mcu_fd_sc_mcu7t5v0__aoi211_1
XFILLER_215_816 VDD VSS VDD VSS gf180mcu_fd_sc_mcu7t5v0__fillcap_16
XFILLER_254_451 VDD VSS VDD VSS gf180mcu_fd_sc_mcu7t5v0__fillcap_4
X_2138_ VDD VSS _2139_/A2 wire119/Z _2150_/A2 VDD VSS gf180mcu_fd_sc_mcu7t5v0__nand2_1
X_2069_ VDD VSS _4582_/D _4605_/D _2066_/Z VDD VSS gf180mcu_fd_sc_mcu7t5v0__xor2_1
XFILLER_82_865 VDD VSS VDD VSS gf180mcu_fd_sc_mcu7t5v0__fillcap_8
XFILLER_26_247 VDD VSS VDD VSS gf180mcu_fd_sc_mcu7t5v0__fillcap_64
XFILLER_41_206 VDD VSS VDD VSS gf180mcu_fd_sc_mcu7t5v0__fillcap_4
XFILLER_222_381 VDD VSS VDD VSS gf180mcu_fd_sc_mcu7t5v0__fillcap_4
XFILLER_179_263 VDD VSS VDD VSS gf180mcu_fd_sc_mcu7t5v0__fillcap_4
XFILLER_195_734 VDD VSS VDD VSS gf180mcu_fd_sc_mcu7t5v0__fillcap_8
XFILLER_195_778 VDD VSS VDD VSS gf180mcu_fd_sc_mcu7t5v0__fillcap_16
XFILLER_249_72 VDD VSS VDD VSS gf180mcu_fd_sc_mcu7t5v0__fillcap_64
XFILLER_151_804 VDD VSS VDD VSS gf180mcu_fd_sc_mcu7t5v0__fillcap_8
XFILLER_190_450 VDD VSS VDD VSS gf180mcu_fd_sc_mcu7t5v0__fillcap_4
XFILLER_135_388 VDD VSS VDD VSS gf180mcu_fd_sc_mcu7t5v0__fillcap_16
XFILLER_162_185 VDD VSS VDD VSS gf180mcu_fd_sc_mcu7t5v0__fillcap_4
XFILLER_118_98 VDD VSS VDD VSS gf180mcu_fd_sc_mcu7t5v0__fillcap_4
XFILLER_249_212 VDD VSS VDD VSS gf180mcu_fd_sc_mcu7t5v0__fillcap_64
XFILLER_1_346 VDD VSS VDD VSS gf180mcu_fd_sc_mcu7t5v0__fillcap_4
XFILLER_103_263 VDD VSS VDD VSS gf180mcu_fd_sc_mcu7t5v0__fillcap_16
XFILLER_77_626 VDD VSS VDD VSS gf180mcu_fd_sc_mcu7t5v0__fillcap_4
XFILLER_89_486 VDD VSS VDD VSS gf180mcu_fd_sc_mcu7t5v0__fillcap_4
XFILLER_134_86 VDD VSS VDD VSS gf180mcu_fd_sc_mcu7t5v0__fillcap_4
XFILLER_182_2 VDD VSS VDD VSS gf180mcu_fd_sc_mcu7t5v0__fillcap_32
XFILLER_18_737 VDD VSS VDD VSS gf180mcu_fd_sc_mcu7t5v0__fillcap_64
XFILLER_232_101 VDD VSS VDD VSS gf180mcu_fd_sc_mcu7t5v0__fillcap_4
XFILLER_45_556 VDD VSS VDD VSS gf180mcu_fd_sc_mcu7t5v0__fillcap_4
XFILLER_214_871 VDD VSS VDD VSS gf180mcu_fd_sc_mcu7t5v0__fillcap_4
XFILLER_186_712 VDD VSS VDD VSS gf180mcu_fd_sc_mcu7t5v0__fillcap_16
XFILLER_198_583 VDD VSS VDD VSS gf180mcu_fd_sc_mcu7t5v0__fillcap_8
XFILLER_13_486 VDD VSS VDD VSS gf180mcu_fd_sc_mcu7t5v0__fillcap_4
XFILLER_43_72 VDD VSS VDD VSS gf180mcu_fd_sc_mcu7t5v0__fillcap_64
XFILLER_159_72 VDD VSS VDD VSS gf180mcu_fd_sc_mcu7t5v0__fillcap_16
XFILLER_185_255 VDD VSS VDD VSS gf180mcu_fd_sc_mcu7t5v0__fillcap_8
XFILLER_138_171 VDD VSS VDD VSS gf180mcu_fd_sc_mcu7t5v0__fillcap_4
XFILLER_154_631 VDD VSS VDD VSS gf180mcu_fd_sc_mcu7t5v0__fillcap_16
XFILLER_153_130 VDD VSS VDD VSS gf180mcu_fd_sc_mcu7t5v0__fillcap_8
XFILLER_126_344 VDD VSS VDD VSS gf180mcu_fd_sc_mcu7t5v0__fillcap_8
XFILLER_142_848 VDD VSS VDD VSS gf180mcu_fd_sc_mcu7t5v0__fillcap_8
XFILLER_5_696 VDD VSS VDD VSS gf180mcu_fd_sc_mcu7t5v0__fillcap_4
X_3110_ VDD VSS _3131_/B wire143/Z wire13/Z VDD VSS gf180mcu_fd_sc_mcu7t5v0__nand2_1
XFILLER_150_870 VDD VSS VDD VSS gf180mcu_fd_sc_mcu7t5v0__fillcap_4
XFILLER_110_723 VDD VSS VDD VSS gf180mcu_fd_sc_mcu7t5v0__fillcap_8
XFILLER_67_136 VDD VSS VDD VSS gf180mcu_fd_sc_mcu7t5v0__fillcap_4
X_4090_ VDD _4090_/Q _4270_/CLK VSS _4090_/D VDD VSS gf180mcu_fd_sc_mcu7t5v0__dffq_1
X_3041_ VDD VSS _3042_/A2 _2896_/B _3041_/A2 VDD VSS gf180mcu_fd_sc_mcu7t5v0__nor2_1
XFILLER_236_451 VDD VSS VDD VSS gf180mcu_fd_sc_mcu7t5v0__fillcap_4
XFILLER_91_695 VDD VSS VDD VSS gf180mcu_fd_sc_mcu7t5v0__fillcap_4
XFILLER_23_206 VDD VSS VDD VSS gf180mcu_fd_sc_mcu7t5v0__fillcap_4
X_3943_ VDD _3943_/Q _3967_/CLK VSS _3943_/D VDD VSS gf180mcu_fd_sc_mcu7t5v0__dffq_1
X_3874_ VDD _3874_/Q _3969_/CLK VSS _3874_/D VDD VSS gf180mcu_fd_sc_mcu7t5v0__dffq_1
XFILLER_220_885 VDD VSS VDD VSS gf180mcu_fd_sc_mcu7t5v0__fillcap_4
X_2825_ _3212_/B _3212_/A2 VDD VSS _2826_/A3 _2156_/B _2821_/Z VDD VSS gf180mcu_fd_sc_mcu7t5v0__aoi22_1
XFILLER_192_737 VDD VSS VDD VSS gf180mcu_fd_sc_mcu7t5v0__fillcap_8
X_2756_ _2763_/S VDD VSS _4289_/D wire137/Z _4289_/Q VDD VSS gf180mcu_fd_sc_mcu7t5v0__mux2_2
XFILLER_145_664 VDD VSS VDD VSS gf180mcu_fd_sc_mcu7t5v0__fillcap_16
X_2687_ VDD VSS _2688_/A2 _4241_/Q _2698_/B VDD VSS gf180mcu_fd_sc_mcu7t5v0__nand2_1
XFILLER_117_366 VDD VSS VDD VSS gf180mcu_fd_sc_mcu7t5v0__fillcap_32
X_4426_ _4426_/D _4426_/Q _4536_/RN VSS _4446_/CLK VDD VDD VSS gf180mcu_fd_sc_mcu7t5v0__dffrnq_1
X_4357_ _4357_/D _4357_/Q wire183/Z VSS _4363_/CLK VDD VDD VSS gf180mcu_fd_sc_mcu7t5v0__dffrnq_1
XFILLER_59_626 VDD VSS VDD VSS gf180mcu_fd_sc_mcu7t5v0__fillcap_4
XFILLER_101_734 VDD VSS VDD VSS gf180mcu_fd_sc_mcu7t5v0__fillcap_16
X_4288_ _4288_/D _4288_/Q wire207/Z VSS _4467_/CLK VDD VDD VSS gf180mcu_fd_sc_mcu7t5v0__dffrnq_1
X_3308_ VDD _3309_/A2 _3308_/B _4381_/Q _3308_/A2 VSS _3308_/A3 VDD VSS gf180mcu_fd_sc_mcu7t5v0__oai31_1
Xclkbuf_4_14_0_host_clk_i _4001_/CLK VSS VDD clkbuf_0_host_clk_i/Z VDD VSS gf180mcu_fd_sc_mcu7t5v0__clkbuf_2
X_3239_ VDD VSS _3240_/B _3239_/A1 _3239_/A2 VDD VSS gf180mcu_fd_sc_mcu7t5v0__and2_1
XFILLER_100_255 VDD VSS VDD VSS gf180mcu_fd_sc_mcu7t5v0__fillcap_4
XFILLER_214_101 VDD VSS VDD VSS gf180mcu_fd_sc_mcu7t5v0__fillcap_4
XFILLER_27_556 VDD VSS VDD VSS gf180mcu_fd_sc_mcu7t5v0__fillcap_4
XFILLER_214_156 VDD VSS VDD VSS gf180mcu_fd_sc_mcu7t5v0__fillcap_4
XFILLER_199_358 VDD VSS VDD VSS gf180mcu_fd_sc_mcu7t5v0__fillcap_32
XFILLER_120_77 VDD VSS VDD VSS gf180mcu_fd_sc_mcu7t5v0__fillcap_4
XFILLER_80_37 VDD VSS VDD VSS gf180mcu_fd_sc_mcu7t5v0__fillcap_64
XFILLER_196_37 VDD VSS VDD VSS gf180mcu_fd_sc_mcu7t5v0__fillcap_8
XFILLER_182_247 VDD VSS VDD VSS gf180mcu_fd_sc_mcu7t5v0__fillcap_32
XFILLER_109_856 VDD VSS VDD VSS gf180mcu_fd_sc_mcu7t5v0__fillcap_32
XFILLER_8_2 VDD VSS VDD VSS gf180mcu_fd_sc_mcu7t5v0__fillcap_32
XFILLER_123_369 VDD VSS VDD VSS gf180mcu_fd_sc_mcu7t5v0__fillcap_32
XFILLER_150_177 VDD VSS VDD VSS gf180mcu_fd_sc_mcu7t5v0__fillcap_32
XFILLER_49_136 VDD VSS VDD VSS gf180mcu_fd_sc_mcu7t5v0__fillcap_4
XFILLER_218_451 VDD VSS VDD VSS gf180mcu_fd_sc_mcu7t5v0__fillcap_4
XFILLER_218_473 VDD VSS VDD VSS gf180mcu_fd_sc_mcu7t5v0__fillcap_8
XFILLER_161_95 VDD VSS VDD VSS gf180mcu_fd_sc_mcu7t5v0__fillcap_4
XFILLER_202_885 VDD VSS VDD VSS gf180mcu_fd_sc_mcu7t5v0__fillcap_4
XFILLER_201_340 VDD VSS VDD VSS gf180mcu_fd_sc_mcu7t5v0__fillcap_8
XFILLER_186_575 VDD VSS VDD VSS gf180mcu_fd_sc_mcu7t5v0__fillcap_16
XFILLER_186_597 VDD VSS VDD VSS gf180mcu_fd_sc_mcu7t5v0__fillcap_4
XFILLER_174_737 VDD VSS VDD VSS gf180mcu_fd_sc_mcu7t5v0__fillcap_8
XFILLER_201_384 VDD VSS VDD VSS gf180mcu_fd_sc_mcu7t5v0__fillcap_32
XFILLER_9_276 VDD VSS VDD VSS gf180mcu_fd_sc_mcu7t5v0__fillcap_4
XFILLER_139_480 VDD VSS VDD VSS gf180mcu_fd_sc_mcu7t5v0__fillcap_4
X_2610_ _4207_/Q _2602_/Z VDD VSS _2623_/A3 _4209_/Q _4208_/Q VDD VSS gf180mcu_fd_sc_mcu7t5v0__nand4_1
Xclkload24 VSS clkload24/Z _4171_/CLK VDD VDD VSS gf180mcu_fd_sc_mcu7t5v0__clkbuf_1
Xclkload13 VSS clkload13/Z _4441_/CLK VDD VDD VSS gf180mcu_fd_sc_mcu7t5v0__clkbuf_1
Xclkload35 VSS clkload35/ZN _4469_/CLK VDD VDD VSS gf180mcu_fd_sc_mcu7t5v0__inv_1
X_3590_ _3590_/B _3590_/C VDD VSS _3591_/A3 _3515_/C _3586_/Z VDD VSS gf180mcu_fd_sc_mcu7t5v0__oai211_1
Xclkload68 VSS clkload68/Z _4214_/CLK VDD VDD VSS gf180mcu_fd_sc_mcu7t5v0__clkbuf_1
Xclkload57 VSS clkload57/Z _4508_/CLK VDD VDD VSS gf180mcu_fd_sc_mcu7t5v0__clkbuf_1
X_2541_ _2546_/S VDD VSS _4164_/D _4438_/Q _4164_/Q VDD VSS gf180mcu_fd_sc_mcu7t5v0__mux2_2
XFILLER_114_303 VDD VSS VDD VSS gf180mcu_fd_sc_mcu7t5v0__fillcap_8
Xclkload46 VDD VSS _4096_/CLK clkload46/ZN VDD VSS gf180mcu_fd_sc_mcu7t5v0__clkinv_1
Xclkload79 VSS clkload79/Z _4530_/CLK VDD VDD VSS gf180mcu_fd_sc_mcu7t5v0__clkbuf_1
X_2472_ _2472_/S VDD VSS _4097_/D wire150/Z _4097_/Q VDD VSS gf180mcu_fd_sc_mcu7t5v0__mux2_2
Xclkbuf_leaf_64_clk_i _4614_/CLK VSS VDD clkload2/I VDD VSS gf180mcu_fd_sc_mcu7t5v0__clkbuf_2
X_4211_ _4211_/D _4211_/Q _4212_/RN VSS _4214_/CLK VDD VDD VSS gf180mcu_fd_sc_mcu7t5v0__dffrnq_1
XFILLER_130_807 VDD VSS VDD VSS gf180mcu_fd_sc_mcu7t5v0__fillcap_4
X_4142_ _4142_/D _4142_/Q wire192/Z VSS _4363_/CLK VDD VDD VSS gf180mcu_fd_sc_mcu7t5v0__dffrnq_1
XFILLER_122_380 VDD VSS VDD VSS gf180mcu_fd_sc_mcu7t5v0__fillcap_4
XFILLER_205_88 VDD VSS VDD VSS gf180mcu_fd_sc_mcu7t5v0__fillcap_8
XFILLER_205_66 VDD VSS VDD VSS gf180mcu_fd_sc_mcu7t5v0__fillcap_4
X_4073_ VDD _4073_/Q _4081_/CLK VSS _4073_/D VDD VSS gf180mcu_fd_sc_mcu7t5v0__dffq_1
XFILLER_209_462 VDD VSS VDD VSS gf180mcu_fd_sc_mcu7t5v0__fillcap_4
X_3024_ VDD _3025_/C _3024_/B _2883_/C _3024_/A2 VSS _3024_/A3 VDD VSS gf180mcu_fd_sc_mcu7t5v0__oai31_1
Xclkbuf_leaf_79_clk_i _4122_/CLK VSS VDD clkbuf_3_2__f_clk_i/Z VDD VSS gf180mcu_fd_sc_mcu7t5v0__clkbuf_2
XFILLER_110_597 VDD VSS VDD VSS gf180mcu_fd_sc_mcu7t5v0__fillcap_64
XFILLER_211_104 VDD VSS VDD VSS gf180mcu_fd_sc_mcu7t5v0__fillcap_8
XFILLER_91_492 VDD VSS VDD VSS gf180mcu_fd_sc_mcu7t5v0__fillcap_8
X_3926_ VDD _3926_/Q _3936_/CLK VSS _3926_/D VDD VSS gf180mcu_fd_sc_mcu7t5v0__dffq_1
XFILLER_196_328 VDD VSS VDD VSS gf180mcu_fd_sc_mcu7t5v0__fillcap_32
XFILLER_177_542 VDD VSS VDD VSS gf180mcu_fd_sc_mcu7t5v0__fillcap_16
Xclkbuf_leaf_17_clk_i _4199_/CLK VSS VDD clkload6/I VDD VSS gf180mcu_fd_sc_mcu7t5v0__clkbuf_2
Xclkload7 VSS clkload7/Z clkload7/I VDD VDD VSS gf180mcu_fd_sc_mcu7t5v0__clkbuf_1
X_3857_ VSS _4449_/CLK VDD input4/Z _3858_/D wire212/Z VDD VSS gf180mcu_fd_sc_mcu7t5v0__dffsnq_1
X_3788_ VDD VSS _3789_/B _4289_/Q wire16/I VDD VSS gf180mcu_fd_sc_mcu7t5v0__nor2_1
X_2808_ _3043_/A1 _3497_/C1 VDD VSS _2967_/B _4328_/Q _2991_/C VDD VSS gf180mcu_fd_sc_mcu7t5v0__nand4_1
X_2739_ _2748_/S VDD VSS _4273_/D _4273_/Q _2739_/I1 VDD VSS gf180mcu_fd_sc_mcu7t5v0__mux2_2
XFILLER_118_653 VDD VSS VDD VSS gf180mcu_fd_sc_mcu7t5v0__fillcap_8
XFILLER_132_155 VDD VSS VDD VSS gf180mcu_fd_sc_mcu7t5v0__fillcap_8
XFILLER_133_678 VDD VSS VDD VSS gf180mcu_fd_sc_mcu7t5v0__fillcap_4
X_4409_ _4409_/D _4409_/Q wire209/Z VSS _4451_/CLK VDD VDD VSS gf180mcu_fd_sc_mcu7t5v0__dffrnq_1
XFILLER_120_317 VDD VSS VDD VSS gf180mcu_fd_sc_mcu7t5v0__fillcap_32
XFILLER_132_177 VDD VSS VDD VSS gf180mcu_fd_sc_mcu7t5v0__fillcap_16
XFILLER_115_44 VDD VSS VDD VSS gf180mcu_fd_sc_mcu7t5v0__fillcap_16
XFILLER_101_553 VDD VSS VDD VSS gf180mcu_fd_sc_mcu7t5v0__fillcap_4
XFILLER_228_760 VDD VSS VDD VSS gf180mcu_fd_sc_mcu7t5v0__fillcap_32
XFILLER_262_527 VDD VSS VDD VSS gf180mcu_fd_sc_mcu7t5v0__fillcap_64
XFILLER_215_454 VDD VSS VDD VSS gf180mcu_fd_sc_mcu7t5v0__fillcap_16
XFILLER_230_457 VDD VSS VDD VSS gf180mcu_fd_sc_mcu7t5v0__fillcap_8
XFILLER_183_512 VDD VSS VDD VSS gf180mcu_fd_sc_mcu7t5v0__fillcap_8
XFILLER_183_567 VDD VSS VDD VSS gf180mcu_fd_sc_mcu7t5v0__fillcap_8
XFILLER_170_228 VDD VSS VDD VSS gf180mcu_fd_sc_mcu7t5v0__fillcap_4
XFILLER_112_807 VDD VSS VDD VSS gf180mcu_fd_sc_mcu7t5v0__fillcap_4
XFILLER_151_486 VDD VSS VDD VSS gf180mcu_fd_sc_mcu7t5v0__fillcap_4
XFILLER_266_877 VDD VSS VDD VSS gf180mcu_fd_sc_mcu7t5v0__fillcap_8
XFILLER_1_56 VDD VSS VDD VSS gf180mcu_fd_sc_mcu7t5v0__fillcap_8
XFILLER_234_730 VDD VSS VDD VSS gf180mcu_fd_sc_mcu7t5v0__fillcap_4
XFILLER_206_432 VDD VSS VDD VSS gf180mcu_fd_sc_mcu7t5v0__fillcap_16
XFILLER_73_492 VDD VSS VDD VSS gf180mcu_fd_sc_mcu7t5v0__fillcap_64
XFILLER_61_632 VDD VSS VDD VSS gf180mcu_fd_sc_mcu7t5v0__fillcap_64
XFILLER_178_339 VDD VSS VDD VSS gf180mcu_fd_sc_mcu7t5v0__fillcap_8
XFILLER_178_317 VDD VSS VDD VSS gf180mcu_fd_sc_mcu7t5v0__fillcap_4
X_1972_ VDD VSS _4353_/Q _3240_/A1 VDD VSS gf180mcu_fd_sc_mcu7t5v0__clkinv_1
X_3711_ _3718_/S VDD VSS _3892_/D _3892_/Q _4291_/Q VDD VSS gf180mcu_fd_sc_mcu7t5v0__mux2_2
Xclkload102 VSS clkload102/Z _4001_/CLK VDD VDD VSS gf180mcu_fd_sc_mcu7t5v0__clkbuf_1
XFILLER_146_236 VDD VSS VDD VSS gf180mcu_fd_sc_mcu7t5v0__fillcap_8
X_3642_ VDD VSS _3645_/A1 _4177_/Q _3679_/A2 VDD VSS gf180mcu_fd_sc_mcu7t5v0__nand2_1
XFILLER_174_567 VDD VSS VDD VSS gf180mcu_fd_sc_mcu7t5v0__fillcap_8
XFILLER_60_2 VDD VSS VDD VSS gf180mcu_fd_sc_mcu7t5v0__fillcap_32
X_3573_ _2040_/Z _4157_/Q VDD VSS _3575_/A2 _4136_/Q _2039_/Z VDD VSS gf180mcu_fd_sc_mcu7t5v0__aoi22_1
XFILLER_216_10 VDD VSS VDD VSS gf180mcu_fd_sc_mcu7t5v0__fillcap_16
X_2524_ _2524_/A3 _3447_/A1 VDD VSS _2536_/S _3386_/A1 _3441_/A3 VDD VSS gf180mcu_fd_sc_mcu7t5v0__nor4_2
XFILLER_115_656 VDD VSS VDD VSS gf180mcu_fd_sc_mcu7t5v0__fillcap_4
XFILLER_102_317 VDD VSS VDD VSS gf180mcu_fd_sc_mcu7t5v0__fillcap_8
XFILLER_114_177 VDD VSS VDD VSS gf180mcu_fd_sc_mcu7t5v0__fillcap_16
X_2455_ VDD VSS _2463_/S _2492_/A1 _2432_/Z VDD VSS gf180mcu_fd_sc_mcu7t5v0__nand2_1
X_2386_ _2393_/S VDD VSS _4026_/D wire167/Z _4026_/Q VDD VSS gf180mcu_fd_sc_mcu7t5v0__mux2_2
X_4125_ VDD _4125_/Q _4473_/CLK VSS _4125_/D VDD VSS gf180mcu_fd_sc_mcu7t5v0__dffq_1
XFILLER_83_212 VDD VSS VDD VSS gf180mcu_fd_sc_mcu7t5v0__fillcap_64
XFILLER_110_372 VDD VSS VDD VSS gf180mcu_fd_sc_mcu7t5v0__fillcap_8
XFILLER_256_387 VDD VSS VDD VSS gf180mcu_fd_sc_mcu7t5v0__fillcap_64
XFILLER_244_527 VDD VSS VDD VSS gf180mcu_fd_sc_mcu7t5v0__fillcap_64
XFILLER_84_768 VDD VSS VDD VSS gf180mcu_fd_sc_mcu7t5v0__fillcap_8
X_4056_ VDD _4056_/Q _4065_/CLK VSS _4056_/D VDD VSS gf180mcu_fd_sc_mcu7t5v0__dffq_1
X_3007_ VDD VSS _3007_/Z _3007_/A1 _3017_/B1 VDD VSS gf180mcu_fd_sc_mcu7t5v0__and2_1
XFILLER_169_306 VDD VSS VDD VSS gf180mcu_fd_sc_mcu7t5v0__fillcap_4
XFILLER_212_457 VDD VSS VDD VSS gf180mcu_fd_sc_mcu7t5v0__fillcap_8
XFILLER_51_142 VDD VSS VDD VSS gf180mcu_fd_sc_mcu7t5v0__fillcap_64
X_3909_ VDD _3909_/Q _4001_/CLK VSS _3909_/D VDD VSS gf180mcu_fd_sc_mcu7t5v0__dffq_1
XFILLER_138_737 VDD VSS VDD VSS gf180mcu_fd_sc_mcu7t5v0__fillcap_4
XFILLER_193_865 VDD VSS VDD VSS gf180mcu_fd_sc_mcu7t5v0__fillcap_16
XFILLER_257_72 VDD VSS VDD VSS gf180mcu_fd_sc_mcu7t5v0__fillcap_64
XFILLER_118_472 VDD VSS VDD VSS gf180mcu_fd_sc_mcu7t5v0__fillcap_16
XFILLER_266_107 VDD VSS VDD VSS gf180mcu_fd_sc_mcu7t5v0__fillcap_64
XFILLER_105_188 VDD VSS VDD VSS gf180mcu_fd_sc_mcu7t5v0__fillcap_16
XFILLER_126_98 VDD VSS VDD VSS gf180mcu_fd_sc_mcu7t5v0__fillcap_4
XFILLER_87_562 VDD VSS VDD VSS gf180mcu_fd_sc_mcu7t5v0__fillcap_64
XFILLER_75_702 VDD VSS VDD VSS gf180mcu_fd_sc_mcu7t5v0__fillcap_64
XFILLER_248_877 VDD VSS VDD VSS gf180mcu_fd_sc_mcu7t5v0__fillcap_8
XFILLER_101_361 VDD VSS VDD VSS gf180mcu_fd_sc_mcu7t5v0__fillcap_8
XFILLER_263_836 VDD VSS VDD VSS gf180mcu_fd_sc_mcu7t5v0__fillcap_4
XFILLER_262_2 VDD VSS VDD VSS gf180mcu_fd_sc_mcu7t5v0__fillcap_32
XFILLER_55_492 VDD VSS VDD VSS gf180mcu_fd_sc_mcu7t5v0__fillcap_64
XFILLER_43_632 VDD VSS VDD VSS gf180mcu_fd_sc_mcu7t5v0__fillcap_64
XFILLER_70_451 VDD VSS VDD VSS gf180mcu_fd_sc_mcu7t5v0__fillcap_4
XFILLER_188_659 VDD VSS VDD VSS gf180mcu_fd_sc_mcu7t5v0__fillcap_4
XFILLER_187_136 VDD VSS VDD VSS gf180mcu_fd_sc_mcu7t5v0__fillcap_4
XFILLER_129_726 VDD VSS VDD VSS gf180mcu_fd_sc_mcu7t5v0__fillcap_4
XFILLER_11_562 VDD VSS VDD VSS gf180mcu_fd_sc_mcu7t5v0__fillcap_64
XFILLER_51_72 VDD VSS VDD VSS gf180mcu_fd_sc_mcu7t5v0__fillcap_64
XFILLER_167_50 VDD VSS VDD VSS gf180mcu_fd_sc_mcu7t5v0__fillcap_8
XFILLER_167_72 VDD VSS VDD VSS gf180mcu_fd_sc_mcu7t5v0__fillcap_16
XFILLER_128_247 VDD VSS VDD VSS gf180mcu_fd_sc_mcu7t5v0__fillcap_64
XFILLER_171_537 VDD VSS VDD VSS gf180mcu_fd_sc_mcu7t5v0__fillcap_16
XFILLER_124_431 VDD VSS VDD VSS gf180mcu_fd_sc_mcu7t5v0__fillcap_16
XFILLER_97_315 VDD VSS VDD VSS gf180mcu_fd_sc_mcu7t5v0__fillcap_8
XFILLER_3_772 VDD VSS VDD VSS gf180mcu_fd_sc_mcu7t5v0__fillcap_64
X_2240_ VSS VDD _4136_/Q _4157_/Q _4135_/Q _4156_/Q _4155_/Q _4134_/Q _2242_/A3 VDD
+ VSS gf180mcu_fd_sc_mcu7t5v0__aoi222_1
XFILLER_226_516 VDD VSS VDD VSS gf180mcu_fd_sc_mcu7t5v0__fillcap_8
X_2171_ _2171_/A3 _2170_/Z VDD VSS _2684_/A2 _2679_/A1 _4240_/Q VDD VSS gf180mcu_fd_sc_mcu7t5v0__nand4_1
XFILLER_65_212 VDD VSS VDD VSS gf180mcu_fd_sc_mcu7t5v0__fillcap_64
XFILLER_238_387 VDD VSS VDD VSS gf180mcu_fd_sc_mcu7t5v0__fillcap_64
XFILLER_226_527 VDD VSS VDD VSS gf180mcu_fd_sc_mcu7t5v0__fillcap_4
XFILLER_253_346 VDD VSS VDD VSS gf180mcu_fd_sc_mcu7t5v0__fillcap_4
XFILLER_206_262 VDD VSS VDD VSS gf180mcu_fd_sc_mcu7t5v0__fillcap_32
XFILLER_33_142 VDD VSS VDD VSS gf180mcu_fd_sc_mcu7t5v0__fillcap_64
XFILLER_222_799 VDD VSS VDD VSS gf180mcu_fd_sc_mcu7t5v0__fillcap_4
XFILLER_147_501 VDD VSS VDD VSS gf180mcu_fd_sc_mcu7t5v0__fillcap_32
XFILLER_221_276 VDD VSS VDD VSS gf180mcu_fd_sc_mcu7t5v0__fillcap_4
X_1955_ VDD VSS _4215_/Q _2276_/B VDD VSS gf180mcu_fd_sc_mcu7t5v0__clkinv_1
XFILLER_119_236 VDD VSS VDD VSS gf180mcu_fd_sc_mcu7t5v0__fillcap_4
XFILLER_30_871 VDD VSS VDD VSS gf180mcu_fd_sc_mcu7t5v0__fillcap_4
X_3625_ _3644_/A2 _3625_/B2 VDD VSS _3626_/I _4478_/Q _3479_/C VDD VSS gf180mcu_fd_sc_mcu7t5v0__aoi22_1
X_3556_ _3556_/A3 VDD VSS _3557_/B _3515_/C _3556_/A2 VDD VSS gf180mcu_fd_sc_mcu7t5v0__nand3_1
XFILLER_143_784 VDD VSS VDD VSS gf180mcu_fd_sc_mcu7t5v0__fillcap_32
XFILLER_130_401 VDD VSS VDD VSS gf180mcu_fd_sc_mcu7t5v0__fillcap_4
X_2507_ _2509_/S VDD VSS _4127_/D wire154/Z _4127_/Q VDD VSS gf180mcu_fd_sc_mcu7t5v0__mux2_2
XFILLER_115_486 VDD VSS VDD VSS gf180mcu_fd_sc_mcu7t5v0__fillcap_4
XFILLER_103_626 VDD VSS VDD VSS gf180mcu_fd_sc_mcu7t5v0__fillcap_4
XFILLER_130_445 VDD VSS VDD VSS gf180mcu_fd_sc_mcu7t5v0__fillcap_8
XFILLER_248_107 VDD VSS VDD VSS gf180mcu_fd_sc_mcu7t5v0__fillcap_64
X_3487_ _3487_/A3 VDD VSS _3495_/A2 wire72/Z _3487_/A2 VDD VSS gf180mcu_fd_sc_mcu7t5v0__nand3_1
XFILLER_57_702 VDD VSS VDD VSS gf180mcu_fd_sc_mcu7t5v0__fillcap_64
XFILLER_69_562 VDD VSS VDD VSS gf180mcu_fd_sc_mcu7t5v0__fillcap_64
X_2438_ _2441_/S VDD VSS _4070_/D _4070_/Q wire157/Z VDD VSS gf180mcu_fd_sc_mcu7t5v0__mux2_2
XFILLER_96_370 VDD VSS VDD VSS gf180mcu_fd_sc_mcu7t5v0__fillcap_8
X_2369_ VDD _2369_/B wire14/Z _4013_/D _3506_/A2 VSS VDD VSS gf180mcu_fd_sc_mcu7t5v0__oai21_1
XFILLER_245_836 VDD VSS VDD VSS gf180mcu_fd_sc_mcu7t5v0__fillcap_4
XFILLER_257_696 VDD VSS VDD VSS gf180mcu_fd_sc_mcu7t5v0__fillcap_4
X_4108_ VDD _4108_/Q _4126_/CLK VSS _4108_/D VDD VSS gf180mcu_fd_sc_mcu7t5v0__dffq_1
X_4039_ VDD _4039_/Q _4047_/CLK VSS _4039_/D VDD VSS gf180mcu_fd_sc_mcu7t5v0__dffq_1
XFILLER_37_492 VDD VSS VDD VSS gf180mcu_fd_sc_mcu7t5v0__fillcap_64
XFILLER_25_632 VDD VSS VDD VSS gf180mcu_fd_sc_mcu7t5v0__fillcap_64
XFILLER_52_451 VDD VSS VDD VSS gf180mcu_fd_sc_mcu7t5v0__fillcap_4
XFILLER_213_766 VDD VSS VDD VSS gf180mcu_fd_sc_mcu7t5v0__fillcap_4
XFILLER_197_467 VDD VSS VDD VSS gf180mcu_fd_sc_mcu7t5v0__fillcap_16
XFILLER_80_793 VDD VSS VDD VSS gf180mcu_fd_sc_mcu7t5v0__fillcap_8
XFILLER_20_381 VDD VSS VDD VSS gf180mcu_fd_sc_mcu7t5v0__fillcap_4
XFILLER_180_356 VDD VSS VDD VSS gf180mcu_fd_sc_mcu7t5v0__fillcap_16
XFILLER_108_2 VDD VSS VDD VSS gf180mcu_fd_sc_mcu7t5v0__fillcap_8
XFILLER_267_416 VDD VSS VDD VSS gf180mcu_fd_sc_mcu7t5v0__fillcap_4
XFILLER_47_212 VDD VSS VDD VSS gf180mcu_fd_sc_mcu7t5v0__fillcap_64
XFILLER_235_346 VDD VSS VDD VSS gf180mcu_fd_sc_mcu7t5v0__fillcap_4
XFILLER_15_142 VDD VSS VDD VSS gf180mcu_fd_sc_mcu7t5v0__fillcap_64
XFILLER_204_788 VDD VSS VDD VSS gf180mcu_fd_sc_mcu7t5v0__fillcap_16
XFILLER_30_101 VDD VSS VDD VSS gf180mcu_fd_sc_mcu7t5v0__fillcap_4
XFILLER_188_489 VDD VSS VDD VSS gf180mcu_fd_sc_mcu7t5v0__fillcap_8
XFILLER_12_871 VDD VSS VDD VSS gf180mcu_fd_sc_mcu7t5v0__fillcap_4
XFILLER_117_718 VDD VSS VDD VSS gf180mcu_fd_sc_mcu7t5v0__fillcap_4
XFILLER_7_352 VDD VSS VDD VSS gf180mcu_fd_sc_mcu7t5v0__fillcap_64
XFILLER_7_66 VDD VSS VDD VSS gf180mcu_fd_sc_mcu7t5v0__fillcap_4
X_3410_ _3424_/S VDD VSS _4453_/D _4411_/Q _4453_/Q VDD VSS gf180mcu_fd_sc_mcu7t5v0__mux2_2
X_4390_ _4390_/D _4390_/Q wire193/I VSS _4436_/CLK VDD VDD VSS gf180mcu_fd_sc_mcu7t5v0__dffrnq_1
X_3341_ _3346_/S VDD VSS _4389_/D _4374_/Q _4389_/Q VDD VSS gf180mcu_fd_sc_mcu7t5v0__mux2_2
XFILLER_125_762 VDD VSS VDD VSS gf180mcu_fd_sc_mcu7t5v0__fillcap_8
X_3272_ wire58/I _3272_/C VDD VSS _3273_/I _4371_/Q _4530_/Q VDD VSS gf180mcu_fd_sc_mcu7t5v0__oai211_1
XFILLER_39_702 VDD VSS VDD VSS gf180mcu_fd_sc_mcu7t5v0__fillcap_64
X_2223_ _2220_/Z VDD VSS _2226_/B _4319_/Q _4505_/Q VDD VSS gf180mcu_fd_sc_mcu7t5v0__nand3_1
XFILLER_78_381 VDD VSS VDD VSS gf180mcu_fd_sc_mcu7t5v0__fillcap_4
XFILLER_66_521 VDD VSS VDD VSS gf180mcu_fd_sc_mcu7t5v0__fillcap_4
XFILLER_23_2 VDD VSS VDD VSS gf180mcu_fd_sc_mcu7t5v0__fillcap_64
X_2154_ _4501_/Q wire58/Z VDD VSS _2682_/S _4315_/Q _4316_/Q VDD VSS gf180mcu_fd_sc_mcu7t5v0__nand4_1
XFILLER_239_696 VDD VSS VDD VSS gf180mcu_fd_sc_mcu7t5v0__fillcap_4
XFILLER_94_885 VDD VSS VDD VSS gf180mcu_fd_sc_mcu7t5v0__fillcap_4
XFILLER_213_88 VDD VSS VDD VSS gf180mcu_fd_sc_mcu7t5v0__fillcap_8
XFILLER_19_492 VDD VSS VDD VSS gf180mcu_fd_sc_mcu7t5v0__fillcap_64
XFILLER_81_535 VDD VSS VDD VSS gf180mcu_fd_sc_mcu7t5v0__fillcap_16
X_2085_ VDD VSS _2097_/A2 _4591_/Q _2085_/A2 VDD VSS gf180mcu_fd_sc_mcu7t5v0__nor2_1
XFILLER_207_593 VDD VSS VDD VSS gf180mcu_fd_sc_mcu7t5v0__fillcap_32
XFILLER_34_451 VDD VSS VDD VSS gf180mcu_fd_sc_mcu7t5v0__fillcap_4
X_2987_ _2987_/B VDD VSS _3019_/A2 _3044_/A1 _2987_/A2 VDD VSS gf180mcu_fd_sc_mcu7t5v0__aoi21_1
Xmax_length37 _2357_/S VSS VDD _2359_/S VDD VSS gf180mcu_fd_sc_mcu7t5v0__clkbuf_3
X_1938_ VDD VSS _2883_/C _2885_/C VDD VSS gf180mcu_fd_sc_mcu7t5v0__clkinv_1
XFILLER_174_161 VDD VSS VDD VSS gf180mcu_fd_sc_mcu7t5v0__fillcap_8
XFILLER_107_228 VDD VSS VDD VSS gf180mcu_fd_sc_mcu7t5v0__fillcap_8
XFILLER_107_206 VDD VSS VDD VSS gf180mcu_fd_sc_mcu7t5v0__fillcap_4
XFILLER_174_18 VDD VSS VDD VSS gf180mcu_fd_sc_mcu7t5v0__fillcap_16
X_3608_ _3608_/A3 VDD VSS _3609_/B wire82/Z _3608_/A2 VDD VSS gf180mcu_fd_sc_mcu7t5v0__nand3_1
XFILLER_150_507 VDD VSS VDD VSS gf180mcu_fd_sc_mcu7t5v0__fillcap_4
X_4588_ _4588_/D _4613_/D _4613_/RN VSS _4606_/CLK VDD VDD VSS gf180mcu_fd_sc_mcu7t5v0__dffrnq_1
XFILLER_249_416 VDD VSS VDD VSS gf180mcu_fd_sc_mcu7t5v0__fillcap_4
X_3539_ VDD VSS _3540_/A3 _3605_/S _4006_/Q VDD VSS gf180mcu_fd_sc_mcu7t5v0__nand2_1
XFILLER_88_101 VDD VSS VDD VSS gf180mcu_fd_sc_mcu7t5v0__fillcap_4
XFILLER_107_89 VDD VSS VDD VSS gf180mcu_fd_sc_mcu7t5v0__fillcap_8
XFILLER_29_212 VDD VSS VDD VSS gf180mcu_fd_sc_mcu7t5v0__fillcap_64
XFILLER_103_478 VDD VSS VDD VSS gf180mcu_fd_sc_mcu7t5v0__fillcap_8
XFILLER_85_830 VDD VSS VDD VSS gf180mcu_fd_sc_mcu7t5v0__fillcap_8
XFILLER_217_346 VDD VSS VDD VSS gf180mcu_fd_sc_mcu7t5v0__fillcap_4
XFILLER_198_721 VDD VSS VDD VSS gf180mcu_fd_sc_mcu7t5v0__fillcap_8
XFILLER_12_101 VDD VSS VDD VSS gf180mcu_fd_sc_mcu7t5v0__fillcap_4
XFILLER_157_117 VDD VSS VDD VSS gf180mcu_fd_sc_mcu7t5v0__fillcap_16
XFILLER_165_150 VDD VSS VDD VSS gf180mcu_fd_sc_mcu7t5v0__fillcap_4
XFILLER_181_632 VDD VSS VDD VSS gf180mcu_fd_sc_mcu7t5v0__fillcap_8
XFILLER_193_492 VDD VSS VDD VSS gf180mcu_fd_sc_mcu7t5v0__fillcap_32
XFILLER_126_559 VDD VSS VDD VSS gf180mcu_fd_sc_mcu7t5v0__fillcap_16
XFILLER_4_311 VDD VSS VDD VSS gf180mcu_fd_sc_mcu7t5v0__fillcap_4
XFILLER_95_616 VDD VSS VDD VSS gf180mcu_fd_sc_mcu7t5v0__fillcap_4
XFILLER_48_521 VDD VSS VDD VSS gf180mcu_fd_sc_mcu7t5v0__fillcap_4
XFILLER_208_357 VDD VSS VDD VSS gf180mcu_fd_sc_mcu7t5v0__fillcap_16
XFILLER_76_885 VDD VSS VDD VSS gf180mcu_fd_sc_mcu7t5v0__fillcap_4
XFILLER_180_94 VDD VSS VDD VSS gf180mcu_fd_sc_mcu7t5v0__fillcap_8
XFILLER_16_451 VDD VSS VDD VSS gf180mcu_fd_sc_mcu7t5v0__fillcap_4
XFILLER_90_387 VDD VSS VDD VSS gf180mcu_fd_sc_mcu7t5v0__fillcap_64
X_2910_ VDD _2910_/B _2919_/S _4306_/D _3271_/A1 VSS VDD VSS gf180mcu_fd_sc_mcu7t5v0__oai21_1
XFILLER_189_732 VDD VSS VDD VSS gf180mcu_fd_sc_mcu7t5v0__fillcap_16
X_3890_ VDD _3890_/Q _3969_/CLK VSS _3890_/D VDD VSS gf180mcu_fd_sc_mcu7t5v0__dffq_1
XFILLER_204_574 VDD VSS VDD VSS gf180mcu_fd_sc_mcu7t5v0__fillcap_16
X_2841_ VDD VSS _2842_/B _4551_/Q _3905_/Q VDD VSS gf180mcu_fd_sc_mcu7t5v0__or2_1
XFILLER_148_139 VDD VSS VDD VSS gf180mcu_fd_sc_mcu7t5v0__fillcap_16
X_2772_ _4515_/Q VDD VSS _2774_/A2 _4515_/D _4514_/D VDD VSS gf180mcu_fd_sc_mcu7t5v0__nand3_1
XFILLER_129_342 VDD VSS VDD VSS gf180mcu_fd_sc_mcu7t5v0__fillcap_8
X_4511_ VSS _4532_/CLK VDD _4511_/D _4511_/Q _4534_/RN VDD VSS gf180mcu_fd_sc_mcu7t5v0__dffsnq_1
XFILLER_157_673 VDD VSS VDD VSS gf180mcu_fd_sc_mcu7t5v0__fillcap_4
XFILLER_8_661 VDD VSS VDD VSS gf180mcu_fd_sc_mcu7t5v0__fillcap_4
XFILLER_117_504 VDD VSS VDD VSS gf180mcu_fd_sc_mcu7t5v0__fillcap_8
X_4442_ _4442_/D _4442_/Q _4498_/RN VSS _4448_/CLK VDD VDD VSS gf180mcu_fd_sc_mcu7t5v0__dffrnq_1
XFILLER_172_687 VDD VSS VDD VSS gf180mcu_fd_sc_mcu7t5v0__fillcap_4
XFILLER_171_142 VDD VSS VDD VSS gf180mcu_fd_sc_mcu7t5v0__fillcap_16
X_4373_ _4373_/D _4373_/Q wire186/Z VSS _4427_/CLK VDD VDD VSS gf180mcu_fd_sc_mcu7t5v0__dffrnq_1
X_3324_ VDD _3324_/B _3324_/A2 _4381_/D _3325_/B VSS VDD VSS gf180mcu_fd_sc_mcu7t5v0__oai21_1
XFILLER_86_605 VDD VSS VDD VSS gf180mcu_fd_sc_mcu7t5v0__fillcap_4
X_3255_ VDD VSS _3268_/B1 _4531_/Q _4525_/Q VDD VSS gf180mcu_fd_sc_mcu7t5v0__nor2_1
XFILLER_100_426 VDD VSS VDD VSS gf180mcu_fd_sc_mcu7t5v0__fillcap_16
XFILLER_86_627 VDD VSS VDD VSS gf180mcu_fd_sc_mcu7t5v0__fillcap_32
X_2206_ VDD VSS _2206_/Z _4316_/Q _2206_/A2 VDD VSS gf180mcu_fd_sc_mcu7t5v0__and2_1
X_3186_ VDD VSS _3187_/B _3185_/S _3968_/Q VDD VSS gf180mcu_fd_sc_mcu7t5v0__nor2_1
XFILLER_67_874 VDD VSS VDD VSS gf180mcu_fd_sc_mcu7t5v0__fillcap_16
X_2137_ VDD VSS _2137_/I _4136_/D VDD VSS gf180mcu_fd_sc_mcu7t5v0__clkinv_1
XFILLER_82_877 VDD VSS VDD VSS gf180mcu_fd_sc_mcu7t5v0__fillcap_8
X_2068_ VDD VSS _4581_/D _2066_/Z _2096_/A2 VDD VSS gf180mcu_fd_sc_mcu7t5v0__nor2_1
XFILLER_195_702 VDD VSS VDD VSS gf180mcu_fd_sc_mcu7t5v0__fillcap_32
XFILLER_175_492 VDD VSS VDD VSS gf180mcu_fd_sc_mcu7t5v0__fillcap_8
XFILLER_135_345 VDD VSS VDD VSS gf180mcu_fd_sc_mcu7t5v0__fillcap_4
XFILLER_265_72 VDD VSS VDD VSS gf180mcu_fd_sc_mcu7t5v0__fillcap_64
XFILLER_78_37 VDD VSS VDD VSS gf180mcu_fd_sc_mcu7t5v0__fillcap_64
XFILLER_134_10 VDD VSS VDD VSS gf180mcu_fd_sc_mcu7t5v0__fillcap_4
XFILLER_131_540 VDD VSS VDD VSS gf180mcu_fd_sc_mcu7t5v0__fillcap_4
XFILLER_131_562 VDD VSS VDD VSS gf180mcu_fd_sc_mcu7t5v0__fillcap_32
XFILLER_134_54 VDD VSS VDD VSS gf180mcu_fd_sc_mcu7t5v0__fillcap_32
XFILLER_58_885 VDD VSS VDD VSS gf180mcu_fd_sc_mcu7t5v0__fillcap_4
XFILLER_233_647 VDD VSS VDD VSS gf180mcu_fd_sc_mcu7t5v0__fillcap_16
XFILLER_72_387 VDD VSS VDD VSS gf180mcu_fd_sc_mcu7t5v0__fillcap_64
XFILLER_60_527 VDD VSS VDD VSS gf180mcu_fd_sc_mcu7t5v0__fillcap_64
XFILLER_201_555 VDD VSS VDD VSS gf180mcu_fd_sc_mcu7t5v0__fillcap_4
XFILLER_185_289 VDD VSS VDD VSS gf180mcu_fd_sc_mcu7t5v0__fillcap_32
XFILLER_153_142 VDD VSS VDD VSS gf180mcu_fd_sc_mcu7t5v0__fillcap_8
XFILLER_181_484 VDD VSS VDD VSS gf180mcu_fd_sc_mcu7t5v0__fillcap_4
XFILLER_175_72 VDD VSS VDD VSS gf180mcu_fd_sc_mcu7t5v0__fillcap_32
X_3040_ _3040_/B VDD VSS _3041_/A2 _3036_/B _3040_/A2 VDD VSS gf180mcu_fd_sc_mcu7t5v0__aoi21_1
XFILLER_82_107 VDD VSS VDD VSS gf180mcu_fd_sc_mcu7t5v0__fillcap_64
XFILLER_49_874 VDD VSS VDD VSS gf180mcu_fd_sc_mcu7t5v0__fillcap_16
XFILLER_209_666 VDD VSS VDD VSS gf180mcu_fd_sc_mcu7t5v0__fillcap_32
XFILLER_208_165 VDD VSS VDD VSS gf180mcu_fd_sc_mcu7t5v0__fillcap_8
XFILLER_251_422 VDD VSS VDD VSS gf180mcu_fd_sc_mcu7t5v0__fillcap_64
XFILLER_263_282 VDD VSS VDD VSS gf180mcu_fd_sc_mcu7t5v0__fillcap_64
XFILLER_64_877 VDD VSS VDD VSS gf180mcu_fd_sc_mcu7t5v0__fillcap_8
X_3942_ VDD _3942_/Q _3967_/CLK VSS _3942_/D VDD VSS gf180mcu_fd_sc_mcu7t5v0__dffq_1
XFILLER_177_702 VDD VSS VDD VSS gf180mcu_fd_sc_mcu7t5v0__fillcap_64
X_3873_ _3873_/D _3873_/Q _4535_/RN VSS _4468_/CLK VDD VDD VSS gf180mcu_fd_sc_mcu7t5v0__dffrnq_1
XFILLER_90_2 VDD VSS VDD VSS gf180mcu_fd_sc_mcu7t5v0__fillcap_32
X_2824_ VDD VSS _2973_/A2 _3212_/A2 _3212_/B VDD VSS gf180mcu_fd_sc_mcu7t5v0__nand2_1
XFILLER_145_610 VDD VSS VDD VSS gf180mcu_fd_sc_mcu7t5v0__fillcap_8
XFILLER_145_632 VDD VSS VDD VSS gf180mcu_fd_sc_mcu7t5v0__fillcap_32
X_2755_ VDD VSS wire25/I _3637_/A1 _2292_/Z VDD VSS gf180mcu_fd_sc_mcu7t5v0__or2_1
X_2686_ _2698_/B VDD VSS _2686_/Z _4241_/Q _2666_/C VDD VSS gf180mcu_fd_sc_mcu7t5v0__or3_1
X_4425_ _4425_/D _4425_/Q wire210/Z VSS _4467_/CLK VDD VDD VSS gf180mcu_fd_sc_mcu7t5v0__dffrnq_1
XFILLER_144_197 VDD VSS VDD VSS gf180mcu_fd_sc_mcu7t5v0__fillcap_4
X_4356_ _4356_/D _4356_/Q wire184/Z VSS _4369_/CLK VDD VDD VSS gf180mcu_fd_sc_mcu7t5v0__dffrnq_1
XFILLER_140_370 VDD VSS VDD VSS gf180mcu_fd_sc_mcu7t5v0__fillcap_4
X_3307_ _3307_/A3 VDD VSS _3308_/B _3852_/D _4386_/Q VDD VSS gf180mcu_fd_sc_mcu7t5v0__nor3_1
XFILLER_113_562 VDD VSS VDD VSS gf180mcu_fd_sc_mcu7t5v0__fillcap_4
XFILLER_101_702 VDD VSS VDD VSS gf180mcu_fd_sc_mcu7t5v0__fillcap_32
X_4287_ _4287_/D _4287_/Q wire206/Z VSS _4466_/CLK VDD VDD VSS gf180mcu_fd_sc_mcu7t5v0__dffrnq_1
XFILLER_98_295 VDD VSS VDD VSS gf180mcu_fd_sc_mcu7t5v0__fillcap_16
XFILLER_86_457 VDD VSS VDD VSS gf180mcu_fd_sc_mcu7t5v0__fillcap_64
XFILLER_113_595 VDD VSS VDD VSS gf180mcu_fd_sc_mcu7t5v0__fillcap_4
X_3238_ VDD VSS _3239_/A2 _3223_/B _3241_/A1 VDD VSS gf180mcu_fd_sc_mcu7t5v0__nand2_1
XFILLER_255_772 VDD VSS VDD VSS gf180mcu_fd_sc_mcu7t5v0__fillcap_64
X_3169_ _3169_/B _3169_/C VDD VSS _3170_/C _2230_/B _4260_/Q VDD VSS gf180mcu_fd_sc_mcu7t5v0__oai211_1
XFILLER_227_485 VDD VSS VDD VSS gf180mcu_fd_sc_mcu7t5v0__fillcap_4
XFILLER_215_625 VDD VSS VDD VSS gf180mcu_fd_sc_mcu7t5v0__fillcap_4
XFILLER_54_387 VDD VSS VDD VSS gf180mcu_fd_sc_mcu7t5v0__fillcap_64
XFILLER_42_527 VDD VSS VDD VSS gf180mcu_fd_sc_mcu7t5v0__fillcap_64
XFILLER_167_212 VDD VSS VDD VSS gf180mcu_fd_sc_mcu7t5v0__fillcap_4
XFILLER_129_10 VDD VSS VDD VSS gf180mcu_fd_sc_mcu7t5v0__fillcap_4
XFILLER_10_457 VDD VSS VDD VSS gf180mcu_fd_sc_mcu7t5v0__fillcap_64
XFILLER_135_142 VDD VSS VDD VSS gf180mcu_fd_sc_mcu7t5v0__fillcap_8
XFILLER_135_186 VDD VSS VDD VSS gf180mcu_fd_sc_mcu7t5v0__fillcap_16
XFILLER_145_53 VDD VSS VDD VSS gf180mcu_fd_sc_mcu7t5v0__fillcap_16
XFILLER_2_667 VDD VSS VDD VSS gf180mcu_fd_sc_mcu7t5v0__fillcap_64
XFILLER_64_107 VDD VSS VDD VSS gf180mcu_fd_sc_mcu7t5v0__fillcap_64
XFILLER_233_422 VDD VSS VDD VSS gf180mcu_fd_sc_mcu7t5v0__fillcap_64
XFILLER_245_282 VDD VSS VDD VSS gf180mcu_fd_sc_mcu7t5v0__fillcap_64
XFILLER_46_877 VDD VSS VDD VSS gf180mcu_fd_sc_mcu7t5v0__fillcap_8
XFILLER_206_658 VDD VSS VDD VSS gf180mcu_fd_sc_mcu7t5v0__fillcap_4
XFILLER_260_241 VDD VSS VDD VSS gf180mcu_fd_sc_mcu7t5v0__fillcap_4
XFILLER_61_836 VDD VSS VDD VSS gf180mcu_fd_sc_mcu7t5v0__fillcap_4
XFILLER_73_696 VDD VSS VDD VSS gf180mcu_fd_sc_mcu7t5v0__fillcap_4
XFILLER_159_702 VDD VSS VDD VSS gf180mcu_fd_sc_mcu7t5v0__fillcap_64
XFILLER_186_521 VDD VSS VDD VSS gf180mcu_fd_sc_mcu7t5v0__fillcap_4
XFILLER_174_705 VDD VSS VDD VSS gf180mcu_fd_sc_mcu7t5v0__fillcap_4
XFILLER_201_352 VDD VSS VDD VSS gf180mcu_fd_sc_mcu7t5v0__fillcap_8
Xclkload25 VSS clkload25/Z _4500_/CLK VDD VDD VSS gf180mcu_fd_sc_mcu7t5v0__clkbuf_1
Xclkload14 VSS clkload14/Z _4400_/CLK VDD VDD VSS gf180mcu_fd_sc_mcu7t5v0__clkbuf_1
XFILLER_127_632 VDD VSS VDD VSS gf180mcu_fd_sc_mcu7t5v0__fillcap_16
XFILLER_62_6 VDD VSS VDD VSS gf180mcu_fd_sc_mcu7t5v0__fillcap_16
Xclkload69 VSS clkload69/Z _4354_/CLK VDD VDD VSS gf180mcu_fd_sc_mcu7t5v0__clkbuf_1
Xclkload58 VSS clkload58/Z _4535_/CLK VDD VDD VSS gf180mcu_fd_sc_mcu7t5v0__clkbuf_1
X_2540_ _2546_/S VDD VSS _4163_/D wire138/Z _4163_/Q VDD VSS gf180mcu_fd_sc_mcu7t5v0__mux2_2
Xclkload47 VSS clkload47/Z _4270_/CLK VDD VDD VSS gf180mcu_fd_sc_mcu7t5v0__clkbuf_1
Xclkload36 VSS clkload36/Z _4081_/CLK VDD VDD VSS gf180mcu_fd_sc_mcu7t5v0__clkbuf_1
XFILLER_115_805 VDD VSS VDD VSS gf180mcu_fd_sc_mcu7t5v0__fillcap_32
X_2471_ _2472_/S VDD VSS _4096_/D wire153/Z _4096_/Q VDD VSS gf180mcu_fd_sc_mcu7t5v0__mux2_2
X_4210_ _4210_/D _4210_/Q _4212_/RN VSS _4210_/CLK VDD VDD VSS gf180mcu_fd_sc_mcu7t5v0__dffrnq_1
XFILLER_141_189 VDD VSS VDD VSS gf180mcu_fd_sc_mcu7t5v0__fillcap_16
Xclkbuf_0_clk_i VDD VSS clkbuf_0_clk_i/Z clk_i VDD VSS gf180mcu_fd_sc_mcu7t5v0__clkbuf_16
X_4141_ _4141_/D _4141_/Q _4527_/RN VSS _4448_/CLK VDD VDD VSS gf180mcu_fd_sc_mcu7t5v0__dffrnq_1
XFILLER_83_416 VDD VSS VDD VSS gf180mcu_fd_sc_mcu7t5v0__fillcap_4
XFILLER_68_457 VDD VSS VDD VSS gf180mcu_fd_sc_mcu7t5v0__fillcap_64
X_4072_ VDD _4072_/Q _4469_/CLK VSS _4072_/D VDD VSS gf180mcu_fd_sc_mcu7t5v0__dffq_1
XFILLER_96_799 VDD VSS VDD VSS gf180mcu_fd_sc_mcu7t5v0__fillcap_4
XFILLER_237_772 VDD VSS VDD VSS gf180mcu_fd_sc_mcu7t5v0__fillcap_64
X_3023_ _3023_/A3 VDD VSS _3025_/B1 _2985_/C _3023_/A2 VDD VSS gf180mcu_fd_sc_mcu7t5v0__nor3_1
XFILLER_252_731 VDD VSS VDD VSS gf180mcu_fd_sc_mcu7t5v0__fillcap_4
XFILLER_264_591 VDD VSS VDD VSS gf180mcu_fd_sc_mcu7t5v0__fillcap_4
XFILLER_36_387 VDD VSS VDD VSS gf180mcu_fd_sc_mcu7t5v0__fillcap_64
XFILLER_221_66 VDD VSS VDD VSS gf180mcu_fd_sc_mcu7t5v0__fillcap_4
XFILLER_24_527 VDD VSS VDD VSS gf180mcu_fd_sc_mcu7t5v0__fillcap_64
XFILLER_51_346 VDD VSS VDD VSS gf180mcu_fd_sc_mcu7t5v0__fillcap_4
X_3925_ VDD _3925_/Q _4001_/CLK VSS _3925_/D VDD VSS gf180mcu_fd_sc_mcu7t5v0__dffq_1
XFILLER_220_683 VDD VSS VDD VSS gf180mcu_fd_sc_mcu7t5v0__fillcap_4
X_3856_ _3856_/D _3856_/Q wire209/Z VSS _4499_/CLK VDD VDD VSS gf180mcu_fd_sc_mcu7t5v0__dffrnq_1
Xclkload8 VSS clkload8/Z clkload8/I VDD VDD VSS gf180mcu_fd_sc_mcu7t5v0__clkbuf_1
X_3787_ VDD VSS wire16/I _3831_/A1 _3768_/Z VDD VSS gf180mcu_fd_sc_mcu7t5v0__nand2_1
X_2807_ VDD _2807_/B _3214_/A3 _2818_/A2 _3208_/A2 VSS VDD VSS gf180mcu_fd_sc_mcu7t5v0__oai21_1
X_2738_ _2748_/S VDD VSS _4272_/D _4272_/Q _3395_/I1 VDD VSS gf180mcu_fd_sc_mcu7t5v0__mux2_2
X_2669_ VDD VSS _4232_/D _2669_/A1 _2669_/A2 VDD VSS gf180mcu_fd_sc_mcu7t5v0__nand2_1
X_4408_ _4408_/D _4408_/Q _4498_/RN VSS _4448_/CLK VDD VDD VSS gf180mcu_fd_sc_mcu7t5v0__dffrnq_1
XFILLER_114_882 VDD VSS VDD VSS gf180mcu_fd_sc_mcu7t5v0__fillcap_8
XFILLER_141_690 VDD VSS VDD VSS gf180mcu_fd_sc_mcu7t5v0__fillcap_8
XFILLER_259_352 VDD VSS VDD VSS gf180mcu_fd_sc_mcu7t5v0__fillcap_64
X_4339_ _4339_/D _4339_/Q _4371_/RN VSS _4346_/CLK VDD VDD VSS gf180mcu_fd_sc_mcu7t5v0__dffrnq_1
XFILLER_87_766 VDD VSS VDD VSS gf180mcu_fd_sc_mcu7t5v0__fillcap_4
XFILLER_46_107 VDD VSS VDD VSS gf180mcu_fd_sc_mcu7t5v0__fillcap_64
XFILLER_215_422 VDD VSS VDD VSS gf180mcu_fd_sc_mcu7t5v0__fillcap_32
XFILLER_227_282 VDD VSS VDD VSS gf180mcu_fd_sc_mcu7t5v0__fillcap_64
XFILLER_28_877 VDD VSS VDD VSS gf180mcu_fd_sc_mcu7t5v0__fillcap_8
XFILLER_242_241 VDD VSS VDD VSS gf180mcu_fd_sc_mcu7t5v0__fillcap_4
XFILLER_131_66 VDD VSS VDD VSS gf180mcu_fd_sc_mcu7t5v0__fillcap_4
XFILLER_43_836 VDD VSS VDD VSS gf180mcu_fd_sc_mcu7t5v0__fillcap_4
XFILLER_55_696 VDD VSS VDD VSS gf180mcu_fd_sc_mcu7t5v0__fillcap_4
XFILLER_187_307 VDD VSS VDD VSS gf180mcu_fd_sc_mcu7t5v0__fillcap_8
XFILLER_196_885 VDD VSS VDD VSS gf180mcu_fd_sc_mcu7t5v0__fillcap_4
Xmax_length200 _4212_/RN wire199/I VDD VSS VDD VSS gf180mcu_fd_sc_mcu7t5v0__buf_4
XFILLER_11_766 VDD VSS VDD VSS gf180mcu_fd_sc_mcu7t5v0__fillcap_4
XFILLER_109_610 VDD VSS VDD VSS gf180mcu_fd_sc_mcu7t5v0__fillcap_16
XFILLER_109_632 VDD VSS VDD VSS gf180mcu_fd_sc_mcu7t5v0__fillcap_64
Xmax_length211 wire196/I wire212/Z VDD VSS VDD VSS gf180mcu_fd_sc_mcu7t5v0__buf_8
XFILLER_6_247 VDD VSS VDD VSS gf180mcu_fd_sc_mcu7t5v0__fillcap_64
XFILLER_170_218 VDD VSS VDD VSS gf180mcu_fd_sc_mcu7t5v0__fillcap_4
XFILLER_163_270 VDD VSS VDD VSS gf180mcu_fd_sc_mcu7t5v0__fillcap_8
XFILLER_151_454 VDD VSS VDD VSS gf180mcu_fd_sc_mcu7t5v0__fillcap_8
XFILLER_266_801 VDD VSS VDD VSS gf180mcu_fd_sc_mcu7t5v0__fillcap_4
XFILLER_104_381 VDD VSS VDD VSS gf180mcu_fd_sc_mcu7t5v0__fillcap_4
XFILLER_49_72 VDD VSS VDD VSS gf180mcu_fd_sc_mcu7t5v0__fillcap_64
XFILLER_120_863 VDD VSS VDD VSS gf180mcu_fd_sc_mcu7t5v0__fillcap_8
XFILLER_172_95 VDD VSS VDD VSS gf180mcu_fd_sc_mcu7t5v0__fillcap_4
XFILLER_77_276 VDD VSS VDD VSS gf180mcu_fd_sc_mcu7t5v0__fillcap_4
XFILLER_120_885 VDD VSS VDD VSS gf180mcu_fd_sc_mcu7t5v0__fillcap_4
XFILLER_65_416 VDD VSS VDD VSS gf180mcu_fd_sc_mcu7t5v0__fillcap_4
XFILLER_219_772 VDD VSS VDD VSS gf180mcu_fd_sc_mcu7t5v0__fillcap_16
XFILLER_206_400 VDD VSS VDD VSS gf180mcu_fd_sc_mcu7t5v0__fillcap_32
XFILLER_246_591 VDD VSS VDD VSS gf180mcu_fd_sc_mcu7t5v0__fillcap_4
XFILLER_18_387 VDD VSS VDD VSS gf180mcu_fd_sc_mcu7t5v0__fillcap_64
XFILLER_33_346 VDD VSS VDD VSS gf180mcu_fd_sc_mcu7t5v0__fillcap_4
XFILLER_159_543 VDD VSS VDD VSS gf180mcu_fd_sc_mcu7t5v0__fillcap_4
X_3710_ _3718_/S VDD VSS _3891_/D _3891_/Q wire178/Z VDD VSS gf180mcu_fd_sc_mcu7t5v0__mux2_2
X_1971_ VDD VSS _4354_/Q _3241_/B2 VDD VSS gf180mcu_fd_sc_mcu7t5v0__clkinv_1
XFILLER_202_683 VDD VSS VDD VSS gf180mcu_fd_sc_mcu7t5v0__fillcap_8
XFILLER_201_193 VDD VSS VDD VSS gf180mcu_fd_sc_mcu7t5v0__fillcap_16
X_3641_ VDD VSS _3641_/I _4482_/D VDD VSS gf180mcu_fd_sc_mcu7t5v0__clkinv_1
X_3572_ _3572_/B1 _3572_/B2 VDD VSS _4474_/D _3572_/A1 _3619_/C VDD VSS gf180mcu_fd_sc_mcu7t5v0__aoi22_1
X_2523_ VDD VSS _3447_/A1 _4429_/Q _3449_/A2 VDD VSS gf180mcu_fd_sc_mcu7t5v0__nand2_1
XFILLER_53_2 VDD VSS VDD VSS gf180mcu_fd_sc_mcu7t5v0__fillcap_64
XFILLER_182_590 VDD VSS VDD VSS gf180mcu_fd_sc_mcu7t5v0__fillcap_4
XFILLER_142_421 VDD VSS VDD VSS gf180mcu_fd_sc_mcu7t5v0__fillcap_8
XFILLER_142_465 VDD VSS VDD VSS gf180mcu_fd_sc_mcu7t5v0__fillcap_4
X_2454_ _2454_/S VDD VSS _4081_/D _2454_/I0 _4081_/Q VDD VSS gf180mcu_fd_sc_mcu7t5v0__mux2_2
X_2385_ _2501_/A1 VDD VSS _2393_/S _4580_/Q _4581_/Q VDD VSS gf180mcu_fd_sc_mcu7t5v0__nand3_1
XFILLER_256_311 VDD VSS VDD VSS gf180mcu_fd_sc_mcu7t5v0__fillcap_4
XFILLER_69_766 VDD VSS VDD VSS gf180mcu_fd_sc_mcu7t5v0__fillcap_4
X_4124_ VDD _4124_/Q _4126_/CLK VSS _4124_/D VDD VSS gf180mcu_fd_sc_mcu7t5v0__dffq_1
Xinput1 VDD VSS input1/Z input1/I VDD VSS gf180mcu_fd_sc_mcu7t5v0__clkbuf_12
XFILLER_28_107 VDD VSS VDD VSS gf180mcu_fd_sc_mcu7t5v0__fillcap_64
X_4055_ VDD _4055_/Q _4123_/CLK VSS _4055_/D VDD VSS gf180mcu_fd_sc_mcu7t5v0__dffq_1
XFILLER_225_764 VDD VSS VDD VSS gf180mcu_fd_sc_mcu7t5v0__fillcap_4
XFILLER_209_282 VDD VSS VDD VSS gf180mcu_fd_sc_mcu7t5v0__fillcap_16
X_3006_ _3218_/C1 VDD VSS _3006_/Z _2813_/C _3017_/B1 VDD VSS gf180mcu_fd_sc_mcu7t5v0__and3_1
XFILLER_224_241 VDD VSS VDD VSS gf180mcu_fd_sc_mcu7t5v0__fillcap_4
XFILLER_37_696 VDD VSS VDD VSS gf180mcu_fd_sc_mcu7t5v0__fillcap_4
XFILLER_25_836 VDD VSS VDD VSS gf180mcu_fd_sc_mcu7t5v0__fillcap_4
X_3908_ VDD _3908_/Q _4001_/CLK VSS _3908_/D VDD VSS gf180mcu_fd_sc_mcu7t5v0__dffq_1
XFILLER_178_885 VDD VSS VDD VSS gf180mcu_fd_sc_mcu7t5v0__fillcap_4
XFILLER_177_18 VDD VSS VDD VSS gf180mcu_fd_sc_mcu7t5v0__fillcap_8
XFILLER_137_204 VDD VSS VDD VSS gf180mcu_fd_sc_mcu7t5v0__fillcap_4
X_3839_ _3839_/S VDD VSS _3993_/D _3848_/I0 _3993_/Q VDD VSS gf180mcu_fd_sc_mcu7t5v0__mux2_2
XFILLER_137_259 VDD VSS VDD VSS gf180mcu_fd_sc_mcu7t5v0__fillcap_4
XFILLER_146_782 VDD VSS VDD VSS gf180mcu_fd_sc_mcu7t5v0__fillcap_16
XFILLER_192_387 VDD VSS VDD VSS gf180mcu_fd_sc_mcu7t5v0__fillcap_16
XFILLER_152_229 VDD VSS VDD VSS gf180mcu_fd_sc_mcu7t5v0__fillcap_16
XFILLER_3_206 VDD VSS VDD VSS gf180mcu_fd_sc_mcu7t5v0__fillcap_4
XFILLER_161_796 VDD VSS VDD VSS gf180mcu_fd_sc_mcu7t5v0__fillcap_4
XFILLER_133_454 VDD VSS VDD VSS gf180mcu_fd_sc_mcu7t5v0__fillcap_4
XFILLER_248_801 VDD VSS VDD VSS gf180mcu_fd_sc_mcu7t5v0__fillcap_4
XFILLER_86_37 VDD VSS VDD VSS gf180mcu_fd_sc_mcu7t5v0__fillcap_64
XFILLER_102_885 VDD VSS VDD VSS gf180mcu_fd_sc_mcu7t5v0__fillcap_4
XFILLER_59_276 VDD VSS VDD VSS gf180mcu_fd_sc_mcu7t5v0__fillcap_4
XFILLER_47_416 VDD VSS VDD VSS gf180mcu_fd_sc_mcu7t5v0__fillcap_4
XFILLER_228_591 VDD VSS VDD VSS gf180mcu_fd_sc_mcu7t5v0__fillcap_4
XFILLER_216_786 VDD VSS VDD VSS gf180mcu_fd_sc_mcu7t5v0__fillcap_4
XFILLER_255_2 VDD VSS VDD VSS gf180mcu_fd_sc_mcu7t5v0__fillcap_64
XFILLER_15_346 VDD VSS VDD VSS gf180mcu_fd_sc_mcu7t5v0__fillcap_4
Xclkbuf_leaf_63_clk_i _4583_/CLK VSS VDD clkload2/I VDD VSS gf180mcu_fd_sc_mcu7t5v0__clkbuf_2
XFILLER_168_351 VDD VSS VDD VSS gf180mcu_fd_sc_mcu7t5v0__fillcap_8
XFILLER_184_844 VDD VSS VDD VSS gf180mcu_fd_sc_mcu7t5v0__fillcap_4
XFILLER_171_505 VDD VSS VDD VSS gf180mcu_fd_sc_mcu7t5v0__fillcap_32
XFILLER_184_877 VDD VSS VDD VSS gf180mcu_fd_sc_mcu7t5v0__fillcap_8
XFILLER_7_556 VDD VSS VDD VSS gf180mcu_fd_sc_mcu7t5v0__fillcap_4
Xclkbuf_leaf_78_clk_i _4126_/CLK VSS VDD clkbuf_3_2__f_clk_i/Z VDD VSS gf180mcu_fd_sc_mcu7t5v0__clkbuf_2
XFILLER_151_240 VDD VSS VDD VSS gf180mcu_fd_sc_mcu7t5v0__fillcap_16
XFILLER_183_72 VDD VSS VDD VSS gf180mcu_fd_sc_mcu7t5v0__fillcap_8
XFILLER_238_311 VDD VSS VDD VSS gf180mcu_fd_sc_mcu7t5v0__fillcap_4
X_2170_ VDD VSS _2170_/Z _4235_/Q _4236_/Q VDD VSS gf180mcu_fd_sc_mcu7t5v0__and2_1
XFILLER_120_682 VDD VSS VDD VSS gf180mcu_fd_sc_mcu7t5v0__fillcap_8
XFILLER_226_539 VDD VSS VDD VSS gf180mcu_fd_sc_mcu7t5v0__fillcap_32
Xclkbuf_leaf_16_clk_i _4198_/CLK VSS VDD clkload3/I VDD VSS gf180mcu_fd_sc_mcu7t5v0__clkbuf_2
XFILLER_206_241 VDD VSS VDD VSS gf180mcu_fd_sc_mcu7t5v0__fillcap_4
XFILLER_19_696 VDD VSS VDD VSS gf180mcu_fd_sc_mcu7t5v0__fillcap_4
X_1954_ VDD VSS _4216_/Q _2635_/A1 VDD VSS gf180mcu_fd_sc_mcu7t5v0__clkinv_1
X_3624_ VDD VSS _3625_/B2 _3624_/A1 _3624_/A2 VDD VSS gf180mcu_fd_sc_mcu7t5v0__nand2_1
XFILLER_162_527 VDD VSS VDD VSS gf180mcu_fd_sc_mcu7t5v0__fillcap_8
XFILLER_174_387 VDD VSS VDD VSS gf180mcu_fd_sc_mcu7t5v0__fillcap_8
XFILLER_127_270 VDD VSS VDD VSS gf180mcu_fd_sc_mcu7t5v0__fillcap_4
X_3555_ VDD VSS _3556_/A3 _3586_/S _4071_/Q VDD VSS gf180mcu_fd_sc_mcu7t5v0__nand2_1
XFILLER_89_806 VDD VSS VDD VSS gf180mcu_fd_sc_mcu7t5v0__fillcap_8
X_2506_ _2509_/S VDD VSS _4126_/D _2506_/I0 _4126_/Q VDD VSS gf180mcu_fd_sc_mcu7t5v0__mux2_2
X_3486_ _3486_/B _3609_/C VDD VSS _3487_/A3 wire82/Z _3483_/Z VDD VSS gf180mcu_fd_sc_mcu7t5v0__oai211_1
X_2437_ _2441_/S VDD VSS _4069_/D _4069_/Q _2505_/I0 VDD VSS gf180mcu_fd_sc_mcu7t5v0__mux2_2
XFILLER_130_457 VDD VSS VDD VSS gf180mcu_fd_sc_mcu7t5v0__fillcap_16
XFILLER_97_850 VDD VSS VDD VSS gf180mcu_fd_sc_mcu7t5v0__fillcap_4
X_2368_ VDD VSS _2369_/B wire158/Z wire14/Z VDD VSS gf180mcu_fd_sc_mcu7t5v0__nand2_1
XFILLER_29_416 VDD VSS VDD VSS gf180mcu_fd_sc_mcu7t5v0__fillcap_4
X_2299_ _2299_/B1 wire69/I VDD VSS _4510_/D _4532_/Q _4223_/Q VDD VSS gf180mcu_fd_sc_mcu7t5v0__aoi22_1
X_4107_ VDD _4107_/Q _4126_/CLK VSS _4107_/D VDD VSS gf180mcu_fd_sc_mcu7t5v0__dffq_1
XFILLER_260_807 VDD VSS VDD VSS gf180mcu_fd_sc_mcu7t5v0__fillcap_64
X_4038_ VDD _4038_/Q _4065_/CLK VSS _4038_/D VDD VSS gf180mcu_fd_sc_mcu7t5v0__dffq_1
XFILLER_240_597 VDD VSS VDD VSS gf180mcu_fd_sc_mcu7t5v0__fillcap_64
XFILLER_184_107 VDD VSS VDD VSS gf180mcu_fd_sc_mcu7t5v0__fillcap_8
XFILLER_138_579 VDD VSS VDD VSS gf180mcu_fd_sc_mcu7t5v0__fillcap_16
XFILLER_166_877 VDD VSS VDD VSS gf180mcu_fd_sc_mcu7t5v0__fillcap_8
XFILLER_181_825 VDD VSS VDD VSS gf180mcu_fd_sc_mcu7t5v0__fillcap_8
XFILLER_153_64 VDD VSS VDD VSS gf180mcu_fd_sc_mcu7t5v0__fillcap_4
XFILLER_216_572 VDD VSS VDD VSS gf180mcu_fd_sc_mcu7t5v0__fillcap_16
XFILLER_262_177 VDD VSS VDD VSS gf180mcu_fd_sc_mcu7t5v0__fillcap_64
XFILLER_250_317 VDD VSS VDD VSS gf180mcu_fd_sc_mcu7t5v0__fillcap_64
XFILLER_90_569 VDD VSS VDD VSS gf180mcu_fd_sc_mcu7t5v0__fillcap_16
XFILLER_204_756 VDD VSS VDD VSS gf180mcu_fd_sc_mcu7t5v0__fillcap_32
XFILLER_188_457 VDD VSS VDD VSS gf180mcu_fd_sc_mcu7t5v0__fillcap_32
XFILLER_203_244 VDD VSS VDD VSS gf180mcu_fd_sc_mcu7t5v0__fillcap_16
XFILLER_71_772 VDD VSS VDD VSS gf180mcu_fd_sc_mcu7t5v0__fillcap_64
XFILLER_169_693 VDD VSS VDD VSS gf180mcu_fd_sc_mcu7t5v0__fillcap_4
XFILLER_156_310 VDD VSS VDD VSS gf180mcu_fd_sc_mcu7t5v0__fillcap_4
XFILLER_144_505 VDD VSS VDD VSS gf180mcu_fd_sc_mcu7t5v0__fillcap_8
XFILLER_184_696 VDD VSS VDD VSS gf180mcu_fd_sc_mcu7t5v0__fillcap_32
XFILLER_156_387 VDD VSS VDD VSS gf180mcu_fd_sc_mcu7t5v0__fillcap_32
X_3340_ _3346_/S VDD VSS _4388_/D _4373_/Q _4388_/Q VDD VSS gf180mcu_fd_sc_mcu7t5v0__mux2_2
XFILLER_112_435 VDD VSS VDD VSS gf180mcu_fd_sc_mcu7t5v0__fillcap_4
XFILLER_97_124 VDD VSS VDD VSS gf180mcu_fd_sc_mcu7t5v0__fillcap_4
X_3271_ _3271_/B _3271_/C VDD VSS _3272_/C _3271_/A1 _2936_/B VDD VSS gf180mcu_fd_sc_mcu7t5v0__oai211_1
XFILLER_140_799 VDD VSS VDD VSS gf180mcu_fd_sc_mcu7t5v0__fillcap_4
X_2222_ _2220_/Z VDD VSS _2728_/S _4319_/Q _4505_/Q VDD VSS gf180mcu_fd_sc_mcu7t5v0__and3_1
X_2153_ VDD VSS _2212_/A3 _4315_/Q _4316_/Q VDD VSS gf180mcu_fd_sc_mcu7t5v0__nand2_1
XFILLER_16_2 VDD VSS VDD VSS gf180mcu_fd_sc_mcu7t5v0__fillcap_32
XFILLER_254_667 VDD VSS VDD VSS gf180mcu_fd_sc_mcu7t5v0__fillcap_64
XFILLER_242_807 VDD VSS VDD VSS gf180mcu_fd_sc_mcu7t5v0__fillcap_64
XFILLER_93_352 VDD VSS VDD VSS gf180mcu_fd_sc_mcu7t5v0__fillcap_64
XFILLER_207_550 VDD VSS VDD VSS gf180mcu_fd_sc_mcu7t5v0__fillcap_8
X_2084_ VDD VSS _4578_/D _4578_/Q _2084_/A2 VDD VSS gf180mcu_fd_sc_mcu7t5v0__xor2_1
XFILLER_210_737 VDD VSS VDD VSS gf180mcu_fd_sc_mcu7t5v0__fillcap_8
XFILLER_222_597 VDD VSS VDD VSS gf180mcu_fd_sc_mcu7t5v0__fillcap_16
XFILLER_179_468 VDD VSS VDD VSS gf180mcu_fd_sc_mcu7t5v0__fillcap_16
XFILLER_166_107 VDD VSS VDD VSS gf180mcu_fd_sc_mcu7t5v0__fillcap_64
XFILLER_61_282 VDD VSS VDD VSS gf180mcu_fd_sc_mcu7t5v0__fillcap_64
XFILLER_194_449 VDD VSS VDD VSS gf180mcu_fd_sc_mcu7t5v0__fillcap_4
X_2986_ VDD VSS _2987_/A2 _2986_/A1 _2986_/A2 VDD VSS gf180mcu_fd_sc_mcu7t5v0__nand2_1
Xmax_length38 VSS _2359_/S _2066_/Z VDD VDD VSS gf180mcu_fd_sc_mcu7t5v0__buf_2
XFILLER_148_877 VDD VSS VDD VSS gf180mcu_fd_sc_mcu7t5v0__fillcap_8
X_1937_ VDD VSS _4325_/Q _3018_/B2 VDD VSS gf180mcu_fd_sc_mcu7t5v0__clkinv_1
XFILLER_163_825 VDD VSS VDD VSS gf180mcu_fd_sc_mcu7t5v0__fillcap_4
X_4587_ _4587_/D _4612_/D _4613_/RN VSS _4606_/CLK VDD VDD VSS gf180mcu_fd_sc_mcu7t5v0__dffrnq_1
X_3607_ VDD VSS _3608_/A3 _3605_/S _4009_/Q VDD VSS gf180mcu_fd_sc_mcu7t5v0__nand2_1
X_3538_ VDD VSS _3540_/A2 wire75/Z _4014_/Q VDD VSS gf180mcu_fd_sc_mcu7t5v0__nand2_1
XFILLER_143_571 VDD VSS VDD VSS gf180mcu_fd_sc_mcu7t5v0__fillcap_16
XFILLER_115_273 VDD VSS VDD VSS gf180mcu_fd_sc_mcu7t5v0__fillcap_4
X_3469_ _3564_/S VDD VSS _3469_/Z _4027_/Q _4019_/Q VDD VSS gf180mcu_fd_sc_mcu7t5v0__mux2_2
XFILLER_85_842 VDD VSS VDD VSS gf180mcu_fd_sc_mcu7t5v0__fillcap_8
XFILLER_85_886 VDD VSS VDD VSS gf180mcu_fd_sc_mcu7t5v0__fillcap_4
XFILLER_244_177 VDD VSS VDD VSS gf180mcu_fd_sc_mcu7t5v0__fillcap_64
XFILLER_232_317 VDD VSS VDD VSS gf180mcu_fd_sc_mcu7t5v0__fillcap_64
XFILLER_53_772 VDD VSS VDD VSS gf180mcu_fd_sc_mcu7t5v0__fillcap_64
XFILLER_185_405 VDD VSS VDD VSS gf180mcu_fd_sc_mcu7t5v0__fillcap_8
XFILLER_80_591 VDD VSS VDD VSS gf180mcu_fd_sc_mcu7t5v0__fillcap_4
XFILLER_200_247 VDD VSS VDD VSS gf180mcu_fd_sc_mcu7t5v0__fillcap_16
XFILLER_218_2 VDD VSS VDD VSS gf180mcu_fd_sc_mcu7t5v0__fillcap_32
XFILLER_120_2 VDD VSS VDD VSS gf180mcu_fd_sc_mcu7t5v0__fillcap_16
XFILLER_126_527 VDD VSS VDD VSS gf180mcu_fd_sc_mcu7t5v0__fillcap_32
XFILLER_141_508 VDD VSS VDD VSS gf180mcu_fd_sc_mcu7t5v0__fillcap_8
XFILLER_181_677 VDD VSS VDD VSS gf180mcu_fd_sc_mcu7t5v0__fillcap_8
XFILLER_121_221 VDD VSS VDD VSS gf180mcu_fd_sc_mcu7t5v0__fillcap_8
XFILLER_122_799 VDD VSS VDD VSS gf180mcu_fd_sc_mcu7t5v0__fillcap_4
XFILLER_121_298 VDD VSS VDD VSS gf180mcu_fd_sc_mcu7t5v0__fillcap_8
XFILLER_180_62 VDD VSS VDD VSS gf180mcu_fd_sc_mcu7t5v0__fillcap_32
XFILLER_75_352 VDD VSS VDD VSS gf180mcu_fd_sc_mcu7t5v0__fillcap_64
XFILLER_57_72 VDD VSS VDD VSS gf180mcu_fd_sc_mcu7t5v0__fillcap_64
XFILLER_90_311 VDD VSS VDD VSS gf180mcu_fd_sc_mcu7t5v0__fillcap_4
XFILLER_251_626 VDD VSS VDD VSS gf180mcu_fd_sc_mcu7t5v0__fillcap_4
XFILLER_263_486 VDD VSS VDD VSS gf180mcu_fd_sc_mcu7t5v0__fillcap_4
XFILLER_204_542 VDD VSS VDD VSS gf180mcu_fd_sc_mcu7t5v0__fillcap_32
XFILLER_188_232 VDD VSS VDD VSS gf180mcu_fd_sc_mcu7t5v0__fillcap_8
XFILLER_31_422 VDD VSS VDD VSS gf180mcu_fd_sc_mcu7t5v0__fillcap_64
X_2840_ _2840_/B _3158_/B VDD VSS _2850_/A1 _3157_/A1 _3961_/Q VDD VSS gf180mcu_fd_sc_mcu7t5v0__oai211_1
XFILLER_43_282 VDD VSS VDD VSS gf180mcu_fd_sc_mcu7t5v0__fillcap_64
XFILLER_148_107 VDD VSS VDD VSS gf180mcu_fd_sc_mcu7t5v0__fillcap_32
XFILLER_176_449 VDD VSS VDD VSS gf180mcu_fd_sc_mcu7t5v0__fillcap_4
X_2771_ _2771_/B VDD VSS _4300_/D _2771_/A1 _2771_/A2 VDD VSS gf180mcu_fd_sc_mcu7t5v0__aoi21_1
X_4510_ VSS _4510_/CLK VDD _4510_/D _4510_/Q _4534_/RN VDD VSS gf180mcu_fd_sc_mcu7t5v0__dffsnq_1
XFILLER_172_622 VDD VSS VDD VSS gf180mcu_fd_sc_mcu7t5v0__fillcap_4
XFILLER_156_195 VDD VSS VDD VSS gf180mcu_fd_sc_mcu7t5v0__fillcap_16
X_4441_ _4441_/D _4441_/Q wire193/I VSS _4441_/CLK VDD VDD VSS gf180mcu_fd_sc_mcu7t5v0__dffrnq_1
XFILLER_172_699 VDD VSS VDD VSS gf180mcu_fd_sc_mcu7t5v0__fillcap_8
X_4372_ _4372_/D _4372_/Q wire209/Z VSS _4427_/CLK VDD VDD VSS gf180mcu_fd_sc_mcu7t5v0__dffrnq_1
X_3323_ VDD VSS _3324_/A2 _4380_/Q _4381_/Q VDD VSS gf180mcu_fd_sc_mcu7t5v0__xnor2_1
X_3254_ wire23/Z VDD VSS _4362_/D _4337_/Q _4362_/Q VDD VSS gf180mcu_fd_sc_mcu7t5v0__mux2_2
XFILLER_140_574 VDD VSS VDD VSS gf180mcu_fd_sc_mcu7t5v0__fillcap_4
XFILLER_258_247 VDD VSS VDD VSS gf180mcu_fd_sc_mcu7t5v0__fillcap_64
XFILLER_224_22 VDD VSS VDD VSS gf180mcu_fd_sc_mcu7t5v0__fillcap_8
X_2205_ _2205_/B _4509_/Q VDD VSS _2206_/A2 _2169_/Z _2205_/A2 VDD VSS gf180mcu_fd_sc_mcu7t5v0__oai211_1
XFILLER_67_842 VDD VSS VDD VSS gf180mcu_fd_sc_mcu7t5v0__fillcap_32
X_3185_ _3185_/S VDD VSS _3185_/Z _3952_/Q _3944_/Q VDD VSS gf180mcu_fd_sc_mcu7t5v0__mux2_2
X_2136_ _4531_/Q VDD VSS _2137_/I _4136_/Q _2136_/A2 VDD VSS gf180mcu_fd_sc_mcu7t5v0__aoi21_1
XFILLER_240_10 VDD VSS VDD VSS gf180mcu_fd_sc_mcu7t5v0__fillcap_16
XFILLER_226_177 VDD VSS VDD VSS gf180mcu_fd_sc_mcu7t5v0__fillcap_64
XFILLER_214_317 VDD VSS VDD VSS gf180mcu_fd_sc_mcu7t5v0__fillcap_64
X_2067_ _4581_/Q VDD VSS _2096_/A2 _4580_/Q _2061_/Z VDD VSS gf180mcu_fd_sc_mcu7t5v0__aoi21_1
XFILLER_241_136 VDD VSS VDD VSS gf180mcu_fd_sc_mcu7t5v0__fillcap_4
XFILLER_35_772 VDD VSS VDD VSS gf180mcu_fd_sc_mcu7t5v0__fillcap_64
XFILLER_62_591 VDD VSS VDD VSS gf180mcu_fd_sc_mcu7t5v0__fillcap_4
XFILLER_50_731 VDD VSS VDD VSS gf180mcu_fd_sc_mcu7t5v0__fillcap_4
XFILLER_179_298 VDD VSS VDD VSS gf180mcu_fd_sc_mcu7t5v0__fillcap_4
XFILLER_210_589 VDD VSS VDD VSS gf180mcu_fd_sc_mcu7t5v0__fillcap_4
X_2969_ VDD VSS _4318_/D _2969_/A1 _2969_/A2 VDD VSS gf180mcu_fd_sc_mcu7t5v0__nand2_1
XFILLER_163_622 VDD VSS VDD VSS gf180mcu_fd_sc_mcu7t5v0__fillcap_8
XFILLER_108_527 VDD VSS VDD VSS gf180mcu_fd_sc_mcu7t5v0__fillcap_8
XFILLER_135_368 VDD VSS VDD VSS gf180mcu_fd_sc_mcu7t5v0__fillcap_8
XFILLER_89_422 VDD VSS VDD VSS gf180mcu_fd_sc_mcu7t5v0__fillcap_64
XFILLER_190_485 VDD VSS VDD VSS gf180mcu_fd_sc_mcu7t5v0__fillcap_16
XFILLER_57_352 VDD VSS VDD VSS gf180mcu_fd_sc_mcu7t5v0__fillcap_64
XFILLER_94_37 VDD VSS VDD VSS gf180mcu_fd_sc_mcu7t5v0__fillcap_32
XFILLER_218_667 VDD VSS VDD VSS gf180mcu_fd_sc_mcu7t5v0__fillcap_4
XFILLER_206_807 VDD VSS VDD VSS gf180mcu_fd_sc_mcu7t5v0__fillcap_64
XFILLER_72_311 VDD VSS VDD VSS gf180mcu_fd_sc_mcu7t5v0__fillcap_4
XFILLER_84_171 VDD VSS VDD VSS gf180mcu_fd_sc_mcu7t5v0__fillcap_4
XFILLER_245_486 VDD VSS VDD VSS gf180mcu_fd_sc_mcu7t5v0__fillcap_4
XFILLER_168_2 VDD VSS VDD VSS gf180mcu_fd_sc_mcu7t5v0__fillcap_32
XFILLER_13_422 VDD VSS VDD VSS gf180mcu_fd_sc_mcu7t5v0__fillcap_64
XFILLER_25_282 VDD VSS VDD VSS gf180mcu_fd_sc_mcu7t5v0__fillcap_64
XFILLER_40_241 VDD VSS VDD VSS gf180mcu_fd_sc_mcu7t5v0__fillcap_4
XFILLER_159_96 VDD VSS VDD VSS gf180mcu_fd_sc_mcu7t5v0__fillcap_4
XFILLER_127_825 VDD VSS VDD VSS gf180mcu_fd_sc_mcu7t5v0__fillcap_8
XFILLER_166_482 VDD VSS VDD VSS gf180mcu_fd_sc_mcu7t5v0__fillcap_8
XFILLER_5_632 VDD VSS VDD VSS gf180mcu_fd_sc_mcu7t5v0__fillcap_64
XFILLER_181_452 VDD VSS VDD VSS gf180mcu_fd_sc_mcu7t5v0__fillcap_32
XFILLER_141_327 VDD VSS VDD VSS gf180mcu_fd_sc_mcu7t5v0__fillcap_16
XFILLER_268_512 VDD VSS VDD VSS gf180mcu_fd_sc_mcu7t5v0__fillcap_32
XFILLER_122_574 VDD VSS VDD VSS gf180mcu_fd_sc_mcu7t5v0__fillcap_16
XFILLER_255_206 VDD VSS VDD VSS gf180mcu_fd_sc_mcu7t5v0__fillcap_4
XFILLER_191_72 VDD VSS VDD VSS gf180mcu_fd_sc_mcu7t5v0__fillcap_32
XFILLER_49_842 VDD VSS VDD VSS gf180mcu_fd_sc_mcu7t5v0__fillcap_32
XFILLER_76_661 VDD VSS VDD VSS gf180mcu_fd_sc_mcu7t5v0__fillcap_4
XFILLER_64_801 VDD VSS VDD VSS gf180mcu_fd_sc_mcu7t5v0__fillcap_4
XFILLER_208_177 VDD VSS VDD VSS gf180mcu_fd_sc_mcu7t5v0__fillcap_16
XFILLER_223_136 VDD VSS VDD VSS gf180mcu_fd_sc_mcu7t5v0__fillcap_4
XFILLER_17_772 VDD VSS VDD VSS gf180mcu_fd_sc_mcu7t5v0__fillcap_64
X_3941_ VDD _3941_/Q _3965_/CLK VSS _3941_/D VDD VSS gf180mcu_fd_sc_mcu7t5v0__dffq_1
XFILLER_44_591 VDD VSS VDD VSS gf180mcu_fd_sc_mcu7t5v0__fillcap_4
XFILLER_32_731 VDD VSS VDD VSS gf180mcu_fd_sc_mcu7t5v0__fillcap_4
X_3872_ _3872_/D _3873_/D _4535_/RN VSS _4468_/CLK VDD VDD VSS gf180mcu_fd_sc_mcu7t5v0__dffrnq_1
X_2823_ _3027_/A3 VDD VSS _3212_/B _4524_/D _2995_/A2 VDD VSS gf180mcu_fd_sc_mcu7t5v0__nor3_1
XFILLER_83_2 VDD VSS VDD VSS gf180mcu_fd_sc_mcu7t5v0__fillcap_64
X_2754_ _2754_/S VDD VSS _4288_/D _4288_/Q _4467_/Q VDD VSS gf180mcu_fd_sc_mcu7t5v0__mux2_2
XFILLER_176_279 VDD VSS VDD VSS gf180mcu_fd_sc_mcu7t5v0__fillcap_16
XFILLER_219_66 VDD VSS VDD VSS gf180mcu_fd_sc_mcu7t5v0__fillcap_4
XFILLER_172_441 VDD VSS VDD VSS gf180mcu_fd_sc_mcu7t5v0__fillcap_8
X_2685_ _2685_/B1 _2685_/C VDD VSS _2698_/B _4318_/Q _2693_/A1 wire59/Z VDD VSS gf180mcu_fd_sc_mcu7t5v0__oai221_1
XFILLER_117_346 VDD VSS VDD VSS gf180mcu_fd_sc_mcu7t5v0__fillcap_4
X_4424_ _4424_/D _4424_/Q wire206/Z VSS _4466_/CLK VDD VDD VSS gf180mcu_fd_sc_mcu7t5v0__dffrnq_1
X_4355_ _4355_/D _4355_/Q _4525_/RN VSS _4355_/CLK VDD VDD VSS gf180mcu_fd_sc_mcu7t5v0__dffrnq_1
XFILLER_113_530 VDD VSS VDD VSS gf180mcu_fd_sc_mcu7t5v0__fillcap_16
XFILLER_259_556 VDD VSS VDD VSS gf180mcu_fd_sc_mcu7t5v0__fillcap_4
X_3306_ _3306_/A3 VDD VSS _3306_/Z _4381_/Q _3306_/A2 VDD VSS gf180mcu_fd_sc_mcu7t5v0__and3_1
X_4286_ _4286_/D _4286_/Q wire206/Z VSS _4466_/CLK VDD VDD VSS gf180mcu_fd_sc_mcu7t5v0__dffrnq_1
X_3237_ _3239_/A1 VDD VSS _3240_/A2 _4352_/Q _2993_/Z VDD VSS gf180mcu_fd_sc_mcu7t5v0__nand3_1
XFILLER_39_352 VDD VSS VDD VSS gf180mcu_fd_sc_mcu7t5v0__fillcap_64
X_3168_ VDD VSS _3169_/C _4508_/Q _4252_/Q VDD VSS gf180mcu_fd_sc_mcu7t5v0__or2_1
XFILLER_54_311 VDD VSS VDD VSS gf180mcu_fd_sc_mcu7t5v0__fillcap_4
XFILLER_66_171 VDD VSS VDD VSS gf180mcu_fd_sc_mcu7t5v0__fillcap_4
X_2119_ VDD VSS _2119_/I _4130_/D VDD VSS gf180mcu_fd_sc_mcu7t5v0__clkinv_1
X_3099_ VDD VSS _3104_/A2 wire94/Z _3098_/Z VDD VSS gf180mcu_fd_sc_mcu7t5v0__nor2_1
XFILLER_22_241 VDD VSS VDD VSS gf180mcu_fd_sc_mcu7t5v0__fillcap_4
XFILLER_13_66 VDD VSS VDD VSS gf180mcu_fd_sc_mcu7t5v0__fillcap_4
XFILLER_108_302 VDD VSS VDD VSS gf180mcu_fd_sc_mcu7t5v0__fillcap_8
XFILLER_109_836 VDD VSS VDD VSS gf180mcu_fd_sc_mcu7t5v0__fillcap_4
XFILLER_191_772 VDD VSS VDD VSS gf180mcu_fd_sc_mcu7t5v0__fillcap_16
XFILLER_108_368 VDD VSS VDD VSS gf180mcu_fd_sc_mcu7t5v0__fillcap_4
XFILLER_190_271 VDD VSS VDD VSS gf180mcu_fd_sc_mcu7t5v0__fillcap_32
XFILLER_237_206 VDD VSS VDD VSS gf180mcu_fd_sc_mcu7t5v0__fillcap_4
XFILLER_104_585 VDD VSS VDD VSS gf180mcu_fd_sc_mcu7t5v0__fillcap_8
XFILLER_58_661 VDD VSS VDD VSS gf180mcu_fd_sc_mcu7t5v0__fillcap_4
XFILLER_46_801 VDD VSS VDD VSS gf180mcu_fd_sc_mcu7t5v0__fillcap_4
XFILLER_206_637 VDD VSS VDD VSS gf180mcu_fd_sc_mcu7t5v0__fillcap_4
XFILLER_26_591 VDD VSS VDD VSS gf180mcu_fd_sc_mcu7t5v0__fillcap_4
XFILLER_14_731 VDD VSS VDD VSS gf180mcu_fd_sc_mcu7t5v0__fillcap_4
XFILLER_158_224 VDD VSS VDD VSS gf180mcu_fd_sc_mcu7t5v0__fillcap_16
XFILLER_9_212 VDD VSS VDD VSS gf180mcu_fd_sc_mcu7t5v0__fillcap_64
Xclkload15 VDD VSS _4402_/CLK clkload15/ZN VDD VSS gf180mcu_fd_sc_mcu7t5v0__clkinv_2
Xclkload26 VDD VSS _4033_/CLK clkload26/ZN VDD VSS gf180mcu_fd_sc_mcu7t5v0__clkinv_2
Xclkload37 VSS clkload37/Z _4364_/CLK VDD VDD VSS gf180mcu_fd_sc_mcu7t5v0__clkbuf_1
Xclkload59 VSS clkload59/Z _4459_/CLK VDD VDD VSS gf180mcu_fd_sc_mcu7t5v0__clkbuf_1
XFILLER_126_143 VDD VSS VDD VSS gf180mcu_fd_sc_mcu7t5v0__fillcap_16
Xclkload48 VSS clkload48/Z _4476_/CLK VDD VDD VSS gf180mcu_fd_sc_mcu7t5v0__clkbuf_1
X_2470_ _2472_/S VDD VSS _4095_/D wire155/Z _4095_/Q VDD VSS gf180mcu_fd_sc_mcu7t5v0__mux2_2
XFILLER_127_688 VDD VSS VDD VSS gf180mcu_fd_sc_mcu7t5v0__fillcap_8
XFILLER_181_282 VDD VSS VDD VSS gf180mcu_fd_sc_mcu7t5v0__fillcap_64
XFILLER_114_349 VDD VSS VDD VSS gf180mcu_fd_sc_mcu7t5v0__fillcap_16
XFILLER_268_342 VDD VSS VDD VSS gf180mcu_fd_sc_mcu7t5v0__fillcap_32
X_4140_ _4140_/D _4140_/Q wire193/Z VSS _4270_/CLK VDD VDD VSS gf180mcu_fd_sc_mcu7t5v0__dffrnq_1
XFILLER_150_680 VDD VSS VDD VSS gf180mcu_fd_sc_mcu7t5v0__fillcap_32
X_4071_ VDD _4071_/Q _4081_/CLK VSS _4071_/D VDD VSS gf180mcu_fd_sc_mcu7t5v0__dffq_1
X_3022_ VDD VSS _3029_/A2 _2788_/Z _2807_/B VDD VSS gf180mcu_fd_sc_mcu7t5v0__nand2_1
XFILLER_36_311 VDD VSS VDD VSS gf180mcu_fd_sc_mcu7t5v0__fillcap_4
XFILLER_48_171 VDD VSS VDD VSS gf180mcu_fd_sc_mcu7t5v0__fillcap_4
XFILLER_205_670 VDD VSS VDD VSS gf180mcu_fd_sc_mcu7t5v0__fillcap_4
XFILLER_212_629 VDD VSS VDD VSS gf180mcu_fd_sc_mcu7t5v0__fillcap_4
X_3924_ VDD _3924_/Q _4001_/CLK VSS _3924_/D VDD VSS gf180mcu_fd_sc_mcu7t5v0__dffq_1
Xclkload9 VSS clkload9/Z clkload9/I VDD VDD VSS gf180mcu_fd_sc_mcu7t5v0__clkbuf_1
X_3855_ input5/Z _3855_/Q wire210/Z VSS _4496_/CLK VDD VDD VSS gf180mcu_fd_sc_mcu7t5v0__dffrnq_1
X_3786_ _3786_/S VDD VSS _3953_/D _4296_/Q _3953_/Q VDD VSS gf180mcu_fd_sc_mcu7t5v0__mux2_2
X_2806_ wire51/Z VDD VSS _2807_/B _4348_/Q _3004_/C VDD VSS gf180mcu_fd_sc_mcu7t5v0__nand3_1
X_2737_ _2748_/S VDD VSS _4271_/D _4271_/Q _3394_/I1 VDD VSS gf180mcu_fd_sc_mcu7t5v0__mux2_2
X_2668_ VDD VSS _2669_/A2 _4232_/Q _2666_/C VDD VSS gf180mcu_fd_sc_mcu7t5v0__nand2_1
XFILLER_145_485 VDD VSS VDD VSS gf180mcu_fd_sc_mcu7t5v0__fillcap_4
XFILLER_173_772 VDD VSS VDD VSS gf180mcu_fd_sc_mcu7t5v0__fillcap_8
XFILLER_106_839 VDD VSS VDD VSS gf180mcu_fd_sc_mcu7t5v0__fillcap_4
X_4407_ _4407_/D _4407_/Q wire196/I VSS _4407_/CLK VDD VDD VSS gf180mcu_fd_sc_mcu7t5v0__dffrnq_1
X_2599_ _2599_/B1 _2586_/Z VDD VSS _4205_/D _2599_/A1 _2599_/A2 VDD VSS gf180mcu_fd_sc_mcu7t5v0__aoi22_1
X_4338_ _4338_/D _4338_/Q _4525_/RN VSS _4338_/CLK VDD VDD VSS gf180mcu_fd_sc_mcu7t5v0__dffrnq_1
XFILLER_219_206 VDD VSS VDD VSS gf180mcu_fd_sc_mcu7t5v0__fillcap_4
X_4269_ _4269_/D _4269_/Q _4534_/RN VSS _4269_/CLK VDD VDD VSS gf180mcu_fd_sc_mcu7t5v0__dffrnq_1
XFILLER_28_801 VDD VSS VDD VSS gf180mcu_fd_sc_mcu7t5v0__fillcap_4
XFILLER_91_38 VDD VSS VDD VSS gf180mcu_fd_sc_mcu7t5v0__fillcap_4
XFILLER_70_667 VDD VSS VDD VSS gf180mcu_fd_sc_mcu7t5v0__fillcap_64
XFILLER_211_640 VDD VSS VDD VSS gf180mcu_fd_sc_mcu7t5v0__fillcap_4
XFILLER_211_662 VDD VSS VDD VSS gf180mcu_fd_sc_mcu7t5v0__fillcap_4
XFILLER_196_842 VDD VSS VDD VSS gf180mcu_fd_sc_mcu7t5v0__fillcap_4
Xclkbuf_4_0_0_host_clk_i _4574_/CLK VSS VDD clkbuf_0_host_clk_i/Z VDD VSS gf180mcu_fd_sc_mcu7t5v0__clkbuf_2
XFILLER_195_352 VDD VSS VDD VSS gf180mcu_fd_sc_mcu7t5v0__fillcap_16
XFILLER_183_536 VDD VSS VDD VSS gf180mcu_fd_sc_mcu7t5v0__fillcap_16
Xmax_length201 _4512_/RN wire199/I VDD VSS VDD VSS gf180mcu_fd_sc_mcu7t5v0__buf_4
XFILLER_108_143 VDD VSS VDD VSS gf180mcu_fd_sc_mcu7t5v0__fillcap_32
XFILLER_151_422 VDD VSS VDD VSS gf180mcu_fd_sc_mcu7t5v0__fillcap_32
XFILLER_163_282 VDD VSS VDD VSS gf180mcu_fd_sc_mcu7t5v0__fillcap_32
XFILLER_105_850 VDD VSS VDD VSS gf180mcu_fd_sc_mcu7t5v0__fillcap_4
XFILLER_92_247 VDD VSS VDD VSS gf180mcu_fd_sc_mcu7t5v0__fillcap_64
XFILLER_18_311 VDD VSS VDD VSS gf180mcu_fd_sc_mcu7t5v0__fillcap_4
XFILLER_65_72 VDD VSS VDD VSS gf180mcu_fd_sc_mcu7t5v0__fillcap_64
XFILLER_261_562 VDD VSS VDD VSS gf180mcu_fd_sc_mcu7t5v0__fillcap_64
XFILLER_206_478 VDD VSS VDD VSS gf180mcu_fd_sc_mcu7t5v0__fillcap_32
X_1970_ VDD VSS _4200_/Q _2934_/B1 VDD VSS gf180mcu_fd_sc_mcu7t5v0__clkinv_1
XFILLER_187_842 VDD VSS VDD VSS gf180mcu_fd_sc_mcu7t5v0__fillcap_8
XFILLER_60_177 VDD VSS VDD VSS gf180mcu_fd_sc_mcu7t5v0__fillcap_64
XFILLER_187_864 VDD VSS VDD VSS gf180mcu_fd_sc_mcu7t5v0__fillcap_16
X_3640_ _3640_/B1 _4176_/Q VDD VSS _3641_/I _4482_/Q _3479_/C VDD VSS gf180mcu_fd_sc_mcu7t5v0__aoi22_1
X_3571_ _3619_/C VDD VSS _3572_/B2 _3619_/B1 _3571_/A2 VDD VSS gf180mcu_fd_sc_mcu7t5v0__aoi21_1
XFILLER_155_761 VDD VSS VDD VSS gf180mcu_fd_sc_mcu7t5v0__fillcap_8
X_2522_ _2522_/B VDD VSS _4150_/D _2041_/B _3859_/Q VDD VSS gf180mcu_fd_sc_mcu7t5v0__aoi21_1
X_2453_ _2454_/S VDD VSS _4080_/D wire152/Z _4080_/Q VDD VSS gf180mcu_fd_sc_mcu7t5v0__mux2_2
XFILLER_46_2 VDD VSS VDD VSS gf180mcu_fd_sc_mcu7t5v0__fillcap_32
X_2384_ _2925_/A1 _4577_/Q VDD VSS _2501_/A1 _4579_/Q _4578_/Q VDD VSS gf180mcu_fd_sc_mcu7t5v0__nor4_1
XFILLER_268_172 VDD VSS VDD VSS gf180mcu_fd_sc_mcu7t5v0__fillcap_32
X_4123_ VDD _4123_/Q _4123_/CLK VSS _4123_/D VDD VSS gf180mcu_fd_sc_mcu7t5v0__dffq_1
Xinput2 VDD scl_pad_i VSS input2/Z VDD VSS gf180mcu_fd_sc_mcu7t5v0__dlyb_1
XFILLER_96_597 VDD VSS VDD VSS gf180mcu_fd_sc_mcu7t5v0__fillcap_16
XFILLER_84_737 VDD VSS VDD VSS gf180mcu_fd_sc_mcu7t5v0__fillcap_16
X_4054_ VDD _4054_/Q _4058_/CLK VSS _4054_/D VDD VSS gf180mcu_fd_sc_mcu7t5v0__dffq_1
XFILLER_209_272 VDD VSS VDD VSS gf180mcu_fd_sc_mcu7t5v0__fillcap_8
X_3005_ _3027_/A3 _3035_/B _3035_/A2 VDD VSS _3218_/C1 _1926_/I VDD VSS gf180mcu_fd_sc_mcu7t5v0__oai22_1
XFILLER_101_48 VDD VSS VDD VSS gf180mcu_fd_sc_mcu7t5v0__fillcap_16
XFILLER_40_807 VDD VSS VDD VSS gf180mcu_fd_sc_mcu7t5v0__fillcap_64
XFILLER_52_667 VDD VSS VDD VSS gf180mcu_fd_sc_mcu7t5v0__fillcap_64
X_3907_ VDD _3907_/Q _3936_/CLK VSS _3907_/D VDD VSS gf180mcu_fd_sc_mcu7t5v0__dffq_1
XFILLER_177_352 VDD VSS VDD VSS gf180mcu_fd_sc_mcu7t5v0__fillcap_8
X_3838_ _3839_/S VDD VSS _3992_/D wire172/Z _3992_/Q VDD VSS gf180mcu_fd_sc_mcu7t5v0__mux2_2
XFILLER_193_834 VDD VSS VDD VSS gf180mcu_fd_sc_mcu7t5v0__fillcap_4
XFILLER_137_227 VDD VSS VDD VSS gf180mcu_fd_sc_mcu7t5v0__fillcap_32
XFILLER_20_597 VDD VSS VDD VSS gf180mcu_fd_sc_mcu7t5v0__fillcap_64
X_3769_ VDD VSS _3777_/S _3813_/A1 _3768_/Z VDD VSS gf180mcu_fd_sc_mcu7t5v0__nand2_1
XFILLER_193_18 VDD VSS VDD VSS gf180mcu_fd_sc_mcu7t5v0__fillcap_8
XFILLER_133_422 VDD VSS VDD VSS gf180mcu_fd_sc_mcu7t5v0__fillcap_32
XFILLER_145_282 VDD VSS VDD VSS gf180mcu_fd_sc_mcu7t5v0__fillcap_8
XFILLER_121_617 VDD VSS VDD VSS gf180mcu_fd_sc_mcu7t5v0__fillcap_8
XFILLER_74_247 VDD VSS VDD VSS gf180mcu_fd_sc_mcu7t5v0__fillcap_64
XFILLER_215_220 VDD VSS VDD VSS gf180mcu_fd_sc_mcu7t5v0__fillcap_16
XFILLER_142_77 VDD VSS VDD VSS gf180mcu_fd_sc_mcu7t5v0__fillcap_4
XFILLER_90_729 VDD VSS VDD VSS gf180mcu_fd_sc_mcu7t5v0__fillcap_4
XFILLER_231_702 VDD VSS VDD VSS gf180mcu_fd_sc_mcu7t5v0__fillcap_16
XFILLER_243_562 VDD VSS VDD VSS gf180mcu_fd_sc_mcu7t5v0__fillcap_64
XFILLER_150_2 VDD VSS VDD VSS gf180mcu_fd_sc_mcu7t5v0__fillcap_32
XFILLER_248_2 VDD VSS VDD VSS gf180mcu_fd_sc_mcu7t5v0__fillcap_32
XFILLER_42_177 VDD VSS VDD VSS gf180mcu_fd_sc_mcu7t5v0__fillcap_64
XFILLER_30_317 VDD VSS VDD VSS gf180mcu_fd_sc_mcu7t5v0__fillcap_64
XFILLER_184_812 VDD VSS VDD VSS gf180mcu_fd_sc_mcu7t5v0__fillcap_32
XFILLER_168_341 VDD VSS VDD VSS gf180mcu_fd_sc_mcu7t5v0__fillcap_4
XFILLER_211_492 VDD VSS VDD VSS gf180mcu_fd_sc_mcu7t5v0__fillcap_16
XFILLER_195_182 VDD VSS VDD VSS gf180mcu_fd_sc_mcu7t5v0__fillcap_16
XFILLER_164_591 VDD VSS VDD VSS gf180mcu_fd_sc_mcu7t5v0__fillcap_4
XFILLER_152_731 VDD VSS VDD VSS gf180mcu_fd_sc_mcu7t5v0__fillcap_4
XFILLER_98_807 VDD VSS VDD VSS gf180mcu_fd_sc_mcu7t5v0__fillcap_8
XFILLER_104_190 VDD VSS VDD VSS gf180mcu_fd_sc_mcu7t5v0__fillcap_4
XFILLER_265_142 VDD VSS VDD VSS gf180mcu_fd_sc_mcu7t5v0__fillcap_64
XFILLER_66_737 VDD VSS VDD VSS gf180mcu_fd_sc_mcu7t5v0__fillcap_64
XFILLER_78_597 VDD VSS VDD VSS gf180mcu_fd_sc_mcu7t5v0__fillcap_64
XFILLER_93_523 VDD VSS VDD VSS gf180mcu_fd_sc_mcu7t5v0__fillcap_8
Xclkbuf_3_2__f_clk_i VDD VSS clkbuf_3_2__f_clk_i/Z clkbuf_0_clk_i/Z VDD VSS gf180mcu_fd_sc_mcu7t5v0__clkbuf_16
XFILLER_207_721 VDD VSS VDD VSS gf180mcu_fd_sc_mcu7t5v0__fillcap_16
XFILLER_262_871 VDD VSS VDD VSS gf180mcu_fd_sc_mcu7t5v0__fillcap_4
XFILLER_221_212 VDD VSS VDD VSS gf180mcu_fd_sc_mcu7t5v0__fillcap_64
XFILLER_22_807 VDD VSS VDD VSS gf180mcu_fd_sc_mcu7t5v0__fillcap_64
XFILLER_34_667 VDD VSS VDD VSS gf180mcu_fd_sc_mcu7t5v0__fillcap_64
XFILLER_178_149 VDD VSS VDD VSS gf180mcu_fd_sc_mcu7t5v0__fillcap_8
XFILLER_61_486 VDD VSS VDD VSS gf180mcu_fd_sc_mcu7t5v0__fillcap_4
X_1953_ VDD VSS _4510_/Q wire69/I VDD VSS gf180mcu_fd_sc_mcu7t5v0__clkinv_1
XFILLER_186_171 VDD VSS VDD VSS gf180mcu_fd_sc_mcu7t5v0__fillcap_4
XFILLER_186_193 VDD VSS VDD VSS gf180mcu_fd_sc_mcu7t5v0__fillcap_8
XFILLER_174_333 VDD VSS VDD VSS gf180mcu_fd_sc_mcu7t5v0__fillcap_4
X_3623_ _2040_/Z _4160_/Q VDD VSS _3624_/A2 _4139_/Q _2039_/Z VDD VSS gf180mcu_fd_sc_mcu7t5v0__aoi22_1
XFILLER_115_400 VDD VSS VDD VSS gf180mcu_fd_sc_mcu7t5v0__fillcap_8
XFILLER_115_422 VDD VSS VDD VSS gf180mcu_fd_sc_mcu7t5v0__fillcap_64
XFILLER_155_591 VDD VSS VDD VSS gf180mcu_fd_sc_mcu7t5v0__fillcap_4
XFILLER_127_282 VDD VSS VDD VSS gf180mcu_fd_sc_mcu7t5v0__fillcap_16
X_3554_ VDD VSS _3556_/A2 wire75/Z _4079_/Q VDD VSS gf180mcu_fd_sc_mcu7t5v0__nand2_1
XFILLER_227_66 VDD VSS VDD VSS gf180mcu_fd_sc_mcu7t5v0__fillcap_4
X_2505_ _2509_/S VDD VSS _4125_/D _2505_/I0 _4125_/Q VDD VSS gf180mcu_fd_sc_mcu7t5v0__mux2_2
X_3485_ _3485_/B wire82/Z VDD VSS _3486_/B _3605_/S _3485_/A2 VDD VSS gf180mcu_fd_sc_mcu7t5v0__oai211_1
XFILLER_88_317 VDD VSS VDD VSS gf180mcu_fd_sc_mcu7t5v0__fillcap_64
X_2436_ _2441_/S VDD VSS _4068_/D _4068_/Q wire163/Z VDD VSS gf180mcu_fd_sc_mcu7t5v0__mux2_2
XFILLER_257_632 VDD VSS VDD VSS gf180mcu_fd_sc_mcu7t5v0__fillcap_64
X_2367_ VDD _2367_/B wire14/Z _4012_/D _3492_/A2 VSS VDD VSS gf180mcu_fd_sc_mcu7t5v0__oai21_1
X_2298_ VDD VSS _2299_/B1 _4534_/Q _4221_/Q VDD VSS gf180mcu_fd_sc_mcu7t5v0__nand2_1
X_4106_ VDD _4106_/Q _4129_/CLK VSS _4106_/D VDD VSS gf180mcu_fd_sc_mcu7t5v0__dffq_1
XFILLER_56_247 VDD VSS VDD VSS gf180mcu_fd_sc_mcu7t5v0__fillcap_64
X_4037_ VDD _4037_/Q _4061_/CLK VSS _4037_/D VDD VSS gf180mcu_fd_sc_mcu7t5v0__dffq_1
XFILLER_71_206 VDD VSS VDD VSS gf180mcu_fd_sc_mcu7t5v0__fillcap_4
XFILLER_225_540 VDD VSS VDD VSS gf180mcu_fd_sc_mcu7t5v0__fillcap_4
XFILLER_225_562 VDD VSS VDD VSS gf180mcu_fd_sc_mcu7t5v0__fillcap_16
XFILLER_213_713 VDD VSS VDD VSS gf180mcu_fd_sc_mcu7t5v0__fillcap_16
XFILLER_240_521 VDD VSS VDD VSS gf180mcu_fd_sc_mcu7t5v0__fillcap_4
XFILLER_252_381 VDD VSS VDD VSS gf180mcu_fd_sc_mcu7t5v0__fillcap_4
XFILLER_212_201 VDD VSS VDD VSS gf180mcu_fd_sc_mcu7t5v0__fillcap_16
XFILLER_169_127 VDD VSS VDD VSS gf180mcu_fd_sc_mcu7t5v0__fillcap_8
XFILLER_24_177 VDD VSS VDD VSS gf180mcu_fd_sc_mcu7t5v0__fillcap_64
XFILLER_12_317 VDD VSS VDD VSS gf180mcu_fd_sc_mcu7t5v0__fillcap_64
XFILLER_166_823 VDD VSS VDD VSS gf180mcu_fd_sc_mcu7t5v0__fillcap_8
XFILLER_166_867 VDD VSS VDD VSS gf180mcu_fd_sc_mcu7t5v0__fillcap_8
XFILLER_165_344 VDD VSS VDD VSS gf180mcu_fd_sc_mcu7t5v0__fillcap_4
XFILLER_4_527 VDD VSS VDD VSS gf180mcu_fd_sc_mcu7t5v0__fillcap_64
XFILLER_21_66 VDD VSS VDD VSS gf180mcu_fd_sc_mcu7t5v0__fillcap_4
XFILLER_137_88 VDD VSS VDD VSS gf180mcu_fd_sc_mcu7t5v0__fillcap_8
XFILLER_121_414 VDD VSS VDD VSS gf180mcu_fd_sc_mcu7t5v0__fillcap_4
XFILLER_121_458 VDD VSS VDD VSS gf180mcu_fd_sc_mcu7t5v0__fillcap_4
XFILLER_121_469 VDD VSS VDD VSS gf180mcu_fd_sc_mcu7t5v0__fillcap_16
XFILLER_247_142 VDD VSS VDD VSS gf180mcu_fd_sc_mcu7t5v0__fillcap_64
XFILLER_48_737 VDD VSS VDD VSS gf180mcu_fd_sc_mcu7t5v0__fillcap_64
XFILLER_262_101 VDD VSS VDD VSS gf180mcu_fd_sc_mcu7t5v0__fillcap_4
XFILLER_75_556 VDD VSS VDD VSS gf180mcu_fd_sc_mcu7t5v0__fillcap_4
XFILLER_244_871 VDD VSS VDD VSS gf180mcu_fd_sc_mcu7t5v0__fillcap_4
XFILLER_203_212 VDD VSS VDD VSS gf180mcu_fd_sc_mcu7t5v0__fillcap_32
XFILLER_16_667 VDD VSS VDD VSS gf180mcu_fd_sc_mcu7t5v0__fillcap_64
XFILLER_231_532 VDD VSS VDD VSS gf180mcu_fd_sc_mcu7t5v0__fillcap_16
XFILLER_43_486 VDD VSS VDD VSS gf180mcu_fd_sc_mcu7t5v0__fillcap_4
XFILLER_31_626 VDD VSS VDD VSS gf180mcu_fd_sc_mcu7t5v0__fillcap_4
XFILLER_169_661 VDD VSS VDD VSS gf180mcu_fd_sc_mcu7t5v0__fillcap_32
XFILLER_231_598 VDD VSS VDD VSS gf180mcu_fd_sc_mcu7t5v0__fillcap_32
XFILLER_8_877 VDD VSS VDD VSS gf180mcu_fd_sc_mcu7t5v0__fillcap_8
XFILLER_109_260 VDD VSS VDD VSS gf180mcu_fd_sc_mcu7t5v0__fillcap_16
XFILLER_109_282 VDD VSS VDD VSS gf180mcu_fd_sc_mcu7t5v0__fillcap_32
X_3270_ _4531_/Q VDD VSS _4370_/D _3270_/A1 _3270_/A2 VDD VSS gf180mcu_fd_sc_mcu7t5v0__aoi21_1
XFILLER_140_767 VDD VSS VDD VSS gf180mcu_fd_sc_mcu7t5v0__fillcap_32
X_2221_ _3868_/Q VDD VSS _3210_/A2 wire111/Z _4370_/Q VDD VSS gf180mcu_fd_sc_mcu7t5v0__nand3_1
XFILLER_239_632 VDD VSS VDD VSS gf180mcu_fd_sc_mcu7t5v0__fillcap_64
XFILLER_266_451 VDD VSS VDD VSS gf180mcu_fd_sc_mcu7t5v0__fillcap_4
X_2152_ VDD VSS _2152_/I _4140_/D VDD VSS gf180mcu_fd_sc_mcu7t5v0__clkinv_1
XFILLER_120_491 VDD VSS VDD VSS gf180mcu_fd_sc_mcu7t5v0__fillcap_32
X_2083_ VDD VSS _2093_/A2 _4578_/Q _2084_/A2 VDD VSS gf180mcu_fd_sc_mcu7t5v0__nor2_1
XFILLER_38_247 VDD VSS VDD VSS gf180mcu_fd_sc_mcu7t5v0__fillcap_64
XFILLER_53_206 VDD VSS VDD VSS gf180mcu_fd_sc_mcu7t5v0__fillcap_4
XFILLER_234_381 VDD VSS VDD VSS gf180mcu_fd_sc_mcu7t5v0__fillcap_4
XFILLER_250_885 VDD VSS VDD VSS gf180mcu_fd_sc_mcu7t5v0__fillcap_4
XFILLER_210_727 VDD VSS VDD VSS gf180mcu_fd_sc_mcu7t5v0__fillcap_8
XFILLER_21_136 VDD VSS VDD VSS gf180mcu_fd_sc_mcu7t5v0__fillcap_4
Xmax_length39 _3840_/A1 VSS VDD _3759_/A1 VDD VSS gf180mcu_fd_sc_mcu7t5v0__clkbuf_2
X_2985_ _3209_/B _2985_/C VDD VSS _2986_/A2 _3024_/A2 _2985_/A2 VDD VSS gf180mcu_fd_sc_mcu7t5v0__oai211_1
X_1936_ VDD VSS _4324_/Q _3015_/C VDD VSS gf180mcu_fd_sc_mcu7t5v0__clkinv_1
X_4586_ _4586_/D _4604_/D _4616_/RN VSS _4586_/CLK VDD VDD VSS gf180mcu_fd_sc_mcu7t5v0__dffrnq_1
XFILLER_147_399 VDD VSS VDD VSS gf180mcu_fd_sc_mcu7t5v0__fillcap_16
X_3606_ VDD VSS _3608_/A2 wire75/Z _4017_/Q VDD VSS gf180mcu_fd_sc_mcu7t5v0__nand2_1
XFILLER_190_667 VDD VSS VDD VSS gf180mcu_fd_sc_mcu7t5v0__fillcap_4
X_3537_ _3605_/S VDD VSS _3537_/Z _4030_/Q _4022_/Q VDD VSS gf180mcu_fd_sc_mcu7t5v0__mux2_2
XFILLER_103_414 VDD VSS VDD VSS gf180mcu_fd_sc_mcu7t5v0__fillcap_4
XFILLER_89_626 VDD VSS VDD VSS gf180mcu_fd_sc_mcu7t5v0__fillcap_4
XFILLER_170_380 VDD VSS VDD VSS gf180mcu_fd_sc_mcu7t5v0__fillcap_4
XFILLER_170_391 VDD VSS VDD VSS gf180mcu_fd_sc_mcu7t5v0__fillcap_16
Xclkbuf_leaf_62_clk_i _4580_/CLK VSS VDD clkload2/I VDD VSS gf180mcu_fd_sc_mcu7t5v0__clkbuf_2
X_3468_ _3468_/B wire74/Z VDD VSS _3473_/A2 wire83/I _3465_/Z VDD VSS gf180mcu_fd_sc_mcu7t5v0__oai211_1
XFILLER_89_659 VDD VSS VDD VSS gf180mcu_fd_sc_mcu7t5v0__fillcap_32
X_3399_ _3425_/S VDD VSS _4442_/D _4400_/Q _4442_/Q VDD VSS gf180mcu_fd_sc_mcu7t5v0__mux2_2
X_2419_ _2422_/S VDD VSS _4054_/D _2506_/I0 _4054_/Q VDD VSS gf180mcu_fd_sc_mcu7t5v0__mux2_2
XFILLER_229_142 VDD VSS VDD VSS gf180mcu_fd_sc_mcu7t5v0__fillcap_64
XFILLER_244_101 VDD VSS VDD VSS gf180mcu_fd_sc_mcu7t5v0__fillcap_4
XFILLER_57_556 VDD VSS VDD VSS gf180mcu_fd_sc_mcu7t5v0__fillcap_4
Xclkbuf_leaf_77_clk_i _4128_/CLK VSS VDD clkbuf_3_2__f_clk_i/Z VDD VSS gf180mcu_fd_sc_mcu7t5v0__clkbuf_2
XFILLER_25_486 VDD VSS VDD VSS gf180mcu_fd_sc_mcu7t5v0__fillcap_4
XFILLER_13_626 VDD VSS VDD VSS gf180mcu_fd_sc_mcu7t5v0__fillcap_4
XFILLER_241_874 VDD VSS VDD VSS gf180mcu_fd_sc_mcu7t5v0__fillcap_16
XFILLER_8_107 VDD VSS VDD VSS gf180mcu_fd_sc_mcu7t5v0__fillcap_64
XFILLER_166_631 VDD VSS VDD VSS gf180mcu_fd_sc_mcu7t5v0__fillcap_16
XFILLER_154_815 VDD VSS VDD VSS gf180mcu_fd_sc_mcu7t5v0__fillcap_4
XFILLER_165_196 VDD VSS VDD VSS gf180mcu_fd_sc_mcu7t5v0__fillcap_8
Xclkbuf_leaf_15_clk_i _4536_/CLK VSS VDD clkload3/I VDD VSS gf180mcu_fd_sc_mcu7t5v0__clkbuf_2
XFILLER_153_314 VDD VSS VDD VSS gf180mcu_fd_sc_mcu7t5v0__fillcap_16
XFILLER_5_836 VDD VSS VDD VSS gf180mcu_fd_sc_mcu7t5v0__fillcap_4
XFILLER_180_155 VDD VSS VDD VSS gf180mcu_fd_sc_mcu7t5v0__fillcap_4
XFILLER_268_716 VDD VSS VDD VSS gf180mcu_fd_sc_mcu7t5v0__fillcap_32
XFILLER_180_177 VDD VSS VDD VSS gf180mcu_fd_sc_mcu7t5v0__fillcap_64
XFILLER_79_136 VDD VSS VDD VSS gf180mcu_fd_sc_mcu7t5v0__fillcap_4
XFILLER_236_613 VDD VSS VDD VSS gf180mcu_fd_sc_mcu7t5v0__fillcap_8
XFILLER_248_451 VDD VSS VDD VSS gf180mcu_fd_sc_mcu7t5v0__fillcap_4
XFILLER_35_206 VDD VSS VDD VSS gf180mcu_fd_sc_mcu7t5v0__fillcap_4
XFILLER_216_381 VDD VSS VDD VSS gf180mcu_fd_sc_mcu7t5v0__fillcap_4
XFILLER_73_72 VDD VSS VDD VSS gf180mcu_fd_sc_mcu7t5v0__fillcap_64
XFILLER_232_885 VDD VSS VDD VSS gf180mcu_fd_sc_mcu7t5v0__fillcap_4
XFILLER_189_72 VDD VSS VDD VSS gf180mcu_fd_sc_mcu7t5v0__fillcap_64
X_2770_ _4518_/Q VDD VSS _2771_/B _4518_/D _4517_/D VDD VSS gf180mcu_fd_sc_mcu7t5v0__nor3_1
XFILLER_144_303 VDD VSS VDD VSS gf180mcu_fd_sc_mcu7t5v0__fillcap_4
XFILLER_144_325 VDD VSS VDD VSS gf180mcu_fd_sc_mcu7t5v0__fillcap_16
X_4440_ _4440_/D _4440_/Q _4527_/RN VSS _4478_/CLK VDD VDD VSS gf180mcu_fd_sc_mcu7t5v0__dffrnq_1
XFILLER_172_667 VDD VSS VDD VSS gf180mcu_fd_sc_mcu7t5v0__fillcap_4
XFILLER_160_807 VDD VSS VDD VSS gf180mcu_fd_sc_mcu7t5v0__fillcap_16
X_4371_ _4371_/D _4371_/Q _4371_/RN VSS _4371_/CLK VDD VDD VSS gf180mcu_fd_sc_mcu7t5v0__dffrnq_1
XFILLER_140_542 VDD VSS VDD VSS gf180mcu_fd_sc_mcu7t5v0__fillcap_32
XFILLER_140_520 VDD VSS VDD VSS gf180mcu_fd_sc_mcu7t5v0__fillcap_4
X_3322_ VDD VSS _3324_/B _4381_/Q _3329_/B VDD VSS gf180mcu_fd_sc_mcu7t5v0__nand2_1
XFILLER_113_734 VDD VSS VDD VSS gf180mcu_fd_sc_mcu7t5v0__fillcap_4
X_3253_ wire23/I VDD VSS _4361_/D _1945_/I _4361_/Q VDD VSS gf180mcu_fd_sc_mcu7t5v0__mux2_2
X_3184_ VDD VSS _3189_/A2 wire94/Z _3183_/Z VDD VSS gf180mcu_fd_sc_mcu7t5v0__nor2_1
X_2204_ VDD _2205_/B _2205_/A2 _2235_/A2 _2169_/Z VSS VDD VSS gf180mcu_fd_sc_mcu7t5v0__oai21_1
X_2135_ VDD VSS _2136_/A2 wire121/Z _2150_/A2 VDD VSS gf180mcu_fd_sc_mcu7t5v0__nand2_1
XFILLER_226_101 VDD VSS VDD VSS gf180mcu_fd_sc_mcu7t5v0__fillcap_4
XFILLER_39_556 VDD VSS VDD VSS gf180mcu_fd_sc_mcu7t5v0__fillcap_4
X_2066_ _2061_/Z VDD VSS _2066_/Z _4580_/Q _4581_/Q VDD VSS gf180mcu_fd_sc_mcu7t5v0__and3_1
XFILLER_223_874 VDD VSS VDD VSS gf180mcu_fd_sc_mcu7t5v0__fillcap_16
X_2968_ _2968_/A3 VDD VSS _2969_/A2 _4341_/Q _2897_/Z VDD VSS gf180mcu_fd_sc_mcu7t5v0__nand3_1
XFILLER_194_247 VDD VSS VDD VSS gf180mcu_fd_sc_mcu7t5v0__fillcap_64
XFILLER_194_236 VDD VSS VDD VSS gf180mcu_fd_sc_mcu7t5v0__fillcap_8
Xclkbuf_4_5_0_host_clk_i _4606_/CLK VSS VDD clkbuf_0_host_clk_i/Z VDD VSS gf180mcu_fd_sc_mcu7t5v0__clkbuf_2
X_1919_ VDD VSS wire97/I _3158_/B VDD VSS gf180mcu_fd_sc_mcu7t5v0__clkinv_1
X_2899_ _3201_/A3 wire45/Z _2899_/B2 VDD VSS _4305_/D _4346_/Q _4341_/Q VDD VSS gf180mcu_fd_sc_mcu7t5v0__oai32_1
XFILLER_147_174 VDD VSS VDD VSS gf180mcu_fd_sc_mcu7t5v0__fillcap_16
XFILLER_190_442 VDD VSS VDD VSS gf180mcu_fd_sc_mcu7t5v0__fillcap_8
X_4569_ _4569_/D _4569_/Q wire187/Z VSS _4573_/CLK VDD VDD VSS gf180mcu_fd_sc_mcu7t5v0__dffrnq_1
XFILLER_162_177 VDD VSS VDD VSS gf180mcu_fd_sc_mcu7t5v0__fillcap_8
XFILLER_104_767 VDD VSS VDD VSS gf180mcu_fd_sc_mcu7t5v0__fillcap_32
XFILLER_218_657 VDD VSS VDD VSS gf180mcu_fd_sc_mcu7t5v0__fillcap_8
XFILLER_17_206 VDD VSS VDD VSS gf180mcu_fd_sc_mcu7t5v0__fillcap_4
XFILLER_260_457 VDD VSS VDD VSS gf180mcu_fd_sc_mcu7t5v0__fillcap_64
XFILLER_150_88 VDD VSS VDD VSS gf180mcu_fd_sc_mcu7t5v0__fillcap_16
XFILLER_214_885 VDD VSS VDD VSS gf180mcu_fd_sc_mcu7t5v0__fillcap_4
XFILLER_198_597 VDD VSS VDD VSS gf180mcu_fd_sc_mcu7t5v0__fillcap_32
XFILLER_186_737 VDD VSS VDD VSS gf180mcu_fd_sc_mcu7t5v0__fillcap_16
XFILLER_9_416 VDD VSS VDD VSS gf180mcu_fd_sc_mcu7t5v0__fillcap_4
XFILLER_230_2 VDD VSS VDD VSS gf180mcu_fd_sc_mcu7t5v0__fillcap_32
XFILLER_154_667 VDD VSS VDD VSS gf180mcu_fd_sc_mcu7t5v0__fillcap_16
XFILLER_175_63 VDD VSS VDD VSS gf180mcu_fd_sc_mcu7t5v0__fillcap_4
XFILLER_153_188 VDD VSS VDD VSS gf180mcu_fd_sc_mcu7t5v0__fillcap_16
XFILLER_122_542 VDD VSS VDD VSS gf180mcu_fd_sc_mcu7t5v0__fillcap_32
XFILLER_268_546 VDD VSS VDD VSS gf180mcu_fd_sc_mcu7t5v0__fillcap_32
XFILLER_209_602 VDD VSS VDD VSS gf180mcu_fd_sc_mcu7t5v0__fillcap_4
XFILLER_122_597 VDD VSS VDD VSS gf180mcu_fd_sc_mcu7t5v0__fillcap_64
XFILLER_110_748 VDD VSS VDD VSS gf180mcu_fd_sc_mcu7t5v0__fillcap_8
XFILLER_208_101 VDD VSS VDD VSS gf180mcu_fd_sc_mcu7t5v0__fillcap_4
XFILLER_236_465 VDD VSS VDD VSS gf180mcu_fd_sc_mcu7t5v0__fillcap_4
XFILLER_91_632 VDD VSS VDD VSS gf180mcu_fd_sc_mcu7t5v0__fillcap_8
XFILLER_217_690 VDD VSS VDD VSS gf180mcu_fd_sc_mcu7t5v0__fillcap_8
X_3940_ VDD _3940_/Q _3967_/CLK VSS _3940_/D VDD VSS gf180mcu_fd_sc_mcu7t5v0__dffq_1
XFILLER_91_687 VDD VSS VDD VSS gf180mcu_fd_sc_mcu7t5v0__fillcap_8
XFILLER_205_874 VDD VSS VDD VSS gf180mcu_fd_sc_mcu7t5v0__fillcap_16
X_3871_ _4299_/Q _3871_/Q _4535_/RN VSS _4535_/CLK VDD VDD VSS gf180mcu_fd_sc_mcu7t5v0__dffrnq_1
XFILLER_220_877 VDD VSS VDD VSS gf180mcu_fd_sc_mcu7t5v0__fillcap_8
XFILLER_176_247 VDD VSS VDD VSS gf180mcu_fd_sc_mcu7t5v0__fillcap_32
XFILLER_176_236 VDD VSS VDD VSS gf180mcu_fd_sc_mcu7t5v0__fillcap_8
X_2822_ VDD VSS _3216_/A2 _1926_/I _3027_/A3 VDD VSS gf180mcu_fd_sc_mcu7t5v0__nor2_1
XFILLER_191_206 VDD VSS VDD VSS gf180mcu_fd_sc_mcu7t5v0__fillcap_4
X_2753_ wire36/Z VDD VSS _4287_/D _4287_/Q _4466_/Q VDD VSS gf180mcu_fd_sc_mcu7t5v0__mux2_2
XFILLER_118_815 VDD VSS VDD VSS gf180mcu_fd_sc_mcu7t5v0__fillcap_4
XFILLER_76_2 VDD VSS VDD VSS gf180mcu_fd_sc_mcu7t5v0__fillcap_32
XFILLER_117_314 VDD VSS VDD VSS gf180mcu_fd_sc_mcu7t5v0__fillcap_16
X_2684_ VDD _2685_/B1 _2684_/B _2684_/A1 _2684_/A2 VSS _2684_/A3 VDD VSS gf180mcu_fd_sc_mcu7t5v0__oai31_1
XFILLER_144_177 VDD VSS VDD VSS gf180mcu_fd_sc_mcu7t5v0__fillcap_4
X_4423_ _4423_/D _4423_/Q wire212/Z VSS clkload7/I VDD VDD VSS gf180mcu_fd_sc_mcu7t5v0__dffrnq_1
X_4354_ _4354_/D _4354_/Q wire199/I VSS _4354_/CLK VDD VDD VSS gf180mcu_fd_sc_mcu7t5v0__dffrnq_1
XFILLER_235_66 VDD VSS VDD VSS gf180mcu_fd_sc_mcu7t5v0__fillcap_4
X_3305_ _3305_/B _3305_/C VDD VSS _3306_/A3 _4380_/Q _3305_/A2 VDD VSS gf180mcu_fd_sc_mcu7t5v0__oai211_1
X_4285_ _4285_/D _4285_/Q wire207/Z VSS _4459_/CLK VDD VDD VSS gf180mcu_fd_sc_mcu7t5v0__dffrnq_1
X_3236_ _3234_/B _3236_/B1 _3241_/A2 VDD VSS _4352_/D _3236_/A1 VDD VSS gf180mcu_fd_sc_mcu7t5v0__oai22_1
XFILLER_100_247 VDD VSS VDD VSS gf180mcu_fd_sc_mcu7t5v0__fillcap_8
XFILLER_227_454 VDD VSS VDD VSS gf180mcu_fd_sc_mcu7t5v0__fillcap_16
X_3167_ VDD _3171_/A2 _3167_/B _3182_/B _3167_/A2 VSS _3167_/A3 VDD VSS gf180mcu_fd_sc_mcu7t5v0__oai31_1
X_2118_ _4314_/Q VDD VSS _2119_/I _4130_/Q _2118_/A2 VDD VSS gf180mcu_fd_sc_mcu7t5v0__aoi21_1
X_3098_ _3996_/Q VSS VDD _3980_/Q _3988_/Q _3113_/S _3972_/Q _3143_/C _3098_/Z VDD
+ VSS gf180mcu_fd_sc_mcu7t5v0__mux4_1
XFILLER_242_457 VDD VSS VDD VSS gf180mcu_fd_sc_mcu7t5v0__fillcap_64
X_2049_ VDD VSS _2098_/A2 _4592_/Q _2086_/A1 VDD VSS gf180mcu_fd_sc_mcu7t5v0__nor2_1
XFILLER_81_142 VDD VSS VDD VSS gf180mcu_fd_sc_mcu7t5v0__fillcap_64
XFILLER_223_682 VDD VSS VDD VSS gf180mcu_fd_sc_mcu7t5v0__fillcap_16
XFILLER_195_512 VDD VSS VDD VSS gf180mcu_fd_sc_mcu7t5v0__fillcap_4
XFILLER_168_737 VDD VSS VDD VSS gf180mcu_fd_sc_mcu7t5v0__fillcap_64
XFILLER_120_69 VDD VSS VDD VSS gf180mcu_fd_sc_mcu7t5v0__fillcap_8
XFILLER_195_578 VDD VSS VDD VSS gf180mcu_fd_sc_mcu7t5v0__fillcap_4
XFILLER_183_718 VDD VSS VDD VSS gf180mcu_fd_sc_mcu7t5v0__fillcap_8
XFILLER_167_269 VDD VSS VDD VSS gf180mcu_fd_sc_mcu7t5v0__fillcap_8
XFILLER_108_325 VDD VSS VDD VSS gf180mcu_fd_sc_mcu7t5v0__fillcap_4
XFILLER_136_667 VDD VSS VDD VSS gf180mcu_fd_sc_mcu7t5v0__fillcap_16
XFILLER_108_336 VDD VSS VDD VSS gf180mcu_fd_sc_mcu7t5v0__fillcap_16
XFILLER_124_807 VDD VSS VDD VSS gf180mcu_fd_sc_mcu7t5v0__fillcap_16
XFILLER_163_486 VDD VSS VDD VSS gf180mcu_fd_sc_mcu7t5v0__fillcap_4
XFILLER_131_372 VDD VSS VDD VSS gf180mcu_fd_sc_mcu7t5v0__fillcap_32
XFILLER_180_2 VDD VSS VDD VSS gf180mcu_fd_sc_mcu7t5v0__fillcap_32
XFILLER_161_87 VDD VSS VDD VSS gf180mcu_fd_sc_mcu7t5v0__fillcap_8
XFILLER_85_492 VDD VSS VDD VSS gf180mcu_fd_sc_mcu7t5v0__fillcap_16
XFILLER_73_632 VDD VSS VDD VSS gf180mcu_fd_sc_mcu7t5v0__fillcap_64
XFILLER_261_766 VDD VSS VDD VSS gf180mcu_fd_sc_mcu7t5v0__fillcap_4
XFILLER_220_107 VDD VSS VDD VSS gf180mcu_fd_sc_mcu7t5v0__fillcap_64
XFILLER_202_877 VDD VSS VDD VSS gf180mcu_fd_sc_mcu7t5v0__fillcap_8
XFILLER_158_247 VDD VSS VDD VSS gf180mcu_fd_sc_mcu7t5v0__fillcap_64
XFILLER_41_562 VDD VSS VDD VSS gf180mcu_fd_sc_mcu7t5v0__fillcap_64
XFILLER_139_472 VDD VSS VDD VSS gf180mcu_fd_sc_mcu7t5v0__fillcap_8
Xclkload16 VDD VSS _4407_/CLK clkload16/ZN VDD VSS gf180mcu_fd_sc_mcu7t5v0__clkinv_2
Xclkload49 VSS clkload49/Z _4265_/CLK VDD VDD VSS gf180mcu_fd_sc_mcu7t5v0__clkbuf_1
Xclkload38 VSS clkload38/Z _4269_/CLK VDD VDD VSS gf180mcu_fd_sc_mcu7t5v0__clkbuf_1
Xclkload27 VSS clkload27/Z _4047_/CLK VDD VDD VSS gf180mcu_fd_sc_mcu7t5v0__clkbuf_1
XFILLER_142_615 VDD VSS VDD VSS gf180mcu_fd_sc_mcu7t5v0__fillcap_16
XFILLER_182_795 VDD VSS VDD VSS gf180mcu_fd_sc_mcu7t5v0__fillcap_8
XFILLER_181_261 VDD VSS VDD VSS gf180mcu_fd_sc_mcu7t5v0__fillcap_8
XFILLER_126_177 VDD VSS VDD VSS gf180mcu_fd_sc_mcu7t5v0__fillcap_4
XFILLER_229_708 VDD VSS VDD VSS gf180mcu_fd_sc_mcu7t5v0__fillcap_32
XFILLER_268_376 VDD VSS VDD VSS gf180mcu_fd_sc_mcu7t5v0__fillcap_32
XFILLER_95_212 VDD VSS VDD VSS gf180mcu_fd_sc_mcu7t5v0__fillcap_16
XFILLER_122_372 VDD VSS VDD VSS gf180mcu_fd_sc_mcu7t5v0__fillcap_8
XFILLER_256_527 VDD VSS VDD VSS gf180mcu_fd_sc_mcu7t5v0__fillcap_64
X_4070_ VDD _4070_/Q _4081_/CLK VSS _4070_/D VDD VSS gf180mcu_fd_sc_mcu7t5v0__dffq_1
XFILLER_237_752 VDD VSS VDD VSS gf180mcu_fd_sc_mcu7t5v0__fillcap_16
XFILLER_209_454 VDD VSS VDD VSS gf180mcu_fd_sc_mcu7t5v0__fillcap_8
X_3021_ _3019_/Z _3020_/Z _3002_/Z _3021_/B3 VDD VSS _4326_/D _2885_/C _3012_/Z VDD
+ VSS gf180mcu_fd_sc_mcu7t5v0__oai33_1
XFILLER_63_142 VDD VSS VDD VSS gf180mcu_fd_sc_mcu7t5v0__fillcap_64
XFILLER_224_457 VDD VSS VDD VSS gf180mcu_fd_sc_mcu7t5v0__fillcap_16
X_3923_ VDD _3923_/Q _3936_/CLK VSS _3923_/D VDD VSS gf180mcu_fd_sc_mcu7t5v0__dffq_1
XFILLER_251_276 VDD VSS VDD VSS gf180mcu_fd_sc_mcu7t5v0__fillcap_4
XFILLER_220_641 VDD VSS VDD VSS gf180mcu_fd_sc_mcu7t5v0__fillcap_16
X_3854_ _3854_/D _3854_/Q _4473_/RN VSS _4436_/CLK VDD VDD VSS gf180mcu_fd_sc_mcu7t5v0__dffrnq_1
XFILLER_60_871 VDD VSS VDD VSS gf180mcu_fd_sc_mcu7t5v0__fillcap_4
X_2805_ VDD _2805_/B _2886_/C _2818_/A1 _2988_/A1 VSS VDD VSS gf180mcu_fd_sc_mcu7t5v0__oai21_1
X_3785_ _3786_/S VDD VSS _3952_/D wire172/Z _3952_/Q VDD VSS gf180mcu_fd_sc_mcu7t5v0__mux2_2
X_2736_ _2736_/S VDD VSS _4270_/D _4270_/Q _4452_/Q VDD VSS gf180mcu_fd_sc_mcu7t5v0__mux2_2
X_2667_ _2667_/B VDD VSS _4231_/D _2667_/A1 _2666_/C VDD VSS gf180mcu_fd_sc_mcu7t5v0__aoi21_1
XFILLER_118_689 VDD VSS VDD VSS gf180mcu_fd_sc_mcu7t5v0__fillcap_4
XFILLER_105_328 VDD VSS VDD VSS gf180mcu_fd_sc_mcu7t5v0__fillcap_8
X_4406_ _4406_/D _4406_/Q _4527_/RN VSS _4478_/CLK VDD VDD VSS gf180mcu_fd_sc_mcu7t5v0__dffrnq_1
X_2598_ VDD VSS _2599_/B1 _2587_/Z _2601_/A3 VDD VSS gf180mcu_fd_sc_mcu7t5v0__nand2_1
XFILLER_99_562 VDD VSS VDD VSS gf180mcu_fd_sc_mcu7t5v0__fillcap_16
XFILLER_87_702 VDD VSS VDD VSS gf180mcu_fd_sc_mcu7t5v0__fillcap_64
X_4337_ _4337_/D _4337_/Q _4530_/RN VSS _4337_/CLK VDD VDD VSS gf180mcu_fd_sc_mcu7t5v0__dffrnq_1
X_4268_ _4268_/D _4268_/Q _4534_/RN VSS _4269_/CLK VDD VDD VSS gf180mcu_fd_sc_mcu7t5v0__dffrnq_1
X_3219_ VDD VSS _3219_/I _4347_/D VDD VSS gf180mcu_fd_sc_mcu7t5v0__clkinv_1
X_4199_ _4199_/D _4199_/Q wire184/Z VSS _4199_/CLK VDD VDD VSS gf180mcu_fd_sc_mcu7t5v0__dffrnq_1
XFILLER_55_632 VDD VSS VDD VSS gf180mcu_fd_sc_mcu7t5v0__fillcap_64
XFILLER_67_492 VDD VSS VDD VSS gf180mcu_fd_sc_mcu7t5v0__fillcap_64
XFILLER_82_451 VDD VSS VDD VSS gf180mcu_fd_sc_mcu7t5v0__fillcap_4
XFILLER_243_766 VDD VSS VDD VSS gf180mcu_fd_sc_mcu7t5v0__fillcap_4
XFILLER_199_136 VDD VSS VDD VSS gf180mcu_fd_sc_mcu7t5v0__fillcap_4
XFILLER_202_107 VDD VSS VDD VSS gf180mcu_fd_sc_mcu7t5v0__fillcap_64
XFILLER_195_320 VDD VSS VDD VSS gf180mcu_fd_sc_mcu7t5v0__fillcap_16
XFILLER_23_562 VDD VSS VDD VSS gf180mcu_fd_sc_mcu7t5v0__fillcap_64
XFILLER_11_702 VDD VSS VDD VSS gf180mcu_fd_sc_mcu7t5v0__fillcap_64
XFILLER_50_381 VDD VSS VDD VSS gf180mcu_fd_sc_mcu7t5v0__fillcap_4
XFILLER_168_589 VDD VSS VDD VSS gf180mcu_fd_sc_mcu7t5v0__fillcap_4
Xmax_length202 wire199/I VSS VDD _4284_/RN VDD VSS gf180mcu_fd_sc_mcu7t5v0__clkbuf_8
XFILLER_164_795 VDD VSS VDD VSS gf180mcu_fd_sc_mcu7t5v0__fillcap_8
XFILLER_108_177 VDD VSS VDD VSS gf180mcu_fd_sc_mcu7t5v0__fillcap_64
XFILLER_151_478 VDD VSS VDD VSS gf180mcu_fd_sc_mcu7t5v0__fillcap_8
XFILLER_6_2 VDD VSS VDD VSS gf180mcu_fd_sc_mcu7t5v0__fillcap_32
XFILLER_77_212 VDD VSS VDD VSS gf180mcu_fd_sc_mcu7t5v0__fillcap_64
XFILLER_238_527 VDD VSS VDD VSS gf180mcu_fd_sc_mcu7t5v0__fillcap_64
XFILLER_265_346 VDD VSS VDD VSS gf180mcu_fd_sc_mcu7t5v0__fillcap_4
XFILLER_105_80 VDD VSS VDD VSS gf180mcu_fd_sc_mcu7t5v0__fillcap_4
XFILLER_45_142 VDD VSS VDD VSS gf180mcu_fd_sc_mcu7t5v0__fillcap_64
XFILLER_60_101 VDD VSS VDD VSS gf180mcu_fd_sc_mcu7t5v0__fillcap_4
XFILLER_233_276 VDD VSS VDD VSS gf180mcu_fd_sc_mcu7t5v0__fillcap_4
XFILLER_221_416 VDD VSS VDD VSS gf180mcu_fd_sc_mcu7t5v0__fillcap_4
XFILLER_159_534 VDD VSS VDD VSS gf180mcu_fd_sc_mcu7t5v0__fillcap_4
XFILLER_81_72 VDD VSS VDD VSS gf180mcu_fd_sc_mcu7t5v0__fillcap_64
XFILLER_42_871 VDD VSS VDD VSS gf180mcu_fd_sc_mcu7t5v0__fillcap_4
XFILLER_159_556 VDD VSS VDD VSS gf180mcu_fd_sc_mcu7t5v0__fillcap_4
XFILLER_197_72 VDD VSS VDD VSS gf180mcu_fd_sc_mcu7t5v0__fillcap_64
XFILLER_186_397 VDD VSS VDD VSS gf180mcu_fd_sc_mcu7t5v0__fillcap_16
X_3570_ _3570_/A3 VDD VSS _3572_/B1 wire42/Z _3570_/A2 VDD VSS gf180mcu_fd_sc_mcu7t5v0__nand3_1
X_2521_ VDD _4435_/Q _3453_/A2 _2522_/B _2035_/Z VSS VDD VSS gf180mcu_fd_sc_mcu7t5v0__oai21_1
XFILLER_115_648 VDD VSS VDD VSS gf180mcu_fd_sc_mcu7t5v0__fillcap_8
XFILLER_5_282 VDD VSS VDD VSS gf180mcu_fd_sc_mcu7t5v0__fillcap_64
XFILLER_114_169 VDD VSS VDD VSS gf180mcu_fd_sc_mcu7t5v0__fillcap_4
X_2452_ _2454_/S VDD VSS _4079_/D wire154/Z _4079_/Q VDD VSS gf180mcu_fd_sc_mcu7t5v0__mux2_2
XFILLER_69_702 VDD VSS VDD VSS gf180mcu_fd_sc_mcu7t5v0__fillcap_64
X_2383_ _2383_/S VDD VSS _4025_/D _4025_/Q _2454_/I0 VDD VSS gf180mcu_fd_sc_mcu7t5v0__mux2_2
XFILLER_39_2 VDD VSS VDD VSS gf180mcu_fd_sc_mcu7t5v0__fillcap_64
XFILLER_257_836 VDD VSS VDD VSS gf180mcu_fd_sc_mcu7t5v0__fillcap_4
X_4122_ VDD _4122_/Q _4122_/CLK VSS _4122_/D VDD VSS gf180mcu_fd_sc_mcu7t5v0__dffq_1
X_4053_ VDD _4053_/Q _4061_/CLK VSS _4053_/D VDD VSS gf180mcu_fd_sc_mcu7t5v0__dffq_1
Xinput3 VDD sda_pad_IN VSS input3/Z VDD VSS gf180mcu_fd_sc_mcu7t5v0__dlyb_1
X_3004_ _3040_/B _3004_/C VDD VSS _3017_/B1 _4327_/Q _3004_/A2 VDD VSS gf180mcu_fd_sc_mcu7t5v0__aoi211_1
XFILLER_49_492 VDD VSS VDD VSS gf180mcu_fd_sc_mcu7t5v0__fillcap_64
XFILLER_37_632 VDD VSS VDD VSS gf180mcu_fd_sc_mcu7t5v0__fillcap_64
XFILLER_64_451 VDD VSS VDD VSS gf180mcu_fd_sc_mcu7t5v0__fillcap_4
X_3906_ VDD _3906_/Q _4001_/CLK VSS _3906_/D VDD VSS gf180mcu_fd_sc_mcu7t5v0__dffq_1
XFILLER_178_854 VDD VSS VDD VSS gf180mcu_fd_sc_mcu7t5v0__fillcap_16
XFILLER_196_139 VDD VSS VDD VSS gf180mcu_fd_sc_mcu7t5v0__fillcap_8
XFILLER_20_521 VDD VSS VDD VSS gf180mcu_fd_sc_mcu7t5v0__fillcap_4
XFILLER_32_381 VDD VSS VDD VSS gf180mcu_fd_sc_mcu7t5v0__fillcap_4
X_3837_ _3839_/S VDD VSS _3991_/D _4294_/Q _3991_/Q VDD VSS gf180mcu_fd_sc_mcu7t5v0__mux2_2
X_3768_ VDD VSS _3768_/Z _4540_/Q _3768_/A2 VDD VSS gf180mcu_fd_sc_mcu7t5v0__and2_1
X_2719_ _2728_/S _2704_/Z _4286_/Q VDD VSS _2720_/I _4254_/Q VDD VSS gf180mcu_fd_sc_mcu7t5v0__oai22_1
X_3699_ _3706_/S VDD VSS _3882_/D _3882_/Q _4289_/Q VDD VSS gf180mcu_fd_sc_mcu7t5v0__mux2_2
XFILLER_161_765 VDD VSS VDD VSS gf180mcu_fd_sc_mcu7t5v0__fillcap_4
XFILLER_105_136 VDD VSS VDD VSS gf180mcu_fd_sc_mcu7t5v0__fillcap_4
XFILLER_59_212 VDD VSS VDD VSS gf180mcu_fd_sc_mcu7t5v0__fillcap_64
XFILLER_120_128 VDD VSS VDD VSS gf180mcu_fd_sc_mcu7t5v0__fillcap_16
XFILLER_247_346 VDD VSS VDD VSS gf180mcu_fd_sc_mcu7t5v0__fillcap_4
XFILLER_19_66 VDD VSS VDD VSS gf180mcu_fd_sc_mcu7t5v0__fillcap_4
XFILLER_27_142 VDD VSS VDD VSS gf180mcu_fd_sc_mcu7t5v0__fillcap_64
XFILLER_42_101 VDD VSS VDD VSS gf180mcu_fd_sc_mcu7t5v0__fillcap_4
XFILLER_24_871 VDD VSS VDD VSS gf180mcu_fd_sc_mcu7t5v0__fillcap_4
XFILLER_143_2 VDD VSS VDD VSS gf180mcu_fd_sc_mcu7t5v0__fillcap_8
XFILLER_129_718 VDD VSS VDD VSS gf180mcu_fd_sc_mcu7t5v0__fillcap_8
XFILLER_183_301 VDD VSS VDD VSS gf180mcu_fd_sc_mcu7t5v0__fillcap_16
XFILLER_156_559 VDD VSS VDD VSS gf180mcu_fd_sc_mcu7t5v0__fillcap_16
XFILLER_137_762 VDD VSS VDD VSS gf180mcu_fd_sc_mcu7t5v0__fillcap_8
XFILLER_151_220 VDD VSS VDD VSS gf180mcu_fd_sc_mcu7t5v0__fillcap_4
XFILLER_2_241 VDD VSS VDD VSS gf180mcu_fd_sc_mcu7t5v0__fillcap_4
XFILLER_151_275 VDD VSS VDD VSS gf180mcu_fd_sc_mcu7t5v0__fillcap_4
XFILLER_78_521 VDD VSS VDD VSS gf180mcu_fd_sc_mcu7t5v0__fillcap_4
XFILLER_239_836 VDD VSS VDD VSS gf180mcu_fd_sc_mcu7t5v0__fillcap_4
XFILLER_105_692 VDD VSS VDD VSS gf180mcu_fd_sc_mcu7t5v0__fillcap_8
XFILLER_116_90 VDD VSS VDD VSS gf180mcu_fd_sc_mcu7t5v0__fillcap_8
XFILLER_19_632 VDD VSS VDD VSS gf180mcu_fd_sc_mcu7t5v0__fillcap_64
XFILLER_46_451 VDD VSS VDD VSS gf180mcu_fd_sc_mcu7t5v0__fillcap_4
XFILLER_202_37 VDD VSS VDD VSS gf180mcu_fd_sc_mcu7t5v0__fillcap_64
XFILLER_207_788 VDD VSS VDD VSS gf180mcu_fd_sc_mcu7t5v0__fillcap_4
X_1952_ VDD VSS _4320_/Q _2159_/A1 VDD VSS gf180mcu_fd_sc_mcu7t5v0__clkinv_1
XFILLER_14_381 VDD VSS VDD VSS gf180mcu_fd_sc_mcu7t5v0__fillcap_4
XFILLER_119_228 VDD VSS VDD VSS gf180mcu_fd_sc_mcu7t5v0__fillcap_8
X_3622_ _4344_/Q _3622_/C VDD VSS _3624_/A1 _4172_/Q _3685_/A2 _3633_/C1 VDD VSS gf180mcu_fd_sc_mcu7t5v0__aoi221_1
XFILLER_30_885 VDD VSS VDD VSS gf180mcu_fd_sc_mcu7t5v0__fillcap_4
X_3553_ _3586_/S VDD VSS _3553_/Z _4095_/Q _4087_/Q VDD VSS gf180mcu_fd_sc_mcu7t5v0__mux2_2
XFILLER_6_591 VDD VSS VDD VSS gf180mcu_fd_sc_mcu7t5v0__fillcap_4
X_3484_ VDD VSS _3485_/B _3605_/S _4068_/Q VDD VSS gf180mcu_fd_sc_mcu7t5v0__nand2_1
X_2504_ _2509_/S VDD VSS _4124_/D wire161/Z _4124_/Q VDD VSS gf180mcu_fd_sc_mcu7t5v0__mux2_2
XFILLER_103_618 VDD VSS VDD VSS gf180mcu_fd_sc_mcu7t5v0__fillcap_8
X_2435_ _2441_/S VDD VSS _4067_/D _4067_/Q wire166/Z VDD VSS gf180mcu_fd_sc_mcu7t5v0__mux2_2
XFILLER_229_346 VDD VSS VDD VSS gf180mcu_fd_sc_mcu7t5v0__fillcap_4
XFILLER_243_66 VDD VSS VDD VSS gf180mcu_fd_sc_mcu7t5v0__fillcap_4
X_4105_ VDD _4105_/Q _4129_/CLK VSS _4105_/D VDD VSS gf180mcu_fd_sc_mcu7t5v0__dffq_1
XFILLER_97_885 VDD VSS VDD VSS gf180mcu_fd_sc_mcu7t5v0__fillcap_4
X_2366_ VDD VSS _2367_/B _2467_/I0 wire14/Z VDD VSS gf180mcu_fd_sc_mcu7t5v0__nand2_1
XFILLER_217_508 VDD VSS VDD VSS gf180mcu_fd_sc_mcu7t5v0__fillcap_4
X_2297_ VDD _2297_/B _2297_/A2 _3860_/D wire36/Z VSS VDD VSS gf180mcu_fd_sc_mcu7t5v0__oai21_1
XFILLER_111_695 VDD VSS VDD VSS gf180mcu_fd_sc_mcu7t5v0__fillcap_4
X_4036_ VDD _4036_/Q _4062_/CLK VSS _4036_/D VDD VSS gf180mcu_fd_sc_mcu7t5v0__dffq_1
XFILLER_24_101 VDD VSS VDD VSS gf180mcu_fd_sc_mcu7t5v0__fillcap_4
XFILLER_21_874 VDD VSS VDD VSS gf180mcu_fd_sc_mcu7t5v0__fillcap_16
XFILLER_193_632 VDD VSS VDD VSS gf180mcu_fd_sc_mcu7t5v0__fillcap_8
XFILLER_161_562 VDD VSS VDD VSS gf180mcu_fd_sc_mcu7t5v0__fillcap_4
XFILLER_106_489 VDD VSS VDD VSS gf180mcu_fd_sc_mcu7t5v0__fillcap_8
XFILLER_121_437 VDD VSS VDD VSS gf180mcu_fd_sc_mcu7t5v0__fillcap_4
XFILLER_88_885 VDD VSS VDD VSS gf180mcu_fd_sc_mcu7t5v0__fillcap_4
XFILLER_102_684 VDD VSS VDD VSS gf180mcu_fd_sc_mcu7t5v0__fillcap_4
Xmax_cap10 VSS _3682_/B1 _3677_/B1 VDD VDD VSS gf180mcu_fd_sc_mcu7t5v0__buf_2
XFILLER_28_451 VDD VSS VDD VSS gf180mcu_fd_sc_mcu7t5v0__fillcap_4
Xmax_cap32 VSS _2730_/S _2731_/S VDD VDD VSS gf180mcu_fd_sc_mcu7t5v0__buf_3
XFILLER_260_2 VDD VSS VDD VSS gf180mcu_fd_sc_mcu7t5v0__fillcap_32
XFILLER_90_527 VDD VSS VDD VSS gf180mcu_fd_sc_mcu7t5v0__fillcap_4
XFILLER_204_725 VDD VSS VDD VSS gf180mcu_fd_sc_mcu7t5v0__fillcap_8
XFILLER_62_30 VDD VSS VDD VSS gf180mcu_fd_sc_mcu7t5v0__fillcap_4
XFILLER_8_801 VDD VSS VDD VSS gf180mcu_fd_sc_mcu7t5v0__fillcap_4
XFILLER_12_885 VDD VSS VDD VSS gf180mcu_fd_sc_mcu7t5v0__fillcap_4
XFILLER_125_710 VDD VSS VDD VSS gf180mcu_fd_sc_mcu7t5v0__fillcap_4
XFILLER_152_573 VDD VSS VDD VSS gf180mcu_fd_sc_mcu7t5v0__fillcap_16
XFILLER_180_871 VDD VSS VDD VSS gf180mcu_fd_sc_mcu7t5v0__fillcap_4
XFILLER_194_95 VDD VSS VDD VSS gf180mcu_fd_sc_mcu7t5v0__fillcap_8
XFILLER_124_275 VDD VSS VDD VSS gf180mcu_fd_sc_mcu7t5v0__fillcap_4
X_2220_ _3868_/Q VDD VSS _2220_/Z wire111/Z _4370_/Q VDD VSS gf180mcu_fd_sc_mcu7t5v0__and3_1
XFILLER_79_874 VDD VSS VDD VSS gf180mcu_fd_sc_mcu7t5v0__fillcap_16
X_2151_ _4533_/Q VDD VSS _2152_/I _4140_/Q _2151_/A2 VDD VSS gf180mcu_fd_sc_mcu7t5v0__aoi21_1
X_2082_ VDD VSS _4551_/D _2082_/A1 _2111_/A2 VDD VSS gf180mcu_fd_sc_mcu7t5v0__nor2_1
XFILLER_93_332 VDD VSS VDD VSS gf180mcu_fd_sc_mcu7t5v0__fillcap_16
XFILLER_94_877 VDD VSS VDD VSS gf180mcu_fd_sc_mcu7t5v0__fillcap_8
XFILLER_81_516 VDD VSS VDD VSS gf180mcu_fd_sc_mcu7t5v0__fillcap_4
XFILLER_222_588 VDD VSS VDD VSS gf180mcu_fd_sc_mcu7t5v0__fillcap_4
X_2984_ _3209_/B _2984_/A4 VDD VSS _2986_/A1 _2304_/Z _2985_/C VDD VSS gf180mcu_fd_sc_mcu7t5v0__nand4_1
X_1935_ VDD VSS _4323_/Q _3015_/B VDD VSS gf180mcu_fd_sc_mcu7t5v0__clkinv_1
Xmax_length18 _3479_/C _3619_/C VDD VSS VDD VSS gf180mcu_fd_sc_mcu7t5v0__buf_4
XFILLER_187_492 VDD VSS VDD VSS gf180mcu_fd_sc_mcu7t5v0__fillcap_8
XFILLER_148_857 VDD VSS VDD VSS gf180mcu_fd_sc_mcu7t5v0__fillcap_16
XFILLER_147_334 VDD VSS VDD VSS gf180mcu_fd_sc_mcu7t5v0__fillcap_16
X_4585_ _4585_/D _4603_/D _4616_/RN VSS _4614_/CLK VDD VDD VSS gf180mcu_fd_sc_mcu7t5v0__dffrnq_1
X_3605_ _3605_/S VDD VSS _3605_/Z _4033_/Q _4025_/Q VDD VSS gf180mcu_fd_sc_mcu7t5v0__mux2_2
XFILLER_143_551 VDD VSS VDD VSS gf180mcu_fd_sc_mcu7t5v0__fillcap_8
X_3536_ _3536_/A3 VDD VSS _3545_/A2 wire72/Z _3536_/A2 VDD VSS gf180mcu_fd_sc_mcu7t5v0__nand3_1
XFILLER_130_223 VDD VSS VDD VSS gf180mcu_fd_sc_mcu7t5v0__fillcap_16
X_3467_ _3467_/B wire83/I VDD VSS _3468_/B wire88/I _3467_/A2 VDD VSS gf180mcu_fd_sc_mcu7t5v0__oai211_1
X_3398_ wire56/I VDD VSS _4441_/D _4399_/Q _4441_/Q VDD VSS gf180mcu_fd_sc_mcu7t5v0__mux2_2
X_2418_ _2422_/S VDD VSS _4053_/D wire158/Z _4053_/Q VDD VSS gf180mcu_fd_sc_mcu7t5v0__mux2_2
X_2349_ VDD VSS _4531_/D _4233_/Q _2213_/Z VDD VSS gf180mcu_fd_sc_mcu7t5v0__nor2_1
XFILLER_97_693 VDD VSS VDD VSS gf180mcu_fd_sc_mcu7t5v0__fillcap_4
XFILLER_84_387 VDD VSS VDD VSS gf180mcu_fd_sc_mcu7t5v0__fillcap_64
XFILLER_72_527 VDD VSS VDD VSS gf180mcu_fd_sc_mcu7t5v0__fillcap_64
X_4019_ VDD _4019_/Q _4612_/CLK VSS _4019_/D VDD VSS gf180mcu_fd_sc_mcu7t5v0__dffq_1
XFILLER_199_18 VDD VSS VDD VSS gf180mcu_fd_sc_mcu7t5v0__fillcap_32
XFILLER_241_842 VDD VSS VDD VSS gf180mcu_fd_sc_mcu7t5v0__fillcap_32
XFILLER_197_212 VDD VSS VDD VSS gf180mcu_fd_sc_mcu7t5v0__fillcap_8
XFILLER_138_301 VDD VSS VDD VSS gf180mcu_fd_sc_mcu7t5v0__fillcap_8
XFILLER_40_457 VDD VSS VDD VSS gf180mcu_fd_sc_mcu7t5v0__fillcap_64
XFILLER_166_676 VDD VSS VDD VSS gf180mcu_fd_sc_mcu7t5v0__fillcap_8
XFILLER_165_142 VDD VSS VDD VSS gf180mcu_fd_sc_mcu7t5v0__fillcap_8
XFILLER_126_518 VDD VSS VDD VSS gf180mcu_fd_sc_mcu7t5v0__fillcap_4
XFILLER_126_507 VDD VSS VDD VSS gf180mcu_fd_sc_mcu7t5v0__fillcap_4
XFILLER_148_77 VDD VSS VDD VSS gf180mcu_fd_sc_mcu7t5v0__fillcap_16
XFILLER_165_164 VDD VSS VDD VSS gf180mcu_fd_sc_mcu7t5v0__fillcap_32
XFILLER_164_10 VDD VSS VDD VSS gf180mcu_fd_sc_mcu7t5v0__fillcap_16
XFILLER_106_2 VDD VSS VDD VSS gf180mcu_fd_sc_mcu7t5v0__fillcap_32
XFILLER_122_724 VDD VSS VDD VSS gf180mcu_fd_sc_mcu7t5v0__fillcap_8
XFILLER_95_608 VDD VSS VDD VSS gf180mcu_fd_sc_mcu7t5v0__fillcap_8
XFILLER_263_422 VDD VSS VDD VSS gf180mcu_fd_sc_mcu7t5v0__fillcap_64
XFILLER_76_877 VDD VSS VDD VSS gf180mcu_fd_sc_mcu7t5v0__fillcap_8
XFILLER_236_658 VDD VSS VDD VSS gf180mcu_fd_sc_mcu7t5v0__fillcap_4
XFILLER_231_352 VDD VSS VDD VSS gf180mcu_fd_sc_mcu7t5v0__fillcap_64
XFILLER_200_761 VDD VSS VDD VSS gf180mcu_fd_sc_mcu7t5v0__fillcap_16
XFILLER_157_687 VDD VSS VDD VSS gf180mcu_fd_sc_mcu7t5v0__fillcap_8
X_4370_ _4370_/D _4370_/Q wire183/Z VSS _4371_/CLK VDD VDD VSS gf180mcu_fd_sc_mcu7t5v0__dffrnq_1
X_3321_ VDD _3321_/B _3325_/B _4380_/D _4380_/Q VSS VDD VSS gf180mcu_fd_sc_mcu7t5v0__oai21_1
XFILLER_125_562 VDD VSS VDD VSS gf180mcu_fd_sc_mcu7t5v0__fillcap_4
XFILLER_113_702 VDD VSS VDD VSS gf180mcu_fd_sc_mcu7t5v0__fillcap_32
XFILLER_98_457 VDD VSS VDD VSS gf180mcu_fd_sc_mcu7t5v0__fillcap_32
X_3252_ wire23/Z VDD VSS _4360_/D wire143/Z _4360_/Q VDD VSS gf180mcu_fd_sc_mcu7t5v0__mux2_2
X_2203_ _2213_/A2 _2210_/A2 VDD VSS _2208_/A2 _2203_/A1 _2203_/A2 VDD VSS gf180mcu_fd_sc_mcu7t5v0__aoi22_1
XFILLER_267_772 VDD VSS VDD VSS gf180mcu_fd_sc_mcu7t5v0__fillcap_64
X_3183_ _4000_/Q VSS VDD _3984_/Q _3992_/Q _3113_/S _3976_/Q _3117_/B _3183_/Z VDD
+ VSS gf180mcu_fd_sc_mcu7t5v0__mux4_1
XFILLER_21_2 VDD VSS VDD VSS gf180mcu_fd_sc_mcu7t5v0__fillcap_64
X_2134_ VDD VSS _2134_/I _4135_/D VDD VSS gf180mcu_fd_sc_mcu7t5v0__clkinv_1
XFILLER_66_387 VDD VSS VDD VSS gf180mcu_fd_sc_mcu7t5v0__fillcap_64
XFILLER_208_850 VDD VSS VDD VSS gf180mcu_fd_sc_mcu7t5v0__fillcap_16
XFILLER_54_527 VDD VSS VDD VSS gf180mcu_fd_sc_mcu7t5v0__fillcap_64
XFILLER_93_151 VDD VSS VDD VSS gf180mcu_fd_sc_mcu7t5v0__fillcap_16
XFILLER_81_346 VDD VSS VDD VSS gf180mcu_fd_sc_mcu7t5v0__fillcap_4
X_2065_ VDD VSS _4580_/D _4580_/Q _2061_/Z VDD VSS gf180mcu_fd_sc_mcu7t5v0__xor2_1
XFILLER_223_842 VDD VSS VDD VSS gf180mcu_fd_sc_mcu7t5v0__fillcap_32
XFILLER_250_661 VDD VSS VDD VSS gf180mcu_fd_sc_mcu7t5v0__fillcap_4
XFILLER_22_457 VDD VSS VDD VSS gf180mcu_fd_sc_mcu7t5v0__fillcap_64
XFILLER_148_643 VDD VSS VDD VSS gf180mcu_fd_sc_mcu7t5v0__fillcap_16
X_2967_ VDD _2967_/B _3035_/B _2968_/A3 _3035_/A2 VSS VDD VSS gf180mcu_fd_sc_mcu7t5v0__oai21_1
XFILLER_147_142 VDD VSS VDD VSS gf180mcu_fd_sc_mcu7t5v0__fillcap_32
X_2898_ _2898_/A3 _3023_/A2 VDD VSS _3201_/A3 _3497_/C1 _2898_/A2 VDD VSS gf180mcu_fd_sc_mcu7t5v0__nand4_1
X_1918_ VDD VSS _4581_/Q _2432_/A2 VDD VSS gf180mcu_fd_sc_mcu7t5v0__clkinv_1
XFILLER_135_337 VDD VSS VDD VSS gf180mcu_fd_sc_mcu7t5v0__fillcap_8
X_4568_ _4568_/D _4568_/Q _4573_/RN VSS _4573_/CLK VDD VDD VSS gf180mcu_fd_sc_mcu7t5v0__dffrnq_1
XFILLER_2_807 VDD VSS VDD VSS gf180mcu_fd_sc_mcu7t5v0__fillcap_64
XFILLER_104_724 VDD VSS VDD VSS gf180mcu_fd_sc_mcu7t5v0__fillcap_8
X_3519_ VDD VSS _3525_/B1 _3619_/C _3518_/Z VDD VSS gf180mcu_fd_sc_mcu7t5v0__nor2_1
X_4499_ _4499_/D _4499_/Q wire209/Z VSS _4499_/CLK VDD VDD VSS gf180mcu_fd_sc_mcu7t5v0__dffrnq_1
XFILLER_76_107 VDD VSS VDD VSS gf180mcu_fd_sc_mcu7t5v0__fillcap_64
XFILLER_245_422 VDD VSS VDD VSS gf180mcu_fd_sc_mcu7t5v0__fillcap_64
XFILLER_257_282 VDD VSS VDD VSS gf180mcu_fd_sc_mcu7t5v0__fillcap_64
XFILLER_58_877 VDD VSS VDD VSS gf180mcu_fd_sc_mcu7t5v0__fillcap_8
XFILLER_73_836 VDD VSS VDD VSS gf180mcu_fd_sc_mcu7t5v0__fillcap_4
XFILLER_85_696 VDD VSS VDD VSS gf180mcu_fd_sc_mcu7t5v0__fillcap_4
XFILLER_217_168 VDD VSS VDD VSS gf180mcu_fd_sc_mcu7t5v0__fillcap_16
XFILLER_27_66 VDD VSS VDD VSS gf180mcu_fd_sc_mcu7t5v0__fillcap_4
XFILLER_213_352 VDD VSS VDD VSS gf180mcu_fd_sc_mcu7t5v0__fillcap_64
XFILLER_81_880 VDD VSS VDD VSS gf180mcu_fd_sc_mcu7t5v0__fillcap_8
XFILLER_240_171 VDD VSS VDD VSS gf180mcu_fd_sc_mcu7t5v0__fillcap_4
XFILLER_41_766 VDD VSS VDD VSS gf180mcu_fd_sc_mcu7t5v0__fillcap_4
XFILLER_201_547 VDD VSS VDD VSS gf180mcu_fd_sc_mcu7t5v0__fillcap_8
XFILLER_139_632 VDD VSS VDD VSS gf180mcu_fd_sc_mcu7t5v0__fillcap_8
XFILLER_139_676 VDD VSS VDD VSS gf180mcu_fd_sc_mcu7t5v0__fillcap_16
XFILLER_223_2 VDD VSS VDD VSS gf180mcu_fd_sc_mcu7t5v0__fillcap_64
XFILLER_193_292 VDD VSS VDD VSS gf180mcu_fd_sc_mcu7t5v0__fillcap_32
XFILLER_141_307 VDD VSS VDD VSS gf180mcu_fd_sc_mcu7t5v0__fillcap_8
XFILLER_4_177 VDD VSS VDD VSS gf180mcu_fd_sc_mcu7t5v0__fillcap_64
XFILLER_4_37 VDD VSS VDD VSS gf180mcu_fd_sc_mcu7t5v0__fillcap_64
XFILLER_150_885 VDD VSS VDD VSS gf180mcu_fd_sc_mcu7t5v0__fillcap_4
XFILLER_249_772 VDD VSS VDD VSS gf180mcu_fd_sc_mcu7t5v0__fillcap_64
XFILLER_95_416 VDD VSS VDD VSS gf180mcu_fd_sc_mcu7t5v0__fillcap_4
XFILLER_264_731 VDD VSS VDD VSS gf180mcu_fd_sc_mcu7t5v0__fillcap_4
XFILLER_48_387 VDD VSS VDD VSS gf180mcu_fd_sc_mcu7t5v0__fillcap_64
XFILLER_36_527 VDD VSS VDD VSS gf180mcu_fd_sc_mcu7t5v0__fillcap_64
XFILLER_236_499 VDD VSS VDD VSS gf180mcu_fd_sc_mcu7t5v0__fillcap_16
XFILLER_63_346 VDD VSS VDD VSS gf180mcu_fd_sc_mcu7t5v0__fillcap_4
XFILLER_205_831 VDD VSS VDD VSS gf180mcu_fd_sc_mcu7t5v0__fillcap_8
XFILLER_205_842 VDD VSS VDD VSS gf180mcu_fd_sc_mcu7t5v0__fillcap_32
XFILLER_220_801 VDD VSS VDD VSS gf180mcu_fd_sc_mcu7t5v0__fillcap_4
XFILLER_210_37 VDD VSS VDD VSS gf180mcu_fd_sc_mcu7t5v0__fillcap_64
X_3870_ VSS _4171_/CLK VDD _3870_/D _3870_/Q wire193/Z VDD VSS gf180mcu_fd_sc_mcu7t5v0__dffsnq_1
X_2821_ VDD VSS _2821_/Z _3024_/A2 _3027_/A3 VDD VSS gf180mcu_fd_sc_mcu7t5v0__or2_1
Xclkbuf_leaf_61_clk_i _4532_/CLK VSS VDD clkload2/I VDD VSS gf180mcu_fd_sc_mcu7t5v0__clkbuf_2
XFILLER_31_276 VDD VSS VDD VSS gf180mcu_fd_sc_mcu7t5v0__fillcap_4
X_2752_ wire36/Z VDD VSS _4286_/D _4286_/Q _4460_/Q VDD VSS gf180mcu_fd_sc_mcu7t5v0__mux2_2
XFILLER_144_101 VDD VSS VDD VSS gf180mcu_fd_sc_mcu7t5v0__fillcap_4
X_2683_ VDD VSS _2684_/B _4501_/Q _2684_/A1 VDD VSS gf180mcu_fd_sc_mcu7t5v0__nand2_1
X_4422_ _4422_/D _4422_/Q wire210/Z VSS _4496_/CLK VDD VDD VSS gf180mcu_fd_sc_mcu7t5v0__dffrnq_1
XFILLER_69_2 VDD VSS VDD VSS gf180mcu_fd_sc_mcu7t5v0__fillcap_64
XFILLER_99_722 VDD VSS VDD VSS gf180mcu_fd_sc_mcu7t5v0__fillcap_4
Xclkbuf_leaf_76_clk_i _4076_/CLK VSS VDD clkbuf_3_2__f_clk_i/Z VDD VSS gf180mcu_fd_sc_mcu7t5v0__clkbuf_2
X_4353_ _4353_/D _4353_/Q wire199/I VSS _4354_/CLK VDD VDD VSS gf180mcu_fd_sc_mcu7t5v0__dffrnq_1
XFILLER_144_189 VDD VSS VDD VSS gf180mcu_fd_sc_mcu7t5v0__fillcap_8
X_4284_ _4284_/D _4284_/Q _4284_/RN VSS _4466_/CLK VDD VDD VSS gf180mcu_fd_sc_mcu7t5v0__dffrnq_1
X_3304_ _3304_/A3 VDD VSS _3305_/B _4380_/Q _3304_/A2 VDD VSS gf180mcu_fd_sc_mcu7t5v0__nand3_1
XFILLER_113_554 VDD VSS VDD VSS gf180mcu_fd_sc_mcu7t5v0__fillcap_4
XFILLER_99_766 VDD VSS VDD VSS gf180mcu_fd_sc_mcu7t5v0__fillcap_4
X_3235_ VDD VSS _3236_/B1 _3236_/A1 _2993_/Z VDD VSS gf180mcu_fd_sc_mcu7t5v0__nand2_1
XFILLER_113_587 VDD VSS VDD VSS gf180mcu_fd_sc_mcu7t5v0__fillcap_8
XFILLER_58_107 VDD VSS VDD VSS gf180mcu_fd_sc_mcu7t5v0__fillcap_64
XFILLER_227_422 VDD VSS VDD VSS gf180mcu_fd_sc_mcu7t5v0__fillcap_32
X_3166_ _3166_/B _3188_/C VDD VSS _3167_/A3 _3143_/C _3165_/Z VDD VSS gf180mcu_fd_sc_mcu7t5v0__aoi211_1
XFILLER_239_282 VDD VSS VDD VSS gf180mcu_fd_sc_mcu7t5v0__fillcap_64
XFILLER_254_241 VDD VSS VDD VSS gf180mcu_fd_sc_mcu7t5v0__fillcap_4
XFILLER_251_66 VDD VSS VDD VSS gf180mcu_fd_sc_mcu7t5v0__fillcap_4
XFILLER_55_836 VDD VSS VDD VSS gf180mcu_fd_sc_mcu7t5v0__fillcap_4
X_3097_ _3097_/B _3182_/B VDD VSS _3104_/B wire96/Z _3091_/Z VDD VSS gf180mcu_fd_sc_mcu7t5v0__oai211_1
X_2117_ VDD VSS _2118_/A2 wire138/Z _2150_/A2 VDD VSS gf180mcu_fd_sc_mcu7t5v0__nand2_1
Xclkbuf_leaf_14_clk_i _4448_/CLK VSS VDD clkload1/I VDD VSS gf180mcu_fd_sc_mcu7t5v0__clkbuf_2
XFILLER_67_696 VDD VSS VDD VSS gf180mcu_fd_sc_mcu7t5v0__fillcap_4
XFILLER_199_318 VDD VSS VDD VSS gf180mcu_fd_sc_mcu7t5v0__fillcap_4
X_2048_ _2048_/A3 _2046_/Z VDD VSS _2086_/A1 wire75/I wire77/Z VDD VSS gf180mcu_fd_sc_mcu7t5v0__nor4_1
XFILLER_120_37 VDD VSS VDD VSS gf180mcu_fd_sc_mcu7t5v0__fillcap_32
XFILLER_222_171 VDD VSS VDD VSS gf180mcu_fd_sc_mcu7t5v0__fillcap_4
XFILLER_167_204 VDD VSS VDD VSS gf180mcu_fd_sc_mcu7t5v0__fillcap_4
XFILLER_23_766 VDD VSS VDD VSS gf180mcu_fd_sc_mcu7t5v0__fillcap_4
X_3999_ VDD _3999_/Q _4001_/CLK VSS _3999_/D VDD VSS gf180mcu_fd_sc_mcu7t5v0__dffq_1
Xclkbuf_leaf_29_clk_i _4271_/CLK VSS VDD clkload4/I VDD VSS gf180mcu_fd_sc_mcu7t5v0__clkbuf_2
XFILLER_131_340 VDD VSS VDD VSS gf180mcu_fd_sc_mcu7t5v0__fillcap_8
XFILLER_104_543 VDD VSS VDD VSS gf180mcu_fd_sc_mcu7t5v0__fillcap_8
XFILLER_1_136 VDD VSS VDD VSS gf180mcu_fd_sc_mcu7t5v0__fillcap_4
XFILLER_89_276 VDD VSS VDD VSS gf180mcu_fd_sc_mcu7t5v0__fillcap_4
XFILLER_77_416 VDD VSS VDD VSS gf180mcu_fd_sc_mcu7t5v0__fillcap_4
XFILLER_132_885 VDD VSS VDD VSS gf180mcu_fd_sc_mcu7t5v0__fillcap_4
XFILLER_246_731 VDD VSS VDD VSS gf180mcu_fd_sc_mcu7t5v0__fillcap_4
XFILLER_258_591 VDD VSS VDD VSS gf180mcu_fd_sc_mcu7t5v0__fillcap_4
XFILLER_173_2 VDD VSS VDD VSS gf180mcu_fd_sc_mcu7t5v0__fillcap_64
XFILLER_18_527 VDD VSS VDD VSS gf180mcu_fd_sc_mcu7t5v0__fillcap_64
XFILLER_45_346 VDD VSS VDD VSS gf180mcu_fd_sc_mcu7t5v0__fillcap_4
XFILLER_214_683 VDD VSS VDD VSS gf180mcu_fd_sc_mcu7t5v0__fillcap_4
XFILLER_199_885 VDD VSS VDD VSS gf180mcu_fd_sc_mcu7t5v0__fillcap_4
XFILLER_13_276 VDD VSS VDD VSS gf180mcu_fd_sc_mcu7t5v0__fillcap_4
Xclkload17 VSS clkload17/Z _4449_/CLK VDD VDD VSS gf180mcu_fd_sc_mcu7t5v0__clkbuf_1
XFILLER_194_590 VDD VSS VDD VSS gf180mcu_fd_sc_mcu7t5v0__fillcap_4
Xclkload39 clkload39/Z VSS VDD _4510_/CLK VDD VSS gf180mcu_fd_sc_mcu7t5v0__clkbuf_2
XFILLER_126_123 VDD VSS VDD VSS gf180mcu_fd_sc_mcu7t5v0__fillcap_8
Xclkload28 VSS clkload28/Z _4028_/CLK VDD VDD VSS gf180mcu_fd_sc_mcu7t5v0__clkbuf_1
XFILLER_79_72 VDD VSS VDD VSS gf180mcu_fd_sc_mcu7t5v0__fillcap_64
XFILLER_5_486 VDD VSS VDD VSS gf180mcu_fd_sc_mcu7t5v0__fillcap_4
XFILLER_209_422 VDD VSS VDD VSS gf180mcu_fd_sc_mcu7t5v0__fillcap_32
X_3020_ VDD VSS _3020_/Z _2883_/C _3024_/A3 VDD VSS gf180mcu_fd_sc_mcu7t5v0__xor2_1
XFILLER_236_241 VDD VSS VDD VSS gf180mcu_fd_sc_mcu7t5v0__fillcap_4
XFILLER_37_836 VDD VSS VDD VSS gf180mcu_fd_sc_mcu7t5v0__fillcap_4
XFILLER_49_696 VDD VSS VDD VSS gf180mcu_fd_sc_mcu7t5v0__fillcap_4
X_3922_ VDD _3922_/Q _4001_/CLK VSS _3922_/D VDD VSS gf180mcu_fd_sc_mcu7t5v0__dffq_1
XFILLER_204_171 VDD VSS VDD VSS gf180mcu_fd_sc_mcu7t5v0__fillcap_4
XFILLER_177_524 VDD VSS VDD VSS gf180mcu_fd_sc_mcu7t5v0__fillcap_4
X_3853_ _3853_/D _3853_/Q _4473_/RN VSS _4441_/CLK VDD VDD VSS gf180mcu_fd_sc_mcu7t5v0__dffrnq_1
X_2804_ VDD VSS _2805_/B _2804_/A1 _2985_/C VDD VSS gf180mcu_fd_sc_mcu7t5v0__nand2_1
X_3784_ _3786_/S VDD VSS _3951_/D _4294_/Q _3951_/Q VDD VSS gf180mcu_fd_sc_mcu7t5v0__mux2_2
XFILLER_192_527 VDD VSS VDD VSS gf180mcu_fd_sc_mcu7t5v0__fillcap_64
XFILLER_118_613 VDD VSS VDD VSS gf180mcu_fd_sc_mcu7t5v0__fillcap_16
X_2735_ _2736_/S VDD VSS _4269_/D _4269_/Q wire114/Z VDD VSS gf180mcu_fd_sc_mcu7t5v0__mux2_2
X_2666_ _4149_/Q _2666_/C VDD VSS _2667_/B _4270_/Q _2168_/Z _2666_/B1 VDD VSS gf180mcu_fd_sc_mcu7t5v0__aoi221_1
XFILLER_172_251 VDD VSS VDD VSS gf180mcu_fd_sc_mcu7t5v0__fillcap_8
X_4405_ _4405_/D _4405_/Q wire186/Z VSS _4478_/CLK VDD VDD VSS gf180mcu_fd_sc_mcu7t5v0__dffrnq_1
X_4336_ _4336_/D _4336_/Q _4530_/RN VSS _4338_/CLK VDD VDD VSS gf180mcu_fd_sc_mcu7t5v0__dffrnq_1
X_2597_ _4205_/Q VDD VSS _2601_/A3 _4204_/Q _4203_/Q VDD VSS gf180mcu_fd_sc_mcu7t5v0__nand3_1
XFILLER_101_524 VDD VSS VDD VSS gf180mcu_fd_sc_mcu7t5v0__fillcap_8
XFILLER_59_416 VDD VSS VDD VSS gf180mcu_fd_sc_mcu7t5v0__fillcap_4
X_4267_ _4267_/D _4267_/Q wire193/Z VSS _4270_/CLK VDD VDD VSS gf180mcu_fd_sc_mcu7t5v0__dffrnq_1
XFILLER_228_731 VDD VSS VDD VSS gf180mcu_fd_sc_mcu7t5v0__fillcap_4
X_3218_ VSS VDD _3218_/C2 _3218_/C1 _2897_/Z _3218_/B1 _3213_/B _4347_/Q _3219_/I
+ VDD VSS gf180mcu_fd_sc_mcu7t5v0__aoi222_1
X_4198_ _4198_/D _4198_/Q _4527_/RN VSS _4198_/CLK VDD VDD VSS gf180mcu_fd_sc_mcu7t5v0__dffrnq_1
X_3149_ wire64/Z _3170_/B VDD VSS _3150_/B _3214_/A1 _3149_/A2 _3149_/B2 VDD VSS gf180mcu_fd_sc_mcu7t5v0__oai221_1
XFILLER_27_346 VDD VSS VDD VSS gf180mcu_fd_sc_mcu7t5v0__fillcap_4
XFILLER_131_58 VDD VSS VDD VSS gf180mcu_fd_sc_mcu7t5v0__fillcap_8
XFILLER_196_877 VDD VSS VDD VSS gf180mcu_fd_sc_mcu7t5v0__fillcap_8
Xmax_length203 _4284_/RN wire207/Z VDD VSS VDD VSS gf180mcu_fd_sc_mcu7t5v0__buf_8
XFILLER_108_101 VDD VSS VDD VSS gf180mcu_fd_sc_mcu7t5v0__fillcap_4
XFILLER_108_123 VDD VSS VDD VSS gf180mcu_fd_sc_mcu7t5v0__fillcap_8
XFILLER_105_830 VDD VSS VDD VSS gf180mcu_fd_sc_mcu7t5v0__fillcap_8
XFILLER_172_87 VDD VSS VDD VSS gf180mcu_fd_sc_mcu7t5v0__fillcap_8
XFILLER_93_717 VDD VSS VDD VSS gf180mcu_fd_sc_mcu7t5v0__fillcap_4
XFILLER_120_877 VDD VSS VDD VSS gf180mcu_fd_sc_mcu7t5v0__fillcap_8
XFILLER_19_836 VDD VSS VDD VSS gf180mcu_fd_sc_mcu7t5v0__fillcap_4
XFILLER_234_789 VDD VSS VDD VSS gf180mcu_fd_sc_mcu7t5v0__fillcap_16
XFILLER_174_527 VDD VSS VDD VSS gf180mcu_fd_sc_mcu7t5v0__fillcap_4
X_2520_ _2730_/S VDD VSS _4149_/D _4149_/Q wire118/Z VDD VSS gf180mcu_fd_sc_mcu7t5v0__mux2_2
XFILLER_182_582 VDD VSS VDD VSS gf180mcu_fd_sc_mcu7t5v0__fillcap_8
X_2451_ _2454_/S VDD VSS _4078_/D _2506_/I0 _4078_/Q VDD VSS gf180mcu_fd_sc_mcu7t5v0__mux2_2
XFILLER_142_457 VDD VSS VDD VSS gf180mcu_fd_sc_mcu7t5v0__fillcap_8
X_2382_ _2383_/S VDD VSS _4024_/D _4024_/Q wire153/Z VDD VSS gf180mcu_fd_sc_mcu7t5v0__mux2_2
XFILLER_110_310 VDD VSS VDD VSS gf180mcu_fd_sc_mcu7t5v0__fillcap_4
X_4121_ VDD _4121_/Q _4129_/CLK VSS _4121_/D VDD VSS gf180mcu_fd_sc_mcu7t5v0__dffq_1
X_4052_ VDD _4052_/Q _4062_/CLK VSS _4052_/D VDD VSS gf180mcu_fd_sc_mcu7t5v0__dffq_1
XFILLER_237_550 VDD VSS VDD VSS gf180mcu_fd_sc_mcu7t5v0__fillcap_8
X_3003_ VDD VSS _3003_/Z _4323_/Q _3002_/Z VDD VSS gf180mcu_fd_sc_mcu7t5v0__or2_1
XFILLER_110_387 VDD VSS VDD VSS gf180mcu_fd_sc_mcu7t5v0__fillcap_8
Xinput4 VDD spi_cs_ni VSS input4/Z VDD VSS gf180mcu_fd_sc_mcu7t5v0__dlyb_1
XFILLER_225_756 VDD VSS VDD VSS gf180mcu_fd_sc_mcu7t5v0__fillcap_8
XFILLER_240_737 VDD VSS VDD VSS gf180mcu_fd_sc_mcu7t5v0__fillcap_64
XFILLER_252_597 VDD VSS VDD VSS gf180mcu_fd_sc_mcu7t5v0__fillcap_64
XFILLER_196_107 VDD VSS VDD VSS gf180mcu_fd_sc_mcu7t5v0__fillcap_32
XFILLER_91_282 VDD VSS VDD VSS gf180mcu_fd_sc_mcu7t5v0__fillcap_64
X_3905_ VDD _3905_/Q _4574_/CLK VSS _3905_/D VDD VSS gf180mcu_fd_sc_mcu7t5v0__dffq_1
XFILLER_178_877 VDD VSS VDD VSS gf180mcu_fd_sc_mcu7t5v0__fillcap_8
X_3836_ _3839_/S VDD VSS _3990_/D _3845_/I0 _3990_/Q VDD VSS gf180mcu_fd_sc_mcu7t5v0__mux2_2
X_3767_ _3767_/S VDD VSS _3937_/D _3848_/I0 _3937_/Q VDD VSS gf180mcu_fd_sc_mcu7t5v0__mux2_2
X_2718_ VDD VSS _2718_/I _4253_/D VDD VSS gf180mcu_fd_sc_mcu7t5v0__clkinv_1
X_3698_ _3739_/A1 VDD VSS _3706_/S _4540_/Q _4541_/Q VDD VSS gf180mcu_fd_sc_mcu7t5v0__and3_1
X_2649_ VDD VSS _2653_/A2 _2695_/B _2699_/A1 VDD VSS gf180mcu_fd_sc_mcu7t5v0__nand2_1
XFILLER_161_788 VDD VSS VDD VSS gf180mcu_fd_sc_mcu7t5v0__fillcap_8
XFILLER_120_107 VDD VSS VDD VSS gf180mcu_fd_sc_mcu7t5v0__fillcap_4
XFILLER_126_69 VDD VSS VDD VSS gf180mcu_fd_sc_mcu7t5v0__fillcap_16
X_4319_ _4319_/D _4319_/Q wire206/Z VSS _4345_/CLK VDD VDD VSS gf180mcu_fd_sc_mcu7t5v0__dffrnq_1
XFILLER_102_877 VDD VSS VDD VSS gf180mcu_fd_sc_mcu7t5v0__fillcap_8
XFILLER_262_317 VDD VSS VDD VSS gf180mcu_fd_sc_mcu7t5v0__fillcap_64
XFILLER_216_745 VDD VSS VDD VSS gf180mcu_fd_sc_mcu7t5v0__fillcap_4
XFILLER_228_572 VDD VSS VDD VSS gf180mcu_fd_sc_mcu7t5v0__fillcap_4
XFILLER_216_778 VDD VSS VDD VSS gf180mcu_fd_sc_mcu7t5v0__fillcap_8
XFILLER_231_726 VDD VSS VDD VSS gf180mcu_fd_sc_mcu7t5v0__fillcap_4
XFILLER_230_247 VDD VSS VDD VSS gf180mcu_fd_sc_mcu7t5v0__fillcap_64
XFILLER_156_527 VDD VSS VDD VSS gf180mcu_fd_sc_mcu7t5v0__fillcap_32
XFILLER_136_2 VDD VSS VDD VSS gf180mcu_fd_sc_mcu7t5v0__fillcap_16
XFILLER_124_457 VDD VSS VDD VSS gf180mcu_fd_sc_mcu7t5v0__fillcap_64
XFILLER_254_807 VDD VSS VDD VSS gf180mcu_fd_sc_mcu7t5v0__fillcap_64
XFILLER_266_667 VDD VSS VDD VSS gf180mcu_fd_sc_mcu7t5v0__fillcap_64
XFILLER_234_520 VDD VSS VDD VSS gf180mcu_fd_sc_mcu7t5v0__fillcap_4
XFILLER_234_542 VDD VSS VDD VSS gf180mcu_fd_sc_mcu7t5v0__fillcap_4
XFILLER_132_90 VDD VSS VDD VSS gf180mcu_fd_sc_mcu7t5v0__fillcap_8
XFILLER_61_422 VDD VSS VDD VSS gf180mcu_fd_sc_mcu7t5v0__fillcap_64
XFILLER_222_737 VDD VSS VDD VSS gf180mcu_fd_sc_mcu7t5v0__fillcap_8
XFILLER_73_282 VDD VSS VDD VSS gf180mcu_fd_sc_mcu7t5v0__fillcap_64
XFILLER_178_107 VDD VSS VDD VSS gf180mcu_fd_sc_mcu7t5v0__fillcap_16
X_1951_ VDD VSS _4370_/Q _3270_/A1 VDD VSS gf180mcu_fd_sc_mcu7t5v0__clkinv_1
XFILLER_159_387 VDD VSS VDD VSS gf180mcu_fd_sc_mcu7t5v0__fillcap_8
XFILLER_147_549 VDD VSS VDD VSS gf180mcu_fd_sc_mcu7t5v0__fillcap_8
X_3621_ VDD VSS _3644_/A2 _2522_/B _3479_/C VDD VSS gf180mcu_fd_sc_mcu7t5v0__nor2_1
X_3552_ VDD VSS _3558_/A2 _3596_/A1 _3551_/Z VDD VSS gf180mcu_fd_sc_mcu7t5v0__nand2_1
XFILLER_127_262 VDD VSS VDD VSS gf180mcu_fd_sc_mcu7t5v0__fillcap_8
X_2503_ _2509_/S VDD VSS _4123_/D wire164/Z _4123_/Q VDD VSS gf180mcu_fd_sc_mcu7t5v0__mux2_2
XFILLER_51_2 VDD VSS VDD VSS gf180mcu_fd_sc_mcu7t5v0__fillcap_64
XFILLER_143_766 VDD VSS VDD VSS gf180mcu_fd_sc_mcu7t5v0__fillcap_4
X_3483_ _3586_/S VDD VSS _3483_/Z _4092_/Q _4084_/Q VDD VSS gf180mcu_fd_sc_mcu7t5v0__mux2_2
XFILLER_102_107 VDD VSS VDD VSS gf180mcu_fd_sc_mcu7t5v0__fillcap_16
X_2434_ _2441_/S VDD VSS _4066_/D _4066_/Q wire168/Z VDD VSS gf180mcu_fd_sc_mcu7t5v0__mux2_2
XFILLER_97_820 VDD VSS VDD VSS gf180mcu_fd_sc_mcu7t5v0__fillcap_4
XFILLER_97_842 VDD VSS VDD VSS gf180mcu_fd_sc_mcu7t5v0__fillcap_8
X_2365_ VDD _2365_/B wire14/Z _4011_/D _3471_/A2 VSS VDD VSS gf180mcu_fd_sc_mcu7t5v0__oai21_1
X_4104_ VDD _4104_/Q _4122_/CLK VSS _4104_/D VDD VSS gf180mcu_fd_sc_mcu7t5v0__dffq_1
X_2296_ VDD VSS _2297_/A2 _3867_/D _2296_/A2 VDD VSS gf180mcu_fd_sc_mcu7t5v0__nand2_1
XFILLER_110_162 VDD VSS VDD VSS gf180mcu_fd_sc_mcu7t5v0__fillcap_4
XFILLER_256_177 VDD VSS VDD VSS gf180mcu_fd_sc_mcu7t5v0__fillcap_64
XFILLER_244_317 VDD VSS VDD VSS gf180mcu_fd_sc_mcu7t5v0__fillcap_64
X_4035_ VDD _4035_/Q _4062_/CLK VSS _4035_/D VDD VSS gf180mcu_fd_sc_mcu7t5v0__dffq_1
XFILLER_65_772 VDD VSS VDD VSS gf180mcu_fd_sc_mcu7t5v0__fillcap_64
XFILLER_80_720 VDD VSS VDD VSS gf180mcu_fd_sc_mcu7t5v0__fillcap_8
XFILLER_212_247 VDD VSS VDD VSS gf180mcu_fd_sc_mcu7t5v0__fillcap_16
XFILLER_138_527 VDD VSS VDD VSS gf180mcu_fd_sc_mcu7t5v0__fillcap_4
XFILLER_138_516 VDD VSS VDD VSS gf180mcu_fd_sc_mcu7t5v0__fillcap_8
XFILLER_21_842 VDD VSS VDD VSS gf180mcu_fd_sc_mcu7t5v0__fillcap_32
X_3819_ _3821_/S VDD VSS _3975_/D _4294_/Q _3975_/Q VDD VSS gf180mcu_fd_sc_mcu7t5v0__mux2_2
XFILLER_177_184 VDD VSS VDD VSS gf180mcu_fd_sc_mcu7t5v0__fillcap_16
XFILLER_165_313 VDD VSS VDD VSS gf180mcu_fd_sc_mcu7t5v0__fillcap_8
XFILLER_153_508 VDD VSS VDD VSS gf180mcu_fd_sc_mcu7t5v0__fillcap_4
XFILLER_118_240 VDD VSS VDD VSS gf180mcu_fd_sc_mcu7t5v0__fillcap_4
XFILLER_106_457 VDD VSS VDD VSS gf180mcu_fd_sc_mcu7t5v0__fillcap_32
XFILLER_87_352 VDD VSS VDD VSS gf180mcu_fd_sc_mcu7t5v0__fillcap_64
XFILLER_248_667 VDD VSS VDD VSS gf180mcu_fd_sc_mcu7t5v0__fillcap_64
XFILLER_236_807 VDD VSS VDD VSS gf180mcu_fd_sc_mcu7t5v0__fillcap_64
XFILLER_263_626 VDD VSS VDD VSS gf180mcu_fd_sc_mcu7t5v0__fillcap_4
Xmax_cap11 VSS _3677_/B1 _3679_/A2 VDD VDD VSS gf180mcu_fd_sc_mcu7t5v0__buf_2
Xmax_cap33 _2736_/S _2731_/S VDD VSS VDD VSS gf180mcu_fd_sc_mcu7t5v0__buf_4
XFILLER_43_422 VDD VSS VDD VSS gf180mcu_fd_sc_mcu7t5v0__fillcap_64
XFILLER_204_737 VDD VSS VDD VSS gf180mcu_fd_sc_mcu7t5v0__fillcap_4
XFILLER_253_2 VDD VSS VDD VSS gf180mcu_fd_sc_mcu7t5v0__fillcap_64
XFILLER_55_282 VDD VSS VDD VSS gf180mcu_fd_sc_mcu7t5v0__fillcap_64
XFILLER_216_597 VDD VSS VDD VSS gf180mcu_fd_sc_mcu7t5v0__fillcap_64
XFILLER_70_241 VDD VSS VDD VSS gf180mcu_fd_sc_mcu7t5v0__fillcap_4
XFILLER_231_556 VDD VSS VDD VSS gf180mcu_fd_sc_mcu7t5v0__fillcap_4
XFILLER_156_302 VDD VSS VDD VSS gf180mcu_fd_sc_mcu7t5v0__fillcap_8
XFILLER_157_858 VDD VSS VDD VSS gf180mcu_fd_sc_mcu7t5v0__fillcap_4
Xwire210 wire210/Z wire212/Z VDD VSS VDD VSS gf180mcu_fd_sc_mcu7t5v0__buf_8
XFILLER_11_352 VDD VSS VDD VSS gf180mcu_fd_sc_mcu7t5v0__fillcap_64
XFILLER_125_722 VDD VSS VDD VSS gf180mcu_fd_sc_mcu7t5v0__fillcap_4
XFILLER_140_725 VDD VSS VDD VSS gf180mcu_fd_sc_mcu7t5v0__fillcap_8
XFILLER_3_562 VDD VSS VDD VSS gf180mcu_fd_sc_mcu7t5v0__fillcap_64
XFILLER_140_758 VDD VSS VDD VSS gf180mcu_fd_sc_mcu7t5v0__fillcap_4
XFILLER_79_842 VDD VSS VDD VSS gf180mcu_fd_sc_mcu7t5v0__fillcap_32
XFILLER_87_72 VDD VSS VDD VSS gf180mcu_fd_sc_mcu7t5v0__fillcap_64
XFILLER_94_801 VDD VSS VDD VSS gf180mcu_fd_sc_mcu7t5v0__fillcap_4
X_2150_ VDD VSS _2151_/A2 _4447_/Q _2150_/A2 VDD VSS gf180mcu_fd_sc_mcu7t5v0__nand2_1
X_2081_ _4551_/Q VDD VSS _2111_/A2 _4305_/Q _2081_/A2 VDD VSS gf180mcu_fd_sc_mcu7t5v0__aoi21_1
XFILLER_238_177 VDD VSS VDD VSS gf180mcu_fd_sc_mcu7t5v0__fillcap_64
XFILLER_226_317 VDD VSS VDD VSS gf180mcu_fd_sc_mcu7t5v0__fillcap_64
XFILLER_253_136 VDD VSS VDD VSS gf180mcu_fd_sc_mcu7t5v0__fillcap_4
XFILLER_47_772 VDD VSS VDD VSS gf180mcu_fd_sc_mcu7t5v0__fillcap_64
XFILLER_74_591 VDD VSS VDD VSS gf180mcu_fd_sc_mcu7t5v0__fillcap_4
XFILLER_62_731 VDD VSS VDD VSS gf180mcu_fd_sc_mcu7t5v0__fillcap_4
X_2983_ _3201_/A3 wire45/I _2983_/B2 VDD VSS _4322_/D _2983_/A1 wire141/Z VDD VSS
+ gf180mcu_fd_sc_mcu7t5v0__oai32_1
XFILLER_99_2 VDD VSS VDD VSS gf180mcu_fd_sc_mcu7t5v0__fillcap_8
XFILLER_175_611 VDD VSS VDD VSS gf180mcu_fd_sc_mcu7t5v0__fillcap_8
X_1934_ VDD VSS _4529_/Q _2796_/A2 VDD VSS gf180mcu_fd_sc_mcu7t5v0__clkinv_1
XFILLER_30_661 VDD VSS VDD VSS gf180mcu_fd_sc_mcu7t5v0__fillcap_4
XFILLER_175_677 VDD VSS VDD VSS gf180mcu_fd_sc_mcu7t5v0__fillcap_4
XFILLER_163_817 VDD VSS VDD VSS gf180mcu_fd_sc_mcu7t5v0__fillcap_8
X_4584_ _4584_/D _4602_/D _4613_/RN VSS _4616_/CLK VDD VDD VSS gf180mcu_fd_sc_mcu7t5v0__dffrnq_1
X_3604_ VDD VSS _3610_/A2 wire74/Z _3603_/Z VDD VSS gf180mcu_fd_sc_mcu7t5v0__nand2_1
X_3535_ _3535_/B _3609_/C VDD VSS _3536_/A3 wire82/Z _3531_/Z VDD VSS gf180mcu_fd_sc_mcu7t5v0__oai211_1
XFILLER_115_265 VDD VSS VDD VSS gf180mcu_fd_sc_mcu7t5v0__fillcap_8
X_3466_ VDD VSS _3467_/B wire88/I _4035_/Q VDD VSS gf180mcu_fd_sc_mcu7t5v0__nand2_1
XFILLER_115_298 VDD VSS VDD VSS gf180mcu_fd_sc_mcu7t5v0__fillcap_4
X_2417_ _2422_/S VDD VSS _4052_/D wire161/Z _4052_/Q VDD VSS gf180mcu_fd_sc_mcu7t5v0__mux2_2
X_3397_ wire56/Z VDD VSS _4440_/D _4398_/Q _4440_/Q VDD VSS gf180mcu_fd_sc_mcu7t5v0__mux2_2
XFILLER_69_352 VDD VSS VDD VSS gf180mcu_fd_sc_mcu7t5v0__fillcap_64
X_2348_ _2348_/A3 VDD VSS _4532_/D wire59/Z _2348_/A2 VDD VSS gf180mcu_fd_sc_mcu7t5v0__nor3_1
XFILLER_84_311 VDD VSS VDD VSS gf180mcu_fd_sc_mcu7t5v0__fillcap_4
XFILLER_245_626 VDD VSS VDD VSS gf180mcu_fd_sc_mcu7t5v0__fillcap_4
XFILLER_257_486 VDD VSS VDD VSS gf180mcu_fd_sc_mcu7t5v0__fillcap_4
X_2279_ _4385_/Q VDD VSS _2280_/I _3333_/A1 _4383_/Q VDD VSS gf180mcu_fd_sc_mcu7t5v0__and3_1
X_4018_ VDD _4018_/Q _4047_/CLK VSS _4018_/D VDD VSS gf180mcu_fd_sc_mcu7t5v0__dffq_1
XFILLER_25_422 VDD VSS VDD VSS gf180mcu_fd_sc_mcu7t5v0__fillcap_64
XFILLER_37_282 VDD VSS VDD VSS gf180mcu_fd_sc_mcu7t5v0__fillcap_64
XFILLER_213_534 VDD VSS VDD VSS gf180mcu_fd_sc_mcu7t5v0__fillcap_16
XFILLER_197_202 VDD VSS VDD VSS gf180mcu_fd_sc_mcu7t5v0__fillcap_8
XFILLER_52_241 VDD VSS VDD VSS gf180mcu_fd_sc_mcu7t5v0__fillcap_4
XFILLER_200_239 VDD VSS VDD VSS gf180mcu_fd_sc_mcu7t5v0__fillcap_4
XFILLER_181_603 VDD VSS VDD VSS gf180mcu_fd_sc_mcu7t5v0__fillcap_16
XFILLER_20_171 VDD VSS VDD VSS gf180mcu_fd_sc_mcu7t5v0__fillcap_4
XFILLER_147_880 VDD VSS VDD VSS gf180mcu_fd_sc_mcu7t5v0__fillcap_8
XFILLER_161_360 VDD VSS VDD VSS gf180mcu_fd_sc_mcu7t5v0__fillcap_4
XFILLER_267_206 VDD VSS VDD VSS gf180mcu_fd_sc_mcu7t5v0__fillcap_4
XFILLER_164_77 VDD VSS VDD VSS gf180mcu_fd_sc_mcu7t5v0__fillcap_16
XFILLER_88_661 VDD VSS VDD VSS gf180mcu_fd_sc_mcu7t5v0__fillcap_4
XFILLER_76_801 VDD VSS VDD VSS gf180mcu_fd_sc_mcu7t5v0__fillcap_4
XFILLER_208_317 VDD VSS VDD VSS gf180mcu_fd_sc_mcu7t5v0__fillcap_4
XFILLER_235_136 VDD VSS VDD VSS gf180mcu_fd_sc_mcu7t5v0__fillcap_4
XFILLER_29_772 VDD VSS VDD VSS gf180mcu_fd_sc_mcu7t5v0__fillcap_64
XFILLER_56_591 VDD VSS VDD VSS gf180mcu_fd_sc_mcu7t5v0__fillcap_4
XFILLER_44_731 VDD VSS VDD VSS gf180mcu_fd_sc_mcu7t5v0__fillcap_4
XFILLER_12_661 VDD VSS VDD VSS gf180mcu_fd_sc_mcu7t5v0__fillcap_4
XFILLER_184_430 VDD VSS VDD VSS gf180mcu_fd_sc_mcu7t5v0__fillcap_16
XFILLER_7_142 VDD VSS VDD VSS gf180mcu_fd_sc_mcu7t5v0__fillcap_64
XFILLER_172_658 VDD VSS VDD VSS gf180mcu_fd_sc_mcu7t5v0__fillcap_4
XFILLER_208_37 VDD VSS VDD VSS gf180mcu_fd_sc_mcu7t5v0__fillcap_64
X_3320_ VDD VSS _3321_/B _4380_/Q _3329_/B VDD VSS gf180mcu_fd_sc_mcu7t5v0__nand2_1
XFILLER_4_871 VDD VSS VDD VSS gf180mcu_fd_sc_mcu7t5v0__fillcap_4
X_3251_ wire23/Z VDD VSS _4359_/D _4334_/Q _4359_/Q VDD VSS gf180mcu_fd_sc_mcu7t5v0__mux2_2
X_3182_ VDD _3189_/B2 _3182_/B _3188_/C _3182_/A2 VSS _3182_/A3 VDD VSS gf180mcu_fd_sc_mcu7t5v0__oai31_1
X_2202_ _2348_/A2 _2347_/A2 VDD VSS _2210_/A2 _2213_/A2 _2202_/A2 VDD VSS gf180mcu_fd_sc_mcu7t5v0__nand4_1
XFILLER_66_311 VDD VSS VDD VSS gf180mcu_fd_sc_mcu7t5v0__fillcap_4
XFILLER_78_171 VDD VSS VDD VSS gf180mcu_fd_sc_mcu7t5v0__fillcap_4
XFILLER_239_486 VDD VSS VDD VSS gf180mcu_fd_sc_mcu7t5v0__fillcap_4
X_2133_ _4526_/Q VDD VSS _2134_/I _4135_/Q _2133_/A2 VDD VSS gf180mcu_fd_sc_mcu7t5v0__aoi21_1
XFILLER_14_2 VDD VSS VDD VSS gf180mcu_fd_sc_mcu7t5v0__fillcap_32
X_2064_ VDD VSS _2095_/A2 _4580_/Q _2061_/Z VDD VSS gf180mcu_fd_sc_mcu7t5v0__nor2_1
XFILLER_19_282 VDD VSS VDD VSS gf180mcu_fd_sc_mcu7t5v0__fillcap_64
XFILLER_34_241 VDD VSS VDD VSS gf180mcu_fd_sc_mcu7t5v0__fillcap_4
XFILLER_210_559 VDD VSS VDD VSS gf180mcu_fd_sc_mcu7t5v0__fillcap_8
X_2966_ VDD VSS _2969_/A1 _4318_/Q _2829_/C VDD VSS gf180mcu_fd_sc_mcu7t5v0__nand2_1
XFILLER_249_66 VDD VSS VDD VSS gf180mcu_fd_sc_mcu7t5v0__fillcap_4
X_1917_ VDD VSS _4314_/Q _2925_/A1 VDD VSS gf180mcu_fd_sc_mcu7t5v0__clkinv_1
X_2897_ VDD VSS _2897_/Z _3208_/A2 _3023_/A2 VDD VSS gf180mcu_fd_sc_mcu7t5v0__and2_1
XFILLER_108_519 VDD VSS VDD VSS gf180mcu_fd_sc_mcu7t5v0__fillcap_4
XFILLER_118_37 VDD VSS VDD VSS gf180mcu_fd_sc_mcu7t5v0__fillcap_16
X_4567_ _4567_/D _4567_/Q wire187/Z VSS _4573_/CLK VDD VDD VSS gf180mcu_fd_sc_mcu7t5v0__dffrnq_1
XFILLER_249_206 VDD VSS VDD VSS gf180mcu_fd_sc_mcu7t5v0__fillcap_4
X_4498_ _4498_/D _4498_/Q _4498_/RN VSS _4498_/CLK VDD VDD VSS gf180mcu_fd_sc_mcu7t5v0__dffrnq_1
X_3518_ _3518_/A3 VDD VSS _3518_/Z wire42/Z _3518_/A2 VDD VSS gf180mcu_fd_sc_mcu7t5v0__and3_1
X_3449_ _3453_/A2 VDD VSS _3451_/B _4431_/Q _3449_/A2 VDD VSS gf180mcu_fd_sc_mcu7t5v0__nand3_1
XFILLER_58_801 VDD VSS VDD VSS gf180mcu_fd_sc_mcu7t5v0__fillcap_4
XFILLER_85_620 VDD VSS VDD VSS gf180mcu_fd_sc_mcu7t5v0__fillcap_8
XFILLER_111_290 VDD VSS VDD VSS gf180mcu_fd_sc_mcu7t5v0__fillcap_32
XFILLER_217_136 VDD VSS VDD VSS gf180mcu_fd_sc_mcu7t5v0__fillcap_4
XFILLER_38_591 VDD VSS VDD VSS gf180mcu_fd_sc_mcu7t5v0__fillcap_4
XFILLER_26_731 VDD VSS VDD VSS gf180mcu_fd_sc_mcu7t5v0__fillcap_4
XFILLER_186_728 VDD VSS VDD VSS gf180mcu_fd_sc_mcu7t5v0__fillcap_4
XFILLER_139_611 VDD VSS VDD VSS gf180mcu_fd_sc_mcu7t5v0__fillcap_16
XFILLER_159_66 VDD VSS VDD VSS gf180mcu_fd_sc_mcu7t5v0__fillcap_4
XFILLER_43_66 VDD VSS VDD VSS gf180mcu_fd_sc_mcu7t5v0__fillcap_4
XFILLER_159_88 VDD VSS VDD VSS gf180mcu_fd_sc_mcu7t5v0__fillcap_8
XFILLER_181_422 VDD VSS VDD VSS gf180mcu_fd_sc_mcu7t5v0__fillcap_16
XFILLER_4_101 VDD VSS VDD VSS gf180mcu_fd_sc_mcu7t5v0__fillcap_4
XFILLER_135_850 VDD VSS VDD VSS gf180mcu_fd_sc_mcu7t5v0__fillcap_4
XFILLER_107_585 VDD VSS VDD VSS gf180mcu_fd_sc_mcu7t5v0__fillcap_4
XFILLER_1_874 VDD VSS VDD VSS gf180mcu_fd_sc_mcu7t5v0__fillcap_16
XFILLER_48_311 VDD VSS VDD VSS gf180mcu_fd_sc_mcu7t5v0__fillcap_4
XFILLER_209_626 VDD VSS VDD VSS gf180mcu_fd_sc_mcu7t5v0__fillcap_4
XFILLER_208_147 VDD VSS VDD VSS gf180mcu_fd_sc_mcu7t5v0__fillcap_4
XFILLER_16_241 VDD VSS VDD VSS gf180mcu_fd_sc_mcu7t5v0__fillcap_4
XFILLER_189_555 VDD VSS VDD VSS gf180mcu_fd_sc_mcu7t5v0__fillcap_4
XFILLER_90_177 VDD VSS VDD VSS gf180mcu_fd_sc_mcu7t5v0__fillcap_64
XFILLER_189_599 VDD VSS VDD VSS gf180mcu_fd_sc_mcu7t5v0__fillcap_16
X_2820_ _3040_/A2 VDD VSS _3225_/A1 _3208_/A2 _3036_/B VDD VSS gf180mcu_fd_sc_mcu7t5v0__nand3_1
X_2751_ _2754_/S VDD VSS _4285_/D _4285_/Q _4459_/Q VDD VSS gf180mcu_fd_sc_mcu7t5v0__mux2_2
XFILLER_185_772 VDD VSS VDD VSS gf180mcu_fd_sc_mcu7t5v0__fillcap_64
X_2682_ _2682_/S VDD VSS _4240_/D _4313_/Q _4240_/Q VDD VSS gf180mcu_fd_sc_mcu7t5v0__mux2_2
XFILLER_8_451 VDD VSS VDD VSS gf180mcu_fd_sc_mcu7t5v0__fillcap_4
XFILLER_117_338 VDD VSS VDD VSS gf180mcu_fd_sc_mcu7t5v0__fillcap_4
XFILLER_129_187 VDD VSS VDD VSS gf180mcu_fd_sc_mcu7t5v0__fillcap_16
X_4421_ _4421_/D _4421_/Q wire212/Z VSS clkload8/I VDD VDD VSS gf180mcu_fd_sc_mcu7t5v0__dffrnq_1
XFILLER_160_639 VDD VSS VDD VSS gf180mcu_fd_sc_mcu7t5v0__fillcap_16
XFILLER_153_680 VDD VSS VDD VSS gf180mcu_fd_sc_mcu7t5v0__fillcap_8
XFILLER_141_842 VDD VSS VDD VSS gf180mcu_fd_sc_mcu7t5v0__fillcap_8
X_4352_ _4352_/D _4352_/Q wire199/I VSS _4523_/CLK VDD VDD VSS gf180mcu_fd_sc_mcu7t5v0__dffrnq_1
XFILLER_125_382 VDD VSS VDD VSS gf180mcu_fd_sc_mcu7t5v0__fillcap_8
X_4283_ _4283_/D _4283_/Q wire207/Z VSS _4283_/CLK VDD VDD VSS gf180mcu_fd_sc_mcu7t5v0__dffrnq_1
XFILLER_98_255 VDD VSS VDD VSS gf180mcu_fd_sc_mcu7t5v0__fillcap_4
X_3303_ VDD VSS _3305_/A2 _3303_/A1 _3303_/A2 VDD VSS gf180mcu_fd_sc_mcu7t5v0__nand2_1
X_3234_ _3234_/B VDD VSS _4351_/D _2859_/B _3234_/A2 VDD VSS gf180mcu_fd_sc_mcu7t5v0__aoi21_1
X_3165_ _3185_/S VDD VSS _3165_/Z _3951_/Q _3943_/Q VDD VSS gf180mcu_fd_sc_mcu7t5v0__mux2_2
X_3096_ _3096_/B1 wire96/Z VDD VSS _3097_/B _3096_/A1 _3096_/A2 _3096_/B2 VDD VSS
+ gf180mcu_fd_sc_mcu7t5v0__oai221_1
X_2116_ _3637_/A1 _2524_/A3 VDD VSS _2141_/A2 _3386_/A1 _3441_/A3 VDD VSS gf180mcu_fd_sc_mcu7t5v0__nor4_1
XFILLER_70_807 VDD VSS VDD VSS gf180mcu_fd_sc_mcu7t5v0__fillcap_64
X_2047_ _2046_/Z VDD VSS _2085_/A2 wire77/Z _2048_/A3 VDD VSS gf180mcu_fd_sc_mcu7t5v0__nor3_1
XFILLER_211_857 VDD VSS VDD VSS gf180mcu_fd_sc_mcu7t5v0__fillcap_32
X_3998_ VDD _3998_/Q _3998_/CLK VSS _3998_/D VDD VSS gf180mcu_fd_sc_mcu7t5v0__dffq_1
X_2949_ VDD VSS _2950_/C _2949_/A1 _2963_/B VDD VSS gf180mcu_fd_sc_mcu7t5v0__and2_1
XFILLER_50_597 VDD VSS VDD VSS gf180mcu_fd_sc_mcu7t5v0__fillcap_64
XFILLER_163_422 VDD VSS VDD VSS gf180mcu_fd_sc_mcu7t5v0__fillcap_64
XFILLER_175_282 VDD VSS VDD VSS gf180mcu_fd_sc_mcu7t5v0__fillcap_64
XFILLER_131_352 VDD VSS VDD VSS gf180mcu_fd_sc_mcu7t5v0__fillcap_4
XFILLER_261_702 VDD VSS VDD VSS gf180mcu_fd_sc_mcu7t5v0__fillcap_64
XFILLER_206_629 VDD VSS VDD VSS gf180mcu_fd_sc_mcu7t5v0__fillcap_8
XFILLER_199_842 VDD VSS VDD VSS gf180mcu_fd_sc_mcu7t5v0__fillcap_8
XFILLER_72_177 VDD VSS VDD VSS gf180mcu_fd_sc_mcu7t5v0__fillcap_64
XFILLER_60_317 VDD VSS VDD VSS gf180mcu_fd_sc_mcu7t5v0__fillcap_64
XFILLER_198_352 VDD VSS VDD VSS gf180mcu_fd_sc_mcu7t5v0__fillcap_16
XFILLER_241_492 VDD VSS VDD VSS gf180mcu_fd_sc_mcu7t5v0__fillcap_64
XFILLER_167_772 VDD VSS VDD VSS gf180mcu_fd_sc_mcu7t5v0__fillcap_16
XFILLER_154_411 VDD VSS VDD VSS gf180mcu_fd_sc_mcu7t5v0__fillcap_16
Xclkload18 VSS clkload18/Z _4494_/CLK VDD VDD VSS gf180mcu_fd_sc_mcu7t5v0__clkbuf_1
Xclkload29 VSS clkload29/Z _4061_/CLK VDD VDD VSS gf180mcu_fd_sc_mcu7t5v0__clkbuf_1
XFILLER_181_252 VDD VSS VDD VSS gf180mcu_fd_sc_mcu7t5v0__fillcap_4
XFILLER_150_661 VDD VSS VDD VSS gf180mcu_fd_sc_mcu7t5v0__fillcap_4
XFILLER_96_737 VDD VSS VDD VSS gf180mcu_fd_sc_mcu7t5v0__fillcap_4
XFILLER_95_203 VDD VSS VDD VSS gf180mcu_fd_sc_mcu7t5v0__fillcap_4
XFILLER_96_759 VDD VSS VDD VSS gf180mcu_fd_sc_mcu7t5v0__fillcap_32
XFILLER_95_72 VDD VSS VDD VSS gf180mcu_fd_sc_mcu7t5v0__fillcap_16
XFILLER_251_212 VDD VSS VDD VSS gf180mcu_fd_sc_mcu7t5v0__fillcap_64
XFILLER_52_807 VDD VSS VDD VSS gf180mcu_fd_sc_mcu7t5v0__fillcap_64
XFILLER_64_667 VDD VSS VDD VSS gf180mcu_fd_sc_mcu7t5v0__fillcap_64
XFILLER_91_486 VDD VSS VDD VSS gf180mcu_fd_sc_mcu7t5v0__fillcap_4
X_3921_ VDD _3921_/Q _3937_/CLK VSS _3921_/D VDD VSS gf180mcu_fd_sc_mcu7t5v0__dffq_1
XFILLER_189_352 VDD VSS VDD VSS gf180mcu_fd_sc_mcu7t5v0__fillcap_64
X_3852_ _3852_/D _3852_/Q wire196/Z VSS _4407_/CLK VDD VDD VSS gf180mcu_fd_sc_mcu7t5v0__dffrnq_1
X_2803_ _2803_/B1 _3038_/C VDD VSS _2828_/S wire58/I _2803_/A2 VDD VSS gf180mcu_fd_sc_mcu7t5v0__aoi22_1
XFILLER_32_597 VDD VSS VDD VSS gf180mcu_fd_sc_mcu7t5v0__fillcap_64
XFILLER_20_737 VDD VSS VDD VSS gf180mcu_fd_sc_mcu7t5v0__fillcap_64
XFILLER_81_2 VDD VSS VDD VSS gf180mcu_fd_sc_mcu7t5v0__fillcap_64
X_3783_ _3786_/S VDD VSS _3950_/D _3845_/I0 _3950_/Q VDD VSS gf180mcu_fd_sc_mcu7t5v0__mux2_2
X_2734_ _2736_/S VDD VSS _4268_/D _4268_/Q _4450_/Q VDD VSS gf180mcu_fd_sc_mcu7t5v0__mux2_2
XFILLER_157_282 VDD VSS VDD VSS gf180mcu_fd_sc_mcu7t5v0__fillcap_16
XFILLER_145_422 VDD VSS VDD VSS gf180mcu_fd_sc_mcu7t5v0__fillcap_16
X_2665_ _2665_/B1 _2665_/B2 VDD VSS _4230_/D _2665_/A1 _2666_/C VDD VSS gf180mcu_fd_sc_mcu7t5v0__aoi22_1
XFILLER_145_477 VDD VSS VDD VSS gf180mcu_fd_sc_mcu7t5v0__fillcap_8
XFILLER_173_764 VDD VSS VDD VSS gf180mcu_fd_sc_mcu7t5v0__fillcap_4
XFILLER_172_241 VDD VSS VDD VSS gf180mcu_fd_sc_mcu7t5v0__fillcap_4
XFILLER_133_606 VDD VSS VDD VSS gf180mcu_fd_sc_mcu7t5v0__fillcap_8
X_2596_ VDD VSS _4204_/D _2599_/A2 _2596_/A2 VDD VSS gf180mcu_fd_sc_mcu7t5v0__and2_1
X_4404_ _4404_/D _4404_/Q _4536_/RN VSS _4446_/CLK VDD VDD VSS gf180mcu_fd_sc_mcu7t5v0__dffrnq_1
X_4335_ _4335_/D _4335_/Q _4530_/RN VSS _4337_/CLK VDD VDD VSS gf180mcu_fd_sc_mcu7t5v0__dffrnq_1
XFILLER_160_447 VDD VSS VDD VSS gf180mcu_fd_sc_mcu7t5v0__fillcap_8
XFILLER_99_553 VDD VSS VDD VSS gf180mcu_fd_sc_mcu7t5v0__fillcap_4
XFILLER_113_352 VDD VSS VDD VSS gf180mcu_fd_sc_mcu7t5v0__fillcap_16
XFILLER_99_586 VDD VSS VDD VSS gf180mcu_fd_sc_mcu7t5v0__fillcap_4
X_4266_ _4266_/D _4266_/Q _4534_/RN VSS _4269_/CLK VDD VDD VSS gf180mcu_fd_sc_mcu7t5v0__dffrnq_1
XFILLER_86_247 VDD VSS VDD VSS gf180mcu_fd_sc_mcu7t5v0__fillcap_64
X_3217_ VDD VSS _4346_/D _3217_/A1 _3217_/A2 VDD VSS gf180mcu_fd_sc_mcu7t5v0__nor2_1
X_4197_ _4197_/D _4197_/Q _4535_/RN VSS _4528_/CLK VDD VDD VSS gf180mcu_fd_sc_mcu7t5v0__dffrnq_1
XFILLER_243_702 VDD VSS VDD VSS gf180mcu_fd_sc_mcu7t5v0__fillcap_64
XFILLER_255_562 VDD VSS VDD VSS gf180mcu_fd_sc_mcu7t5v0__fillcap_64
X_3148_ VDD _3169_/B _4259_/Q _3149_/B2 _2230_/B VSS VDD VSS gf180mcu_fd_sc_mcu7t5v0__oai21_1
X_3079_ VDD VSS _3084_/A2 wire94/Z _3078_/Z VDD VSS gf180mcu_fd_sc_mcu7t5v0__nor2_1
XFILLER_54_177 VDD VSS VDD VSS gf180mcu_fd_sc_mcu7t5v0__fillcap_64
XFILLER_42_317 VDD VSS VDD VSS gf180mcu_fd_sc_mcu7t5v0__fillcap_64
XFILLER_211_632 VDD VSS VDD VSS gf180mcu_fd_sc_mcu7t5v0__fillcap_8
XFILLER_196_834 VDD VSS VDD VSS gf180mcu_fd_sc_mcu7t5v0__fillcap_8
XFILLER_196_867 VDD VSS VDD VSS gf180mcu_fd_sc_mcu7t5v0__fillcap_8
XFILLER_138_6 VDD VSS VDD VSS gf180mcu_fd_sc_mcu7t5v0__fillcap_16
XFILLER_195_344 VDD VSS VDD VSS gf180mcu_fd_sc_mcu7t5v0__fillcap_4
XFILLER_149_772 VDD VSS VDD VSS gf180mcu_fd_sc_mcu7t5v0__fillcap_16
Xmax_length204 _4525_/RN VSS VDD _4371_/RN VDD VSS gf180mcu_fd_sc_mcu7t5v0__clkbuf_8
XFILLER_10_247 VDD VSS VDD VSS gf180mcu_fd_sc_mcu7t5v0__fillcap_64
XFILLER_164_731 VDD VSS VDD VSS gf180mcu_fd_sc_mcu7t5v0__fillcap_4
XFILLER_164_753 VDD VSS VDD VSS gf180mcu_fd_sc_mcu7t5v0__fillcap_8
XFILLER_151_414 VDD VSS VDD VSS gf180mcu_fd_sc_mcu7t5v0__fillcap_4
Xhold270 _4559_/D VSS _4564_/Q VDD VDD VSS gf180mcu_fd_sc_mcu7t5v0__dlyc_1
XFILLER_2_457 VDD VSS VDD VSS gf180mcu_fd_sc_mcu7t5v0__fillcap_64
XFILLER_105_842 VDD VSS VDD VSS gf180mcu_fd_sc_mcu7t5v0__fillcap_8
XFILLER_132_683 VDD VSS VDD VSS gf180mcu_fd_sc_mcu7t5v0__fillcap_4
XFILLER_78_737 VDD VSS VDD VSS gf180mcu_fd_sc_mcu7t5v0__fillcap_64
Xclkbuf_leaf_60_clk_i _4510_/CLK VSS VDD clkload2/I VDD VSS gf180mcu_fd_sc_mcu7t5v0__clkbuf_2
XFILLER_219_765 VDD VSS VDD VSS gf180mcu_fd_sc_mcu7t5v0__fillcap_4
XFILLER_233_212 VDD VSS VDD VSS gf180mcu_fd_sc_mcu7t5v0__fillcap_64
XFILLER_34_807 VDD VSS VDD VSS gf180mcu_fd_sc_mcu7t5v0__fillcap_64
XFILLER_100_591 VDD VSS VDD VSS gf180mcu_fd_sc_mcu7t5v0__fillcap_4
XFILLER_46_667 VDD VSS VDD VSS gf180mcu_fd_sc_mcu7t5v0__fillcap_64
XFILLER_234_757 VDD VSS VDD VSS gf180mcu_fd_sc_mcu7t5v0__fillcap_32
XFILLER_206_448 VDD VSS VDD VSS gf180mcu_fd_sc_mcu7t5v0__fillcap_4
XFILLER_61_626 VDD VSS VDD VSS gf180mcu_fd_sc_mcu7t5v0__fillcap_4
XFILLER_73_486 VDD VSS VDD VSS gf180mcu_fd_sc_mcu7t5v0__fillcap_4
Xclkbuf_leaf_75_clk_i _4123_/CLK VSS VDD clkbuf_3_2__f_clk_i/Z VDD VSS gf180mcu_fd_sc_mcu7t5v0__clkbuf_2
XFILLER_214_492 VDD VSS VDD VSS gf180mcu_fd_sc_mcu7t5v0__fillcap_32
XFILLER_201_142 VDD VSS VDD VSS gf180mcu_fd_sc_mcu7t5v0__fillcap_16
XFILLER_197_63 VDD VSS VDD VSS gf180mcu_fd_sc_mcu7t5v0__fillcap_4
XFILLER_14_597 VDD VSS VDD VSS gf180mcu_fd_sc_mcu7t5v0__fillcap_64
XFILLER_154_230 VDD VSS VDD VSS gf180mcu_fd_sc_mcu7t5v0__fillcap_8
XFILLER_115_617 VDD VSS VDD VSS gf180mcu_fd_sc_mcu7t5v0__fillcap_4
XFILLER_182_572 VDD VSS VDD VSS gf180mcu_fd_sc_mcu7t5v0__fillcap_4
XFILLER_142_403 VDD VSS VDD VSS gf180mcu_fd_sc_mcu7t5v0__fillcap_4
Xclkbuf_leaf_13_clk_i _4478_/CLK VSS VDD clkload1/I VDD VSS gf180mcu_fd_sc_mcu7t5v0__clkbuf_2
X_2450_ _2450_/B VDD VSS _4077_/D _3515_/A2 _2454_/S VDD VSS gf180mcu_fd_sc_mcu7t5v0__aoi21_1
XFILLER_216_37 VDD VSS VDD VSS gf180mcu_fd_sc_mcu7t5v0__fillcap_64
XFILLER_216_26 VDD VSS VDD VSS gf180mcu_fd_sc_mcu7t5v0__fillcap_8
XFILLER_123_683 VDD VSS VDD VSS gf180mcu_fd_sc_mcu7t5v0__fillcap_16
XFILLER_111_812 VDD VSS VDD VSS gf180mcu_fd_sc_mcu7t5v0__fillcap_16
X_2381_ _2383_/S VDD VSS _4023_/D _4023_/Q wire155/Z VDD VSS gf180mcu_fd_sc_mcu7t5v0__mux2_2
XFILLER_229_507 VDD VSS VDD VSS gf180mcu_fd_sc_mcu7t5v0__fillcap_4
Xclkbuf_leaf_28_clk_i _4518_/CLK VSS VDD clkload4/I VDD VSS gf180mcu_fd_sc_mcu7t5v0__clkbuf_2
XFILLER_110_333 VDD VSS VDD VSS gf180mcu_fd_sc_mcu7t5v0__fillcap_4
XFILLER_68_247 VDD VSS VDD VSS gf180mcu_fd_sc_mcu7t5v0__fillcap_64
X_4120_ VDD _4120_/Q _4122_/CLK VSS _4120_/D VDD VSS gf180mcu_fd_sc_mcu7t5v0__dffq_1
XFILLER_96_589 VDD VSS VDD VSS gf180mcu_fd_sc_mcu7t5v0__fillcap_4
X_4051_ VDD _4051_/Q _4061_/CLK VSS _4051_/D VDD VSS gf180mcu_fd_sc_mcu7t5v0__dffq_1
XFILLER_83_206 VDD VSS VDD VSS gf180mcu_fd_sc_mcu7t5v0__fillcap_4
XFILLER_237_562 VDD VSS VDD VSS gf180mcu_fd_sc_mcu7t5v0__fillcap_64
XFILLER_209_242 VDD VSS VDD VSS gf180mcu_fd_sc_mcu7t5v0__fillcap_4
X_3002_ VDD VSS _3002_/Z _2805_/B _3001_/I VDD VSS gf180mcu_fd_sc_mcu7t5v0__and2_1
Xinput5 VDD spi_mosi_i VSS input5/Z VDD VSS gf180mcu_fd_sc_mcu7t5v0__dlyb_1
XFILLER_252_521 VDD VSS VDD VSS gf180mcu_fd_sc_mcu7t5v0__fillcap_4
XFILLER_264_381 VDD VSS VDD VSS gf180mcu_fd_sc_mcu7t5v0__fillcap_4
XFILLER_36_177 VDD VSS VDD VSS gf180mcu_fd_sc_mcu7t5v0__fillcap_64
XFILLER_24_317 VDD VSS VDD VSS gf180mcu_fd_sc_mcu7t5v0__fillcap_64
XFILLER_51_136 VDD VSS VDD VSS gf180mcu_fd_sc_mcu7t5v0__fillcap_4
X_3904_ VDD _3904_/Q _4541_/CLK VSS _3904_/D VDD VSS gf180mcu_fd_sc_mcu7t5v0__dffq_1
XFILLER_205_492 VDD VSS VDD VSS gf180mcu_fd_sc_mcu7t5v0__fillcap_32
XFILLER_205_481 VDD VSS VDD VSS gf180mcu_fd_sc_mcu7t5v0__fillcap_8
XFILLER_178_823 VDD VSS VDD VSS gf180mcu_fd_sc_mcu7t5v0__fillcap_4
XFILLER_220_451 VDD VSS VDD VSS gf180mcu_fd_sc_mcu7t5v0__fillcap_4
XFILLER_193_804 VDD VSS VDD VSS gf180mcu_fd_sc_mcu7t5v0__fillcap_8
X_3835_ _3839_/S VDD VSS _3989_/D _4292_/Q _3989_/Q VDD VSS gf180mcu_fd_sc_mcu7t5v0__mux2_2
X_3766_ _3767_/S VDD VSS _3936_/D _3766_/I0 _3936_/Q VDD VSS gf180mcu_fd_sc_mcu7t5v0__mux2_2
XFILLER_146_731 VDD VSS VDD VSS gf180mcu_fd_sc_mcu7t5v0__fillcap_4
XFILLER_257_66 VDD VSS VDD VSS gf180mcu_fd_sc_mcu7t5v0__fillcap_4
X_2717_ _2728_/S _2704_/Z _4285_/Q VDD VSS _2718_/I _4253_/Q VDD VSS gf180mcu_fd_sc_mcu7t5v0__oai22_1
X_3697_ _3719_/A3 VDD VSS _3739_/A1 _4538_/Q _3707_/A1 VDD VSS gf180mcu_fd_sc_mcu7t5v0__nor3_1
XFILLER_133_414 VDD VSS VDD VSS gf180mcu_fd_sc_mcu7t5v0__fillcap_4
XFILLER_118_488 VDD VSS VDD VSS gf180mcu_fd_sc_mcu7t5v0__fillcap_8
XFILLER_10_37 VDD VSS VDD VSS gf180mcu_fd_sc_mcu7t5v0__fillcap_64
X_2648_ _2666_/B1 _4143_/Q VDD VSS _2652_/B1 _4264_/Q _2168_/Z VDD VSS gf180mcu_fd_sc_mcu7t5v0__aoi22_1
XFILLER_126_37 VDD VSS VDD VSS gf180mcu_fd_sc_mcu7t5v0__fillcap_32
X_2579_ wire27/Z VDD VSS _4198_/D wire129/I _4198_/Q VDD VSS gf180mcu_fd_sc_mcu7t5v0__mux2_2
XFILLER_102_801 VDD VSS VDD VSS gf180mcu_fd_sc_mcu7t5v0__fillcap_4
X_4318_ _4318_/D _4318_/Q _4530_/RN VSS _4337_/CLK VDD VDD VSS gf180mcu_fd_sc_mcu7t5v0__dffrnq_1
XFILLER_259_142 VDD VSS VDD VSS gf180mcu_fd_sc_mcu7t5v0__fillcap_64
X_4249_ _4249_/D _4249_/Q _4284_/RN VSS _4271_/CLK VDD VDD VSS gf180mcu_fd_sc_mcu7t5v0__dffrnq_1
XFILLER_87_556 VDD VSS VDD VSS gf180mcu_fd_sc_mcu7t5v0__fillcap_4
XFILLER_256_871 VDD VSS VDD VSS gf180mcu_fd_sc_mcu7t5v0__fillcap_4
XFILLER_16_807 VDD VSS VDD VSS gf180mcu_fd_sc_mcu7t5v0__fillcap_64
XFILLER_28_667 VDD VSS VDD VSS gf180mcu_fd_sc_mcu7t5v0__fillcap_64
XFILLER_43_626 VDD VSS VDD VSS gf180mcu_fd_sc_mcu7t5v0__fillcap_4
XFILLER_55_486 VDD VSS VDD VSS gf180mcu_fd_sc_mcu7t5v0__fillcap_4
XFILLER_168_333 VDD VSS VDD VSS gf180mcu_fd_sc_mcu7t5v0__fillcap_8
XFILLER_156_517 VDD VSS VDD VSS gf180mcu_fd_sc_mcu7t5v0__fillcap_8
XFILLER_196_675 VDD VSS VDD VSS gf180mcu_fd_sc_mcu7t5v0__fillcap_16
XFILLER_11_556 VDD VSS VDD VSS gf180mcu_fd_sc_mcu7t5v0__fillcap_4
XFILLER_137_742 VDD VSS VDD VSS gf180mcu_fd_sc_mcu7t5v0__fillcap_4
XFILLER_109_422 VDD VSS VDD VSS gf180mcu_fd_sc_mcu7t5v0__fillcap_16
XFILLER_129_2 VDD VSS VDD VSS gf180mcu_fd_sc_mcu7t5v0__fillcap_8
XFILLER_51_66 VDD VSS VDD VSS gf180mcu_fd_sc_mcu7t5v0__fillcap_4
XFILLER_124_447 VDD VSS VDD VSS gf180mcu_fd_sc_mcu7t5v0__fillcap_8
XFILLER_3_766 VDD VSS VDD VSS gf180mcu_fd_sc_mcu7t5v0__fillcap_4
XFILLER_104_182 VDD VSS VDD VSS gf180mcu_fd_sc_mcu7t5v0__fillcap_8
XFILLER_219_562 VDD VSS VDD VSS gf180mcu_fd_sc_mcu7t5v0__fillcap_16
XFILLER_65_206 VDD VSS VDD VSS gf180mcu_fd_sc_mcu7t5v0__fillcap_4
XFILLER_246_381 VDD VSS VDD VSS gf180mcu_fd_sc_mcu7t5v0__fillcap_4
XFILLER_18_177 VDD VSS VDD VSS gf180mcu_fd_sc_mcu7t5v0__fillcap_64
XFILLER_262_885 VDD VSS VDD VSS gf180mcu_fd_sc_mcu7t5v0__fillcap_4
XFILLER_33_136 VDD VSS VDD VSS gf180mcu_fd_sc_mcu7t5v0__fillcap_4
X_1950_ VDD VSS _4343_/Q _3210_/B2 VDD VSS gf180mcu_fd_sc_mcu7t5v0__clkinv_1
XFILLER_159_344 VDD VSS VDD VSS gf180mcu_fd_sc_mcu7t5v0__fillcap_4
XFILLER_187_664 VDD VSS VDD VSS gf180mcu_fd_sc_mcu7t5v0__fillcap_16
X_3620_ _3620_/B VDD VSS _4477_/D _3620_/A1 _3619_/C VDD VSS gf180mcu_fd_sc_mcu7t5v0__aoi21_1
XFILLER_190_807 VDD VSS VDD VSS gf180mcu_fd_sc_mcu7t5v0__fillcap_16
X_3551_ _4127_/Q VSS VDD _4111_/Q _4119_/Q _3586_/S _4103_/Q wire82/Z _3551_/Z VDD
+ VSS gf180mcu_fd_sc_mcu7t5v0__mux4_1
X_2502_ _2509_/S VDD VSS _4122_/D wire168/Z _4122_/Q VDD VSS gf180mcu_fd_sc_mcu7t5v0__mux2_2
X_3482_ VDD VSS _3487_/A2 _3596_/A1 _3481_/Z VDD VSS gf180mcu_fd_sc_mcu7t5v0__nand2_1
XFILLER_170_575 VDD VSS VDD VSS gf180mcu_fd_sc_mcu7t5v0__fillcap_8
XFILLER_142_255 VDD VSS VDD VSS gf180mcu_fd_sc_mcu7t5v0__fillcap_4
X_2433_ VDD VSS _2441_/S _2061_/Z _2432_/Z VDD VSS gf180mcu_fd_sc_mcu7t5v0__and2_1
XFILLER_44_2 VDD VSS VDD VSS gf180mcu_fd_sc_mcu7t5v0__fillcap_32
XFILLER_170_597 VDD VSS VDD VSS gf180mcu_fd_sc_mcu7t5v0__fillcap_16
X_2364_ VDD VSS _2365_/B _2466_/I0 wire14/Z VDD VSS gf180mcu_fd_sc_mcu7t5v0__nand2_1
XFILLER_256_101 VDD VSS VDD VSS gf180mcu_fd_sc_mcu7t5v0__fillcap_4
X_4103_ VDD _4103_/Q _4128_/CLK VSS _4103_/D VDD VSS gf180mcu_fd_sc_mcu7t5v0__dffq_1
XFILLER_69_556 VDD VSS VDD VSS gf180mcu_fd_sc_mcu7t5v0__fillcap_4
X_2295_ VDD VSS _2296_/A2 _3873_/D _3873_/Q VDD VSS gf180mcu_fd_sc_mcu7t5v0__xnor2_1
XFILLER_238_871 VDD VSS VDD VSS gf180mcu_fd_sc_mcu7t5v0__fillcap_4
XFILLER_110_185 VDD VSS VDD VSS gf180mcu_fd_sc_mcu7t5v0__fillcap_4
X_4034_ VDD _4034_/Q _4058_/CLK VSS _4034_/D VDD VSS gf180mcu_fd_sc_mcu7t5v0__dffq_1
XFILLER_253_874 VDD VSS VDD VSS gf180mcu_fd_sc_mcu7t5v0__fillcap_16
XFILLER_37_486 VDD VSS VDD VSS gf180mcu_fd_sc_mcu7t5v0__fillcap_4
XFILLER_25_626 VDD VSS VDD VSS gf180mcu_fd_sc_mcu7t5v0__fillcap_4
XFILLER_178_675 VDD VSS VDD VSS gf180mcu_fd_sc_mcu7t5v0__fillcap_4
X_3818_ _3821_/S VDD VSS _3974_/D _3845_/I0 _3974_/Q VDD VSS gf180mcu_fd_sc_mcu7t5v0__mux2_2
XFILLER_138_539 VDD VSS VDD VSS gf180mcu_fd_sc_mcu7t5v0__fillcap_16
XFILLER_193_656 VDD VSS VDD VSS gf180mcu_fd_sc_mcu7t5v0__fillcap_32
XFILLER_119_764 VDD VSS VDD VSS gf180mcu_fd_sc_mcu7t5v0__fillcap_4
X_3749_ _3758_/S VDD VSS _3922_/D _3841_/I0 _3922_/Q VDD VSS gf180mcu_fd_sc_mcu7t5v0__mux2_2
XFILLER_192_177 VDD VSS VDD VSS gf180mcu_fd_sc_mcu7t5v0__fillcap_32
XFILLER_180_317 VDD VSS VDD VSS gf180mcu_fd_sc_mcu7t5v0__fillcap_4
XFILLER_97_18 VDD VSS VDD VSS gf180mcu_fd_sc_mcu7t5v0__fillcap_32
XFILLER_102_653 VDD VSS VDD VSS gf180mcu_fd_sc_mcu7t5v0__fillcap_4
XFILLER_47_206 VDD VSS VDD VSS gf180mcu_fd_sc_mcu7t5v0__fillcap_4
Xmax_cap12 VSS _3679_/A2 _3640_/B1 VDD VDD VSS gf180mcu_fd_sc_mcu7t5v0__buf_2
XFILLER_228_381 VDD VSS VDD VSS gf180mcu_fd_sc_mcu7t5v0__fillcap_4
Xmax_cap34 _2748_/S _2754_/S VDD VSS VDD VSS gf180mcu_fd_sc_mcu7t5v0__buf_4
XFILLER_83_570 VDD VSS VDD VSS gf180mcu_fd_sc_mcu7t5v0__fillcap_4
XFILLER_244_885 VDD VSS VDD VSS gf180mcu_fd_sc_mcu7t5v0__fillcap_4
XFILLER_15_136 VDD VSS VDD VSS gf180mcu_fd_sc_mcu7t5v0__fillcap_4
XFILLER_246_2 VDD VSS VDD VSS gf180mcu_fd_sc_mcu7t5v0__fillcap_32
XFILLER_168_141 VDD VSS VDD VSS gf180mcu_fd_sc_mcu7t5v0__fillcap_32
XFILLER_178_87 VDD VSS VDD VSS gf180mcu_fd_sc_mcu7t5v0__fillcap_16
XFILLER_7_346 VDD VSS VDD VSS gf180mcu_fd_sc_mcu7t5v0__fillcap_4
XFILLER_152_597 VDD VSS VDD VSS gf180mcu_fd_sc_mcu7t5v0__fillcap_32
XFILLER_140_737 VDD VSS VDD VSS gf180mcu_fd_sc_mcu7t5v0__fillcap_8
XFILLER_238_101 VDD VSS VDD VSS gf180mcu_fd_sc_mcu7t5v0__fillcap_4
X_2080_ VDD VSS _4555_/D _4576_/D _2080_/A2 VDD VSS gf180mcu_fd_sc_mcu7t5v0__xnor2_1
XFILLER_213_38 VDD VSS VDD VSS gf180mcu_fd_sc_mcu7t5v0__fillcap_32
XFILLER_235_830 VDD VSS VDD VSS gf180mcu_fd_sc_mcu7t5v0__fillcap_8
XFILLER_235_874 VDD VSS VDD VSS gf180mcu_fd_sc_mcu7t5v0__fillcap_16
XFILLER_222_502 VDD VSS VDD VSS gf180mcu_fd_sc_mcu7t5v0__fillcap_16
XFILLER_19_486 VDD VSS VDD VSS gf180mcu_fd_sc_mcu7t5v0__fillcap_4
XFILLER_250_877 VDD VSS VDD VSS gf180mcu_fd_sc_mcu7t5v0__fillcap_8
X_2982_ _2982_/S VDD VSS _4321_/D _2321_/Z _4321_/Q VDD VSS gf180mcu_fd_sc_mcu7t5v0__mux2_2
X_1933_ VDD VSS _4302_/Q _2156_/B VDD VSS gf180mcu_fd_sc_mcu7t5v0__clkinv_1
XFILLER_194_409 VDD VSS VDD VSS gf180mcu_fd_sc_mcu7t5v0__fillcap_32
XFILLER_175_645 VDD VSS VDD VSS gf180mcu_fd_sc_mcu7t5v0__fillcap_32
X_3603_ _4065_/Q VSS VDD _4049_/Q _4057_/Q wire88/Z _4041_/Q wire83/Z _3603_/Z VDD
+ VSS gf180mcu_fd_sc_mcu7t5v0__mux4_1
X_4583_ _4583_/D _4601_/D _4613_/RN VSS _4583_/CLK VDD VDD VSS gf180mcu_fd_sc_mcu7t5v0__dffrnq_1
XFILLER_174_177 VDD VSS VDD VSS gf180mcu_fd_sc_mcu7t5v0__fillcap_64
X_3534_ _3534_/A3 VDD VSS _3535_/B wire82/Z _3534_/A2 VDD VSS gf180mcu_fd_sc_mcu7t5v0__nand3_1
XFILLER_171_884 VDD VSS VDD VSS gf180mcu_fd_sc_mcu7t5v0__fillcap_4
X_3465_ wire88/I VDD VSS _3465_/Z _4059_/Q _4051_/Q VDD VSS gf180mcu_fd_sc_mcu7t5v0__mux2_2
X_2416_ _2422_/S VDD VSS _4051_/D wire164/Z _4051_/Q VDD VSS gf180mcu_fd_sc_mcu7t5v0__mux2_2
XFILLER_130_247 VDD VSS VDD VSS gf180mcu_fd_sc_mcu7t5v0__fillcap_8
X_3396_ wire56/Z VDD VSS _4439_/D _4397_/Q _4439_/Q VDD VSS gf180mcu_fd_sc_mcu7t5v0__mux2_2
X_2347_ _2348_/A3 VDD VSS _4534_/D wire59/Z _2347_/A2 VDD VSS gf180mcu_fd_sc_mcu7t5v0__nor3_1
XFILLER_29_206 VDD VSS VDD VSS gf180mcu_fd_sc_mcu7t5v0__fillcap_4
X_2278_ VDD VSS _4521_/D _4219_/Q _2588_/A2 VDD VSS gf180mcu_fd_sc_mcu7t5v0__nor2_1
XFILLER_123_38 VDD VSS VDD VSS gf180mcu_fd_sc_mcu7t5v0__fillcap_4
X_4017_ VDD _4017_/Q _4076_/CLK VSS _4017_/D VDD VSS gf180mcu_fd_sc_mcu7t5v0__dffq_1
XFILLER_226_885 VDD VSS VDD VSS gf180mcu_fd_sc_mcu7t5v0__fillcap_4
XFILLER_213_502 VDD VSS VDD VSS gf180mcu_fd_sc_mcu7t5v0__fillcap_32
XFILLER_240_387 VDD VSS VDD VSS gf180mcu_fd_sc_mcu7t5v0__fillcap_64
XFILLER_139_804 VDD VSS VDD VSS gf180mcu_fd_sc_mcu7t5v0__fillcap_16
XFILLER_197_258 VDD VSS VDD VSS gf180mcu_fd_sc_mcu7t5v0__fillcap_16
XFILLER_154_807 VDD VSS VDD VSS gf180mcu_fd_sc_mcu7t5v0__fillcap_8
XFILLER_134_531 VDD VSS VDD VSS gf180mcu_fd_sc_mcu7t5v0__fillcap_16
XFILLER_134_597 VDD VSS VDD VSS gf180mcu_fd_sc_mcu7t5v0__fillcap_8
XFILLER_122_737 VDD VSS VDD VSS gf180mcu_fd_sc_mcu7t5v0__fillcap_16
XFILLER_196_2 VDD VSS VDD VSS gf180mcu_fd_sc_mcu7t5v0__fillcap_32
XFILLER_91_816 VDD VSS VDD VSS gf180mcu_fd_sc_mcu7t5v0__fillcap_4
XFILLER_217_874 VDD VSS VDD VSS gf180mcu_fd_sc_mcu7t5v0__fillcap_16
XFILLER_250_107 VDD VSS VDD VSS gf180mcu_fd_sc_mcu7t5v0__fillcap_64
Xclkbuf_0_host_clk_i VDD VSS clkbuf_0_host_clk_i/Z host_clk_i VDD VSS gf180mcu_fd_sc_mcu7t5v0__clkbuf_16
XFILLER_113_93 VDD VSS VDD VSS gf180mcu_fd_sc_mcu7t5v0__fillcap_4
XFILLER_232_877 VDD VSS VDD VSS gf180mcu_fd_sc_mcu7t5v0__fillcap_8
XFILLER_189_748 VDD VSS VDD VSS gf180mcu_fd_sc_mcu7t5v0__fillcap_4
XFILLER_188_247 VDD VSS VDD VSS gf180mcu_fd_sc_mcu7t5v0__fillcap_16
XFILLER_71_562 VDD VSS VDD VSS gf180mcu_fd_sc_mcu7t5v0__fillcap_64
XFILLER_129_314 VDD VSS VDD VSS gf180mcu_fd_sc_mcu7t5v0__fillcap_16
XFILLER_200_785 VDD VSS VDD VSS gf180mcu_fd_sc_mcu7t5v0__fillcap_4
XFILLER_184_475 VDD VSS VDD VSS gf180mcu_fd_sc_mcu7t5v0__fillcap_4
XFILLER_156_177 VDD VSS VDD VSS gf180mcu_fd_sc_mcu7t5v0__fillcap_4
XFILLER_156_155 VDD VSS VDD VSS gf180mcu_fd_sc_mcu7t5v0__fillcap_4
XFILLER_140_512 VDD VSS VDD VSS gf180mcu_fd_sc_mcu7t5v0__fillcap_8
X_3250_ wire23/Z VDD VSS _4358_/D _4333_/Q _4358_/Q VDD VSS gf180mcu_fd_sc_mcu7t5v0__mux2_2
XFILLER_112_247 VDD VSS VDD VSS gf180mcu_fd_sc_mcu7t5v0__fillcap_32
X_3181_ _3181_/B VDD VSS _3182_/A3 _3176_/S _3695_/A1 VDD VSS gf180mcu_fd_sc_mcu7t5v0__aoi21_1
X_2201_ VDD VSS _2347_/A2 _2201_/A1 _2205_/A2 VDD VSS gf180mcu_fd_sc_mcu7t5v0__nand2_1
XFILLER_224_37 VDD VSS VDD VSS gf180mcu_fd_sc_mcu7t5v0__fillcap_64
X_2132_ VDD VSS _2133_/A2 wire123/I _2150_/A2 VDD VSS gf180mcu_fd_sc_mcu7t5v0__nand2_1
XFILLER_254_457 VDD VSS VDD VSS gf180mcu_fd_sc_mcu7t5v0__fillcap_64
XFILLER_208_885 VDD VSS VDD VSS gf180mcu_fd_sc_mcu7t5v0__fillcap_4
X_2063_ VDD VSS _4579_/D _2061_/Z _2094_/A2 VDD VSS gf180mcu_fd_sc_mcu7t5v0__nor2_1
XFILLER_222_387 VDD VSS VDD VSS gf180mcu_fd_sc_mcu7t5v0__fillcap_64
XFILLER_210_527 VDD VSS VDD VSS gf180mcu_fd_sc_mcu7t5v0__fillcap_32
X_2965_ _2965_/S VDD VSS _4317_/D _4317_/Q _4524_/Q VDD VSS gf180mcu_fd_sc_mcu7t5v0__mux2_2
XFILLER_148_667 VDD VSS VDD VSS gf180mcu_fd_sc_mcu7t5v0__fillcap_4
X_2896_ _2896_/B VDD VSS _4304_/D _2896_/A1 _2895_/Z VDD VSS gf180mcu_fd_sc_mcu7t5v0__aoi21_1
XFILLER_187_291 VDD VSS VDD VSS gf180mcu_fd_sc_mcu7t5v0__fillcap_16
X_1916_ VDD VSS wire78/Z wire72/I VDD VSS gf180mcu_fd_sc_mcu7t5v0__clkinv_1
X_4566_ VSS _4586_/CLK VDD _4566_/D _4566_/Q wire187/Z VDD VSS gf180mcu_fd_sc_mcu7t5v0__dffsnq_1
XFILLER_162_125 VDD VSS VDD VSS gf180mcu_fd_sc_mcu7t5v0__fillcap_16
XFILLER_265_66 VDD VSS VDD VSS gf180mcu_fd_sc_mcu7t5v0__fillcap_4
X_3517_ _3517_/A3 VDD VSS _3518_/A3 wire72/Z _3517_/A2 VDD VSS gf180mcu_fd_sc_mcu7t5v0__nand3_1
XFILLER_116_575 VDD VSS VDD VSS gf180mcu_fd_sc_mcu7t5v0__fillcap_4
XFILLER_116_597 VDD VSS VDD VSS gf180mcu_fd_sc_mcu7t5v0__fillcap_16
XFILLER_104_737 VDD VSS VDD VSS gf180mcu_fd_sc_mcu7t5v0__fillcap_8
X_4497_ _4497_/D _4497_/Q wire196/I VSS clkload9/I VDD VDD VSS gf180mcu_fd_sc_mcu7t5v0__dffrnq_1
X_3448_ VDD VSS _3499_/A2 _4431_/Q _3453_/A2 VDD VSS gf180mcu_fd_sc_mcu7t5v0__nand2_1
X_3379_ wire21/Z VDD VSS _4426_/D _4418_/Q _4426_/Q VDD VSS gf180mcu_fd_sc_mcu7t5v0__mux2_2
XFILLER_232_107 VDD VSS VDD VSS gf180mcu_fd_sc_mcu7t5v0__fillcap_64
XFILLER_214_877 VDD VSS VDD VSS gf180mcu_fd_sc_mcu7t5v0__fillcap_8
XFILLER_53_562 VDD VSS VDD VSS gf180mcu_fd_sc_mcu7t5v0__fillcap_64
XFILLER_41_702 VDD VSS VDD VSS gf180mcu_fd_sc_mcu7t5v0__fillcap_64
XFILLER_241_696 VDD VSS VDD VSS gf180mcu_fd_sc_mcu7t5v0__fillcap_4
XFILLER_80_381 VDD VSS VDD VSS gf180mcu_fd_sc_mcu7t5v0__fillcap_4
XFILLER_21_492 VDD VSS VDD VSS gf180mcu_fd_sc_mcu7t5v0__fillcap_64
XFILLER_209_2 VDD VSS VDD VSS gf180mcu_fd_sc_mcu7t5v0__fillcap_64
XFILLER_153_114 VDD VSS VDD VSS gf180mcu_fd_sc_mcu7t5v0__fillcap_16
XFILLER_119_380 VDD VSS VDD VSS gf180mcu_fd_sc_mcu7t5v0__fillcap_4
XFILLER_175_55 VDD VSS VDD VSS gf180mcu_fd_sc_mcu7t5v0__fillcap_8
XFILLER_1_842 VDD VSS VDD VSS gf180mcu_fd_sc_mcu7t5v0__fillcap_32
XFILLER_108_93 VDD VSS VDD VSS gf180mcu_fd_sc_mcu7t5v0__fillcap_8
XFILLER_91_613 VDD VSS VDD VSS gf180mcu_fd_sc_mcu7t5v0__fillcap_16
XFILLER_75_142 VDD VSS VDD VSS gf180mcu_fd_sc_mcu7t5v0__fillcap_64
XFILLER_236_457 VDD VSS VDD VSS gf180mcu_fd_sc_mcu7t5v0__fillcap_8
XFILLER_90_101 VDD VSS VDD VSS gf180mcu_fd_sc_mcu7t5v0__fillcap_4
XFILLER_251_416 VDD VSS VDD VSS gf180mcu_fd_sc_mcu7t5v0__fillcap_4
XFILLER_263_276 VDD VSS VDD VSS gf180mcu_fd_sc_mcu7t5v0__fillcap_4
XFILLER_72_871 VDD VSS VDD VSS gf180mcu_fd_sc_mcu7t5v0__fillcap_4
XFILLER_31_212 VDD VSS VDD VSS gf180mcu_fd_sc_mcu7t5v0__fillcap_64
X_2750_ _2754_/S VDD VSS _4284_/D _4284_/Q _4458_/Q VDD VSS gf180mcu_fd_sc_mcu7t5v0__mux2_2
XFILLER_129_133 VDD VSS VDD VSS gf180mcu_fd_sc_mcu7t5v0__fillcap_4
XFILLER_118_807 VDD VSS VDD VSS gf180mcu_fd_sc_mcu7t5v0__fillcap_8
XFILLER_157_486 VDD VSS VDD VSS gf180mcu_fd_sc_mcu7t5v0__fillcap_4
X_2681_ _2682_/S VDD VSS _4239_/D _4312_/Q _4239_/Q VDD VSS gf180mcu_fd_sc_mcu7t5v0__mux2_2
X_4420_ _4420_/D _4420_/Q wire210/Z VSS _4462_/CLK VDD VDD VSS gf180mcu_fd_sc_mcu7t5v0__dffrnq_1
X_4351_ _4351_/D _4351_/Q wire199/I VSS _4522_/CLK VDD VDD VSS gf180mcu_fd_sc_mcu7t5v0__dffrnq_1
X_4282_ _4282_/D _4282_/Q wire207/Z VSS _4283_/CLK VDD VDD VSS gf180mcu_fd_sc_mcu7t5v0__dffrnq_1
X_3302_ _3334_/A2 _4490_/Q VDD VSS _3303_/A2 _4498_/Q _3302_/A2 VDD VSS gf180mcu_fd_sc_mcu7t5v0__aoi22_1
X_3233_ VDD VSS _3234_/B _3239_/A1 _3232_/Z VDD VSS gf180mcu_fd_sc_mcu7t5v0__and2_1
XFILLER_79_492 VDD VSS VDD VSS gf180mcu_fd_sc_mcu7t5v0__fillcap_64
XFILLER_67_632 VDD VSS VDD VSS gf180mcu_fd_sc_mcu7t5v0__fillcap_64
X_3164_ _3164_/B _3187_/C VDD VSS _3166_/B _3185_/S _3799_/A1 VDD VSS gf180mcu_fd_sc_mcu7t5v0__aoi211_1
XFILLER_94_451 VDD VSS VDD VSS gf180mcu_fd_sc_mcu7t5v0__fillcap_4
XFILLER_255_766 VDD VSS VDD VSS gf180mcu_fd_sc_mcu7t5v0__fillcap_4
X_3095_ VDD _3158_/B _3900_/Q _3096_/B2 _4551_/Q VSS VDD VSS gf180mcu_fd_sc_mcu7t5v0__oai21_1
X_2115_ _4435_/Q VDD VSS _2524_/A3 _3859_/Q _4436_/Q VDD VSS gf180mcu_fd_sc_mcu7t5v0__nand3_1
XFILLER_214_107 VDD VSS VDD VSS gf180mcu_fd_sc_mcu7t5v0__fillcap_4
X_2046_ VDD VSS _2046_/Z _3866_/D _3866_/Q VDD VSS gf180mcu_fd_sc_mcu7t5v0__and2_1
XFILLER_35_562 VDD VSS VDD VSS gf180mcu_fd_sc_mcu7t5v0__fillcap_64
XFILLER_23_702 VDD VSS VDD VSS gf180mcu_fd_sc_mcu7t5v0__fillcap_64
XFILLER_211_836 VDD VSS VDD VSS gf180mcu_fd_sc_mcu7t5v0__fillcap_4
XFILLER_195_504 VDD VSS VDD VSS gf180mcu_fd_sc_mcu7t5v0__fillcap_8
XFILLER_50_521 VDD VSS VDD VSS gf180mcu_fd_sc_mcu7t5v0__fillcap_4
XFILLER_62_381 VDD VSS VDD VSS gf180mcu_fd_sc_mcu7t5v0__fillcap_4
X_3997_ VDD _3997_/Q _3998_/CLK VSS _3997_/D VDD VSS gf180mcu_fd_sc_mcu7t5v0__dffq_1
X_2948_ VDD VSS _2963_/A2 _1926_/I _2936_/B VDD VSS gf180mcu_fd_sc_mcu7t5v0__nor2_1
XFILLER_108_317 VDD VSS VDD VSS gf180mcu_fd_sc_mcu7t5v0__fillcap_8
XFILLER_129_48 VDD VSS VDD VSS gf180mcu_fd_sc_mcu7t5v0__fillcap_8
X_2879_ VDD VSS _2880_/B _4370_/Q _4364_/Q VDD VSS gf180mcu_fd_sc_mcu7t5v0__nand2_1
XFILLER_190_253 VDD VSS VDD VSS gf180mcu_fd_sc_mcu7t5v0__fillcap_8
X_4549_ _4549_/D _4574_/D wire187/Z VSS _4553_/CLK VDD VDD VSS gf180mcu_fd_sc_mcu7t5v0__dffrnq_1
XFILLER_89_212 VDD VSS VDD VSS gf180mcu_fd_sc_mcu7t5v0__fillcap_64
XFILLER_57_142 VDD VSS VDD VSS gf180mcu_fd_sc_mcu7t5v0__fillcap_64
XFILLER_218_457 VDD VSS VDD VSS gf180mcu_fd_sc_mcu7t5v0__fillcap_16
XFILLER_72_101 VDD VSS VDD VSS gf180mcu_fd_sc_mcu7t5v0__fillcap_4
XFILLER_245_276 VDD VSS VDD VSS gf180mcu_fd_sc_mcu7t5v0__fillcap_4
XFILLER_233_416 VDD VSS VDD VSS gf180mcu_fd_sc_mcu7t5v0__fillcap_4
XFILLER_54_871 VDD VSS VDD VSS gf180mcu_fd_sc_mcu7t5v0__fillcap_4
XFILLER_159_2 VDD VSS VDD VSS gf180mcu_fd_sc_mcu7t5v0__fillcap_64
XFILLER_13_212 VDD VSS VDD VSS gf180mcu_fd_sc_mcu7t5v0__fillcap_64
XFILLER_201_324 VDD VSS VDD VSS gf180mcu_fd_sc_mcu7t5v0__fillcap_16
XFILLER_213_173 VDD VSS VDD VSS gf180mcu_fd_sc_mcu7t5v0__fillcap_16
XFILLER_186_559 VDD VSS VDD VSS gf180mcu_fd_sc_mcu7t5v0__fillcap_8
XFILLER_5_422 VDD VSS VDD VSS gf180mcu_fd_sc_mcu7t5v0__fillcap_64
Xclkload19 VSS clkload19/Z _4499_/CLK VDD VDD VSS gf180mcu_fd_sc_mcu7t5v0__clkbuf_1
XFILLER_127_648 VDD VSS VDD VSS gf180mcu_fd_sc_mcu7t5v0__fillcap_8
XFILLER_154_489 VDD VSS VDD VSS gf180mcu_fd_sc_mcu7t5v0__fillcap_16
XFILLER_181_275 VDD VSS VDD VSS gf180mcu_fd_sc_mcu7t5v0__fillcap_4
XFILLER_49_632 VDD VSS VDD VSS gf180mcu_fd_sc_mcu7t5v0__fillcap_64
XFILLER_76_451 VDD VSS VDD VSS gf180mcu_fd_sc_mcu7t5v0__fillcap_4
Xclkbuf_3_5__f_clk_i VDD VSS clkload4/I clkbuf_0_clk_i/Z VDD VSS gf180mcu_fd_sc_mcu7t5v0__clkbuf_16
X_3920_ VDD _3920_/Q _3936_/CLK VSS _3920_/D VDD VSS gf180mcu_fd_sc_mcu7t5v0__dffq_1
XFILLER_17_562 VDD VSS VDD VSS gf180mcu_fd_sc_mcu7t5v0__fillcap_64
XFILLER_32_521 VDD VSS VDD VSS gf180mcu_fd_sc_mcu7t5v0__fillcap_4
XFILLER_44_381 VDD VSS VDD VSS gf180mcu_fd_sc_mcu7t5v0__fillcap_4
XFILLER_60_885 VDD VSS VDD VSS gf180mcu_fd_sc_mcu7t5v0__fillcap_4
X_3851_ _3851_/D _3852_/D wire196/I VSS _4449_/CLK VDD VDD VSS gf180mcu_fd_sc_mcu7t5v0__dffrnq_1
X_3782_ _3786_/S VDD VSS _3949_/D _4292_/Q _3949_/Q VDD VSS gf180mcu_fd_sc_mcu7t5v0__mux2_2
X_2802_ _2802_/B _2802_/C VDD VSS _2803_/B1 _4340_/Q _2802_/A2 VDD VSS gf180mcu_fd_sc_mcu7t5v0__oai211_1
XFILLER_9_772 VDD VSS VDD VSS gf180mcu_fd_sc_mcu7t5v0__fillcap_64
X_2733_ _2736_/S VDD VSS _4267_/D _4267_/Q wire115/Z VDD VSS gf180mcu_fd_sc_mcu7t5v0__mux2_2
XFILLER_74_2 VDD VSS VDD VSS gf180mcu_fd_sc_mcu7t5v0__fillcap_32
XFILLER_118_637 VDD VSS VDD VSS gf180mcu_fd_sc_mcu7t5v0__fillcap_16
X_2664_ VSS VDD _2168_/Z _4269_/Q _4148_/Q _2666_/B1 _2664_/A2 _4233_/Q _2665_/B2
+ VDD VSS gf180mcu_fd_sc_mcu7t5v0__aoi222_1
XFILLER_117_136 VDD VSS VDD VSS gf180mcu_fd_sc_mcu7t5v0__fillcap_4
X_2595_ VDD VSS _2596_/A2 _2606_/C _2595_/A2 VDD VSS gf180mcu_fd_sc_mcu7t5v0__nor2_1
X_4403_ _4403_/D _4403_/Q wire209/Z VSS _4451_/CLK VDD VDD VSS gf180mcu_fd_sc_mcu7t5v0__dffrnq_1
X_4334_ _4334_/D _4334_/Q wire183/Z VSS _4365_/CLK VDD VDD VSS gf180mcu_fd_sc_mcu7t5v0__dffrnq_1
XFILLER_132_139 VDD VSS VDD VSS gf180mcu_fd_sc_mcu7t5v0__fillcap_16
XFILLER_259_346 VDD VSS VDD VSS gf180mcu_fd_sc_mcu7t5v0__fillcap_4
XFILLER_113_386 VDD VSS VDD VSS gf180mcu_fd_sc_mcu7t5v0__fillcap_16
XFILLER_101_537 VDD VSS VDD VSS gf180mcu_fd_sc_mcu7t5v0__fillcap_16
X_4265_ _4265_/D _4265_/Q wire193/Z VSS _4265_/CLK VDD VDD VSS gf180mcu_fd_sc_mcu7t5v0__dffrnq_1
X_4196_ _4196_/D _4196_/Q _4535_/RN VSS _4528_/CLK VDD VDD VSS gf180mcu_fd_sc_mcu7t5v0__dffrnq_1
X_3216_ _3216_/B1 _4346_/Q VDD VSS _3217_/A2 _3218_/C2 _3216_/A2 VDD VSS gf180mcu_fd_sc_mcu7t5v0__aoi22_1
XFILLER_39_142 VDD VSS VDD VSS gf180mcu_fd_sc_mcu7t5v0__fillcap_64
X_3147_ VDD VSS wire64/I _4508_/Q _4251_/Q VDD VSS gf180mcu_fd_sc_mcu7t5v0__nor2_1
XFILLER_54_101 VDD VSS VDD VSS gf180mcu_fd_sc_mcu7t5v0__fillcap_4
XFILLER_227_276 VDD VSS VDD VSS gf180mcu_fd_sc_mcu7t5v0__fillcap_4
XFILLER_215_416 VDD VSS VDD VSS gf180mcu_fd_sc_mcu7t5v0__fillcap_4
XFILLER_94_281 VDD VSS VDD VSS gf180mcu_fd_sc_mcu7t5v0__fillcap_32
X_3078_ _3995_/Q VSS VDD _3979_/Q _3987_/Q _3124_/A1 _3971_/Q _3143_/C _3078_/Z VDD
+ VSS gf180mcu_fd_sc_mcu7t5v0__mux4_1
XFILLER_36_871 VDD VSS VDD VSS gf180mcu_fd_sc_mcu7t5v0__fillcap_4
X_2029_ VDD VSS _4519_/D _2771_/A1 VDD VSS gf180mcu_fd_sc_mcu7t5v0__clkinv_1
XFILLER_51_874 VDD VSS VDD VSS gf180mcu_fd_sc_mcu7t5v0__fillcap_16
Xmax_length205 _4371_/RN wire206/Z VDD VSS VDD VSS gf180mcu_fd_sc_mcu7t5v0__buf_8
XFILLER_195_389 VDD VSS VDD VSS gf180mcu_fd_sc_mcu7t5v0__fillcap_16
XFILLER_109_626 VDD VSS VDD VSS gf180mcu_fd_sc_mcu7t5v0__fillcap_4
XFILLER_191_562 VDD VSS VDD VSS gf180mcu_fd_sc_mcu7t5v0__fillcap_64
Xhold260 _4609_/D VSS _4614_/Q VDD VDD VSS gf180mcu_fd_sc_mcu7t5v0__dlyc_1
Xhold271 _4600_/D VSS _4605_/Q VDD VDD VSS gf180mcu_fd_sc_mcu7t5v0__dlyc_1
XFILLER_132_651 VDD VSS VDD VSS gf180mcu_fd_sc_mcu7t5v0__fillcap_8
Xclkbuf_leaf_9_clk_i _4451_/CLK VSS VDD clkload3/I VDD VSS gf180mcu_fd_sc_mcu7t5v0__clkbuf_2
XFILLER_49_66 VDD VSS VDD VSS gf180mcu_fd_sc_mcu7t5v0__fillcap_4
XFILLER_58_451 VDD VSS VDD VSS gf180mcu_fd_sc_mcu7t5v0__fillcap_4
XFILLER_105_72 VDD VSS VDD VSS gf180mcu_fd_sc_mcu7t5v0__fillcap_8
XFILLER_234_714 VDD VSS VDD VSS gf180mcu_fd_sc_mcu7t5v0__fillcap_16
XFILLER_219_788 VDD VSS VDD VSS gf180mcu_fd_sc_mcu7t5v0__fillcap_4
XFILLER_14_521 VDD VSS VDD VSS gf180mcu_fd_sc_mcu7t5v0__fillcap_4
XFILLER_26_381 VDD VSS VDD VSS gf180mcu_fd_sc_mcu7t5v0__fillcap_4
XFILLER_187_835 VDD VSS VDD VSS gf180mcu_fd_sc_mcu7t5v0__fillcap_4
XFILLER_186_334 VDD VSS VDD VSS gf180mcu_fd_sc_mcu7t5v0__fillcap_16
XFILLER_42_885 VDD VSS VDD VSS gf180mcu_fd_sc_mcu7t5v0__fillcap_4
XFILLER_202_699 VDD VSS VDD VSS gf180mcu_fd_sc_mcu7t5v0__fillcap_4
XFILLER_174_507 VDD VSS VDD VSS gf180mcu_fd_sc_mcu7t5v0__fillcap_4
XFILLER_6_731 VDD VSS VDD VSS gf180mcu_fd_sc_mcu7t5v0__fillcap_4
XFILLER_155_787 VDD VSS VDD VSS gf180mcu_fd_sc_mcu7t5v0__fillcap_32
XFILLER_154_286 VDD VSS VDD VSS gf180mcu_fd_sc_mcu7t5v0__fillcap_16
X_2380_ _2383_/S VDD VSS _4022_/D _4022_/Q wire157/Z VDD VSS gf180mcu_fd_sc_mcu7t5v0__mux2_2
X_4050_ VDD _4050_/Q _4058_/CLK VSS _4050_/D VDD VSS gf180mcu_fd_sc_mcu7t5v0__dffq_1
X_3001_ VDD VSS _3001_/I _3017_/A2 VDD VSS gf180mcu_fd_sc_mcu7t5v0__clkinv_1
XFILLER_232_37 VDD VSS VDD VSS gf180mcu_fd_sc_mcu7t5v0__fillcap_64
XFILLER_36_101 VDD VSS VDD VSS gf180mcu_fd_sc_mcu7t5v0__fillcap_4
XFILLER_92_752 VDD VSS VDD VSS gf180mcu_fd_sc_mcu7t5v0__fillcap_4
XFILLER_209_298 VDD VSS VDD VSS gf180mcu_fd_sc_mcu7t5v0__fillcap_8
XFILLER_18_871 VDD VSS VDD VSS gf180mcu_fd_sc_mcu7t5v0__fillcap_4
X_3903_ VDD _3903_/Q _3937_/CLK VSS _3903_/D VDD VSS gf180mcu_fd_sc_mcu7t5v0__dffq_1
XFILLER_189_150 VDD VSS VDD VSS gf180mcu_fd_sc_mcu7t5v0__fillcap_4
XFILLER_33_874 VDD VSS VDD VSS gf180mcu_fd_sc_mcu7t5v0__fillcap_16
X_3834_ _3839_/S VDD VSS _3988_/D wire177/Z _3988_/Q VDD VSS gf180mcu_fd_sc_mcu7t5v0__mux2_2
XFILLER_189_183 VDD VSS VDD VSS gf180mcu_fd_sc_mcu7t5v0__fillcap_16
X_3765_ _3767_/S VDD VSS _3935_/D _3765_/I0 _3935_/Q VDD VSS gf180mcu_fd_sc_mcu7t5v0__mux2_2
X_3696_ _3696_/S VDD VSS _3881_/D _3881_/Q _4296_/Q VDD VSS gf180mcu_fd_sc_mcu7t5v0__mux2_2
X_2716_ VDD VSS _2716_/I _4252_/D VDD VSS gf180mcu_fd_sc_mcu7t5v0__clkinv_1
XFILLER_173_562 VDD VSS VDD VSS gf180mcu_fd_sc_mcu7t5v0__fillcap_64
X_2647_ _2644_/Z _2647_/B2 VDD VSS _4224_/D _3066_/A2 _2666_/C VDD VSS gf180mcu_fd_sc_mcu7t5v0__aoi22_1
XFILLER_161_702 VDD VSS VDD VSS gf180mcu_fd_sc_mcu7t5v0__fillcap_4
XFILLER_146_798 VDD VSS VDD VSS gf180mcu_fd_sc_mcu7t5v0__fillcap_4
XFILLER_160_278 VDD VSS VDD VSS gf180mcu_fd_sc_mcu7t5v0__fillcap_32
X_2578_ wire27/Z VDD VSS _4197_/D wire132/Z _4197_/Q VDD VSS gf180mcu_fd_sc_mcu7t5v0__mux2_2
X_4317_ _4317_/D _4317_/Q _4525_/RN VSS _4365_/CLK VDD VDD VSS gf180mcu_fd_sc_mcu7t5v0__dffrnq_1
XFILLER_141_492 VDD VSS VDD VSS gf180mcu_fd_sc_mcu7t5v0__fillcap_16
X_4248_ _4248_/D _4248_/Q _4284_/RN VSS _4283_/CLK VDD VDD VSS gf180mcu_fd_sc_mcu7t5v0__dffrnq_1
XFILLER_142_37 VDD VSS VDD VSS gf180mcu_fd_sc_mcu7t5v0__fillcap_4
X_4179_ _4179_/D _4179_/Q wire209/Z VSS _4485_/CLK VDD VDD VSS gf180mcu_fd_sc_mcu7t5v0__dffrnq_1
XFILLER_70_457 VDD VSS VDD VSS gf180mcu_fd_sc_mcu7t5v0__fillcap_64
XFILLER_24_885 VDD VSS VDD VSS gf180mcu_fd_sc_mcu7t5v0__fillcap_4
XFILLER_195_142 VDD VSS VDD VSS gf180mcu_fd_sc_mcu7t5v0__fillcap_4
XFILLER_167_34 VDD VSS VDD VSS gf180mcu_fd_sc_mcu7t5v0__fillcap_16
XFILLER_136_231 VDD VSS VDD VSS gf180mcu_fd_sc_mcu7t5v0__fillcap_8
XFILLER_151_212 VDD VSS VDD VSS gf180mcu_fd_sc_mcu7t5v0__fillcap_8
XFILLER_136_297 VDD VSS VDD VSS gf180mcu_fd_sc_mcu7t5v0__fillcap_16
XFILLER_183_66 VDD VSS VDD VSS gf180mcu_fd_sc_mcu7t5v0__fillcap_4
XFILLER_151_267 VDD VSS VDD VSS gf180mcu_fd_sc_mcu7t5v0__fillcap_8
XFILLER_4_2 VDD VSS VDD VSS gf180mcu_fd_sc_mcu7t5v0__fillcap_32
XFILLER_86_590 VDD VSS VDD VSS gf180mcu_fd_sc_mcu7t5v0__fillcap_4
XFILLER_93_549 VDD VSS VDD VSS gf180mcu_fd_sc_mcu7t5v0__fillcap_8
XFILLER_18_101 VDD VSS VDD VSS gf180mcu_fd_sc_mcu7t5v0__fillcap_4
XFILLER_261_352 VDD VSS VDD VSS gf180mcu_fd_sc_mcu7t5v0__fillcap_64
XFILLER_215_780 VDD VSS VDD VSS gf180mcu_fd_sc_mcu7t5v0__fillcap_16
XFILLER_187_632 VDD VSS VDD VSS gf180mcu_fd_sc_mcu7t5v0__fillcap_32
XFILLER_199_492 VDD VSS VDD VSS gf180mcu_fd_sc_mcu7t5v0__fillcap_32
XFILLER_15_874 VDD VSS VDD VSS gf180mcu_fd_sc_mcu7t5v0__fillcap_16
XFILLER_30_877 VDD VSS VDD VSS gf180mcu_fd_sc_mcu7t5v0__fillcap_8
X_3550_ VDD VSS _3571_/A2 _3550_/A1 _3550_/A2 VDD VSS gf180mcu_fd_sc_mcu7t5v0__nand2_1
XFILLER_155_562 VDD VSS VDD VSS gf180mcu_fd_sc_mcu7t5v0__fillcap_8
XFILLER_143_702 VDD VSS VDD VSS gf180mcu_fd_sc_mcu7t5v0__fillcap_16
X_2501_ VDD VSS _2509_/S _2501_/A1 _2501_/A2 VDD VSS gf180mcu_fd_sc_mcu7t5v0__nand2_1
XFILLER_170_543 VDD VSS VDD VSS gf180mcu_fd_sc_mcu7t5v0__fillcap_8
X_3481_ _4124_/Q VSS VDD _4108_/Q _4116_/Q wire88/Z _4100_/Q wire83/Z _3481_/Z VDD
+ VSS gf180mcu_fd_sc_mcu7t5v0__mux4_1
X_2432_ VDD VSS _2432_/Z _4580_/Q _2432_/A2 VDD VSS gf180mcu_fd_sc_mcu7t5v0__and2_1
XFILLER_130_429 VDD VSS VDD VSS gf180mcu_fd_sc_mcu7t5v0__fillcap_16
X_2363_ VDD _2363_/B wire14/Z _4010_/D _3431_/A2 VSS VDD VSS gf180mcu_fd_sc_mcu7t5v0__oai21_1
X_4102_ VDD _4102_/Q _4122_/CLK VSS _4102_/D VDD VSS gf180mcu_fd_sc_mcu7t5v0__dffq_1
XFILLER_123_492 VDD VSS VDD VSS gf180mcu_fd_sc_mcu7t5v0__fillcap_4
XFILLER_111_632 VDD VSS VDD VSS gf180mcu_fd_sc_mcu7t5v0__fillcap_16
XFILLER_96_387 VDD VSS VDD VSS gf180mcu_fd_sc_mcu7t5v0__fillcap_64
X_2294_ VDD VSS _2297_/B _4468_/Q wire36/Z VDD VSS gf180mcu_fd_sc_mcu7t5v0__nand2_1
X_4033_ VDD _4033_/Q _4033_/CLK VSS _4033_/D VDD VSS gf180mcu_fd_sc_mcu7t5v0__dffq_1
XFILLER_253_842 VDD VSS VDD VSS gf180mcu_fd_sc_mcu7t5v0__fillcap_32
XFILLER_112_18 VDD VSS VDD VSS gf180mcu_fd_sc_mcu7t5v0__fillcap_8
XFILLER_52_457 VDD VSS VDD VSS gf180mcu_fd_sc_mcu7t5v0__fillcap_64
XFILLER_80_777 VDD VSS VDD VSS gf180mcu_fd_sc_mcu7t5v0__fillcap_16
XFILLER_221_772 VDD VSS VDD VSS gf180mcu_fd_sc_mcu7t5v0__fillcap_64
XFILLER_177_142 VDD VSS VDD VSS gf180mcu_fd_sc_mcu7t5v0__fillcap_8
X_3817_ _3821_/S VDD VSS _3973_/D _4292_/Q _3973_/Q VDD VSS gf180mcu_fd_sc_mcu7t5v0__mux2_2
XFILLER_20_387 VDD VSS VDD VSS gf180mcu_fd_sc_mcu7t5v0__fillcap_64
X_3748_ VDD VSS _3758_/S _3707_/Z _3759_/A2 VDD VSS gf180mcu_fd_sc_mcu7t5v0__nand2_1
XFILLER_133_212 VDD VSS VDD VSS gf180mcu_fd_sc_mcu7t5v0__fillcap_16
X_3679_ VDD VSS _3681_/A2 _4192_/Q _3679_/A2 VDD VSS gf180mcu_fd_sc_mcu7t5v0__nand2_1
XFILLER_161_576 VDD VSS VDD VSS gf180mcu_fd_sc_mcu7t5v0__fillcap_32
Xclkbuf_leaf_74_clk_i _4065_/CLK VSS VDD clkbuf_3_2__f_clk_i/Z VDD VSS gf180mcu_fd_sc_mcu7t5v0__clkbuf_2
XFILLER_121_429 VDD VSS VDD VSS gf180mcu_fd_sc_mcu7t5v0__fillcap_8
XFILLER_88_877 VDD VSS VDD VSS gf180mcu_fd_sc_mcu7t5v0__fillcap_8
XFILLER_198_6 VDD VSS VDD VSS gf180mcu_fd_sc_mcu7t5v0__fillcap_16
Xclkbuf_leaf_89_clk_i _4171_/CLK VSS VDD clkload1/I VDD VSS gf180mcu_fd_sc_mcu7t5v0__clkbuf_2
XFILLER_101_142 VDD VSS VDD VSS gf180mcu_fd_sc_mcu7t5v0__fillcap_8
XFILLER_102_676 VDD VSS VDD VSS gf180mcu_fd_sc_mcu7t5v0__fillcap_8
XFILLER_216_533 VDD VSS VDD VSS gf180mcu_fd_sc_mcu7t5v0__fillcap_8
Xmax_cap35 _2754_/S wire36/Z VDD VSS VDD VSS gf180mcu_fd_sc_mcu7t5v0__buf_4
XFILLER_243_352 VDD VSS VDD VSS gf180mcu_fd_sc_mcu7t5v0__fillcap_64
Xclkbuf_leaf_12_clk_i _4498_/CLK VSS VDD clkload1/I VDD VSS gf180mcu_fd_sc_mcu7t5v0__clkbuf_2
XFILLER_216_588 VDD VSS VDD VSS gf180mcu_fd_sc_mcu7t5v0__fillcap_4
XFILLER_188_407 VDD VSS VDD VSS gf180mcu_fd_sc_mcu7t5v0__fillcap_4
XFILLER_71_766 VDD VSS VDD VSS gf180mcu_fd_sc_mcu7t5v0__fillcap_4
XFILLER_169_632 VDD VSS VDD VSS gf180mcu_fd_sc_mcu7t5v0__fillcap_16
XFILLER_62_22 VDD VSS VDD VSS gf180mcu_fd_sc_mcu7t5v0__fillcap_8
XFILLER_30_107 VDD VSS VDD VSS gf180mcu_fd_sc_mcu7t5v0__fillcap_64
XFILLER_239_2 VDD VSS VDD VSS gf180mcu_fd_sc_mcu7t5v0__fillcap_64
XFILLER_178_55 VDD VSS VDD VSS gf180mcu_fd_sc_mcu7t5v0__fillcap_32
XFILLER_141_2 VDD VSS VDD VSS gf180mcu_fd_sc_mcu7t5v0__fillcap_32
XFILLER_196_473 VDD VSS VDD VSS gf180mcu_fd_sc_mcu7t5v0__fillcap_4
XFILLER_211_282 VDD VSS VDD VSS gf180mcu_fd_sc_mcu7t5v0__fillcap_64
Xclkbuf_leaf_27_clk_i _4283_/CLK VSS VDD clkload3/I VDD VSS gf180mcu_fd_sc_mcu7t5v0__clkbuf_2
XFILLER_12_877 VDD VSS VDD VSS gf180mcu_fd_sc_mcu7t5v0__fillcap_8
Xwire212 wire212/Z VSS VDD wire213/Z VDD VSS gf180mcu_fd_sc_mcu7t5v0__clkbuf_8
XFILLER_109_220 VDD VSS VDD VSS gf180mcu_fd_sc_mcu7t5v0__fillcap_4
XFILLER_137_562 VDD VSS VDD VSS gf180mcu_fd_sc_mcu7t5v0__fillcap_64
XFILLER_125_702 VDD VSS VDD VSS gf180mcu_fd_sc_mcu7t5v0__fillcap_8
XFILLER_152_521 VDD VSS VDD VSS gf180mcu_fd_sc_mcu7t5v0__fillcap_4
XFILLER_180_863 VDD VSS VDD VSS gf180mcu_fd_sc_mcu7t5v0__fillcap_8
XFILLER_180_885 VDD VSS VDD VSS gf180mcu_fd_sc_mcu7t5v0__fillcap_4
XFILLER_78_387 VDD VSS VDD VSS gf180mcu_fd_sc_mcu7t5v0__fillcap_64
XFILLER_66_527 VDD VSS VDD VSS gf180mcu_fd_sc_mcu7t5v0__fillcap_64
XFILLER_235_842 VDD VSS VDD VSS gf180mcu_fd_sc_mcu7t5v0__fillcap_32
XFILLER_81_508 VDD VSS VDD VSS gf180mcu_fd_sc_mcu7t5v0__fillcap_8
XFILLER_250_801 VDD VSS VDD VSS gf180mcu_fd_sc_mcu7t5v0__fillcap_4
XFILLER_262_661 VDD VSS VDD VSS gf180mcu_fd_sc_mcu7t5v0__fillcap_4
XFILLER_34_457 VDD VSS VDD VSS gf180mcu_fd_sc_mcu7t5v0__fillcap_64
XFILLER_203_750 VDD VSS VDD VSS gf180mcu_fd_sc_mcu7t5v0__fillcap_8
X_2981_ _2981_/S VDD VSS _4320_/D _4328_/Q _4320_/Q VDD VSS gf180mcu_fd_sc_mcu7t5v0__mux2_2
XFILLER_61_276 VDD VSS VDD VSS gf180mcu_fd_sc_mcu7t5v0__fillcap_4
XFILLER_203_772 VDD VSS VDD VSS gf180mcu_fd_sc_mcu7t5v0__fillcap_8
XFILLER_187_462 VDD VSS VDD VSS gf180mcu_fd_sc_mcu7t5v0__fillcap_16
X_1932_ VDD VSS _4304_/Q _2158_/A1 VDD VSS gf180mcu_fd_sc_mcu7t5v0__clkinv_1
XFILLER_159_142 VDD VSS VDD VSS gf180mcu_fd_sc_mcu7t5v0__fillcap_16
XFILLER_174_123 VDD VSS VDD VSS gf180mcu_fd_sc_mcu7t5v0__fillcap_4
X_3602_ _3602_/A3 VDD VSS _3611_/A2 wire72/Z _3602_/A2 VDD VSS gf180mcu_fd_sc_mcu7t5v0__nand3_1
X_4582_ _4582_/D _4605_/D _4616_/RN VSS _4614_/CLK VDD VDD VSS gf180mcu_fd_sc_mcu7t5v0__dffrnq_1
XFILLER_162_307 VDD VSS VDD VSS gf180mcu_fd_sc_mcu7t5v0__fillcap_8
XFILLER_115_212 VDD VSS VDD VSS gf180mcu_fd_sc_mcu7t5v0__fillcap_16
XFILLER_115_201 VDD VSS VDD VSS gf180mcu_fd_sc_mcu7t5v0__fillcap_8
X_3533_ VDD VSS _3534_/A3 _3586_/S _4070_/Q VDD VSS gf180mcu_fd_sc_mcu7t5v0__nand2_1
X_3464_ _3464_/A3 VDD VSS _3474_/A2 wire72/Z _3464_/A2 VDD VSS gf180mcu_fd_sc_mcu7t5v0__nand3_1
XFILLER_131_716 VDD VSS VDD VSS gf180mcu_fd_sc_mcu7t5v0__fillcap_4
XFILLER_88_107 VDD VSS VDD VSS gf180mcu_fd_sc_mcu7t5v0__fillcap_64
X_2415_ _2422_/S VDD VSS _4050_/D wire167/Z _4050_/Q VDD VSS gf180mcu_fd_sc_mcu7t5v0__mux2_2
XFILLER_257_422 VDD VSS VDD VSS gf180mcu_fd_sc_mcu7t5v0__fillcap_64
X_3395_ _3425_/S VDD VSS _4438_/D _4396_/Q _3395_/I1 VDD VSS gf180mcu_fd_sc_mcu7t5v0__mux2_2
X_2346_ _2780_/B _3035_/B VDD VSS _4527_/D _2346_/A1 _3007_/A1 VDD VSS gf180mcu_fd_sc_mcu7t5v0__nor4_1
XFILLER_97_685 VDD VSS VDD VSS gf180mcu_fd_sc_mcu7t5v0__fillcap_8
X_2277_ _4217_/Q _4218_/Q VDD VSS _2588_/A2 _4216_/Q _2277_/A2 VDD VSS gf180mcu_fd_sc_mcu7t5v0__aoi211_1
X_4016_ VDD _4016_/Q _4583_/CLK VSS _4016_/D VDD VSS gf180mcu_fd_sc_mcu7t5v0__dffq_1
XFILLER_226_864 VDD VSS VDD VSS gf180mcu_fd_sc_mcu7t5v0__fillcap_8
XFILLER_225_352 VDD VSS VDD VSS gf180mcu_fd_sc_mcu7t5v0__fillcap_64
XFILLER_203_72 VDD VSS VDD VSS gf180mcu_fd_sc_mcu7t5v0__fillcap_64
XFILLER_240_311 VDD VSS VDD VSS gf180mcu_fd_sc_mcu7t5v0__fillcap_4
XFILLER_252_171 VDD VSS VDD VSS gf180mcu_fd_sc_mcu7t5v0__fillcap_4
XFILLER_53_766 VDD VSS VDD VSS gf180mcu_fd_sc_mcu7t5v0__fillcap_4
XFILLER_16_37 VDD VSS VDD VSS gf180mcu_fd_sc_mcu7t5v0__fillcap_64
XFILLER_197_226 VDD VSS VDD VSS gf180mcu_fd_sc_mcu7t5v0__fillcap_32
XFILLER_12_107 VDD VSS VDD VSS gf180mcu_fd_sc_mcu7t5v0__fillcap_64
Xclkbuf_4_10_0_host_clk_i _3989_/CLK VSS VDD clkbuf_0_host_clk_i/Z VDD VSS gf180mcu_fd_sc_mcu7t5v0__clkbuf_2
XFILLER_21_696 VDD VSS VDD VSS gf180mcu_fd_sc_mcu7t5v0__fillcap_4
XFILLER_119_562 VDD VSS VDD VSS gf180mcu_fd_sc_mcu7t5v0__fillcap_16
XFILLER_107_702 VDD VSS VDD VSS gf180mcu_fd_sc_mcu7t5v0__fillcap_4
XFILLER_113_6 VDD VSS VDD VSS gf180mcu_fd_sc_mcu7t5v0__fillcap_8
XFILLER_4_317 VDD VSS VDD VSS gf180mcu_fd_sc_mcu7t5v0__fillcap_64
XFILLER_162_885 VDD VSS VDD VSS gf180mcu_fd_sc_mcu7t5v0__fillcap_4
XFILLER_121_204 VDD VSS VDD VSS gf180mcu_fd_sc_mcu7t5v0__fillcap_4
XFILLER_0_512 VDD VSS VDD VSS gf180mcu_fd_sc_mcu7t5v0__fillcap_32
XFILLER_48_527 VDD VSS VDD VSS gf180mcu_fd_sc_mcu7t5v0__fillcap_64
XFILLER_75_346 VDD VSS VDD VSS gf180mcu_fd_sc_mcu7t5v0__fillcap_4
XFILLER_57_66 VDD VSS VDD VSS gf180mcu_fd_sc_mcu7t5v0__fillcap_4
XFILLER_217_831 VDD VSS VDD VSS gf180mcu_fd_sc_mcu7t5v0__fillcap_8
XFILLER_217_842 VDD VSS VDD VSS gf180mcu_fd_sc_mcu7t5v0__fillcap_32
XFILLER_244_661 VDD VSS VDD VSS gf180mcu_fd_sc_mcu7t5v0__fillcap_4
XFILLER_113_72 VDD VSS VDD VSS gf180mcu_fd_sc_mcu7t5v0__fillcap_4
XFILLER_16_457 VDD VSS VDD VSS gf180mcu_fd_sc_mcu7t5v0__fillcap_64
XFILLER_31_416 VDD VSS VDD VSS gf180mcu_fd_sc_mcu7t5v0__fillcap_4
XFILLER_43_276 VDD VSS VDD VSS gf180mcu_fd_sc_mcu7t5v0__fillcap_4
XFILLER_212_591 VDD VSS VDD VSS gf180mcu_fd_sc_mcu7t5v0__fillcap_4
XFILLER_197_782 VDD VSS VDD VSS gf180mcu_fd_sc_mcu7t5v0__fillcap_16
XFILLER_156_101 VDD VSS VDD VSS gf180mcu_fd_sc_mcu7t5v0__fillcap_4
XFILLER_8_667 VDD VSS VDD VSS gf180mcu_fd_sc_mcu7t5v0__fillcap_64
XFILLER_153_885 VDD VSS VDD VSS gf180mcu_fd_sc_mcu7t5v0__fillcap_4
X_2200_ _2200_/A3 _2205_/A2 VDD VSS _2348_/A2 _2675_/A1 _2677_/A1 VDD VSS gf180mcu_fd_sc_mcu7t5v0__nand4_1
XFILLER_239_422 VDD VSS VDD VSS gf180mcu_fd_sc_mcu7t5v0__fillcap_64
X_3180_ VDD _3180_/B _3888_/Q _3181_/B _2846_/S VSS VDD VSS gf180mcu_fd_sc_mcu7t5v0__oai21_1
XFILLER_266_241 VDD VSS VDD VSS gf180mcu_fd_sc_mcu7t5v0__fillcap_4
X_2131_ VDD VSS _2131_/I _4134_/D VDD VSS gf180mcu_fd_sc_mcu7t5v0__clkinv_1
XFILLER_120_270 VDD VSS VDD VSS gf180mcu_fd_sc_mcu7t5v0__fillcap_4
XFILLER_79_696 VDD VSS VDD VSS gf180mcu_fd_sc_mcu7t5v0__fillcap_4
XFILLER_67_836 VDD VSS VDD VSS gf180mcu_fd_sc_mcu7t5v0__fillcap_4
X_2062_ _4579_/Q VDD VSS _2094_/A2 _4578_/Q _2084_/A2 VDD VSS gf180mcu_fd_sc_mcu7t5v0__aoi21_1
XFILLER_207_352 VDD VSS VDD VSS gf180mcu_fd_sc_mcu7t5v0__fillcap_16
XFILLER_240_37 VDD VSS VDD VSS gf180mcu_fd_sc_mcu7t5v0__fillcap_64
XFILLER_240_26 VDD VSS VDD VSS gf180mcu_fd_sc_mcu7t5v0__fillcap_8
XFILLER_222_311 VDD VSS VDD VSS gf180mcu_fd_sc_mcu7t5v0__fillcap_4
XFILLER_234_171 VDD VSS VDD VSS gf180mcu_fd_sc_mcu7t5v0__fillcap_4
XFILLER_35_766 VDD VSS VDD VSS gf180mcu_fd_sc_mcu7t5v0__fillcap_4
X_2964_ _2964_/A3 VDD VSS _2965_/S _3200_/A1 _3200_/A2 VDD VSS gf180mcu_fd_sc_mcu7t5v0__nor3_1
X_1915_ VDD VSS _4593_/Q wire74/I VDD VSS gf180mcu_fd_sc_mcu7t5v0__clkinv_1
XFILLER_175_443 VDD VSS VDD VSS gf180mcu_fd_sc_mcu7t5v0__fillcap_4
X_2895_ _2321_/Z _2895_/A4 VDD VSS _2895_/Z _4330_/Q _3039_/A1 VDD VSS gf180mcu_fd_sc_mcu7t5v0__or4_1
X_4565_ _4565_/D _4565_/Q wire187/Z VSS _4565_/CLK VDD VDD VSS gf180mcu_fd_sc_mcu7t5v0__dffrnq_1
XFILLER_118_28 VDD VSS VDD VSS gf180mcu_fd_sc_mcu7t5v0__fillcap_4
XFILLER_116_521 VDD VSS VDD VSS gf180mcu_fd_sc_mcu7t5v0__fillcap_4
X_3516_ _3516_/B _3609_/C VDD VSS _3517_/A3 _3515_/C _3513_/Z VDD VSS gf180mcu_fd_sc_mcu7t5v0__oai211_1
XFILLER_116_543 VDD VSS VDD VSS gf180mcu_fd_sc_mcu7t5v0__fillcap_32
XFILLER_144_885 VDD VSS VDD VSS gf180mcu_fd_sc_mcu7t5v0__fillcap_4
XFILLER_89_416 VDD VSS VDD VSS gf180mcu_fd_sc_mcu7t5v0__fillcap_4
XFILLER_131_524 VDD VSS VDD VSS gf180mcu_fd_sc_mcu7t5v0__fillcap_16
X_4496_ _4496_/D _4496_/Q wire209/Z VSS _4496_/CLK VDD VDD VSS gf180mcu_fd_sc_mcu7t5v0__dffrnq_1
X_3447_ VDD VSS _3633_/C1 _3447_/A1 _3637_/A3 VDD VSS gf180mcu_fd_sc_mcu7t5v0__nor2_1
XFILLER_258_731 VDD VSS VDD VSS gf180mcu_fd_sc_mcu7t5v0__fillcap_4
X_3378_ wire20/Z VDD VSS _4425_/D _4417_/Q _4425_/Q VDD VSS gf180mcu_fd_sc_mcu7t5v0__mux2_2
X_2329_ wire143/Z VDD VSS _2926_/A4 _4333_/Q _4334_/Q VDD VSS gf180mcu_fd_sc_mcu7t5v0__nand3_1
XFILLER_57_346 VDD VSS VDD VSS gf180mcu_fd_sc_mcu7t5v0__fillcap_4
XFILLER_214_801 VDD VSS VDD VSS gf180mcu_fd_sc_mcu7t5v0__fillcap_4
XFILLER_233_609 VDD VSS VDD VSS gf180mcu_fd_sc_mcu7t5v0__fillcap_4
XFILLER_226_661 VDD VSS VDD VSS gf180mcu_fd_sc_mcu7t5v0__fillcap_4
XFILLER_150_37 VDD VSS VDD VSS gf180mcu_fd_sc_mcu7t5v0__fillcap_16
XFILLER_85_688 VDD VSS VDD VSS gf180mcu_fd_sc_mcu7t5v0__fillcap_8
XFILLER_198_535 VDD VSS VDD VSS gf180mcu_fd_sc_mcu7t5v0__fillcap_4
XFILLER_13_416 VDD VSS VDD VSS gf180mcu_fd_sc_mcu7t5v0__fillcap_4
XFILLER_25_276 VDD VSS VDD VSS gf180mcu_fd_sc_mcu7t5v0__fillcap_4
XFILLER_166_432 VDD VSS VDD VSS gf180mcu_fd_sc_mcu7t5v0__fillcap_8
XFILLER_5_626 VDD VSS VDD VSS gf180mcu_fd_sc_mcu7t5v0__fillcap_4
XFILLER_104_2 VDD VSS VDD VSS gf180mcu_fd_sc_mcu7t5v0__fillcap_32
XFILLER_150_877 VDD VSS VDD VSS gf180mcu_fd_sc_mcu7t5v0__fillcap_8
XFILLER_0_342 VDD VSS VDD VSS gf180mcu_fd_sc_mcu7t5v0__fillcap_32
XFILLER_248_241 VDD VSS VDD VSS gf180mcu_fd_sc_mcu7t5v0__fillcap_4
XFILLER_191_66 VDD VSS VDD VSS gf180mcu_fd_sc_mcu7t5v0__fillcap_4
XFILLER_49_836 VDD VSS VDD VSS gf180mcu_fd_sc_mcu7t5v0__fillcap_4
XFILLER_17_766 VDD VSS VDD VSS gf180mcu_fd_sc_mcu7t5v0__fillcap_4
XFILLER_232_675 VDD VSS VDD VSS gf180mcu_fd_sc_mcu7t5v0__fillcap_4
XFILLER_200_550 VDD VSS VDD VSS gf180mcu_fd_sc_mcu7t5v0__fillcap_8
X_2680_ _2682_/S VDD VSS _4238_/D _4311_/Q _4238_/Q VDD VSS gf180mcu_fd_sc_mcu7t5v0__mux2_2
XFILLER_172_413 VDD VSS VDD VSS gf180mcu_fd_sc_mcu7t5v0__fillcap_4
XFILLER_172_457 VDD VSS VDD VSS gf180mcu_fd_sc_mcu7t5v0__fillcap_64
X_4350_ _4350_/D _4350_/Q wire199/I VSS _4523_/CLK VDD VDD VSS gf180mcu_fd_sc_mcu7t5v0__dffrnq_1
XFILLER_98_213 VDD VSS VDD VSS gf180mcu_fd_sc_mcu7t5v0__fillcap_32
X_3301_ _3278_/Z _4482_/Q VDD VSS _3303_/A1 _4474_/Q _2280_/I VDD VSS gf180mcu_fd_sc_mcu7t5v0__aoi22_1
XFILLER_126_885 VDD VSS VDD VSS gf180mcu_fd_sc_mcu7t5v0__fillcap_4
X_4281_ _4281_/D _4281_/Q wire207/Z VSS _4467_/CLK VDD VDD VSS gf180mcu_fd_sc_mcu7t5v0__dffrnq_1
XFILLER_113_546 VDD VSS VDD VSS gf180mcu_fd_sc_mcu7t5v0__fillcap_8
XFILLER_99_758 VDD VSS VDD VSS gf180mcu_fd_sc_mcu7t5v0__fillcap_8
X_3232_ VDD VSS _3232_/Z _2865_/C _2993_/Z VDD VSS gf180mcu_fd_sc_mcu7t5v0__or2_1
XFILLER_140_354 VDD VSS VDD VSS gf180mcu_fd_sc_mcu7t5v0__fillcap_16
XFILLER_140_387 VDD VSS VDD VSS gf180mcu_fd_sc_mcu7t5v0__fillcap_64
X_3163_ VDD VSS _3164_/B _3185_/S _3967_/Q VDD VSS gf180mcu_fd_sc_mcu7t5v0__nor2_1
X_2114_ VDD VSS _4550_/D _4576_/D _2114_/A2 VDD VSS gf180mcu_fd_sc_mcu7t5v0__xnor2_1
XFILLER_39_346 VDD VSS VDD VSS gf180mcu_fd_sc_mcu7t5v0__fillcap_4
X_3094_ VDD VSS _3096_/B1 _3157_/A1 _3892_/Q VDD VSS gf180mcu_fd_sc_mcu7t5v0__nor2_1
XFILLER_215_609 VDD VSS VDD VSS gf180mcu_fd_sc_mcu7t5v0__fillcap_16
XFILLER_208_683 VDD VSS VDD VSS gf180mcu_fd_sc_mcu7t5v0__fillcap_8
XFILLER_82_658 VDD VSS VDD VSS gf180mcu_fd_sc_mcu7t5v0__fillcap_4
X_2045_ VDD VSS _2048_/A3 _3866_/D _3866_/Q VDD VSS gf180mcu_fd_sc_mcu7t5v0__nor2_1
XFILLER_223_664 VDD VSS VDD VSS gf180mcu_fd_sc_mcu7t5v0__fillcap_8
X_3996_ VDD _3996_/Q _3998_/CLK VSS _3996_/D VDD VSS gf180mcu_fd_sc_mcu7t5v0__dffq_1
X_2947_ _2936_/B VDD VSS _2963_/B _3271_/A1 _2975_/A1 VDD VSS gf180mcu_fd_sc_mcu7t5v0__or3_1
X_2878_ _2878_/B VDD VSS _2885_/A2 _2878_/A1 _2878_/A2 VDD VSS gf180mcu_fd_sc_mcu7t5v0__aoi21_1
XFILLER_191_766 VDD VSS VDD VSS gf180mcu_fd_sc_mcu7t5v0__fillcap_4
XFILLER_117_863 VDD VSS VDD VSS gf180mcu_fd_sc_mcu7t5v0__fillcap_16
X_4548_ _4548_/D _4573_/D _4573_/RN VSS _4553_/CLK VDD VDD VSS gf180mcu_fd_sc_mcu7t5v0__dffrnq_1
XFILLER_191_788 VDD VSS VDD VSS gf180mcu_fd_sc_mcu7t5v0__fillcap_8
XFILLER_150_107 VDD VSS VDD VSS gf180mcu_fd_sc_mcu7t5v0__fillcap_4
XFILLER_116_351 VDD VSS VDD VSS gf180mcu_fd_sc_mcu7t5v0__fillcap_16
X_4479_ _4479_/D _4479_/Q wire186/Z VSS _4500_/CLK VDD VDD VSS gf180mcu_fd_sc_mcu7t5v0__dffrnq_1
XFILLER_132_877 VDD VSS VDD VSS gf180mcu_fd_sc_mcu7t5v0__fillcap_8
XFILLER_97_290 VDD VSS VDD VSS gf180mcu_fd_sc_mcu7t5v0__fillcap_4
XFILLER_260_247 VDD VSS VDD VSS gf180mcu_fd_sc_mcu7t5v0__fillcap_64
XFILLER_202_859 VDD VSS VDD VSS gf180mcu_fd_sc_mcu7t5v0__fillcap_16
XFILLER_186_527 VDD VSS VDD VSS gf180mcu_fd_sc_mcu7t5v0__fillcap_32
XFILLER_198_387 VDD VSS VDD VSS gf180mcu_fd_sc_mcu7t5v0__fillcap_4
XFILLER_9_206 VDD VSS VDD VSS gf180mcu_fd_sc_mcu7t5v0__fillcap_4
XFILLER_221_2 VDD VSS VDD VSS gf180mcu_fd_sc_mcu7t5v0__fillcap_64
XFILLER_154_457 VDD VSS VDD VSS gf180mcu_fd_sc_mcu7t5v0__fillcap_32
XFILLER_126_159 VDD VSS VDD VSS gf180mcu_fd_sc_mcu7t5v0__fillcap_8
XFILLER_135_682 VDD VSS VDD VSS gf180mcu_fd_sc_mcu7t5v0__fillcap_8
XFILLER_108_885 VDD VSS VDD VSS gf180mcu_fd_sc_mcu7t5v0__fillcap_4
XFILLER_107_384 VDD VSS VDD VSS gf180mcu_fd_sc_mcu7t5v0__fillcap_16
XFILLER_96_717 VDD VSS VDD VSS gf180mcu_fd_sc_mcu7t5v0__fillcap_16
XFILLER_122_387 VDD VSS VDD VSS gf180mcu_fd_sc_mcu7t5v0__fillcap_32
XFILLER_110_527 VDD VSS VDD VSS gf180mcu_fd_sc_mcu7t5v0__fillcap_64
XFILLER_0_172 VDD VSS VDD VSS gf180mcu_fd_sc_mcu7t5v0__fillcap_32
XFILLER_91_422 VDD VSS VDD VSS gf180mcu_fd_sc_mcu7t5v0__fillcap_64
XFILLER_252_737 VDD VSS VDD VSS gf180mcu_fd_sc_mcu7t5v0__fillcap_64
XFILLER_264_597 VDD VSS VDD VSS gf180mcu_fd_sc_mcu7t5v0__fillcap_64
XFILLER_151_80 VDD VSS VDD VSS gf180mcu_fd_sc_mcu7t5v0__fillcap_4
XFILLER_189_343 VDD VSS VDD VSS gf180mcu_fd_sc_mcu7t5v0__fillcap_4
X_3850_ spi_sclk_i _3850_/Q wire212/Z VSS _4449_/CLK VDD VDD VSS gf180mcu_fd_sc_mcu7t5v0__dffrnq_1
XFILLER_220_667 VDD VSS VDD VSS gf180mcu_fd_sc_mcu7t5v0__fillcap_16
X_3781_ _3786_/S VDD VSS _3948_/D _4291_/Q _3948_/Q VDD VSS gf180mcu_fd_sc_mcu7t5v0__mux2_2
X_2801_ _3212_/A2 _3030_/A2 VDD VSS _2802_/C _2813_/A2 _2971_/A3 VDD VSS gf180mcu_fd_sc_mcu7t5v0__aoi22_1
X_2732_ _2736_/S VDD VSS _4266_/D _4266_/Q _4448_/Q VDD VSS gf180mcu_fd_sc_mcu7t5v0__mux2_2
XFILLER_200_380 VDD VSS VDD VSS gf180mcu_fd_sc_mcu7t5v0__fillcap_4
X_2663_ _2663_/B1 _2663_/B2 VDD VSS _4229_/D _3170_/A2 _2666_/C VDD VSS gf180mcu_fd_sc_mcu7t5v0__aoi22_1
XFILLER_67_2 VDD VSS VDD VSS gf180mcu_fd_sc_mcu7t5v0__fillcap_64
X_2594_ _4204_/Q VDD VSS _2595_/A2 _4203_/Q _2586_/Z VDD VSS gf180mcu_fd_sc_mcu7t5v0__aoi21_1
X_4402_ _4402_/D _4402_/Q wire186/Z VSS _4402_/CLK VDD VDD VSS gf180mcu_fd_sc_mcu7t5v0__dffrnq_1
XFILLER_132_107 VDD VSS VDD VSS gf180mcu_fd_sc_mcu7t5v0__fillcap_32
X_4333_ _4333_/D _4333_/Q wire183/Z VSS _4365_/CLK VDD VDD VSS gf180mcu_fd_sc_mcu7t5v0__dffrnq_1
XFILLER_114_855 VDD VSS VDD VSS gf180mcu_fd_sc_mcu7t5v0__fillcap_4
XFILLER_5_72 VDD VSS VDD VSS gf180mcu_fd_sc_mcu7t5v0__fillcap_64
X_4264_ _4264_/D _4264_/Q wire192/Z VSS _4364_/CLK VDD VDD VSS gf180mcu_fd_sc_mcu7t5v0__dffrnq_1
XFILLER_141_674 VDD VSS VDD VSS gf180mcu_fd_sc_mcu7t5v0__fillcap_16
X_3215_ VDD VSS _3216_/B1 _2897_/Z _3214_/Z VDD VSS gf180mcu_fd_sc_mcu7t5v0__nand2_1
XFILLER_113_376 VDD VSS VDD VSS gf180mcu_fd_sc_mcu7t5v0__fillcap_4
XFILLER_228_745 VDD VSS VDD VSS gf180mcu_fd_sc_mcu7t5v0__fillcap_4
X_4195_ _4195_/D _4195_/Q wire184/Z VSS _4199_/CLK VDD VDD VSS gf180mcu_fd_sc_mcu7t5v0__dffrnq_1
X_3146_ VDD _3150_/A2 _3146_/B _3182_/B _3146_/A2 VSS _3146_/A3 VDD VSS gf180mcu_fd_sc_mcu7t5v0__oai31_1
XFILLER_95_772 VDD VSS VDD VSS gf180mcu_fd_sc_mcu7t5v0__fillcap_64
X_3077_ _3077_/B _3182_/B VDD VSS _3084_/B _3159_/C _3071_/Z VDD VSS gf180mcu_fd_sc_mcu7t5v0__oai211_1
X_2028_ VDD VSS _4230_/Q _2665_/A1 VDD VSS gf180mcu_fd_sc_mcu7t5v0__clkinv_1
XFILLER_242_247 VDD VSS VDD VSS gf180mcu_fd_sc_mcu7t5v0__fillcap_64
XFILLER_211_72 VDD VSS VDD VSS gf180mcu_fd_sc_mcu7t5v0__fillcap_32
XFILLER_51_842 VDD VSS VDD VSS gf180mcu_fd_sc_mcu7t5v0__fillcap_32
XFILLER_168_527 VDD VSS VDD VSS gf180mcu_fd_sc_mcu7t5v0__fillcap_8
XFILLER_24_37 VDD VSS VDD VSS gf180mcu_fd_sc_mcu7t5v0__fillcap_64
X_3979_ VDD _3979_/Q _3989_/CLK VSS _3979_/D VDD VSS gf180mcu_fd_sc_mcu7t5v0__dffq_1
XFILLER_149_752 VDD VSS VDD VSS gf180mcu_fd_sc_mcu7t5v0__fillcap_4
XFILLER_210_177 VDD VSS VDD VSS gf180mcu_fd_sc_mcu7t5v0__fillcap_8
XFILLER_195_368 VDD VSS VDD VSS gf180mcu_fd_sc_mcu7t5v0__fillcap_8
XFILLER_148_240 VDD VSS VDD VSS gf180mcu_fd_sc_mcu7t5v0__fillcap_4
XFILLER_136_457 VDD VSS VDD VSS gf180mcu_fd_sc_mcu7t5v0__fillcap_16
Xhold261 _4560_/D VSS _4565_/Q VDD VDD VSS gf180mcu_fd_sc_mcu7t5v0__dlyc_1
XFILLER_104_310 VDD VSS VDD VSS gf180mcu_fd_sc_mcu7t5v0__fillcap_4
XFILLER_123_129 VDD VSS VDD VSS gf180mcu_fd_sc_mcu7t5v0__fillcap_8
XFILLER_116_170 VDD VSS VDD VSS gf180mcu_fd_sc_mcu7t5v0__fillcap_4
Xhold250 input1/I VSS rst_ni VDD VDD VSS gf180mcu_fd_sc_mcu7t5v0__dlyc_1
Xhold272 _3868_/D VSS _3867_/Q VDD VDD VSS gf180mcu_fd_sc_mcu7t5v0__dlyc_1
XFILLER_266_807 VDD VSS VDD VSS gf180mcu_fd_sc_mcu7t5v0__fillcap_64
XFILLER_120_847 VDD VSS VDD VSS gf180mcu_fd_sc_mcu7t5v0__fillcap_16
XFILLER_73_422 VDD VSS VDD VSS gf180mcu_fd_sc_mcu7t5v0__fillcap_64
XFILLER_234_737 VDD VSS VDD VSS gf180mcu_fd_sc_mcu7t5v0__fillcap_4
XFILLER_246_597 VDD VSS VDD VSS gf180mcu_fd_sc_mcu7t5v0__fillcap_64
XFILLER_171_2 VDD VSS VDD VSS gf180mcu_fd_sc_mcu7t5v0__fillcap_32
XFILLER_85_282 VDD VSS VDD VSS gf180mcu_fd_sc_mcu7t5v0__fillcap_64
XFILLER_65_66 VDD VSS VDD VSS gf180mcu_fd_sc_mcu7t5v0__fillcap_4
XFILLER_261_556 VDD VSS VDD VSS gf180mcu_fd_sc_mcu7t5v0__fillcap_4
XFILLER_121_72 VDD VSS VDD VSS gf180mcu_fd_sc_mcu7t5v0__fillcap_16
XFILLER_202_667 VDD VSS VDD VSS gf180mcu_fd_sc_mcu7t5v0__fillcap_16
XFILLER_41_352 VDD VSS VDD VSS gf180mcu_fd_sc_mcu7t5v0__fillcap_64
XFILLER_142_449 VDD VSS VDD VSS gf180mcu_fd_sc_mcu7t5v0__fillcap_4
XFILLER_123_663 VDD VSS VDD VSS gf180mcu_fd_sc_mcu7t5v0__fillcap_4
XFILLER_110_302 VDD VSS VDD VSS gf180mcu_fd_sc_mcu7t5v0__fillcap_8
XFILLER_111_836 VDD VSS VDD VSS gf180mcu_fd_sc_mcu7t5v0__fillcap_4
XFILLER_256_317 VDD VSS VDD VSS gf180mcu_fd_sc_mcu7t5v0__fillcap_64
XFILLER_1_492 VDD VSS VDD VSS gf180mcu_fd_sc_mcu7t5v0__fillcap_64
X_3000_ _2985_/C _3004_/C VDD VSS _3001_/I _4327_/Q _3004_/A2 _3212_/A2 VDD VSS gf180mcu_fd_sc_mcu7t5v0__aoi221_1
XFILLER_77_772 VDD VSS VDD VSS gf180mcu_fd_sc_mcu7t5v0__fillcap_64
XFILLER_224_247 VDD VSS VDD VSS gf180mcu_fd_sc_mcu7t5v0__fillcap_64
X_3902_ VDD _3902_/Q _4541_/CLK VSS _3902_/D VDD VSS gf180mcu_fd_sc_mcu7t5v0__dffq_1
XFILLER_189_162 VDD VSS VDD VSS gf180mcu_fd_sc_mcu7t5v0__fillcap_4
XFILLER_33_842 VDD VSS VDD VSS gf180mcu_fd_sc_mcu7t5v0__fillcap_32
X_3833_ _3839_/S VDD VSS _3987_/D wire179/Z _3987_/Q VDD VSS gf180mcu_fd_sc_mcu7t5v0__mux2_2
XFILLER_60_661 VDD VSS VDD VSS gf180mcu_fd_sc_mcu7t5v0__fillcap_4
Xclkbuf_4_15_0_host_clk_i _3936_/CLK VSS VDD clkbuf_0_host_clk_i/Z VDD VSS gf180mcu_fd_sc_mcu7t5v0__clkbuf_2
XFILLER_192_305 VDD VSS VDD VSS gf180mcu_fd_sc_mcu7t5v0__fillcap_8
X_3764_ _3767_/S VDD VSS _3934_/D wire174/Z _3934_/Q VDD VSS gf180mcu_fd_sc_mcu7t5v0__mux2_2
X_3695_ VDD _3695_/B _3696_/S _3880_/D _3695_/A1 VSS VDD VSS gf180mcu_fd_sc_mcu7t5v0__oai21_1
X_2715_ _2728_/S _2704_/Z _4284_/Q VDD VSS _2716_/I _4252_/Q VDD VSS gf180mcu_fd_sc_mcu7t5v0__oai22_1
XFILLER_118_435 VDD VSS VDD VSS gf180mcu_fd_sc_mcu7t5v0__fillcap_8
X_2646_ _4142_/Q _2646_/C VDD VSS _2647_/B2 _4263_/Q _2168_/Z _2666_/B1 VDD VSS gf180mcu_fd_sc_mcu7t5v0__aoi221_1
X_2577_ _2577_/B VDD VSS _4196_/D _2934_/A2 wire27/Z VDD VSS gf180mcu_fd_sc_mcu7t5v0__aoi21_1
XFILLER_99_352 VDD VSS VDD VSS gf180mcu_fd_sc_mcu7t5v0__fillcap_16
XFILLER_248_807 VDD VSS VDD VSS gf180mcu_fd_sc_mcu7t5v0__fillcap_64
X_4316_ _4316_/D _4316_/Q _4530_/RN VSS _4337_/CLK VDD VDD VSS gf180mcu_fd_sc_mcu7t5v0__dffrnq_1
XFILLER_113_173 VDD VSS VDD VSS gf180mcu_fd_sc_mcu7t5v0__fillcap_32
X_4247_ _4247_/D _4247_/Q _4284_/RN VSS _4271_/CLK VDD VDD VSS gf180mcu_fd_sc_mcu7t5v0__dffrnq_1
XFILLER_101_346 VDD VSS VDD VSS gf180mcu_fd_sc_mcu7t5v0__fillcap_4
X_4178_ _4178_/D _4178_/Q wire186/Z VSS _4498_/CLK VDD VDD VSS gf180mcu_fd_sc_mcu7t5v0__dffrnq_1
XFILLER_55_422 VDD VSS VDD VSS gf180mcu_fd_sc_mcu7t5v0__fillcap_64
XFILLER_216_726 VDD VSS VDD VSS gf180mcu_fd_sc_mcu7t5v0__fillcap_8
XFILLER_67_282 VDD VSS VDD VSS gf180mcu_fd_sc_mcu7t5v0__fillcap_64
XFILLER_216_737 VDD VSS VDD VSS gf180mcu_fd_sc_mcu7t5v0__fillcap_8
XFILLER_228_597 VDD VSS VDD VSS gf180mcu_fd_sc_mcu7t5v0__fillcap_16
X_3129_ _3169_/B _3129_/C VDD VSS _3131_/A2 _2854_/B _3129_/A2 wire65/Z VDD VSS gf180mcu_fd_sc_mcu7t5v0__aoi221_1
XFILLER_215_236 VDD VSS VDD VSS gf180mcu_fd_sc_mcu7t5v0__fillcap_4
XFILLER_82_241 VDD VSS VDD VSS gf180mcu_fd_sc_mcu7t5v0__fillcap_4
XFILLER_231_718 VDD VSS VDD VSS gf180mcu_fd_sc_mcu7t5v0__fillcap_8
XFILLER_243_556 VDD VSS VDD VSS gf180mcu_fd_sc_mcu7t5v0__fillcap_4
XFILLER_169_836 VDD VSS VDD VSS gf180mcu_fd_sc_mcu7t5v0__fillcap_4
XFILLER_195_121 VDD VSS VDD VSS gf180mcu_fd_sc_mcu7t5v0__fillcap_16
XFILLER_23_352 VDD VSS VDD VSS gf180mcu_fd_sc_mcu7t5v0__fillcap_64
XFILLER_211_486 VDD VSS VDD VSS gf180mcu_fd_sc_mcu7t5v0__fillcap_4
XFILLER_50_171 VDD VSS VDD VSS gf180mcu_fd_sc_mcu7t5v0__fillcap_4
XFILLER_149_582 VDD VSS VDD VSS gf180mcu_fd_sc_mcu7t5v0__fillcap_16
XFILLER_195_198 VDD VSS VDD VSS gf180mcu_fd_sc_mcu7t5v0__fillcap_8
XFILLER_3_702 VDD VSS VDD VSS gf180mcu_fd_sc_mcu7t5v0__fillcap_64
XFILLER_238_317 VDD VSS VDD VSS gf180mcu_fd_sc_mcu7t5v0__fillcap_64
XFILLER_265_136 VDD VSS VDD VSS gf180mcu_fd_sc_mcu7t5v0__fillcap_4
XFILLER_59_772 VDD VSS VDD VSS gf180mcu_fd_sc_mcu7t5v0__fillcap_64
XFILLER_74_731 VDD VSS VDD VSS gf180mcu_fd_sc_mcu7t5v0__fillcap_4
XFILLER_206_247 VDD VSS VDD VSS gf180mcu_fd_sc_mcu7t5v0__fillcap_4
XFILLER_221_206 VDD VSS VDD VSS gf180mcu_fd_sc_mcu7t5v0__fillcap_4
XFILLER_15_842 VDD VSS VDD VSS gf180mcu_fd_sc_mcu7t5v0__fillcap_32
XFILLER_92_86 VDD VSS VDD VSS gf180mcu_fd_sc_mcu7t5v0__fillcap_16
XFILLER_42_661 VDD VSS VDD VSS gf180mcu_fd_sc_mcu7t5v0__fillcap_4
XFILLER_30_801 VDD VSS VDD VSS gf180mcu_fd_sc_mcu7t5v0__fillcap_4
X_3480_ _3480_/B VDD VSS _4470_/D _3480_/A1 _3479_/C VDD VSS gf180mcu_fd_sc_mcu7t5v0__aoi21_1
XFILLER_10_591 VDD VSS VDD VSS gf180mcu_fd_sc_mcu7t5v0__fillcap_4
X_2500_ _2500_/S VDD VSS _4121_/D wire150/Z _4121_/Q VDD VSS gf180mcu_fd_sc_mcu7t5v0__mux2_2
XFILLER_143_758 VDD VSS VDD VSS gf180mcu_fd_sc_mcu7t5v0__fillcap_8
XFILLER_142_235 VDD VSS VDD VSS gf180mcu_fd_sc_mcu7t5v0__fillcap_8
XFILLER_127_298 VDD VSS VDD VSS gf180mcu_fd_sc_mcu7t5v0__fillcap_4
X_2431_ _2431_/S VDD VSS _4065_/D _2454_/I0 _4065_/Q VDD VSS gf180mcu_fd_sc_mcu7t5v0__mux2_2
XFILLER_97_812 VDD VSS VDD VSS gf180mcu_fd_sc_mcu7t5v0__fillcap_8
X_2362_ VDD VSS _2363_/B wire167/Z wire14/Z VDD VSS gf180mcu_fd_sc_mcu7t5v0__nand2_1
XFILLER_257_626 VDD VSS VDD VSS gf180mcu_fd_sc_mcu7t5v0__fillcap_4
X_2293_ VDD VSS wire36/I _3451_/A1 _2292_/Z VDD VSS gf180mcu_fd_sc_mcu7t5v0__nor2_1
X_4101_ VDD _4101_/Q _4473_/CLK VSS _4101_/D VDD VSS gf180mcu_fd_sc_mcu7t5v0__dffq_1
XFILLER_110_154 VDD VSS VDD VSS gf180mcu_fd_sc_mcu7t5v0__fillcap_8
X_4032_ VDD _4032_/Q _4032_/CLK VSS _4032_/D VDD VSS gf180mcu_fd_sc_mcu7t5v0__dffq_1
XFILLER_37_422 VDD VSS VDD VSS gf180mcu_fd_sc_mcu7t5v0__fillcap_64
XFILLER_49_282 VDD VSS VDD VSS gf180mcu_fd_sc_mcu7t5v0__fillcap_64
XFILLER_64_241 VDD VSS VDD VSS gf180mcu_fd_sc_mcu7t5v0__fillcap_4
XFILLER_225_578 VDD VSS VDD VSS gf180mcu_fd_sc_mcu7t5v0__fillcap_4
XFILLER_213_729 VDD VSS VDD VSS gf180mcu_fd_sc_mcu7t5v0__fillcap_8
XFILLER_212_217 VDD VSS VDD VSS gf180mcu_fd_sc_mcu7t5v0__fillcap_8
XFILLER_212_239 VDD VSS VDD VSS gf180mcu_fd_sc_mcu7t5v0__fillcap_4
XFILLER_20_311 VDD VSS VDD VSS gf180mcu_fd_sc_mcu7t5v0__fillcap_4
XFILLER_32_171 VDD VSS VDD VSS gf180mcu_fd_sc_mcu7t5v0__fillcap_4
X_3816_ _3821_/S VDD VSS _3972_/D wire177/Z _3972_/Q VDD VSS gf180mcu_fd_sc_mcu7t5v0__mux2_2
Xclkbuf_leaf_8_clk_i _4462_/CLK VSS VDD clkload3/I VDD VSS gf180mcu_fd_sc_mcu7t5v0__clkbuf_2
X_3747_ _3747_/S VDD VSS _3921_/D _3848_/I0 _3921_/Q VDD VSS gf180mcu_fd_sc_mcu7t5v0__mux2_2
XFILLER_181_809 VDD VSS VDD VSS gf180mcu_fd_sc_mcu7t5v0__fillcap_16
XFILLER_118_232 VDD VSS VDD VSS gf180mcu_fd_sc_mcu7t5v0__fillcap_8
XFILLER_180_308 VDD VSS VDD VSS gf180mcu_fd_sc_mcu7t5v0__fillcap_4
XFILLER_106_427 VDD VSS VDD VSS gf180mcu_fd_sc_mcu7t5v0__fillcap_16
XFILLER_106_449 VDD VSS VDD VSS gf180mcu_fd_sc_mcu7t5v0__fillcap_4
X_3678_ VDD VSS _3678_/I _4497_/D VDD VSS gf180mcu_fd_sc_mcu7t5v0__clkinv_1
X_2629_ VDD VSS _2634_/A4 _4214_/Q _2629_/A2 VDD VSS gf180mcu_fd_sc_mcu7t5v0__nand2_1
XFILLER_0_716 VDD VSS VDD VSS gf180mcu_fd_sc_mcu7t5v0__fillcap_32
XFILLER_153_26 VDD VSS VDD VSS gf180mcu_fd_sc_mcu7t5v0__fillcap_4
XFILLER_247_136 VDD VSS VDD VSS gf180mcu_fd_sc_mcu7t5v0__fillcap_4
XFILLER_68_591 VDD VSS VDD VSS gf180mcu_fd_sc_mcu7t5v0__fillcap_4
XFILLER_56_731 VDD VSS VDD VSS gf180mcu_fd_sc_mcu7t5v0__fillcap_4
XFILLER_203_206 VDD VSS VDD VSS gf180mcu_fd_sc_mcu7t5v0__fillcap_4
XFILLER_231_548 VDD VSS VDD VSS gf180mcu_fd_sc_mcu7t5v0__fillcap_8
XFILLER_24_661 VDD VSS VDD VSS gf180mcu_fd_sc_mcu7t5v0__fillcap_4
XFILLER_12_801 VDD VSS VDD VSS gf180mcu_fd_sc_mcu7t5v0__fillcap_4
XFILLER_184_603 VDD VSS VDD VSS gf180mcu_fd_sc_mcu7t5v0__fillcap_8
XFILLER_157_806 VDD VSS VDD VSS gf180mcu_fd_sc_mcu7t5v0__fillcap_32
XFILLER_134_2 VDD VSS VDD VSS gf180mcu_fd_sc_mcu7t5v0__fillcap_8
XFILLER_212_795 VDD VSS VDD VSS gf180mcu_fd_sc_mcu7t5v0__fillcap_8
Xwire213 wire213/Z VSS VDD input1/Z VDD VSS gf180mcu_fd_sc_mcu7t5v0__clkbuf_2
XFILLER_109_276 VDD VSS VDD VSS gf180mcu_fd_sc_mcu7t5v0__fillcap_4
XFILLER_78_311 VDD VSS VDD VSS gf180mcu_fd_sc_mcu7t5v0__fillcap_4
XFILLER_239_626 VDD VSS VDD VSS gf180mcu_fd_sc_mcu7t5v0__fillcap_4
XFILLER_120_430 VDD VSS VDD VSS gf180mcu_fd_sc_mcu7t5v0__fillcap_4
XFILLER_19_422 VDD VSS VDD VSS gf180mcu_fd_sc_mcu7t5v0__fillcap_64
XFILLER_207_534 VDD VSS VDD VSS gf180mcu_fd_sc_mcu7t5v0__fillcap_16
XFILLER_46_241 VDD VSS VDD VSS gf180mcu_fd_sc_mcu7t5v0__fillcap_4
XFILLER_179_408 VDD VSS VDD VSS gf180mcu_fd_sc_mcu7t5v0__fillcap_4
XFILLER_222_548 VDD VSS VDD VSS gf180mcu_fd_sc_mcu7t5v0__fillcap_32
X_2980_ _3214_/A4 VDD VSS _2981_/S _2991_/C _2980_/A2 VDD VSS gf180mcu_fd_sc_mcu7t5v0__nand3_1
X_1931_ VDD VSS _4141_/Q _2510_/B VDD VSS gf180mcu_fd_sc_mcu7t5v0__clkinv_1
XFILLER_14_171 VDD VSS VDD VSS gf180mcu_fd_sc_mcu7t5v0__fillcap_4
XFILLER_230_581 VDD VSS VDD VSS gf180mcu_fd_sc_mcu7t5v0__fillcap_8
XFILLER_238_37 VDD VSS VDD VSS gf180mcu_fd_sc_mcu7t5v0__fillcap_64
X_3601_ _3601_/B _3609_/C VDD VSS _3602_/A3 wire82/Z _3597_/Z VDD VSS gf180mcu_fd_sc_mcu7t5v0__oai211_1
X_4581_ _4581_/D _4581_/Q _4613_/RN VSS _4583_/CLK VDD VDD VSS gf180mcu_fd_sc_mcu7t5v0__dffrnq_1
X_3532_ VDD VSS _3534_/A2 wire75/Z _4078_/Q VDD VSS gf180mcu_fd_sc_mcu7t5v0__nand2_1
X_3463_ _3463_/B _3590_/C VDD VSS _3464_/A3 _3515_/C _3460_/Z VDD VSS gf180mcu_fd_sc_mcu7t5v0__oai211_1
XFILLER_6_381 VDD VSS VDD VSS gf180mcu_fd_sc_mcu7t5v0__fillcap_4
X_2414_ VDD VSS _2422_/S _2492_/A1 _2423_/A2 VDD VSS gf180mcu_fd_sc_mcu7t5v0__nand2_1
X_3394_ _3424_/S VDD VSS _4437_/D _4395_/Q _3394_/I1 VDD VSS gf180mcu_fd_sc_mcu7t5v0__mux2_2
XFILLER_229_136 VDD VSS VDD VSS gf180mcu_fd_sc_mcu7t5v0__fillcap_4
X_2345_ _4340_/Q _4339_/Q VDD VSS _3035_/B _4345_/Q _2345_/A2 VDD VSS gf180mcu_fd_sc_mcu7t5v0__oai211_1
X_2276_ _2276_/B _2276_/C VDD VSS _2277_/A2 _2623_/A2 _2276_/A2 VDD VSS gf180mcu_fd_sc_mcu7t5v0__oai211_1
XFILLER_38_731 VDD VSS VDD VSS gf180mcu_fd_sc_mcu7t5v0__fillcap_4
XFILLER_111_474 VDD VSS VDD VSS gf180mcu_fd_sc_mcu7t5v0__fillcap_16
X_4015_ VDD _4015_/Q _4032_/CLK VSS _4015_/D VDD VSS gf180mcu_fd_sc_mcu7t5v0__dffq_1
XFILLER_80_597 VDD VSS VDD VSS gf180mcu_fd_sc_mcu7t5v0__fillcap_64
XFILLER_221_570 VDD VSS VDD VSS gf180mcu_fd_sc_mcu7t5v0__fillcap_4
XFILLER_32_37 VDD VSS VDD VSS gf180mcu_fd_sc_mcu7t5v0__fillcap_64
XFILLER_166_647 VDD VSS VDD VSS gf180mcu_fd_sc_mcu7t5v0__fillcap_4
XFILLER_148_37 VDD VSS VDD VSS gf180mcu_fd_sc_mcu7t5v0__fillcap_4
XFILLER_193_422 VDD VSS VDD VSS gf180mcu_fd_sc_mcu7t5v0__fillcap_16
XFILLER_146_371 VDD VSS VDD VSS gf180mcu_fd_sc_mcu7t5v0__fillcap_8
XFILLER_161_352 VDD VSS VDD VSS gf180mcu_fd_sc_mcu7t5v0__fillcap_8
XFILLER_134_588 VDD VSS VDD VSS gf180mcu_fd_sc_mcu7t5v0__fillcap_4
XFILLER_0_546 VDD VSS VDD VSS gf180mcu_fd_sc_mcu7t5v0__fillcap_32
XFILLER_28_241 VDD VSS VDD VSS gf180mcu_fd_sc_mcu7t5v0__fillcap_4
XFILLER_90_317 VDD VSS VDD VSS gf180mcu_fd_sc_mcu7t5v0__fillcap_64
XFILLER_232_868 VDD VSS VDD VSS gf180mcu_fd_sc_mcu7t5v0__fillcap_4
XFILLER_251_2 VDD VSS VDD VSS gf180mcu_fd_sc_mcu7t5v0__fillcap_64
XFILLER_73_66 VDD VSS VDD VSS gf180mcu_fd_sc_mcu7t5v0__fillcap_4
XFILLER_157_625 VDD VSS VDD VSS gf180mcu_fd_sc_mcu7t5v0__fillcap_4
XFILLER_172_606 VDD VSS VDD VSS gf180mcu_fd_sc_mcu7t5v0__fillcap_16
XFILLER_153_820 VDD VSS VDD VSS gf180mcu_fd_sc_mcu7t5v0__fillcap_16
XFILLER_137_360 VDD VSS VDD VSS gf180mcu_fd_sc_mcu7t5v0__fillcap_4
XFILLER_98_52 VDD VSS VDD VSS gf180mcu_fd_sc_mcu7t5v0__fillcap_8
XFILLER_180_661 VDD VSS VDD VSS gf180mcu_fd_sc_mcu7t5v0__fillcap_4
XFILLER_152_363 VDD VSS VDD VSS gf180mcu_fd_sc_mcu7t5v0__fillcap_4
XFILLER_4_885 VDD VSS VDD VSS gf180mcu_fd_sc_mcu7t5v0__fillcap_4
XFILLER_98_85 VDD VSS VDD VSS gf180mcu_fd_sc_mcu7t5v0__fillcap_4
XFILLER_105_290 VDD VSS VDD VSS gf180mcu_fd_sc_mcu7t5v0__fillcap_4
XFILLER_121_772 VDD VSS VDD VSS gf180mcu_fd_sc_mcu7t5v0__fillcap_4
XFILLER_227_607 VDD VSS VDD VSS gf180mcu_fd_sc_mcu7t5v0__fillcap_8
X_2130_ _4536_/Q VDD VSS _2131_/I _4134_/Q _2130_/A2 VDD VSS gf180mcu_fd_sc_mcu7t5v0__aoi21_1
XFILLER_82_807 VDD VSS VDD VSS gf180mcu_fd_sc_mcu7t5v0__fillcap_8
X_2061_ _2084_/A2 VDD VSS _2061_/Z _4579_/Q _4578_/Q VDD VSS gf180mcu_fd_sc_mcu7t5v0__and3_1
XFILLER_94_667 VDD VSS VDD VSS gf180mcu_fd_sc_mcu7t5v0__fillcap_4
Xclkbuf_leaf_73_clk_i _4058_/CLK VSS VDD clkbuf_3_2__f_clk_i/Z VDD VSS gf180mcu_fd_sc_mcu7t5v0__clkbuf_2
X_2963_ VDD _2963_/B _2963_/A2 _2964_/A3 _4341_/Q VSS VDD VSS gf180mcu_fd_sc_mcu7t5v0__oai21_1
XFILLER_62_597 VDD VSS VDD VSS gf180mcu_fd_sc_mcu7t5v0__fillcap_64
XFILLER_50_737 VDD VSS VDD VSS gf180mcu_fd_sc_mcu7t5v0__fillcap_64
X_1914_ VDD VSS _3586_/S wire75/I VDD VSS gf180mcu_fd_sc_mcu7t5v0__clkinv_1
X_2894_ VDD _2896_/A1 _4304_/Q _2894_/A1 _2895_/A4 VSS _2894_/A3 VDD VSS gf180mcu_fd_sc_mcu7t5v0__oai31_1
Xclkbuf_leaf_88_clk_i _4526_/CLK VSS VDD clkload1/I VDD VSS gf180mcu_fd_sc_mcu7t5v0__clkbuf_2
XFILLER_163_606 VDD VSS VDD VSS gf180mcu_fd_sc_mcu7t5v0__fillcap_16
XFILLER_190_403 VDD VSS VDD VSS gf180mcu_fd_sc_mcu7t5v0__fillcap_4
X_4564_ _4564_/D _4564_/Q _4616_/RN VSS _4565_/CLK VDD VDD VSS gf180mcu_fd_sc_mcu7t5v0__dffrnq_1
X_3515_ _3515_/B _3515_/C VDD VSS _3516_/B _3597_/S _3515_/A2 VDD VSS gf180mcu_fd_sc_mcu7t5v0__oai211_1
Xclkbuf_leaf_11_clk_i _4492_/CLK VSS VDD clkload1/I VDD VSS gf180mcu_fd_sc_mcu7t5v0__clkbuf_2
XFILLER_143_352 VDD VSS VDD VSS gf180mcu_fd_sc_mcu7t5v0__fillcap_8
X_4495_ _4495_/D _4495_/Q wire209/Z VSS clkload8/I VDD VDD VSS gf180mcu_fd_sc_mcu7t5v0__dffrnq_1
XFILLER_170_171 VDD VSS VDD VSS gf180mcu_fd_sc_mcu7t5v0__fillcap_4
X_3446_ VDD VSS _3454_/A2 _4130_/Q _2039_/Z VDD VSS gf180mcu_fd_sc_mcu7t5v0__nand2_1
X_3377_ wire21/Z VDD VSS _4424_/D _4416_/Q _4424_/Q VDD VSS gf180mcu_fd_sc_mcu7t5v0__mux2_2
X_2328_ VDD VSS _2926_/A3 _4337_/Q _1945_/I VDD VSS gf180mcu_fd_sc_mcu7t5v0__nand2_1
Xclkbuf_leaf_26_clk_i _4467_/CLK VSS VDD clkload3/I VDD VSS gf180mcu_fd_sc_mcu7t5v0__clkbuf_2
X_2259_ VDD VSS _4537_/D _2259_/A1 _2259_/A2 VDD VSS gf180mcu_fd_sc_mcu7t5v0__nor2_1
XFILLER_84_177 VDD VSS VDD VSS gf180mcu_fd_sc_mcu7t5v0__fillcap_64
XFILLER_72_317 VDD VSS VDD VSS gf180mcu_fd_sc_mcu7t5v0__fillcap_64
XFILLER_198_503 VDD VSS VDD VSS gf180mcu_fd_sc_mcu7t5v0__fillcap_16
XFILLER_241_632 VDD VSS VDD VSS gf180mcu_fd_sc_mcu7t5v0__fillcap_64
XFILLER_253_492 VDD VSS VDD VSS gf180mcu_fd_sc_mcu7t5v0__fillcap_64
XFILLER_198_547 VDD VSS VDD VSS gf180mcu_fd_sc_mcu7t5v0__fillcap_4
XFILLER_179_750 VDD VSS VDD VSS gf180mcu_fd_sc_mcu7t5v0__fillcap_8
XFILLER_40_247 VDD VSS VDD VSS gf180mcu_fd_sc_mcu7t5v0__fillcap_64
XFILLER_166_466 VDD VSS VDD VSS gf180mcu_fd_sc_mcu7t5v0__fillcap_16
XFILLER_193_263 VDD VSS VDD VSS gf180mcu_fd_sc_mcu7t5v0__fillcap_8
XFILLER_107_511 VDD VSS VDD VSS gf180mcu_fd_sc_mcu7t5v0__fillcap_16
XFILLER_107_500 VDD VSS VDD VSS gf180mcu_fd_sc_mcu7t5v0__fillcap_4
XFILLER_135_842 VDD VSS VDD VSS gf180mcu_fd_sc_mcu7t5v0__fillcap_8
XFILLER_134_363 VDD VSS VDD VSS gf180mcu_fd_sc_mcu7t5v0__fillcap_16
XFILLER_209_618 VDD VSS VDD VSS gf180mcu_fd_sc_mcu7t5v0__fillcap_8
XFILLER_103_772 VDD VSS VDD VSS gf180mcu_fd_sc_mcu7t5v0__fillcap_16
XFILLER_0_376 VDD VSS VDD VSS gf180mcu_fd_sc_mcu7t5v0__fillcap_32
XFILLER_263_212 VDD VSS VDD VSS gf180mcu_fd_sc_mcu7t5v0__fillcap_64
XFILLER_124_61 VDD VSS VDD VSS gf180mcu_fd_sc_mcu7t5v0__fillcap_16
XFILLER_64_807 VDD VSS VDD VSS gf180mcu_fd_sc_mcu7t5v0__fillcap_64
XFILLER_76_667 VDD VSS VDD VSS gf180mcu_fd_sc_mcu7t5v0__fillcap_64
XFILLER_232_654 VDD VSS VDD VSS gf180mcu_fd_sc_mcu7t5v0__fillcap_8
XFILLER_189_547 VDD VSS VDD VSS gf180mcu_fd_sc_mcu7t5v0__fillcap_8
XFILLER_231_142 VDD VSS VDD VSS gf180mcu_fd_sc_mcu7t5v0__fillcap_64
XFILLER_44_597 VDD VSS VDD VSS gf180mcu_fd_sc_mcu7t5v0__fillcap_64
XFILLER_32_737 VDD VSS VDD VSS gf180mcu_fd_sc_mcu7t5v0__fillcap_64
XFILLER_157_422 VDD VSS VDD VSS gf180mcu_fd_sc_mcu7t5v0__fillcap_64
XFILLER_197_591 VDD VSS VDD VSS gf180mcu_fd_sc_mcu7t5v0__fillcap_32
XFILLER_169_282 VDD VSS VDD VSS gf180mcu_fd_sc_mcu7t5v0__fillcap_16
XFILLER_129_157 VDD VSS VDD VSS gf180mcu_fd_sc_mcu7t5v0__fillcap_4
XFILLER_172_425 VDD VSS VDD VSS gf180mcu_fd_sc_mcu7t5v0__fillcap_16
XFILLER_184_263 VDD VSS VDD VSS gf180mcu_fd_sc_mcu7t5v0__fillcap_4
X_3300_ _3278_/Z _4481_/Q VDD VSS _3304_/A3 _4497_/Q _3302_/A2 VDD VSS gf180mcu_fd_sc_mcu7t5v0__aoi22_1
XFILLER_141_834 VDD VSS VDD VSS gf180mcu_fd_sc_mcu7t5v0__fillcap_4
X_4280_ _4280_/D _4280_/Q wire207/Z VSS _4283_/CLK VDD VDD VSS gf180mcu_fd_sc_mcu7t5v0__dffrnq_1
XFILLER_140_322 VDD VSS VDD VSS gf180mcu_fd_sc_mcu7t5v0__fillcap_32
XFILLER_98_247 VDD VSS VDD VSS gf180mcu_fd_sc_mcu7t5v0__fillcap_8
X_3231_ _3239_/A1 VDD VSS _3234_/A2 _4349_/Q _4350_/Q VDD VSS gf180mcu_fd_sc_mcu7t5v0__nand3_1
XFILLER_255_702 VDD VSS VDD VSS gf180mcu_fd_sc_mcu7t5v0__fillcap_64
XFILLER_267_562 VDD VSS VDD VSS gf180mcu_fd_sc_mcu7t5v0__fillcap_64
X_3162_ VDD VSS _3167_/A2 wire94/Z _3161_/Z VDD VSS gf180mcu_fd_sc_mcu7t5v0__nor2_1
X_2113_ VDD VSS _4549_/D _2853_/C _2113_/A2 VDD VSS gf180mcu_fd_sc_mcu7t5v0__xor2_1
X_3093_ VDD wire97/Z _3876_/Q _3096_/A2 _3157_/A1 VSS VDD VSS gf180mcu_fd_sc_mcu7t5v0__oai21_1
XFILLER_66_177 VDD VSS VDD VSS gf180mcu_fd_sc_mcu7t5v0__fillcap_64
XFILLER_54_317 VDD VSS VDD VSS gf180mcu_fd_sc_mcu7t5v0__fillcap_64
XFILLER_235_470 VDD VSS VDD VSS gf180mcu_fd_sc_mcu7t5v0__fillcap_4
X_2044_ VDD VSS _2044_/I _3859_/D VDD VSS gf180mcu_fd_sc_mcu7t5v0__clkinv_1
XFILLER_81_136 VDD VSS VDD VSS gf180mcu_fd_sc_mcu7t5v0__fillcap_4
XFILLER_235_492 VDD VSS VDD VSS gf180mcu_fd_sc_mcu7t5v0__fillcap_8
XFILLER_223_632 VDD VSS VDD VSS gf180mcu_fd_sc_mcu7t5v0__fillcap_32
XFILLER_250_451 VDD VSS VDD VSS gf180mcu_fd_sc_mcu7t5v0__fillcap_4
X_3995_ VDD _3995_/Q _3998_/CLK VSS _3995_/D VDD VSS gf180mcu_fd_sc_mcu7t5v0__dffq_1
XFILLER_22_247 VDD VSS VDD VSS gf180mcu_fd_sc_mcu7t5v0__fillcap_64
X_2946_ VDD VSS _3200_/A1 _2950_/A1 _2950_/A2 VDD VSS gf180mcu_fd_sc_mcu7t5v0__nor2_1
XFILLER_148_466 VDD VSS VDD VSS gf180mcu_fd_sc_mcu7t5v0__fillcap_16
X_2877_ VDD _4343_/Q _2874_/Z _2878_/B _4324_/Q VSS VDD VSS gf180mcu_fd_sc_mcu7t5v0__oai21_1
X_4616_ _4616_/D _4616_/Q _4616_/RN VSS _4616_/CLK VDD VDD VSS gf180mcu_fd_sc_mcu7t5v0__dffrnq_1
XFILLER_129_680 VDD VSS VDD VSS gf180mcu_fd_sc_mcu7t5v0__fillcap_4
XFILLER_117_820 VDD VSS VDD VSS gf180mcu_fd_sc_mcu7t5v0__fillcap_4
XFILLER_209_72 VDD VSS VDD VSS gf180mcu_fd_sc_mcu7t5v0__fillcap_32
XFILLER_117_842 VDD VSS VDD VSS gf180mcu_fd_sc_mcu7t5v0__fillcap_4
X_4547_ _4547_/D _4572_/D wire187/Z VSS _4553_/CLK VDD VDD VSS gf180mcu_fd_sc_mcu7t5v0__dffrnq_1
X_4478_ _4478_/D _4478_/Q wire186/Z VSS _4478_/CLK VDD VDD VSS gf180mcu_fd_sc_mcu7t5v0__dffrnq_1
X_3429_ _3605_/S VDD VSS _3429_/Z _4026_/Q _4018_/Q VDD VSS gf180mcu_fd_sc_mcu7t5v0__mux2_2
XFILLER_245_212 VDD VSS VDD VSS gf180mcu_fd_sc_mcu7t5v0__fillcap_64
XFILLER_46_807 VDD VSS VDD VSS gf180mcu_fd_sc_mcu7t5v0__fillcap_64
XFILLER_58_667 VDD VSS VDD VSS gf180mcu_fd_sc_mcu7t5v0__fillcap_64
XFILLER_73_626 VDD VSS VDD VSS gf180mcu_fd_sc_mcu7t5v0__fillcap_4
XFILLER_85_486 VDD VSS VDD VSS gf180mcu_fd_sc_mcu7t5v0__fillcap_4
XFILLER_226_481 VDD VSS VDD VSS gf180mcu_fd_sc_mcu7t5v0__fillcap_4
XFILLER_26_597 VDD VSS VDD VSS gf180mcu_fd_sc_mcu7t5v0__fillcap_64
XFILLER_14_737 VDD VSS VDD VSS gf180mcu_fd_sc_mcu7t5v0__fillcap_64
XFILLER_202_827 VDD VSS VDD VSS gf180mcu_fd_sc_mcu7t5v0__fillcap_32
XFILLER_139_400 VDD VSS VDD VSS gf180mcu_fd_sc_mcu7t5v0__fillcap_4
XFILLER_41_556 VDD VSS VDD VSS gf180mcu_fd_sc_mcu7t5v0__fillcap_4
XFILLER_181_244 VDD VSS VDD VSS gf180mcu_fd_sc_mcu7t5v0__fillcap_8
XFILLER_119_72 VDD VSS VDD VSS gf180mcu_fd_sc_mcu7t5v0__fillcap_4
XFILLER_107_352 VDD VSS VDD VSS gf180mcu_fd_sc_mcu7t5v0__fillcap_32
XFILLER_96_707 VDD VSS VDD VSS gf180mcu_fd_sc_mcu7t5v0__fillcap_4
XFILLER_237_702 VDD VSS VDD VSS gf180mcu_fd_sc_mcu7t5v0__fillcap_16
XFILLER_249_562 VDD VSS VDD VSS gf180mcu_fd_sc_mcu7t5v0__fillcap_64
XFILLER_95_228 VDD VSS VDD VSS gf180mcu_fd_sc_mcu7t5v0__fillcap_8
XFILLER_1_696 VDD VSS VDD VSS gf180mcu_fd_sc_mcu7t5v0__fillcap_4
XFILLER_264_521 VDD VSS VDD VSS gf180mcu_fd_sc_mcu7t5v0__fillcap_4
XFILLER_95_64 VDD VSS VDD VSS gf180mcu_fd_sc_mcu7t5v0__fillcap_4
XFILLER_48_177 VDD VSS VDD VSS gf180mcu_fd_sc_mcu7t5v0__fillcap_64
XFILLER_36_317 VDD VSS VDD VSS gf180mcu_fd_sc_mcu7t5v0__fillcap_64
XFILLER_63_136 VDD VSS VDD VSS gf180mcu_fd_sc_mcu7t5v0__fillcap_4
XFILLER_217_492 VDD VSS VDD VSS gf180mcu_fd_sc_mcu7t5v0__fillcap_16
XFILLER_205_632 VDD VSS VDD VSS gf180mcu_fd_sc_mcu7t5v0__fillcap_8
XFILLER_232_451 VDD VSS VDD VSS gf180mcu_fd_sc_mcu7t5v0__fillcap_4
XFILLER_232_473 VDD VSS VDD VSS gf180mcu_fd_sc_mcu7t5v0__fillcap_8
XFILLER_220_657 VDD VSS VDD VSS gf180mcu_fd_sc_mcu7t5v0__fillcap_8
X_3780_ _3786_/S VDD VSS _3947_/D _4290_/Q _3947_/Q VDD VSS gf180mcu_fd_sc_mcu7t5v0__mux2_2
X_2800_ VDD VSS _3030_/A2 _2989_/A1 _2865_/C VDD VSS gf180mcu_fd_sc_mcu7t5v0__nor2_1
X_2731_ _2731_/S VDD VSS _4265_/D _4265_/Q _4447_/Q VDD VSS gf180mcu_fd_sc_mcu7t5v0__mux2_2
X_2662_ VDD VSS _2663_/B2 _2666_/C _2650_/Z VDD VSS gf180mcu_fd_sc_mcu7t5v0__nor2_1
XFILLER_246_37 VDD VSS VDD VSS gf180mcu_fd_sc_mcu7t5v0__fillcap_64
X_4401_ _4401_/D _4401_/Q wire196/I VSS clkload9/I VDD VDD VSS gf180mcu_fd_sc_mcu7t5v0__dffrnq_1
X_2593_ VDD VSS _2620_/B _2586_/Z _2634_/A3 VDD VSS gf180mcu_fd_sc_mcu7t5v0__nand2_1
X_4332_ _4332_/D _4332_/Q _4525_/RN VSS _4365_/CLK VDD VDD VSS gf180mcu_fd_sc_mcu7t5v0__dffrnq_1
X_4263_ _4263_/D _4263_/Q _4534_/RN VSS _4269_/CLK VDD VDD VSS gf180mcu_fd_sc_mcu7t5v0__dffrnq_1
XFILLER_99_578 VDD VSS VDD VSS gf180mcu_fd_sc_mcu7t5v0__fillcap_8
X_3214_ _3214_/A3 _3214_/A4 VDD VSS _3214_/Z _3214_/A1 _3214_/A2 VDD VSS gf180mcu_fd_sc_mcu7t5v0__and4_1
XFILLER_227_212 VDD VSS VDD VSS gf180mcu_fd_sc_mcu7t5v0__fillcap_64
X_4194_ _4194_/D _4194_/Q _4527_/RN VSS _4468_/CLK VDD VDD VSS gf180mcu_fd_sc_mcu7t5v0__dffrnq_1
XFILLER_28_807 VDD VSS VDD VSS gf180mcu_fd_sc_mcu7t5v0__fillcap_64
X_3145_ _3145_/B _3188_/C VDD VSS _3146_/A3 _3143_/C _3144_/Z VDD VSS gf180mcu_fd_sc_mcu7t5v0__aoi211_1
XFILLER_55_626 VDD VSS VDD VSS gf180mcu_fd_sc_mcu7t5v0__fillcap_4
XFILLER_67_486 VDD VSS VDD VSS gf180mcu_fd_sc_mcu7t5v0__fillcap_4
X_3076_ _3076_/B1 _3159_/C VDD VSS _3077_/B _3076_/A1 _3076_/A2 _3076_/B2 VDD VSS
+ gf180mcu_fd_sc_mcu7t5v0__oai221_1
XFILLER_131_18 VDD VSS VDD VSS gf180mcu_fd_sc_mcu7t5v0__fillcap_4
X_2027_ VDD VSS _3880_/Q _3695_/A1 VDD VSS gf180mcu_fd_sc_mcu7t5v0__clkinv_1
XFILLER_208_492 VDD VSS VDD VSS gf180mcu_fd_sc_mcu7t5v0__fillcap_16
XFILLER_210_101 VDD VSS VDD VSS gf180mcu_fd_sc_mcu7t5v0__fillcap_4
XFILLER_23_556 VDD VSS VDD VSS gf180mcu_fd_sc_mcu7t5v0__fillcap_4
X_3978_ VDD _3978_/Q _3989_/CLK VSS _3978_/D VDD VSS gf180mcu_fd_sc_mcu7t5v0__dffq_1
XFILLER_195_336 VDD VSS VDD VSS gf180mcu_fd_sc_mcu7t5v0__fillcap_8
X_2929_ VDD VSS _2929_/Z wire143/Z _4199_/Q VDD VSS gf180mcu_fd_sc_mcu7t5v0__xor2_1
XFILLER_40_37 VDD VSS VDD VSS gf180mcu_fd_sc_mcu7t5v0__fillcap_64
XFILLER_156_37 VDD VSS VDD VSS gf180mcu_fd_sc_mcu7t5v0__fillcap_64
XFILLER_151_406 VDD VSS VDD VSS gf180mcu_fd_sc_mcu7t5v0__fillcap_8
XFILLER_117_672 VDD VSS VDD VSS gf180mcu_fd_sc_mcu7t5v0__fillcap_16
Xhold262 _4568_/D VSS _4573_/Q VDD VDD VSS gf180mcu_fd_sc_mcu7t5v0__dlyc_1
Xhold251 _4558_/D VSS _4563_/Q VDD VDD VSS gf180mcu_fd_sc_mcu7t5v0__dlyc_1
Xhold273 _3862_/D VSS _3861_/Q VDD VDD VSS gf180mcu_fd_sc_mcu7t5v0__dlyc_1
XFILLER_77_206 VDD VSS VDD VSS gf180mcu_fd_sc_mcu7t5v0__fillcap_4
XFILLER_246_521 VDD VSS VDD VSS gf180mcu_fd_sc_mcu7t5v0__fillcap_4
XFILLER_258_381 VDD VSS VDD VSS gf180mcu_fd_sc_mcu7t5v0__fillcap_4
XFILLER_18_317 VDD VSS VDD VSS gf180mcu_fd_sc_mcu7t5v0__fillcap_64
XFILLER_45_136 VDD VSS VDD VSS gf180mcu_fd_sc_mcu7t5v0__fillcap_4
XFILLER_218_289 VDD VSS VDD VSS gf180mcu_fd_sc_mcu7t5v0__fillcap_16
XFILLER_214_451 VDD VSS VDD VSS gf180mcu_fd_sc_mcu7t5v0__fillcap_4
XFILLER_199_664 VDD VSS VDD VSS gf180mcu_fd_sc_mcu7t5v0__fillcap_4
XFILLER_81_66 VDD VSS VDD VSS gf180mcu_fd_sc_mcu7t5v0__fillcap_4
XFILLER_197_55 VDD VSS VDD VSS gf180mcu_fd_sc_mcu7t5v0__fillcap_8
XFILLER_127_436 VDD VSS VDD VSS gf180mcu_fd_sc_mcu7t5v0__fillcap_8
XFILLER_115_609 VDD VSS VDD VSS gf180mcu_fd_sc_mcu7t5v0__fillcap_8
XFILLER_182_597 VDD VSS VDD VSS gf180mcu_fd_sc_mcu7t5v0__fillcap_8
XFILLER_170_737 VDD VSS VDD VSS gf180mcu_fd_sc_mcu7t5v0__fillcap_64
XFILLER_5_276 VDD VSS VDD VSS gf180mcu_fd_sc_mcu7t5v0__fillcap_4
XFILLER_122_141 VDD VSS VDD VSS gf180mcu_fd_sc_mcu7t5v0__fillcap_16
XFILLER_265_874 VDD VSS VDD VSS gf180mcu_fd_sc_mcu7t5v0__fillcap_16
XFILLER_37_626 VDD VSS VDD VSS gf180mcu_fd_sc_mcu7t5v0__fillcap_4
XFILLER_49_486 VDD VSS VDD VSS gf180mcu_fd_sc_mcu7t5v0__fillcap_4
X_3901_ VDD _3901_/Q _3969_/CLK VSS _3901_/D VDD VSS gf180mcu_fd_sc_mcu7t5v0__dffq_1
X_3832_ _3839_/S VDD VSS _3986_/D _3841_/I0 _3986_/Q VDD VSS gf180mcu_fd_sc_mcu7t5v0__mux2_2
XFILLER_220_465 VDD VSS VDD VSS gf180mcu_fd_sc_mcu7t5v0__fillcap_4
XFILLER_193_818 VDD VSS VDD VSS gf180mcu_fd_sc_mcu7t5v0__fillcap_16
X_3763_ _3767_/S VDD VSS _3933_/D _3763_/I0 _3933_/Q VDD VSS gf180mcu_fd_sc_mcu7t5v0__mux2_2
XFILLER_186_870 VDD VSS VDD VSS gf180mcu_fd_sc_mcu7t5v0__fillcap_4
XFILLER_118_403 VDD VSS VDD VSS gf180mcu_fd_sc_mcu7t5v0__fillcap_32
X_3694_ VDD VSS _3695_/B _3766_/I0 _3696_/S VDD VSS gf180mcu_fd_sc_mcu7t5v0__nand2_1
XFILLER_173_542 VDD VSS VDD VSS gf180mcu_fd_sc_mcu7t5v0__fillcap_16
X_2714_ VDD VSS _2714_/I _4251_/D VDD VSS gf180mcu_fd_sc_mcu7t5v0__clkinv_1
XFILLER_185_380 VDD VSS VDD VSS gf180mcu_fd_sc_mcu7t5v0__fillcap_16
X_2645_ VDD VSS _2646_/C _2664_/A2 _2666_/C VDD VSS gf180mcu_fd_sc_mcu7t5v0__or2_1
X_4315_ _4315_/D _4315_/Q _4525_/RN VSS _4355_/CLK VDD VDD VSS gf180mcu_fd_sc_mcu7t5v0__dffrnq_1
X_2576_ VDD VSS _2577_/B _4438_/Q wire27/Z VDD VSS gf180mcu_fd_sc_mcu7t5v0__nor2_1
XFILLER_126_491 VDD VSS VDD VSS gf180mcu_fd_sc_mcu7t5v0__fillcap_16
XFILLER_141_483 VDD VSS VDD VSS gf180mcu_fd_sc_mcu7t5v0__fillcap_4
XFILLER_59_206 VDD VSS VDD VSS gf180mcu_fd_sc_mcu7t5v0__fillcap_4
X_4246_ _4246_/D _4246_/Q wire206/Z VSS _4535_/CLK VDD VDD VSS gf180mcu_fd_sc_mcu7t5v0__dffrnq_1
X_4177_ _4177_/D _4177_/Q wire209/Z VSS _4451_/CLK VDD VDD VSS gf180mcu_fd_sc_mcu7t5v0__dffrnq_1
XFILLER_256_885 VDD VSS VDD VSS gf180mcu_fd_sc_mcu7t5v0__fillcap_4
X_3128_ VDD _3170_/B _3128_/A2 _3129_/C _3214_/A1 VSS VDD VSS gf180mcu_fd_sc_mcu7t5v0__oai21_1
XFILLER_95_592 VDD VSS VDD VSS gf180mcu_fd_sc_mcu7t5v0__fillcap_16
XFILLER_27_136 VDD VSS VDD VSS gf180mcu_fd_sc_mcu7t5v0__fillcap_4
X_3059_ VDD VSS _3060_/B _3124_/A1 _3962_/Q VDD VSS gf180mcu_fd_sc_mcu7t5v0__nor2_1
XFILLER_183_317 VDD VSS VDD VSS gf180mcu_fd_sc_mcu7t5v0__fillcap_4
XFILLER_137_734 VDD VSS VDD VSS gf180mcu_fd_sc_mcu7t5v0__fillcap_8
XFILLER_167_58 VDD VSS VDD VSS gf180mcu_fd_sc_mcu7t5v0__fillcap_4
XFILLER_164_597 VDD VSS VDD VSS gf180mcu_fd_sc_mcu7t5v0__fillcap_32
XFILLER_152_737 VDD VSS VDD VSS gf180mcu_fd_sc_mcu7t5v0__fillcap_64
XFILLER_191_383 VDD VSS VDD VSS gf180mcu_fd_sc_mcu7t5v0__fillcap_32
XFILLER_247_874 VDD VSS VDD VSS gf180mcu_fd_sc_mcu7t5v0__fillcap_16
XFILLER_19_626 VDD VSS VDD VSS gf180mcu_fd_sc_mcu7t5v0__fillcap_4
XFILLER_262_877 VDD VSS VDD VSS gf180mcu_fd_sc_mcu7t5v0__fillcap_8
XFILLER_186_177 VDD VSS VDD VSS gf180mcu_fd_sc_mcu7t5v0__fillcap_16
XFILLER_174_317 VDD VSS VDD VSS gf180mcu_fd_sc_mcu7t5v0__fillcap_16
XFILLER_155_575 VDD VSS VDD VSS gf180mcu_fd_sc_mcu7t5v0__fillcap_16
X_2430_ _2431_/S VDD VSS _4064_/D wire152/Z _4064_/Q VDD VSS gf180mcu_fd_sc_mcu7t5v0__mux2_2
XFILLER_142_247 VDD VSS VDD VSS gf180mcu_fd_sc_mcu7t5v0__fillcap_8
X_2361_ _2483_/A1 VDD VSS wire14/I _4580_/Q _4581_/Q VDD VSS gf180mcu_fd_sc_mcu7t5v0__and3_1
X_2292_ _2524_/A3 VDD VSS _2292_/Z _4431_/Q _3441_/A3 VDD VSS gf180mcu_fd_sc_mcu7t5v0__or3_1
X_4100_ VDD _4100_/Q _4126_/CLK VSS _4100_/D VDD VSS gf180mcu_fd_sc_mcu7t5v0__dffq_1
XFILLER_96_378 VDD VSS VDD VSS gf180mcu_fd_sc_mcu7t5v0__fillcap_4
X_4031_ VDD _4031_/Q _4612_/CLK VSS _4031_/D VDD VSS gf180mcu_fd_sc_mcu7t5v0__dffq_1
XFILLER_238_885 VDD VSS VDD VSS gf180mcu_fd_sc_mcu7t5v0__fillcap_4
XFILLER_225_524 VDD VSS VDD VSS gf180mcu_fd_sc_mcu7t5v0__fillcap_16
XFILLER_252_387 VDD VSS VDD VSS gf180mcu_fd_sc_mcu7t5v0__fillcap_64
XFILLER_240_527 VDD VSS VDD VSS gf180mcu_fd_sc_mcu7t5v0__fillcap_64
XFILLER_178_667 VDD VSS VDD VSS gf180mcu_fd_sc_mcu7t5v0__fillcap_8
XFILLER_166_807 VDD VSS VDD VSS gf180mcu_fd_sc_mcu7t5v0__fillcap_16
X_3815_ _3821_/S VDD VSS _3971_/D wire179/Z _3971_/Q VDD VSS gf180mcu_fd_sc_mcu7t5v0__mux2_2
XFILLER_165_328 VDD VSS VDD VSS gf180mcu_fd_sc_mcu7t5v0__fillcap_16
X_3746_ _3747_/S VDD VSS _3920_/D _3766_/I0 _3920_/Q VDD VSS gf180mcu_fd_sc_mcu7t5v0__mux2_2
XFILLER_118_200 VDD VSS VDD VSS gf180mcu_fd_sc_mcu7t5v0__fillcap_32
XFILLER_119_756 VDD VSS VDD VSS gf180mcu_fd_sc_mcu7t5v0__fillcap_8
XFILLER_134_715 VDD VSS VDD VSS gf180mcu_fd_sc_mcu7t5v0__fillcap_4
XFILLER_134_737 VDD VSS VDD VSS gf180mcu_fd_sc_mcu7t5v0__fillcap_64
XFILLER_146_597 VDD VSS VDD VSS gf180mcu_fd_sc_mcu7t5v0__fillcap_16
XFILLER_146_586 VDD VSS VDD VSS gf180mcu_fd_sc_mcu7t5v0__fillcap_8
X_3677_ _3677_/B1 _4191_/Q VDD VSS _3678_/I _4497_/Q _3682_/A2 VDD VSS gf180mcu_fd_sc_mcu7t5v0__aoi22_1
X_2628_ VDD _2628_/B _2628_/A2 _4214_/D _2276_/C VSS VDD VSS gf180mcu_fd_sc_mcu7t5v0__oai21_1
XFILLER_133_236 VDD VSS VDD VSS gf180mcu_fd_sc_mcu7t5v0__fillcap_4
XFILLER_217_72 VDD VSS VDD VSS gf180mcu_fd_sc_mcu7t5v0__fillcap_64
X_2559_ wire28/Z VDD VSS _4182_/D _4456_/Q _4182_/Q VDD VSS gf180mcu_fd_sc_mcu7t5v0__mux2_2
XFILLER_102_645 VDD VSS VDD VSS gf180mcu_fd_sc_mcu7t5v0__fillcap_8
X_4229_ _4229_/D _4229_/Q _4530_/RN VSS _4530_/CLK VDD VDD VSS gf180mcu_fd_sc_mcu7t5v0__dffrnq_1
XFILLER_229_874 VDD VSS VDD VSS gf180mcu_fd_sc_mcu7t5v0__fillcap_16
XFILLER_262_107 VDD VSS VDD VSS gf180mcu_fd_sc_mcu7t5v0__fillcap_64
Xmax_cap26 VSS _2637_/A2 _2600_/A1 VDD VDD VSS gf180mcu_fd_sc_mcu7t5v0__buf_2
XFILLER_244_877 VDD VSS VDD VSS gf180mcu_fd_sc_mcu7t5v0__fillcap_8
XFILLER_83_562 VDD VSS VDD VSS gf180mcu_fd_sc_mcu7t5v0__fillcap_8
XFILLER_71_702 VDD VSS VDD VSS gf180mcu_fd_sc_mcu7t5v0__fillcap_64
XFILLER_212_730 VDD VSS VDD VSS gf180mcu_fd_sc_mcu7t5v0__fillcap_4
XFILLER_51_492 VDD VSS VDD VSS gf180mcu_fd_sc_mcu7t5v0__fillcap_64
XFILLER_184_648 VDD VSS VDD VSS gf180mcu_fd_sc_mcu7t5v0__fillcap_16
XFILLER_168_199 VDD VSS VDD VSS gf180mcu_fd_sc_mcu7t5v0__fillcap_16
XFILLER_165_884 VDD VSS VDD VSS gf180mcu_fd_sc_mcu7t5v0__fillcap_4
XFILLER_171_309 VDD VSS VDD VSS gf180mcu_fd_sc_mcu7t5v0__fillcap_32
XFILLER_124_236 VDD VSS VDD VSS gf180mcu_fd_sc_mcu7t5v0__fillcap_8
XFILLER_11_72 VDD VSS VDD VSS gf180mcu_fd_sc_mcu7t5v0__fillcap_64
XFILLER_152_589 VDD VSS VDD VSS gf180mcu_fd_sc_mcu7t5v0__fillcap_4
XFILLER_127_83 VDD VSS VDD VSS gf180mcu_fd_sc_mcu7t5v0__fillcap_16
XFILLER_127_72 VDD VSS VDD VSS gf180mcu_fd_sc_mcu7t5v0__fillcap_4
XFILLER_266_457 VDD VSS VDD VSS gf180mcu_fd_sc_mcu7t5v0__fillcap_64
XFILLER_143_60 VDD VSS VDD VSS gf180mcu_fd_sc_mcu7t5v0__fillcap_8
XFILLER_207_502 VDD VSS VDD VSS gf180mcu_fd_sc_mcu7t5v0__fillcap_32
XFILLER_234_387 VDD VSS VDD VSS gf180mcu_fd_sc_mcu7t5v0__fillcap_64
XFILLER_222_527 VDD VSS VDD VSS gf180mcu_fd_sc_mcu7t5v0__fillcap_4
XFILLER_61_212 VDD VSS VDD VSS gf180mcu_fd_sc_mcu7t5v0__fillcap_64
X_1930_ VDD VSS _4541_/Q _3768_/A2 VDD VSS gf180mcu_fd_sc_mcu7t5v0__clkinv_1
XFILLER_148_807 VDD VSS VDD VSS gf180mcu_fd_sc_mcu7t5v0__fillcap_4
XFILLER_199_291 VDD VSS VDD VSS gf180mcu_fd_sc_mcu7t5v0__fillcap_8
XFILLER_187_486 VDD VSS VDD VSS gf180mcu_fd_sc_mcu7t5v0__fillcap_4
XFILLER_159_199 VDD VSS VDD VSS gf180mcu_fd_sc_mcu7t5v0__fillcap_8
X_3600_ _3600_/A3 VDD VSS _3601_/B wire82/Z _3600_/A2 VDD VSS gf180mcu_fd_sc_mcu7t5v0__nand3_1
X_4580_ _4580_/D _4580_/Q _4580_/RN VSS _4580_/CLK VDD VDD VSS gf180mcu_fd_sc_mcu7t5v0__dffrnq_1
XFILLER_174_169 VDD VSS VDD VSS gf180mcu_fd_sc_mcu7t5v0__fillcap_4
XFILLER_128_542 VDD VSS VDD VSS gf180mcu_fd_sc_mcu7t5v0__fillcap_4
X_3531_ _3597_/S VDD VSS _3531_/Z _4094_/Q _4086_/Q VDD VSS gf180mcu_fd_sc_mcu7t5v0__mux2_2
XFILLER_128_597 VDD VSS VDD VSS gf180mcu_fd_sc_mcu7t5v0__fillcap_8
XFILLER_116_715 VDD VSS VDD VSS gf180mcu_fd_sc_mcu7t5v0__fillcap_4
XFILLER_116_737 VDD VSS VDD VSS gf180mcu_fd_sc_mcu7t5v0__fillcap_64
XFILLER_171_876 VDD VSS VDD VSS gf180mcu_fd_sc_mcu7t5v0__fillcap_8
X_3462_ _3462_/B _3515_/C VDD VSS _3463_/B _3586_/S _3462_/A2 VDD VSS gf180mcu_fd_sc_mcu7t5v0__oai211_1
XFILLER_254_37 VDD VSS VDD VSS gf180mcu_fd_sc_mcu7t5v0__fillcap_64
XFILLER_170_364 VDD VSS VDD VSS gf180mcu_fd_sc_mcu7t5v0__fillcap_16
X_3393_ _3393_/B VDD VSS _4436_/D _3426_/A3 wire56/Z VDD VSS gf180mcu_fd_sc_mcu7t5v0__aoi21_1
X_2413_ _2413_/S VDD VSS _4049_/D _2454_/I0 _4049_/Q VDD VSS gf180mcu_fd_sc_mcu7t5v0__mux2_2
XFILLER_42_2 VDD VSS VDD VSS gf180mcu_fd_sc_mcu7t5v0__fillcap_32
X_2344_ VDD _2344_/B _4343_/Q _3027_/A3 _4344_/Q VSS VDD VSS gf180mcu_fd_sc_mcu7t5v0__oai21_1
XFILLER_130_239 VDD VSS VDD VSS gf180mcu_fd_sc_mcu7t5v0__fillcap_4
XFILLER_97_632 VDD VSS VDD VSS gf180mcu_fd_sc_mcu7t5v0__fillcap_8
X_2275_ _4208_/Q _4207_/Q VDD VSS _2276_/A2 _4210_/Q _4209_/Q VDD VSS gf180mcu_fd_sc_mcu7t5v0__nor4_1
XFILLER_244_107 VDD VSS VDD VSS gf180mcu_fd_sc_mcu7t5v0__fillcap_64
X_4014_ VDD _4014_/Q _4033_/CLK VSS _4014_/D VDD VSS gf180mcu_fd_sc_mcu7t5v0__dffq_1
XFILLER_226_877 VDD VSS VDD VSS gf180mcu_fd_sc_mcu7t5v0__fillcap_8
XFILLER_65_562 VDD VSS VDD VSS gf180mcu_fd_sc_mcu7t5v0__fillcap_64
XFILLER_53_702 VDD VSS VDD VSS gf180mcu_fd_sc_mcu7t5v0__fillcap_64
XFILLER_241_836 VDD VSS VDD VSS gf180mcu_fd_sc_mcu7t5v0__fillcap_4
XFILLER_253_696 VDD VSS VDD VSS gf180mcu_fd_sc_mcu7t5v0__fillcap_4
XFILLER_198_729 VDD VSS VDD VSS gf180mcu_fd_sc_mcu7t5v0__fillcap_4
XFILLER_92_381 VDD VSS VDD VSS gf180mcu_fd_sc_mcu7t5v0__fillcap_4
XFILLER_80_521 VDD VSS VDD VSS gf180mcu_fd_sc_mcu7t5v0__fillcap_4
XFILLER_178_431 VDD VSS VDD VSS gf180mcu_fd_sc_mcu7t5v0__fillcap_16
XFILLER_33_492 VDD VSS VDD VSS gf180mcu_fd_sc_mcu7t5v0__fillcap_64
XFILLER_21_632 VDD VSS VDD VSS gf180mcu_fd_sc_mcu7t5v0__fillcap_64
XFILLER_166_659 VDD VSS VDD VSS gf180mcu_fd_sc_mcu7t5v0__fillcap_4
X_3729_ VDD VSS _3759_/A2 _4540_/Q _3768_/A2 VDD VSS gf180mcu_fd_sc_mcu7t5v0__nor2_1
XFILLER_180_139 VDD VSS VDD VSS gf180mcu_fd_sc_mcu7t5v0__fillcap_16
XFILLER_106_247 VDD VSS VDD VSS gf180mcu_fd_sc_mcu7t5v0__fillcap_32
XFILLER_164_26 VDD VSS VDD VSS gf180mcu_fd_sc_mcu7t5v0__fillcap_8
XFILLER_164_37 VDD VSS VDD VSS gf180mcu_fd_sc_mcu7t5v0__fillcap_4
XFILLER_87_142 VDD VSS VDD VSS gf180mcu_fd_sc_mcu7t5v0__fillcap_64
XFILLER_248_457 VDD VSS VDD VSS gf180mcu_fd_sc_mcu7t5v0__fillcap_64
XFILLER_263_416 VDD VSS VDD VSS gf180mcu_fd_sc_mcu7t5v0__fillcap_4
XFILLER_216_387 VDD VSS VDD VSS gf180mcu_fd_sc_mcu7t5v0__fillcap_64
XFILLER_232_836 VDD VSS VDD VSS gf180mcu_fd_sc_mcu7t5v0__fillcap_32
XFILLER_43_212 VDD VSS VDD VSS gf180mcu_fd_sc_mcu7t5v0__fillcap_64
XFILLER_231_346 VDD VSS VDD VSS gf180mcu_fd_sc_mcu7t5v0__fillcap_4
XFILLER_244_2 VDD VSS VDD VSS gf180mcu_fd_sc_mcu7t5v0__fillcap_32
XFILLER_11_142 VDD VSS VDD VSS gf180mcu_fd_sc_mcu7t5v0__fillcap_64
XFILLER_184_467 VDD VSS VDD VSS gf180mcu_fd_sc_mcu7t5v0__fillcap_8
XFILLER_200_777 VDD VSS VDD VSS gf180mcu_fd_sc_mcu7t5v0__fillcap_8
XFILLER_125_556 VDD VSS VDD VSS gf180mcu_fd_sc_mcu7t5v0__fillcap_4
XFILLER_3_352 VDD VSS VDD VSS gf180mcu_fd_sc_mcu7t5v0__fillcap_64
XFILLER_112_228 VDD VSS VDD VSS gf180mcu_fd_sc_mcu7t5v0__fillcap_16
XFILLER_79_632 VDD VSS VDD VSS gf180mcu_fd_sc_mcu7t5v0__fillcap_64
Xclkbuf_leaf_7_clk_i _4485_/CLK VSS VDD clkload1/I VDD VSS gf180mcu_fd_sc_mcu7t5v0__clkbuf_2
XFILLER_267_766 VDD VSS VDD VSS gf180mcu_fd_sc_mcu7t5v0__fillcap_4
XFILLER_226_107 VDD VSS VDD VSS gf180mcu_fd_sc_mcu7t5v0__fillcap_64
XFILLER_120_283 VDD VSS VDD VSS gf180mcu_fd_sc_mcu7t5v0__fillcap_16
X_2060_ VDD VSS _2360_/A2 _4579_/Q _2084_/A2 VDD VSS gf180mcu_fd_sc_mcu7t5v0__nand2_1
XFILLER_208_866 VDD VSS VDD VSS gf180mcu_fd_sc_mcu7t5v0__fillcap_8
XFILLER_47_562 VDD VSS VDD VSS gf180mcu_fd_sc_mcu7t5v0__fillcap_64
XFILLER_35_702 VDD VSS VDD VSS gf180mcu_fd_sc_mcu7t5v0__fillcap_64
XFILLER_93_167 VDD VSS VDD VSS gf180mcu_fd_sc_mcu7t5v0__fillcap_4
XFILLER_208_877 VDD VSS VDD VSS gf180mcu_fd_sc_mcu7t5v0__fillcap_8
XFILLER_74_381 VDD VSS VDD VSS gf180mcu_fd_sc_mcu7t5v0__fillcap_4
XFILLER_62_521 VDD VSS VDD VSS gf180mcu_fd_sc_mcu7t5v0__fillcap_4
XFILLER_179_206 VDD VSS VDD VSS gf180mcu_fd_sc_mcu7t5v0__fillcap_4
XFILLER_90_885 VDD VSS VDD VSS gf180mcu_fd_sc_mcu7t5v0__fillcap_4
X_2962_ VDD VSS _3200_/A2 _3271_/B _2957_/B VDD VSS gf180mcu_fd_sc_mcu7t5v0__nand2_1
XFILLER_179_239 VDD VSS VDD VSS gf180mcu_fd_sc_mcu7t5v0__fillcap_16
X_1913_ VDD VSS _4329_/Q _3039_/A1 VDD VSS gf180mcu_fd_sc_mcu7t5v0__clkinv_1
XFILLER_15_492 VDD VSS VDD VSS gf180mcu_fd_sc_mcu7t5v0__fillcap_64
XFILLER_148_659 VDD VSS VDD VSS gf180mcu_fd_sc_mcu7t5v0__fillcap_4
X_2893_ VDD VSS _2894_/A3 _2893_/A1 _2893_/A2 VDD VSS gf180mcu_fd_sc_mcu7t5v0__nand2_1
XFILLER_30_451 VDD VSS VDD VSS gf180mcu_fd_sc_mcu7t5v0__fillcap_4
XFILLER_147_136 VDD VSS VDD VSS gf180mcu_fd_sc_mcu7t5v0__fillcap_4
X_4563_ _4563_/D _4563_/Q wire187/Z VSS _4565_/CLK VDD VDD VSS gf180mcu_fd_sc_mcu7t5v0__dffrnq_1
XFILLER_190_426 VDD VSS VDD VSS gf180mcu_fd_sc_mcu7t5v0__fillcap_16
XFILLER_190_415 VDD VSS VDD VSS gf180mcu_fd_sc_mcu7t5v0__fillcap_4
X_4494_ _4494_/D _4494_/Q wire209/Z VSS _4494_/CLK VDD VDD VSS gf180mcu_fd_sc_mcu7t5v0__dffrnq_1
X_3514_ VDD VSS _3515_/B _3597_/S _4069_/Q VDD VSS gf180mcu_fd_sc_mcu7t5v0__nand2_1
X_3445_ VSS VDD _3685_/C2 _4363_/Q _4195_/Q _3685_/B1 _3685_/A2 _4163_/Q _3454_/A1
+ VDD VSS gf180mcu_fd_sc_mcu7t5v0__aoi222_1
XFILLER_69_142 VDD VSS VDD VSS gf180mcu_fd_sc_mcu7t5v0__fillcap_64
X_3376_ wire20/I VDD VSS _4423_/D _4415_/Q _4423_/Q VDD VSS gf180mcu_fd_sc_mcu7t5v0__mux2_2
XFILLER_218_619 VDD VSS VDD VSS gf180mcu_fd_sc_mcu7t5v0__fillcap_4
X_2327_ wire51/Z VDD VSS _4528_/D _2896_/B _2858_/B VDD VSS gf180mcu_fd_sc_mcu7t5v0__nor3_1
XFILLER_84_101 VDD VSS VDD VSS gf180mcu_fd_sc_mcu7t5v0__fillcap_4
X_2258_ _2258_/A3 _2258_/A4 VDD VSS _2259_/A2 _2254_/Z _2258_/A2 VDD VSS gf180mcu_fd_sc_mcu7t5v0__nand4_1
XFILLER_245_416 VDD VSS VDD VSS gf180mcu_fd_sc_mcu7t5v0__fillcap_4
XFILLER_257_276 VDD VSS VDD VSS gf180mcu_fd_sc_mcu7t5v0__fillcap_4
XFILLER_66_871 VDD VSS VDD VSS gf180mcu_fd_sc_mcu7t5v0__fillcap_4
X_2189_ wire58/Z VDD VSS _2666_/C _4318_/Q _4504_/Q VDD VSS gf180mcu_fd_sc_mcu7t5v0__nand3_1
XFILLER_25_212 VDD VSS VDD VSS gf180mcu_fd_sc_mcu7t5v0__fillcap_64
XFILLER_201_508 VDD VSS VDD VSS gf180mcu_fd_sc_mcu7t5v0__fillcap_8
XFILLER_193_220 VDD VSS VDD VSS gf180mcu_fd_sc_mcu7t5v0__fillcap_4
XFILLER_178_294 VDD VSS VDD VSS gf180mcu_fd_sc_mcu7t5v0__fillcap_4
XFILLER_119_372 VDD VSS VDD VSS gf180mcu_fd_sc_mcu7t5v0__fillcap_8
XFILLER_134_331 VDD VSS VDD VSS gf180mcu_fd_sc_mcu7t5v0__fillcap_32
XFILLER_88_451 VDD VSS VDD VSS gf180mcu_fd_sc_mcu7t5v0__fillcap_4
XFILLER_249_766 VDD VSS VDD VSS gf180mcu_fd_sc_mcu7t5v0__fillcap_4
XFILLER_194_2 VDD VSS VDD VSS gf180mcu_fd_sc_mcu7t5v0__fillcap_32
XFILLER_208_107 VDD VSS VDD VSS gf180mcu_fd_sc_mcu7t5v0__fillcap_4
XFILLER_102_294 VDD VSS VDD VSS gf180mcu_fd_sc_mcu7t5v0__fillcap_16
XFILLER_29_562 VDD VSS VDD VSS gf180mcu_fd_sc_mcu7t5v0__fillcap_64
XFILLER_17_702 VDD VSS VDD VSS gf180mcu_fd_sc_mcu7t5v0__fillcap_64
XFILLER_44_521 VDD VSS VDD VSS gf180mcu_fd_sc_mcu7t5v0__fillcap_4
XFILLER_56_381 VDD VSS VDD VSS gf180mcu_fd_sc_mcu7t5v0__fillcap_4
XFILLER_204_357 VDD VSS VDD VSS gf180mcu_fd_sc_mcu7t5v0__fillcap_16
XFILLER_72_885 VDD VSS VDD VSS gf180mcu_fd_sc_mcu7t5v0__fillcap_4
XFILLER_157_412 VDD VSS VDD VSS gf180mcu_fd_sc_mcu7t5v0__fillcap_8
XFILLER_12_451 VDD VSS VDD VSS gf180mcu_fd_sc_mcu7t5v0__fillcap_4
XFILLER_145_618 VDD VSS VDD VSS gf180mcu_fd_sc_mcu7t5v0__fillcap_4
XFILLER_144_128 VDD VSS VDD VSS gf180mcu_fd_sc_mcu7t5v0__fillcap_4
XFILLER_137_180 VDD VSS VDD VSS gf180mcu_fd_sc_mcu7t5v0__fillcap_16
XFILLER_4_661 VDD VSS VDD VSS gf180mcu_fd_sc_mcu7t5v0__fillcap_4
XFILLER_180_470 VDD VSS VDD VSS gf180mcu_fd_sc_mcu7t5v0__fillcap_8
X_3230_ _3239_/A1 _3228_/Z _3241_/A2 VDD VSS _4350_/D _2863_/B VDD VSS gf180mcu_fd_sc_mcu7t5v0__oai22_1
X_3161_ _3999_/Q VSS VDD _3983_/Q _3991_/Q _3185_/S _3975_/Q _3187_/C _3161_/Z VDD
+ VSS gf180mcu_fd_sc_mcu7t5v0__mux4_1
XFILLER_66_101 VDD VSS VDD VSS gf180mcu_fd_sc_mcu7t5v0__fillcap_4
X_2112_ VDD VSS _4548_/D wire71/I _2112_/A2 VDD VSS gf180mcu_fd_sc_mcu7t5v0__xor2_1
XFILLER_239_276 VDD VSS VDD VSS gf180mcu_fd_sc_mcu7t5v0__fillcap_4
XFILLER_227_416 VDD VSS VDD VSS gf180mcu_fd_sc_mcu7t5v0__fillcap_4
X_3092_ VDD VSS _3096_/A1 _4551_/Q _3884_/Q VDD VSS gf180mcu_fd_sc_mcu7t5v0__nor2_1
XFILLER_48_871 VDD VSS VDD VSS gf180mcu_fd_sc_mcu7t5v0__fillcap_4
X_2043_ VDD VSS _2044_/I _3853_/Q _3390_/A2 VDD VSS gf180mcu_fd_sc_mcu7t5v0__nand2_1
XFILLER_63_874 VDD VSS VDD VSS gf180mcu_fd_sc_mcu7t5v0__fillcap_16
XFILLER_90_682 VDD VSS VDD VSS gf180mcu_fd_sc_mcu7t5v0__fillcap_16
X_3994_ VDD _3994_/Q _3998_/CLK VSS _3994_/D VDD VSS gf180mcu_fd_sc_mcu7t5v0__dffq_1
X_2945_ _2943_/Z _2945_/A4 VDD VSS _2950_/A2 _2945_/A1 _2945_/A2 VDD VSS gf180mcu_fd_sc_mcu7t5v0__nor4_1
XFILLER_191_702 VDD VSS VDD VSS gf180mcu_fd_sc_mcu7t5v0__fillcap_64
X_2876_ _3015_/C VDD VSS _2878_/A2 _4370_/Q _4363_/Q VDD VSS gf180mcu_fd_sc_mcu7t5v0__aoi21_1
X_4615_ _4615_/D _4615_/Q _4616_/RN VSS _4615_/CLK VDD VDD VSS gf180mcu_fd_sc_mcu7t5v0__dffrnq_1
X_4546_ _4546_/D _4564_/D _4616_/RN VSS _4595_/CLK VDD VDD VSS gf180mcu_fd_sc_mcu7t5v0__dffrnq_1
XFILLER_128_191 VDD VSS VDD VSS gf180mcu_fd_sc_mcu7t5v0__fillcap_8
XFILLER_171_492 VDD VSS VDD VSS gf180mcu_fd_sc_mcu7t5v0__fillcap_8
X_4477_ _4477_/D _4477_/Q wire193/Z VSS _4477_/CLK VDD VDD VSS gf180mcu_fd_sc_mcu7t5v0__dffrnq_1
XFILLER_132_857 VDD VSS VDD VSS gf180mcu_fd_sc_mcu7t5v0__fillcap_4
XFILLER_225_50 VDD VSS VDD VSS gf180mcu_fd_sc_mcu7t5v0__fillcap_16
X_3428_ VDD VSS _3433_/A2 wire74/Z _3427_/Z VDD VSS gf180mcu_fd_sc_mcu7t5v0__nand2_1
XFILLER_225_72 VDD VSS VDD VSS gf180mcu_fd_sc_mcu7t5v0__fillcap_64
X_3359_ wire21/Z VDD VSS _4406_/D _4398_/Q _4406_/Q VDD VSS gf180mcu_fd_sc_mcu7t5v0__mux2_2
XFILLER_38_37 VDD VSS VDD VSS gf180mcu_fd_sc_mcu7t5v0__fillcap_64
XFILLER_100_765 VDD VSS VDD VSS gf180mcu_fd_sc_mcu7t5v0__fillcap_4
XFILLER_26_521 VDD VSS VDD VSS gf180mcu_fd_sc_mcu7t5v0__fillcap_4
XFILLER_38_381 VDD VSS VDD VSS gf180mcu_fd_sc_mcu7t5v0__fillcap_4
XFILLER_166_6 VDD VSS VDD VSS gf180mcu_fd_sc_mcu7t5v0__fillcap_16
XFILLER_214_655 VDD VSS VDD VSS gf180mcu_fd_sc_mcu7t5v0__fillcap_8
XFILLER_54_885 VDD VSS VDD VSS gf180mcu_fd_sc_mcu7t5v0__fillcap_4
XFILLER_81_693 VDD VSS VDD VSS gf180mcu_fd_sc_mcu7t5v0__fillcap_4
XFILLER_139_456 VDD VSS VDD VSS gf180mcu_fd_sc_mcu7t5v0__fillcap_16
XFILLER_181_212 VDD VSS VDD VSS gf180mcu_fd_sc_mcu7t5v0__fillcap_32
XFILLER_119_51 VDD VSS VDD VSS gf180mcu_fd_sc_mcu7t5v0__fillcap_16
XFILLER_207_2 VDD VSS VDD VSS gf180mcu_fd_sc_mcu7t5v0__fillcap_32
XFILLER_122_323 VDD VSS VDD VSS gf180mcu_fd_sc_mcu7t5v0__fillcap_16
XFILLER_79_66 VDD VSS VDD VSS gf180mcu_fd_sc_mcu7t5v0__fillcap_4
Xclkbuf_leaf_72_clk_i _4062_/CLK VSS VDD clkbuf_3_2__f_clk_i/Z VDD VSS gf180mcu_fd_sc_mcu7t5v0__clkbuf_2
XFILLER_89_760 VDD VSS VDD VSS gf180mcu_fd_sc_mcu7t5v0__fillcap_4
XFILLER_135_72 VDD VSS VDD VSS gf180mcu_fd_sc_mcu7t5v0__fillcap_16
XFILLER_48_101 VDD VSS VDD VSS gf180mcu_fd_sc_mcu7t5v0__fillcap_4
Xclkbuf_leaf_87_clk_i _4265_/CLK VSS VDD clkload2/I VDD VSS gf180mcu_fd_sc_mcu7t5v0__clkbuf_2
XFILLER_45_874 VDD VSS VDD VSS gf180mcu_fd_sc_mcu7t5v0__fillcap_16
Xclkbuf_leaf_10_clk_i _4446_/CLK VSS VDD clkload3/I VDD VSS gf180mcu_fd_sc_mcu7t5v0__clkbuf_2
XFILLER_60_877 VDD VSS VDD VSS gf180mcu_fd_sc_mcu7t5v0__fillcap_8
X_2730_ _2730_/S VDD VSS _4264_/D _4264_/Q _4446_/Q VDD VSS gf180mcu_fd_sc_mcu7t5v0__mux2_2
XFILLER_185_584 VDD VSS VDD VSS gf180mcu_fd_sc_mcu7t5v0__fillcap_4
X_2661_ _2666_/B1 _4147_/Q VDD VSS _2663_/B1 _4268_/Q _2168_/Z VDD VSS gf180mcu_fd_sc_mcu7t5v0__aoi22_1
XFILLER_173_702 VDD VSS VDD VSS gf180mcu_fd_sc_mcu7t5v0__fillcap_4
Xclkbuf_leaf_25_clk_i _4459_/CLK VSS VDD clkload3/I VDD VSS gf180mcu_fd_sc_mcu7t5v0__clkbuf_2
XFILLER_8_241 VDD VSS VDD VSS gf180mcu_fd_sc_mcu7t5v0__fillcap_4
X_4400_ _4400_/D _4400_/Q wire196/Z VSS _4400_/CLK VDD VDD VSS gf180mcu_fd_sc_mcu7t5v0__dffrnq_1
X_2592_ VDD VSS _2606_/C _2600_/A1 _2587_/Z VDD VSS gf180mcu_fd_sc_mcu7t5v0__nor2_1
X_4331_ _4331_/D _4331_/Q _4525_/RN VSS _4355_/CLK VDD VDD VSS gf180mcu_fd_sc_mcu7t5v0__dffrnq_1
XFILLER_153_492 VDD VSS VDD VSS gf180mcu_fd_sc_mcu7t5v0__fillcap_16
XFILLER_141_632 VDD VSS VDD VSS gf180mcu_fd_sc_mcu7t5v0__fillcap_8
XFILLER_126_684 VDD VSS VDD VSS gf180mcu_fd_sc_mcu7t5v0__fillcap_32
X_4262_ _4262_/D _4262_/Q _4371_/RN VSS _4535_/CLK VDD VDD VSS gf180mcu_fd_sc_mcu7t5v0__dffrnq_1
XFILLER_113_345 VDD VSS VDD VSS gf180mcu_fd_sc_mcu7t5v0__fillcap_4
XFILLER_262_37 VDD VSS VDD VSS gf180mcu_fd_sc_mcu7t5v0__fillcap_64
X_3213_ _3213_/B VDD VSS _4345_/D _2344_/B _3213_/A2 VDD VSS gf180mcu_fd_sc_mcu7t5v0__aoi21_1
X_4193_ _4193_/D _4193_/Q wire210/Z VSS _4467_/CLK VDD VDD VSS gf180mcu_fd_sc_mcu7t5v0__dffrnq_1
X_3144_ _3185_/S VDD VSS _3144_/Z _3950_/Q _3942_/Q VDD VSS gf180mcu_fd_sc_mcu7t5v0__mux2_2
X_3075_ VDD _3158_/B _3899_/Q _3076_/B2 _4551_/Q VSS VDD VSS gf180mcu_fd_sc_mcu7t5v0__oai21_1
X_2026_ VDD VSS _3896_/Q _3717_/A1 VDD VSS gf180mcu_fd_sc_mcu7t5v0__clkinv_1
XFILLER_82_457 VDD VSS VDD VSS gf180mcu_fd_sc_mcu7t5v0__fillcap_64
XFILLER_36_885 VDD VSS VDD VSS gf180mcu_fd_sc_mcu7t5v0__fillcap_4
XFILLER_251_772 VDD VSS VDD VSS gf180mcu_fd_sc_mcu7t5v0__fillcap_64
XFILLER_211_625 VDD VSS VDD VSS gf180mcu_fd_sc_mcu7t5v0__fillcap_4
X_3977_ VDD _3977_/Q _3998_/CLK VSS _3977_/D VDD VSS gf180mcu_fd_sc_mcu7t5v0__dffq_1
XFILLER_50_387 VDD VSS VDD VSS gf180mcu_fd_sc_mcu7t5v0__fillcap_64
X_2928_ _2928_/A2 _4197_/Q _3244_/A1 VDD VSS _2931_/A2 _4331_/Q VDD VSS gf180mcu_fd_sc_mcu7t5v0__oai22_1
Xmax_length208 _4498_/RN wire209/Z VDD VSS VDD VSS gf180mcu_fd_sc_mcu7t5v0__buf_8
XFILLER_163_212 VDD VSS VDD VSS gf180mcu_fd_sc_mcu7t5v0__fillcap_16
X_2859_ _2859_/B VDD VSS _2861_/A2 _4349_/Q _2863_/B VDD VSS gf180mcu_fd_sc_mcu7t5v0__aoi21_1
XFILLER_191_554 VDD VSS VDD VSS gf180mcu_fd_sc_mcu7t5v0__fillcap_4
X_4529_ VSS _4529_/CLK VDD _4529_/D _4529_/Q wire199/Z VDD VSS gf180mcu_fd_sc_mcu7t5v0__dffsnq_1
Xhold252 _3856_/D VSS _3855_/Q VDD VDD VSS gf180mcu_fd_sc_mcu7t5v0__dlyc_1
Xhold263 _4571_/D VSS _4576_/Q VDD VDD VSS gf180mcu_fd_sc_mcu7t5v0__dlyc_1
Xhold274 _4570_/D VSS _4575_/Q VDD VDD VSS gf180mcu_fd_sc_mcu7t5v0__dlyc_1
XFILLER_131_142 VDD VSS VDD VSS gf180mcu_fd_sc_mcu7t5v0__fillcap_16
XFILLER_218_257 VDD VSS VDD VSS gf180mcu_fd_sc_mcu7t5v0__fillcap_32
XFILLER_199_632 VDD VSS VDD VSS gf180mcu_fd_sc_mcu7t5v0__fillcap_32
XFILLER_27_874 VDD VSS VDD VSS gf180mcu_fd_sc_mcu7t5v0__fillcap_16
XFILLER_60_107 VDD VSS VDD VSS gf180mcu_fd_sc_mcu7t5v0__fillcap_64
XFILLER_157_2 VDD VSS VDD VSS gf180mcu_fd_sc_mcu7t5v0__fillcap_64
XFILLER_241_282 VDD VSS VDD VSS gf180mcu_fd_sc_mcu7t5v0__fillcap_64
XFILLER_42_877 VDD VSS VDD VSS gf180mcu_fd_sc_mcu7t5v0__fillcap_8
XFILLER_167_562 VDD VSS VDD VSS gf180mcu_fd_sc_mcu7t5v0__fillcap_8
XFILLER_182_521 VDD VSS VDD VSS gf180mcu_fd_sc_mcu7t5v0__fillcap_4
XFILLER_194_381 VDD VSS VDD VSS gf180mcu_fd_sc_mcu7t5v0__fillcap_4
XFILLER_108_651 VDD VSS VDD VSS gf180mcu_fd_sc_mcu7t5v0__fillcap_8
XFILLER_142_429 VDD VSS VDD VSS gf180mcu_fd_sc_mcu7t5v0__fillcap_4
XFILLER_135_492 VDD VSS VDD VSS gf180mcu_fd_sc_mcu7t5v0__fillcap_4
XFILLER_96_527 VDD VSS VDD VSS gf180mcu_fd_sc_mcu7t5v0__fillcap_4
XFILLER_237_500 VDD VSS VDD VSS gf180mcu_fd_sc_mcu7t5v0__fillcap_4
XFILLER_96_549 VDD VSS VDD VSS gf180mcu_fd_sc_mcu7t5v0__fillcap_32
XFILLER_265_842 VDD VSS VDD VSS gf180mcu_fd_sc_mcu7t5v0__fillcap_32
XFILLER_218_780 VDD VSS VDD VSS gf180mcu_fd_sc_mcu7t5v0__fillcap_8
XFILLER_64_457 VDD VSS VDD VSS gf180mcu_fd_sc_mcu7t5v0__fillcap_64
XFILLER_91_276 VDD VSS VDD VSS gf180mcu_fd_sc_mcu7t5v0__fillcap_4
XFILLER_18_885 VDD VSS VDD VSS gf180mcu_fd_sc_mcu7t5v0__fillcap_4
X_3900_ VDD _3900_/Q _3969_/CLK VSS _3900_/D VDD VSS gf180mcu_fd_sc_mcu7t5v0__dffq_1
XFILLER_189_142 VDD VSS VDD VSS gf180mcu_fd_sc_mcu7t5v0__fillcap_8
XFILLER_260_591 VDD VSS VDD VSS gf180mcu_fd_sc_mcu7t5v0__fillcap_4
X_3831_ VDD VSS _3839_/S _3831_/A1 _3840_/A2 VDD VSS gf180mcu_fd_sc_mcu7t5v0__nand2_1
XFILLER_32_387 VDD VSS VDD VSS gf180mcu_fd_sc_mcu7t5v0__fillcap_64
X_3762_ _3767_/S VDD VSS _3932_/D wire177/Z _3932_/Q VDD VSS gf180mcu_fd_sc_mcu7t5v0__mux2_2
XFILLER_20_527 VDD VSS VDD VSS gf180mcu_fd_sc_mcu7t5v0__fillcap_64
XFILLER_72_2 VDD VSS VDD VSS gf180mcu_fd_sc_mcu7t5v0__fillcap_32
X_3693_ _3696_/S VDD VSS _3879_/D _3879_/Q _3765_/I0 VDD VSS gf180mcu_fd_sc_mcu7t5v0__mux2_2
XFILLER_145_212 VDD VSS VDD VSS gf180mcu_fd_sc_mcu7t5v0__fillcap_32
X_2713_ _2713_/B1 _4283_/Q VDD VSS _2714_/I _4251_/Q _2226_/B VDD VSS gf180mcu_fd_sc_mcu7t5v0__aoi22_1
X_2644_ VDD VSS _2644_/Z _2644_/A1 _2644_/A2 VDD VSS gf180mcu_fd_sc_mcu7t5v0__or2_1
XFILLER_161_749 VDD VSS VDD VSS gf180mcu_fd_sc_mcu7t5v0__fillcap_16
X_2575_ _2575_/B VDD VSS _4195_/D _2928_/A2 wire27/Z VDD VSS gf180mcu_fd_sc_mcu7t5v0__aoi21_1
X_4314_ _4314_/D _4314_/Q wire192/Z VSS _4364_/CLK VDD VDD VSS gf180mcu_fd_sc_mcu7t5v0__dffrnq_1
XFILLER_114_654 VDD VSS VDD VSS gf180mcu_fd_sc_mcu7t5v0__fillcap_8
XFILLER_141_462 VDD VSS VDD VSS gf180mcu_fd_sc_mcu7t5v0__fillcap_4
XFILLER_114_687 VDD VSS VDD VSS gf180mcu_fd_sc_mcu7t5v0__fillcap_32
X_4245_ _4245_/D _4245_/Q wire206/Z VSS _4508_/CLK VDD VDD VSS gf180mcu_fd_sc_mcu7t5v0__dffrnq_1
X_4176_ _4176_/D _4176_/Q _4498_/RN VSS _4492_/CLK VDD VDD VSS gf180mcu_fd_sc_mcu7t5v0__dffrnq_1
XFILLER_110_871 VDD VSS VDD VSS gf180mcu_fd_sc_mcu7t5v0__fillcap_4
XFILLER_255_352 VDD VSS VDD VSS gf180mcu_fd_sc_mcu7t5v0__fillcap_64
X_3127_ _4508_/Q VDD VSS wire65/I _4250_/Q _4258_/Q VDD VSS gf180mcu_fd_sc_mcu7t5v0__mux2_2
X_3058_ VDD VSS _3063_/A2 wire94/Z _3057_/Z VDD VSS gf180mcu_fd_sc_mcu7t5v0__nor2_1
XFILLER_42_107 VDD VSS VDD VSS gf180mcu_fd_sc_mcu7t5v0__fillcap_64
X_2009_ VDD VSS _3954_/Q _3789_/A1 VDD VSS gf180mcu_fd_sc_mcu7t5v0__clkinv_1
XFILLER_211_422 VDD VSS VDD VSS gf180mcu_fd_sc_mcu7t5v0__fillcap_64
XFILLER_223_282 VDD VSS VDD VSS gf180mcu_fd_sc_mcu7t5v0__fillcap_64
XFILLER_24_877 VDD VSS VDD VSS gf180mcu_fd_sc_mcu7t5v0__fillcap_8
XFILLER_149_540 VDD VSS VDD VSS gf180mcu_fd_sc_mcu7t5v0__fillcap_16
XFILLER_51_696 VDD VSS VDD VSS gf180mcu_fd_sc_mcu7t5v0__fillcap_4
XFILLER_149_562 VDD VSS VDD VSS gf180mcu_fd_sc_mcu7t5v0__fillcap_4
XFILLER_137_702 VDD VSS VDD VSS gf180mcu_fd_sc_mcu7t5v0__fillcap_32
XFILLER_195_156 VDD VSS VDD VSS gf180mcu_fd_sc_mcu7t5v0__fillcap_4
XFILLER_109_415 VDD VSS VDD VSS gf180mcu_fd_sc_mcu7t5v0__fillcap_4
XFILLER_192_885 VDD VSS VDD VSS gf180mcu_fd_sc_mcu7t5v0__fillcap_4
XFILLER_191_340 VDD VSS VDD VSS gf180mcu_fd_sc_mcu7t5v0__fillcap_8
XFILLER_117_492 VDD VSS VDD VSS gf180mcu_fd_sc_mcu7t5v0__fillcap_4
XFILLER_105_632 VDD VSS VDD VSS gf180mcu_fd_sc_mcu7t5v0__fillcap_4
XFILLER_2_247 VDD VSS VDD VSS gf180mcu_fd_sc_mcu7t5v0__fillcap_64
XFILLER_78_527 VDD VSS VDD VSS gf180mcu_fd_sc_mcu7t5v0__fillcap_64
XFILLER_105_676 VDD VSS VDD VSS gf180mcu_fd_sc_mcu7t5v0__fillcap_16
XFILLER_247_842 VDD VSS VDD VSS gf180mcu_fd_sc_mcu7t5v0__fillcap_32
XFILLER_262_801 VDD VSS VDD VSS gf180mcu_fd_sc_mcu7t5v0__fillcap_4
XFILLER_207_706 VDD VSS VDD VSS gf180mcu_fd_sc_mcu7t5v0__fillcap_4
XFILLER_86_582 VDD VSS VDD VSS gf180mcu_fd_sc_mcu7t5v0__fillcap_8
XFILLER_100_381 VDD VSS VDD VSS gf180mcu_fd_sc_mcu7t5v0__fillcap_4
XFILLER_46_457 VDD VSS VDD VSS gf180mcu_fd_sc_mcu7t5v0__fillcap_64
XFILLER_73_276 VDD VSS VDD VSS gf180mcu_fd_sc_mcu7t5v0__fillcap_4
XFILLER_61_416 VDD VSS VDD VSS gf180mcu_fd_sc_mcu7t5v0__fillcap_4
XFILLER_230_731 VDD VSS VDD VSS gf180mcu_fd_sc_mcu7t5v0__fillcap_4
XFILLER_242_591 VDD VSS VDD VSS gf180mcu_fd_sc_mcu7t5v0__fillcap_4
XFILLER_186_101 VDD VSS VDD VSS gf180mcu_fd_sc_mcu7t5v0__fillcap_4
XFILLER_14_387 VDD VSS VDD VSS gf180mcu_fd_sc_mcu7t5v0__fillcap_64
XFILLER_202_444 VDD VSS VDD VSS gf180mcu_fd_sc_mcu7t5v0__fillcap_8
XFILLER_6_597 VDD VSS VDD VSS gf180mcu_fd_sc_mcu7t5v0__fillcap_64
X_2360_ VDD VSS _2483_/A1 _4578_/Q _2360_/A2 VDD VSS gf180mcu_fd_sc_mcu7t5v0__nor2_1
X_2291_ VDD VSS _3451_/A1 _4430_/Q _3453_/A3 VDD VSS gf180mcu_fd_sc_mcu7t5v0__nand2_1
XFILLER_110_101 VDD VSS VDD VSS gf180mcu_fd_sc_mcu7t5v0__fillcap_4
X_4030_ VDD _4030_/Q _4033_/CLK VSS _4030_/D VDD VSS gf180mcu_fd_sc_mcu7t5v0__dffq_1
XFILLER_111_679 VDD VSS VDD VSS gf180mcu_fd_sc_mcu7t5v0__fillcap_16
XFILLER_237_352 VDD VSS VDD VSS gf180mcu_fd_sc_mcu7t5v0__fillcap_64
XFILLER_252_311 VDD VSS VDD VSS gf180mcu_fd_sc_mcu7t5v0__fillcap_4
XFILLER_264_171 VDD VSS VDD VSS gf180mcu_fd_sc_mcu7t5v0__fillcap_4
XFILLER_65_766 VDD VSS VDD VSS gf180mcu_fd_sc_mcu7t5v0__fillcap_4
XFILLER_24_107 VDD VSS VDD VSS gf180mcu_fd_sc_mcu7t5v0__fillcap_64
XFILLER_205_282 VDD VSS VDD VSS gf180mcu_fd_sc_mcu7t5v0__fillcap_16
XFILLER_220_241 VDD VSS VDD VSS gf180mcu_fd_sc_mcu7t5v0__fillcap_4
XFILLER_268_36 VDD VSS VDD VSS gf180mcu_fd_sc_mcu7t5v0__fillcap_32
XFILLER_33_696 VDD VSS VDD VSS gf180mcu_fd_sc_mcu7t5v0__fillcap_4
XFILLER_21_836 VDD VSS VDD VSS gf180mcu_fd_sc_mcu7t5v0__fillcap_4
X_3814_ _3821_/S VDD VSS _3970_/D _3841_/I0 _3970_/Q VDD VSS gf180mcu_fd_sc_mcu7t5v0__mux2_2
XFILLER_119_702 VDD VSS VDD VSS gf180mcu_fd_sc_mcu7t5v0__fillcap_8
X_3745_ _3747_/S VDD VSS _3919_/D _3765_/I0 _3919_/Q VDD VSS gf180mcu_fd_sc_mcu7t5v0__mux2_2
XFILLER_146_543 VDD VSS VDD VSS gf180mcu_fd_sc_mcu7t5v0__fillcap_8
XFILLER_137_18 VDD VSS VDD VSS gf180mcu_fd_sc_mcu7t5v0__fillcap_8
XFILLER_161_524 VDD VSS VDD VSS gf180mcu_fd_sc_mcu7t5v0__fillcap_8
XFILLER_174_885 VDD VSS VDD VSS gf180mcu_fd_sc_mcu7t5v0__fillcap_4
X_3676_ VDD VSS _3676_/I _4496_/D VDD VSS gf180mcu_fd_sc_mcu7t5v0__clkinv_1
X_2627_ _2629_/A2 VDD VSS _2628_/B _2276_/C _2587_/Z VDD VSS gf180mcu_fd_sc_mcu7t5v0__nand3_1
Xclkbuf_4_1_0_host_clk_i _4573_/CLK VSS VDD clkbuf_0_host_clk_i/Z VDD VSS gf180mcu_fd_sc_mcu7t5v0__clkbuf_2
X_2558_ wire28/Z VDD VSS _4181_/D _4455_/Q _4181_/Q VDD VSS gf180mcu_fd_sc_mcu7t5v0__mux2_2
X_2489_ _2491_/S VDD VSS _4111_/D wire154/Z _4111_/Q VDD VSS gf180mcu_fd_sc_mcu7t5v0__mux2_2
XFILLER_229_842 VDD VSS VDD VSS gf180mcu_fd_sc_mcu7t5v0__fillcap_32
X_4228_ _4228_/D _4228_/Q _4530_/RN VSS _4530_/CLK VDD VDD VSS gf180mcu_fd_sc_mcu7t5v0__dffrnq_1
XFILLER_87_346 VDD VSS VDD VSS gf180mcu_fd_sc_mcu7t5v0__fillcap_4
XFILLER_244_801 VDD VSS VDD VSS gf180mcu_fd_sc_mcu7t5v0__fillcap_4
XFILLER_256_661 VDD VSS VDD VSS gf180mcu_fd_sc_mcu7t5v0__fillcap_4
XFILLER_233_72 VDD VSS VDD VSS gf180mcu_fd_sc_mcu7t5v0__fillcap_64
XFILLER_101_189 VDD VSS VDD VSS gf180mcu_fd_sc_mcu7t5v0__fillcap_16
XFILLER_216_514 VDD VSS VDD VSS gf180mcu_fd_sc_mcu7t5v0__fillcap_8
XFILLER_28_457 VDD VSS VDD VSS gf180mcu_fd_sc_mcu7t5v0__fillcap_64
X_4159_ _4159_/D _4159_/Q wire193/Z VSS _4476_/CLK VDD VDD VSS gf180mcu_fd_sc_mcu7t5v0__dffrnq_1
XFILLER_46_37 VDD VSS VDD VSS gf180mcu_fd_sc_mcu7t5v0__fillcap_64
XFILLER_204_709 VDD VSS VDD VSS gf180mcu_fd_sc_mcu7t5v0__fillcap_16
Xmax_cap49 VSS _2150_/A2 _2141_/A2 VDD VDD VSS gf180mcu_fd_sc_mcu7t5v0__buf_2
XFILLER_55_276 VDD VSS VDD VSS gf180mcu_fd_sc_mcu7t5v0__fillcap_4
XFILLER_43_416 VDD VSS VDD VSS gf180mcu_fd_sc_mcu7t5v0__fillcap_4
XFILLER_8_807 VDD VSS VDD VSS gf180mcu_fd_sc_mcu7t5v0__fillcap_64
XFILLER_11_346 VDD VSS VDD VSS gf180mcu_fd_sc_mcu7t5v0__fillcap_4
XFILLER_109_212 VDD VSS VDD VSS gf180mcu_fd_sc_mcu7t5v0__fillcap_8
XFILLER_183_148 VDD VSS VDD VSS gf180mcu_fd_sc_mcu7t5v0__fillcap_8
XFILLER_152_535 VDD VSS VDD VSS gf180mcu_fd_sc_mcu7t5v0__fillcap_4
XFILLER_194_79 VDD VSS VDD VSS gf180mcu_fd_sc_mcu7t5v0__fillcap_16
XFILLER_180_877 VDD VSS VDD VSS gf180mcu_fd_sc_mcu7t5v0__fillcap_8
XFILLER_3_556 VDD VSS VDD VSS gf180mcu_fd_sc_mcu7t5v0__fillcap_4
XFILLER_2_2 VDD VSS VDD VSS gf180mcu_fd_sc_mcu7t5v0__fillcap_32
XFILLER_79_836 VDD VSS VDD VSS gf180mcu_fd_sc_mcu7t5v0__fillcap_4
XFILLER_219_352 VDD VSS VDD VSS gf180mcu_fd_sc_mcu7t5v0__fillcap_64
XFILLER_143_72 VDD VSS VDD VSS gf180mcu_fd_sc_mcu7t5v0__fillcap_16
XFILLER_234_311 VDD VSS VDD VSS gf180mcu_fd_sc_mcu7t5v0__fillcap_4
XFILLER_246_171 VDD VSS VDD VSS gf180mcu_fd_sc_mcu7t5v0__fillcap_4
XFILLER_47_766 VDD VSS VDD VSS gf180mcu_fd_sc_mcu7t5v0__fillcap_4
XFILLER_15_696 VDD VSS VDD VSS gf180mcu_fd_sc_mcu7t5v0__fillcap_4
X_3530_ VDD VSS _3536_/A2 _3596_/A1 _3529_/Z VDD VSS gf180mcu_fd_sc_mcu7t5v0__nand2_1
XFILLER_156_885 VDD VSS VDD VSS gf180mcu_fd_sc_mcu7t5v0__fillcap_4
XFILLER_182_192 VDD VSS VDD VSS gf180mcu_fd_sc_mcu7t5v0__fillcap_32
X_3461_ VDD VSS _3462_/B _3586_/S _4067_/Q VDD VSS gf180mcu_fd_sc_mcu7t5v0__nand2_1
X_3392_ VDD VSS _3393_/B _4386_/Q wire56/Z VDD VSS gf180mcu_fd_sc_mcu7t5v0__nor2_1
X_2412_ _2413_/S VDD VSS _4048_/D wire152/Z _4048_/Q VDD VSS gf180mcu_fd_sc_mcu7t5v0__mux2_2
XFILLER_131_708 VDD VSS VDD VSS gf180mcu_fd_sc_mcu7t5v0__fillcap_8
X_2343_ VDD VSS _2345_/A2 _4344_/Q _4343_/Q VDD VSS gf180mcu_fd_sc_mcu7t5v0__nor2_1
XFILLER_123_270 VDD VSS VDD VSS gf180mcu_fd_sc_mcu7t5v0__fillcap_8
XFILLER_69_346 VDD VSS VDD VSS gf180mcu_fd_sc_mcu7t5v0__fillcap_4
XFILLER_238_661 VDD VSS VDD VSS gf180mcu_fd_sc_mcu7t5v0__fillcap_4
X_2274_ _4211_/Q VDD VSS _2623_/A2 _4213_/Q _4212_/Q VDD VSS gf180mcu_fd_sc_mcu7t5v0__nand3_1
X_4013_ VDD _4013_/Q _4028_/CLK VSS _4013_/D VDD VSS gf180mcu_fd_sc_mcu7t5v0__dffq_1
XFILLER_25_416 VDD VSS VDD VSS gf180mcu_fd_sc_mcu7t5v0__fillcap_4
XFILLER_37_276 VDD VSS VDD VSS gf180mcu_fd_sc_mcu7t5v0__fillcap_4
XFILLER_206_591 VDD VSS VDD VSS gf180mcu_fd_sc_mcu7t5v0__fillcap_4
XFILLER_178_487 VDD VSS VDD VSS gf180mcu_fd_sc_mcu7t5v0__fillcap_4
XFILLER_165_126 VDD VSS VDD VSS gf180mcu_fd_sc_mcu7t5v0__fillcap_4
XFILLER_181_619 VDD VSS VDD VSS gf180mcu_fd_sc_mcu7t5v0__fillcap_8
X_1989_ VDD VSS _4205_/Q _2599_/A1 VDD VSS gf180mcu_fd_sc_mcu7t5v0__clkinv_1
X_3728_ _3728_/S VDD VSS _3905_/D _3905_/Q _4296_/Q VDD VSS gf180mcu_fd_sc_mcu7t5v0__mux2_2
XFILLER_180_107 VDD VSS VDD VSS gf180mcu_fd_sc_mcu7t5v0__fillcap_32
XFILLER_162_866 VDD VSS VDD VSS gf180mcu_fd_sc_mcu7t5v0__fillcap_8
XFILLER_173_192 VDD VSS VDD VSS gf180mcu_fd_sc_mcu7t5v0__fillcap_8
XFILLER_106_237 VDD VSS VDD VSS gf180mcu_fd_sc_mcu7t5v0__fillcap_8
X_3659_ VDD VSS _3660_/A3 _4489_/Q _3682_/A2 VDD VSS gf180mcu_fd_sc_mcu7t5v0__nand2_1
XFILLER_162_877 VDD VSS VDD VSS gf180mcu_fd_sc_mcu7t5v0__fillcap_8
XFILLER_180_37 VDD VSS VDD VSS gf180mcu_fd_sc_mcu7t5v0__fillcap_8
XFILLER_228_171 VDD VSS VDD VSS gf180mcu_fd_sc_mcu7t5v0__fillcap_4
XFILLER_29_766 VDD VSS VDD VSS gf180mcu_fd_sc_mcu7t5v0__fillcap_4
XFILLER_212_583 VDD VSS VDD VSS gf180mcu_fd_sc_mcu7t5v0__fillcap_8
XFILLER_237_2 VDD VSS VDD VSS gf180mcu_fd_sc_mcu7t5v0__fillcap_64
XFILLER_196_284 VDD VSS VDD VSS gf180mcu_fd_sc_mcu7t5v0__fillcap_16
XFILLER_184_446 VDD VSS VDD VSS gf180mcu_fd_sc_mcu7t5v0__fillcap_8
XFILLER_138_841 VDD VSS VDD VSS gf180mcu_fd_sc_mcu7t5v0__fillcap_32
XFILLER_7_136 VDD VSS VDD VSS gf180mcu_fd_sc_mcu7t5v0__fillcap_4
XFILLER_138_885 VDD VSS VDD VSS gf180mcu_fd_sc_mcu7t5v0__fillcap_4
XFILLER_171_129 VDD VSS VDD VSS gf180mcu_fd_sc_mcu7t5v0__fillcap_8
XFILLER_138_94 VDD VSS VDD VSS gf180mcu_fd_sc_mcu7t5v0__fillcap_8
XFILLER_153_877 VDD VSS VDD VSS gf180mcu_fd_sc_mcu7t5v0__fillcap_8
XFILLER_106_793 VDD VSS VDD VSS gf180mcu_fd_sc_mcu7t5v0__fillcap_8
XFILLER_121_763 VDD VSS VDD VSS gf180mcu_fd_sc_mcu7t5v0__fillcap_4
XFILLER_235_664 VDD VSS VDD VSS gf180mcu_fd_sc_mcu7t5v0__fillcap_4
XFILLER_19_276 VDD VSS VDD VSS gf180mcu_fd_sc_mcu7t5v0__fillcap_4
XFILLER_250_667 VDD VSS VDD VSS gf180mcu_fd_sc_mcu7t5v0__fillcap_64
X_2961_ VDD VSS _2961_/I _4316_/D VDD VSS gf180mcu_fd_sc_mcu7t5v0__clkinv_1
X_1912_ VDD VSS _4330_/Q _3043_/A1 VDD VSS gf180mcu_fd_sc_mcu7t5v0__clkinv_1
X_2892_ _2892_/B VDD VSS _2893_/A2 _2892_/A1 _3032_/A2 VDD VSS gf180mcu_fd_sc_mcu7t5v0__aoi21_1
X_4562_ _4562_/D _4562_/Q _4573_/RN VSS _4562_/CLK VDD VDD VSS gf180mcu_fd_sc_mcu7t5v0__dffrnq_1
XFILLER_162_107 VDD VSS VDD VSS gf180mcu_fd_sc_mcu7t5v0__fillcap_4
X_4493_ _4493_/D _4493_/Q wire209/Z VSS _4499_/CLK VDD VDD VSS gf180mcu_fd_sc_mcu7t5v0__dffrnq_1
X_3513_ _3597_/S VDD VSS _3513_/Z _4093_/Q _4085_/Q VDD VSS gf180mcu_fd_sc_mcu7t5v0__mux2_2
XFILLER_144_877 VDD VSS VDD VSS gf180mcu_fd_sc_mcu7t5v0__fillcap_8
X_3444_ VDD VSS _3685_/C2 _3444_/A1 _3637_/A3 VDD VSS gf180mcu_fd_sc_mcu7t5v0__nor2_1
XFILLER_170_184 VDD VSS VDD VSS gf180mcu_fd_sc_mcu7t5v0__fillcap_8
X_3375_ wire20/Z VDD VSS _4422_/D _4414_/Q _4422_/Q VDD VSS gf180mcu_fd_sc_mcu7t5v0__mux2_2
XFILLER_214_30 VDD VSS VDD VSS gf180mcu_fd_sc_mcu7t5v0__fillcap_4
X_2326_ VDD VSS _2829_/B _2858_/B wire51/Z VDD VSS gf180mcu_fd_sc_mcu7t5v0__nor2_1
X_2257_ VDD VSS _2258_/A4 _4569_/Q _4545_/D VDD VSS gf180mcu_fd_sc_mcu7t5v0__xnor2_1
XFILLER_226_653 VDD VSS VDD VSS gf180mcu_fd_sc_mcu7t5v0__fillcap_8
X_2188_ _2188_/B VDD VSS _2191_/B _2653_/A1 _2696_/A1 VDD VSS gf180mcu_fd_sc_mcu7t5v0__aoi21_1
XFILLER_81_842 VDD VSS VDD VSS gf180mcu_fd_sc_mcu7t5v0__fillcap_4
XFILLER_93_691 VDD VSS VDD VSS gf180mcu_fd_sc_mcu7t5v0__fillcap_8
XFILLER_198_527 VDD VSS VDD VSS gf180mcu_fd_sc_mcu7t5v0__fillcap_8
XFILLER_81_864 VDD VSS VDD VSS gf180mcu_fd_sc_mcu7t5v0__fillcap_16
XFILLER_240_177 VDD VSS VDD VSS gf180mcu_fd_sc_mcu7t5v0__fillcap_64
XFILLER_119_340 VDD VSS VDD VSS gf180mcu_fd_sc_mcu7t5v0__fillcap_4
XFILLER_181_438 VDD VSS VDD VSS gf180mcu_fd_sc_mcu7t5v0__fillcap_8
XFILLER_108_53 VDD VSS VDD VSS gf180mcu_fd_sc_mcu7t5v0__fillcap_4
XFILLER_108_31 VDD VSS VDD VSS gf180mcu_fd_sc_mcu7t5v0__fillcap_4
XFILLER_122_505 VDD VSS VDD VSS gf180mcu_fd_sc_mcu7t5v0__fillcap_4
XFILLER_134_387 VDD VSS VDD VSS gf180mcu_fd_sc_mcu7t5v0__fillcap_32
XFILLER_102_262 VDD VSS VDD VSS gf180mcu_fd_sc_mcu7t5v0__fillcap_32
XFILLER_264_737 VDD VSS VDD VSS gf180mcu_fd_sc_mcu7t5v0__fillcap_64
XFILLER_187_2 VDD VSS VDD VSS gf180mcu_fd_sc_mcu7t5v0__fillcap_64
XFILLER_205_815 VDD VSS VDD VSS gf180mcu_fd_sc_mcu7t5v0__fillcap_16
XFILLER_204_325 VDD VSS VDD VSS gf180mcu_fd_sc_mcu7t5v0__fillcap_32
XFILLER_71_352 VDD VSS VDD VSS gf180mcu_fd_sc_mcu7t5v0__fillcap_64
XFILLER_17_72 VDD VSS VDD VSS gf180mcu_fd_sc_mcu7t5v0__fillcap_64
XFILLER_232_667 VDD VSS VDD VSS gf180mcu_fd_sc_mcu7t5v0__fillcap_8
XFILLER_220_807 VDD VSS VDD VSS gf180mcu_fd_sc_mcu7t5v0__fillcap_64
XFILLER_185_766 VDD VSS VDD VSS gf180mcu_fd_sc_mcu7t5v0__fillcap_4
XFILLER_200_597 VDD VSS VDD VSS gf180mcu_fd_sc_mcu7t5v0__fillcap_64
XFILLER_184_287 VDD VSS VDD VSS gf180mcu_fd_sc_mcu7t5v0__fillcap_16
XFILLER_172_449 VDD VSS VDD VSS gf180mcu_fd_sc_mcu7t5v0__fillcap_4
XFILLER_126_855 VDD VSS VDD VSS gf180mcu_fd_sc_mcu7t5v0__fillcap_4
XFILLER_126_877 VDD VSS VDD VSS gf180mcu_fd_sc_mcu7t5v0__fillcap_8
X_3160_ _3160_/B _3182_/B VDD VSS _3167_/B _3159_/C _3154_/Z VDD VSS gf180mcu_fd_sc_mcu7t5v0__oai211_1
X_3091_ _3932_/Q VSS VDD _3916_/Q _3924_/Q _3113_/S _3908_/Q _3117_/B _3091_/Z VDD
+ VSS gf180mcu_fd_sc_mcu7t5v0__mux4_1
X_2111_ VDD VSS _4547_/D _3158_/B _2111_/A2 VDD VSS gf180mcu_fd_sc_mcu7t5v0__xor2_1
XFILLER_254_247 VDD VSS VDD VSS gf180mcu_fd_sc_mcu7t5v0__fillcap_64
X_2042_ VDD VSS _3390_/A2 _3859_/Q _3426_/A4 VDD VSS gf180mcu_fd_sc_mcu7t5v0__nand2_1
XFILLER_207_185 VDD VSS VDD VSS gf180mcu_fd_sc_mcu7t5v0__fillcap_16
XFILLER_63_842 VDD VSS VDD VSS gf180mcu_fd_sc_mcu7t5v0__fillcap_32
X_3993_ VDD _3993_/Q _4001_/CLK VSS _3993_/D VDD VSS gf180mcu_fd_sc_mcu7t5v0__dffq_1
XFILLER_222_177 VDD VSS VDD VSS gf180mcu_fd_sc_mcu7t5v0__fillcap_64
XFILLER_210_317 VDD VSS VDD VSS gf180mcu_fd_sc_mcu7t5v0__fillcap_64
X_2944_ _4366_/Q _2944_/B1 _1945_/I VDD VSS _2945_/A4 _2944_/A1 VDD VSS gf180mcu_fd_sc_mcu7t5v0__oai22_1
XFILLER_31_772 VDD VSS VDD VSS gf180mcu_fd_sc_mcu7t5v0__fillcap_64
X_2875_ VDD VSS _2878_/A1 _3270_/A1 _4195_/Q VDD VSS gf180mcu_fd_sc_mcu7t5v0__nand2_1
X_4614_ _4614_/D _4614_/Q _4616_/RN VSS _4614_/CLK VDD VDD VSS gf180mcu_fd_sc_mcu7t5v0__dffrnq_1
XFILLER_175_276 VDD VSS VDD VSS gf180mcu_fd_sc_mcu7t5v0__fillcap_4
XFILLER_163_416 VDD VSS VDD VSS gf180mcu_fd_sc_mcu7t5v0__fillcap_4
XFILLER_144_630 VDD VSS VDD VSS gf180mcu_fd_sc_mcu7t5v0__fillcap_16
X_4545_ _4545_/D _4563_/D wire187/Z VSS _4595_/CLK VDD VDD VSS gf180mcu_fd_sc_mcu7t5v0__dffrnq_1
XFILLER_135_129 VDD VSS VDD VSS gf180mcu_fd_sc_mcu7t5v0__fillcap_8
XFILLER_171_471 VDD VSS VDD VSS gf180mcu_fd_sc_mcu7t5v0__fillcap_16
XFILLER_131_324 VDD VSS VDD VSS gf180mcu_fd_sc_mcu7t5v0__fillcap_16
XFILLER_116_387 VDD VSS VDD VSS gf180mcu_fd_sc_mcu7t5v0__fillcap_16
XFILLER_104_527 VDD VSS VDD VSS gf180mcu_fd_sc_mcu7t5v0__fillcap_16
X_4476_ _4476_/D _4476_/Q wire193/Z VSS _4476_/CLK VDD VDD VSS gf180mcu_fd_sc_mcu7t5v0__dffrnq_1
X_3427_ _4058_/Q VSS VDD _4042_/Q _4050_/Q wire88/I _4034_/Q wire83/I _3427_/Z VDD
+ VSS gf180mcu_fd_sc_mcu7t5v0__mux4_1
X_3358_ wire21/I VDD VSS _4405_/D _4397_/Q _4405_/Q VDD VSS gf180mcu_fd_sc_mcu7t5v0__mux2_2
XFILLER_85_422 VDD VSS VDD VSS gf180mcu_fd_sc_mcu7t5v0__fillcap_64
XFILLER_246_737 VDD VSS VDD VSS gf180mcu_fd_sc_mcu7t5v0__fillcap_64
X_2309_ VDD VSS _2813_/A2 _2804_/A1 _2898_/A2 VDD VSS gf180mcu_fd_sc_mcu7t5v0__nand2_1
XFILLER_97_282 VDD VSS VDD VSS gf180mcu_fd_sc_mcu7t5v0__fillcap_8
XFILLER_258_597 VDD VSS VDD VSS gf180mcu_fd_sc_mcu7t5v0__fillcap_64
X_3289_ VSS VDD _4479_/Q _3278_/Z _4495_/Q _3302_/A2 _2280_/I _4471_/Q _3290_/A3 VDD
+ VSS gf180mcu_fd_sc_mcu7t5v0__aoi222_1
XFILLER_214_623 VDD VSS VDD VSS gf180mcu_fd_sc_mcu7t5v0__fillcap_32
XFILLER_199_836 VDD VSS VDD VSS gf180mcu_fd_sc_mcu7t5v0__fillcap_4
XFILLER_241_72 VDD VSS VDD VSS gf180mcu_fd_sc_mcu7t5v0__fillcap_64
XFILLER_54_37 VDD VSS VDD VSS gf180mcu_fd_sc_mcu7t5v0__fillcap_64
XFILLER_214_667 VDD VSS VDD VSS gf180mcu_fd_sc_mcu7t5v0__fillcap_16
XFILLER_213_133 VDD VSS VDD VSS gf180mcu_fd_sc_mcu7t5v0__fillcap_4
XFILLER_53_352 VDD VSS VDD VSS gf180mcu_fd_sc_mcu7t5v0__fillcap_64
XFILLER_241_486 VDD VSS VDD VSS gf180mcu_fd_sc_mcu7t5v0__fillcap_4
XFILLER_198_368 VDD VSS VDD VSS gf180mcu_fd_sc_mcu7t5v0__fillcap_4
XFILLER_80_171 VDD VSS VDD VSS gf180mcu_fd_sc_mcu7t5v0__fillcap_4
XFILLER_167_766 VDD VSS VDD VSS gf180mcu_fd_sc_mcu7t5v0__fillcap_4
XFILLER_21_282 VDD VSS VDD VSS gf180mcu_fd_sc_mcu7t5v0__fillcap_64
XFILLER_167_788 VDD VSS VDD VSS gf180mcu_fd_sc_mcu7t5v0__fillcap_8
XFILLER_126_107 VDD VSS VDD VSS gf180mcu_fd_sc_mcu7t5v0__fillcap_16
Xclkbuf_leaf_6_clk_i _4499_/CLK VSS VDD clkload1/I VDD VSS gf180mcu_fd_sc_mcu7t5v0__clkbuf_2
XFILLER_166_287 VDD VSS VDD VSS gf180mcu_fd_sc_mcu7t5v0__fillcap_4
XFILLER_154_427 VDD VSS VDD VSS gf180mcu_fd_sc_mcu7t5v0__fillcap_8
XFILLER_102_2 VDD VSS VDD VSS gf180mcu_fd_sc_mcu7t5v0__fillcap_32
XFILLER_108_877 VDD VSS VDD VSS gf180mcu_fd_sc_mcu7t5v0__fillcap_8
XFILLER_1_632 VDD VSS VDD VSS gf180mcu_fd_sc_mcu7t5v0__fillcap_64
XFILLER_89_772 VDD VSS VDD VSS gf180mcu_fd_sc_mcu7t5v0__fillcap_4
XFILLER_95_88 VDD VSS VDD VSS gf180mcu_fd_sc_mcu7t5v0__fillcap_8
XFILLER_236_247 VDD VSS VDD VSS gf180mcu_fd_sc_mcu7t5v0__fillcap_64
XFILLER_251_206 VDD VSS VDD VSS gf180mcu_fd_sc_mcu7t5v0__fillcap_4
XFILLER_151_72 VDD VSS VDD VSS gf180mcu_fd_sc_mcu7t5v0__fillcap_8
XFILLER_45_842 VDD VSS VDD VSS gf180mcu_fd_sc_mcu7t5v0__fillcap_32
XFILLER_189_335 VDD VSS VDD VSS gf180mcu_fd_sc_mcu7t5v0__fillcap_8
XFILLER_72_661 VDD VSS VDD VSS gf180mcu_fd_sc_mcu7t5v0__fillcap_4
XFILLER_60_801 VDD VSS VDD VSS gf180mcu_fd_sc_mcu7t5v0__fillcap_4
XFILLER_204_177 VDD VSS VDD VSS gf180mcu_fd_sc_mcu7t5v0__fillcap_64
XFILLER_13_772 VDD VSS VDD VSS gf180mcu_fd_sc_mcu7t5v0__fillcap_64
X_2660_ _2644_/Z _2660_/B2 VDD VSS _4228_/D _3149_/A2 _2666_/C VDD VSS gf180mcu_fd_sc_mcu7t5v0__aoi22_1
XFILLER_157_276 VDD VSS VDD VSS gf180mcu_fd_sc_mcu7t5v0__fillcap_4
XFILLER_40_591 VDD VSS VDD VSS gf180mcu_fd_sc_mcu7t5v0__fillcap_4
XFILLER_185_596 VDD VSS VDD VSS gf180mcu_fd_sc_mcu7t5v0__fillcap_16
XFILLER_145_438 VDD VSS VDD VSS gf180mcu_fd_sc_mcu7t5v0__fillcap_4
X_2591_ _2586_/Z VDD VSS _2599_/A2 _4204_/Q _4203_/Q VDD VSS gf180mcu_fd_sc_mcu7t5v0__nand3_1
X_4330_ _4330_/D _4330_/Q wire206/Z VSS _4330_/CLK VDD VDD VSS gf180mcu_fd_sc_mcu7t5v0__dffrnq_1
XFILLER_125_173 VDD VSS VDD VSS gf180mcu_fd_sc_mcu7t5v0__fillcap_16
XFILLER_125_151 VDD VSS VDD VSS gf180mcu_fd_sc_mcu7t5v0__fillcap_8
X_4261_ _4261_/D _4261_/Q wire199/I VSS _4518_/CLK VDD VDD VSS gf180mcu_fd_sc_mcu7t5v0__dffrnq_1
X_3212_ _3212_/B _3271_/C VDD VSS _3213_/A2 _2896_/B _3212_/A2 VDD VSS gf180mcu_fd_sc_mcu7t5v0__oai211_1
XFILLER_113_368 VDD VSS VDD VSS gf180mcu_fd_sc_mcu7t5v0__fillcap_8
XFILLER_67_422 VDD VSS VDD VSS gf180mcu_fd_sc_mcu7t5v0__fillcap_64
XFILLER_228_715 VDD VSS VDD VSS gf180mcu_fd_sc_mcu7t5v0__fillcap_16
Xclkbuf_4_6_0_host_clk_i _4604_/CLK VSS VDD clkbuf_0_host_clk_i/Z VDD VSS gf180mcu_fd_sc_mcu7t5v0__clkbuf_2
X_4192_ _4192_/D _4192_/Q wire206/Z VSS _4535_/CLK VDD VDD VSS gf180mcu_fd_sc_mcu7t5v0__dffrnq_1
XFILLER_79_282 VDD VSS VDD VSS gf180mcu_fd_sc_mcu7t5v0__fillcap_64
XFILLER_228_737 VDD VSS VDD VSS gf180mcu_fd_sc_mcu7t5v0__fillcap_8
X_3143_ _3143_/B _3143_/C VDD VSS _3145_/B _3185_/S _3797_/A1 VDD VSS gf180mcu_fd_sc_mcu7t5v0__aoi211_1
XFILLER_255_556 VDD VSS VDD VSS gf180mcu_fd_sc_mcu7t5v0__fillcap_4
X_3074_ VDD VSS _3076_/B1 _3157_/A1 _3891_/Q VDD VSS gf180mcu_fd_sc_mcu7t5v0__nor2_1
X_2025_ VDD VSS _3928_/Q _3757_/A1 VDD VSS gf180mcu_fd_sc_mcu7t5v0__clkinv_1
XFILLER_35_352 VDD VSS VDD VSS gf180mcu_fd_sc_mcu7t5v0__fillcap_64
XFILLER_223_486 VDD VSS VDD VSS gf180mcu_fd_sc_mcu7t5v0__fillcap_4
XFILLER_50_311 VDD VSS VDD VSS gf180mcu_fd_sc_mcu7t5v0__fillcap_4
XFILLER_62_171 VDD VSS VDD VSS gf180mcu_fd_sc_mcu7t5v0__fillcap_4
X_3976_ VDD _3976_/Q _4001_/CLK VSS _3976_/D VDD VSS gf180mcu_fd_sc_mcu7t5v0__dffq_1
XFILLER_176_541 VDD VSS VDD VSS gf180mcu_fd_sc_mcu7t5v0__fillcap_16
XFILLER_149_744 VDD VSS VDD VSS gf180mcu_fd_sc_mcu7t5v0__fillcap_8
XFILLER_210_169 VDD VSS VDD VSS gf180mcu_fd_sc_mcu7t5v0__fillcap_4
XFILLER_148_232 VDD VSS VDD VSS gf180mcu_fd_sc_mcu7t5v0__fillcap_8
X_2927_ _2934_/A2 _4201_/Q _2939_/A1 VDD VSS _2931_/A1 _4332_/Q VDD VSS gf180mcu_fd_sc_mcu7t5v0__oai22_1
XFILLER_149_788 VDD VSS VDD VSS gf180mcu_fd_sc_mcu7t5v0__fillcap_8
XFILLER_108_107 VDD VSS VDD VSS gf180mcu_fd_sc_mcu7t5v0__fillcap_16
XFILLER_191_522 VDD VSS VDD VSS gf180mcu_fd_sc_mcu7t5v0__fillcap_32
X_2858_ _2858_/B VDD VSS _2887_/A1 _2858_/A1 _2858_/A2 VDD VSS gf180mcu_fd_sc_mcu7t5v0__aoi21_1
X_2789_ _2977_/A2 VDD VSS _2988_/A1 _2789_/A1 _2789_/A2 VDD VSS gf180mcu_fd_sc_mcu7t5v0__nand3_1
Xhold253 _4567_/D VSS _4572_/Q VDD VDD VSS gf180mcu_fd_sc_mcu7t5v0__dlyc_1
X_4528_ _4528_/D _4528_/Q _4535_/RN VSS _4528_/CLK VDD VDD VSS gf180mcu_fd_sc_mcu7t5v0__dffrnq_1
XFILLER_116_162 VDD VSS VDD VSS gf180mcu_fd_sc_mcu7t5v0__fillcap_8
XFILLER_117_696 VDD VSS VDD VSS gf180mcu_fd_sc_mcu7t5v0__fillcap_4
Xhold275 _3863_/D VSS _3862_/Q VDD VDD VSS gf180mcu_fd_sc_mcu7t5v0__dlyc_1
Xhold264 _4596_/D VSS _4601_/Q VDD VDD VSS gf180mcu_fd_sc_mcu7t5v0__dlyc_1
X_4459_ _4459_/D _4459_/Q wire207/Z VSS _4459_/CLK VDD VDD VSS gf180mcu_fd_sc_mcu7t5v0__dffrnq_1
XFILLER_86_731 VDD VSS VDD VSS gf180mcu_fd_sc_mcu7t5v0__fillcap_4
XFILLER_218_247 VDD VSS VDD VSS gf180mcu_fd_sc_mcu7t5v0__fillcap_4
XFILLER_233_206 VDD VSS VDD VSS gf180mcu_fd_sc_mcu7t5v0__fillcap_4
XFILLER_27_842 VDD VSS VDD VSS gf180mcu_fd_sc_mcu7t5v0__fillcap_32
XFILLER_54_661 VDD VSS VDD VSS gf180mcu_fd_sc_mcu7t5v0__fillcap_4
XFILLER_42_801 VDD VSS VDD VSS gf180mcu_fd_sc_mcu7t5v0__fillcap_4
XFILLER_202_626 VDD VSS VDD VSS gf180mcu_fd_sc_mcu7t5v0__fillcap_4
XFILLER_202_648 VDD VSS VDD VSS gf180mcu_fd_sc_mcu7t5v0__fillcap_16
XFILLER_201_136 VDD VSS VDD VSS gf180mcu_fd_sc_mcu7t5v0__fillcap_4
XFILLER_198_187 VDD VSS VDD VSS gf180mcu_fd_sc_mcu7t5v0__fillcap_8
XFILLER_167_541 VDD VSS VDD VSS gf180mcu_fd_sc_mcu7t5v0__fillcap_4
XFILLER_167_574 VDD VSS VDD VSS gf180mcu_fd_sc_mcu7t5v0__fillcap_4
XFILLER_22_591 VDD VSS VDD VSS gf180mcu_fd_sc_mcu7t5v0__fillcap_4
XFILLER_10_731 VDD VSS VDD VSS gf180mcu_fd_sc_mcu7t5v0__fillcap_4
XFILLER_5_212 VDD VSS VDD VSS gf180mcu_fd_sc_mcu7t5v0__fillcap_64
XFILLER_170_728 VDD VSS VDD VSS gf180mcu_fd_sc_mcu7t5v0__fillcap_4
XFILLER_150_441 VDD VSS VDD VSS gf180mcu_fd_sc_mcu7t5v0__fillcap_8
XFILLER_122_165 VDD VSS VDD VSS gf180mcu_fd_sc_mcu7t5v0__fillcap_4
XFILLER_111_828 VDD VSS VDD VSS gf180mcu_fd_sc_mcu7t5v0__fillcap_8
XFILLER_49_422 VDD VSS VDD VSS gf180mcu_fd_sc_mcu7t5v0__fillcap_64
XFILLER_237_534 VDD VSS VDD VSS gf180mcu_fd_sc_mcu7t5v0__fillcap_16
XFILLER_76_241 VDD VSS VDD VSS gf180mcu_fd_sc_mcu7t5v0__fillcap_4
XFILLER_209_258 VDD VSS VDD VSS gf180mcu_fd_sc_mcu7t5v0__fillcap_8
XFILLER_17_352 VDD VSS VDD VSS gf180mcu_fd_sc_mcu7t5v0__fillcap_64
XFILLER_233_762 VDD VSS VDD VSS gf180mcu_fd_sc_mcu7t5v0__fillcap_8
XFILLER_32_311 VDD VSS VDD VSS gf180mcu_fd_sc_mcu7t5v0__fillcap_4
XFILLER_44_171 VDD VSS VDD VSS gf180mcu_fd_sc_mcu7t5v0__fillcap_4
X_3830_ _3830_/S VDD VSS _3985_/D _3848_/I0 _3985_/Q VDD VSS gf180mcu_fd_sc_mcu7t5v0__mux2_2
X_3761_ _3767_/S VDD VSS _3931_/D wire178/Z _3931_/Q VDD VSS gf180mcu_fd_sc_mcu7t5v0__mux2_2
X_2712_ VDD VSS _2712_/I _4250_/D VDD VSS gf180mcu_fd_sc_mcu7t5v0__clkinv_1
XFILLER_9_562 VDD VSS VDD VSS gf180mcu_fd_sc_mcu7t5v0__fillcap_64
X_3692_ _3696_/S VDD VSS _3878_/D _3878_/Q wire174/Z VDD VSS gf180mcu_fd_sc_mcu7t5v0__mux2_2
X_2643_ _4244_/Q _4241_/Q VDD VSS _2644_/A2 _4242_/Q _4243_/Q VDD VSS gf180mcu_fd_sc_mcu7t5v0__aoi211_1
XFILLER_161_717 VDD VSS VDD VSS gf180mcu_fd_sc_mcu7t5v0__fillcap_32
XFILLER_65_2 VDD VSS VDD VSS gf180mcu_fd_sc_mcu7t5v0__fillcap_64
XFILLER_160_227 VDD VSS VDD VSS gf180mcu_fd_sc_mcu7t5v0__fillcap_16
X_2574_ VDD VSS _2575_/B wire138/Z wire27/Z VDD VSS gf180mcu_fd_sc_mcu7t5v0__nor2_1
X_4313_ VDD _4313_/Q _4366_/CLK VSS _4313_/D VDD VSS gf180mcu_fd_sc_mcu7t5v0__dffq_1
XFILLER_99_344 VDD VSS VDD VSS gf180mcu_fd_sc_mcu7t5v0__fillcap_4
XFILLER_259_136 VDD VSS VDD VSS gf180mcu_fd_sc_mcu7t5v0__fillcap_4
X_4244_ _4244_/D _4244_/Q _4530_/RN VSS _4554_/CLK VDD VDD VSS gf180mcu_fd_sc_mcu7t5v0__dffrnq_1
XFILLER_68_731 VDD VSS VDD VSS gf180mcu_fd_sc_mcu7t5v0__fillcap_4
X_4175_ _4175_/D _4175_/Q wire196/I VSS clkload9/I VDD VDD VSS gf180mcu_fd_sc_mcu7t5v0__dffrnq_1
X_3126_ _3126_/A3 _3126_/B1 _3126_/B2 VDD VSS _3129_/A2 _3182_/B _3126_/A2 VDD VSS
+ gf180mcu_fd_sc_mcu7t5v0__oai32_1
XFILLER_228_556 VDD VSS VDD VSS gf180mcu_fd_sc_mcu7t5v0__fillcap_16
X_3057_ _3994_/Q VSS VDD _3978_/Q _3986_/Q _3124_/A1 _3970_/Q _3143_/C _3057_/Z VDD
+ VSS gf180mcu_fd_sc_mcu7t5v0__mux4_1
XFILLER_36_661 VDD VSS VDD VSS gf180mcu_fd_sc_mcu7t5v0__fillcap_4
XFILLER_24_801 VDD VSS VDD VSS gf180mcu_fd_sc_mcu7t5v0__fillcap_4
X_2008_ VDD VSS _4231_/Q _2667_/A1 VDD VSS gf180mcu_fd_sc_mcu7t5v0__clkinv_1
XFILLER_196_625 VDD VSS VDD VSS gf180mcu_fd_sc_mcu7t5v0__fillcap_4
Xclkbuf_leaf_71_clk_i _4061_/CLK VSS VDD clkbuf_3_2__f_clk_i/Z VDD VSS gf180mcu_fd_sc_mcu7t5v0__clkbuf_2
X_3959_ VDD _3959_/Q _3967_/CLK VSS _3959_/D VDD VSS gf180mcu_fd_sc_mcu7t5v0__dffq_1
XFILLER_109_438 VDD VSS VDD VSS gf180mcu_fd_sc_mcu7t5v0__fillcap_8
XFILLER_191_352 VDD VSS VDD VSS gf180mcu_fd_sc_mcu7t5v0__fillcap_8
Xclkbuf_leaf_86_clk_i _4476_/CLK VSS VDD clkload2/I VDD VSS gf180mcu_fd_sc_mcu7t5v0__clkbuf_2
XFILLER_151_205 VDD VSS VDD VSS gf180mcu_fd_sc_mcu7t5v0__fillcap_4
XFILLER_58_241 VDD VSS VDD VSS gf180mcu_fd_sc_mcu7t5v0__fillcap_4
XFILLER_234_504 VDD VSS VDD VSS gf180mcu_fd_sc_mcu7t5v0__fillcap_16
XFILLER_219_578 VDD VSS VDD VSS gf180mcu_fd_sc_mcu7t5v0__fillcap_4
Xclkbuf_leaf_24_clk_i _4466_/CLK VSS VDD clkload3/I VDD VSS gf180mcu_fd_sc_mcu7t5v0__clkbuf_2
XFILLER_267_2 VDD VSS VDD VSS gf180mcu_fd_sc_mcu7t5v0__fillcap_64
XFILLER_92_45 VDD VSS VDD VSS gf180mcu_fd_sc_mcu7t5v0__fillcap_4
XFILLER_14_311 VDD VSS VDD VSS gf180mcu_fd_sc_mcu7t5v0__fillcap_4
XFILLER_26_171 VDD VSS VDD VSS gf180mcu_fd_sc_mcu7t5v0__fillcap_4
XFILLER_199_485 VDD VSS VDD VSS gf180mcu_fd_sc_mcu7t5v0__fillcap_4
XFILLER_214_261 VDD VSS VDD VSS gf180mcu_fd_sc_mcu7t5v0__fillcap_4
XFILLER_202_412 VDD VSS VDD VSS gf180mcu_fd_sc_mcu7t5v0__fillcap_32
Xclkbuf_leaf_39_clk_i _4525_/CLK VSS VDD clkload6/I VDD VSS gf180mcu_fd_sc_mcu7t5v0__clkbuf_2
XFILLER_25_72 VDD VSS VDD VSS gf180mcu_fd_sc_mcu7t5v0__fillcap_64
XFILLER_167_360 VDD VSS VDD VSS gf180mcu_fd_sc_mcu7t5v0__fillcap_16
XFILLER_6_521 VDD VSS VDD VSS gf180mcu_fd_sc_mcu7t5v0__fillcap_4
XFILLER_170_514 VDD VSS VDD VSS gf180mcu_fd_sc_mcu7t5v0__fillcap_8
XFILLER_136_780 VDD VSS VDD VSS gf180mcu_fd_sc_mcu7t5v0__fillcap_16
XFILLER_183_886 VDD VSS VDD VSS gf180mcu_fd_sc_mcu7t5v0__fillcap_4
XFILLER_151_772 VDD VSS VDD VSS gf180mcu_fd_sc_mcu7t5v0__fillcap_32
X_2290_ _2290_/B1 _2290_/B2 VDD VSS _3854_/D _4386_/Q _2290_/A2 VDD VSS gf180mcu_fd_sc_mcu7t5v0__aoi22_1
XFILLER_37_6 VDD VSS VDD VSS gf180mcu_fd_sc_mcu7t5v0__fillcap_64
XFILLER_18_661 VDD VSS VDD VSS gf180mcu_fd_sc_mcu7t5v0__fillcap_4
XFILLER_80_737 VDD VSS VDD VSS gf180mcu_fd_sc_mcu7t5v0__fillcap_8
X_3813_ VDD VSS _3821_/S _3813_/A1 _3840_/A2 VDD VSS gf180mcu_fd_sc_mcu7t5v0__nand2_1
XFILLER_177_135 VDD VSS VDD VSS gf180mcu_fd_sc_mcu7t5v0__fillcap_4
XFILLER_159_850 VDD VSS VDD VSS gf180mcu_fd_sc_mcu7t5v0__fillcap_4
X_3744_ _3747_/S VDD VSS _3918_/D wire174/Z _3918_/Q VDD VSS gf180mcu_fd_sc_mcu7t5v0__mux2_2
X_3675_ _3682_/B1 _4190_/Q VDD VSS _3676_/I _4496_/Q _3682_/A2 VDD VSS gf180mcu_fd_sc_mcu7t5v0__aoi22_1
X_2626_ VDD VSS _4213_/D _2626_/A1 _2628_/A2 VDD VSS gf180mcu_fd_sc_mcu7t5v0__nor2_1
XFILLER_173_352 VDD VSS VDD VSS gf180mcu_fd_sc_mcu7t5v0__fillcap_64
X_2557_ wire29/Z VDD VSS _4180_/D _4454_/Q _4180_/Q VDD VSS gf180mcu_fd_sc_mcu7t5v0__mux2_2
XFILLER_88_815 VDD VSS VDD VSS gf180mcu_fd_sc_mcu7t5v0__fillcap_4
XFILLER_153_18 VDD VSS VDD VSS gf180mcu_fd_sc_mcu7t5v0__fillcap_8
XFILLER_141_282 VDD VSS VDD VSS gf180mcu_fd_sc_mcu7t5v0__fillcap_8
X_2488_ _2491_/S VDD VSS _4110_/D _2506_/I0 _4110_/Q VDD VSS gf180mcu_fd_sc_mcu7t5v0__mux2_2
X_4227_ _4227_/D _4227_/Q _4530_/RN VSS _4366_/CLK VDD VDD VSS gf180mcu_fd_sc_mcu7t5v0__dffrnq_1
XFILLER_101_157 VDD VSS VDD VSS gf180mcu_fd_sc_mcu7t5v0__fillcap_32
X_4158_ _4158_/D _4158_/Q wire184/Z VSS _4171_/CLK VDD VDD VSS gf180mcu_fd_sc_mcu7t5v0__dffrnq_1
Xmax_cap17 _3682_/A2 _3479_/C VDD VSS VDD VSS gf180mcu_fd_sc_mcu7t5v0__buf_4
X_3109_ VDD _4334_/D _3109_/B wire13/Z _3109_/A2 VSS _3109_/A3 VDD VSS gf180mcu_fd_sc_mcu7t5v0__oai31_1
X_4089_ VDD _4089_/Q _4270_/CLK VSS _4089_/D VDD VSS gf180mcu_fd_sc_mcu7t5v0__dffq_1
XFILLER_70_247 VDD VSS VDD VSS gf180mcu_fd_sc_mcu7t5v0__fillcap_64
XFILLER_62_37 VDD VSS VDD VSS gf180mcu_fd_sc_mcu7t5v0__fillcap_64
XFILLER_178_37 VDD VSS VDD VSS gf180mcu_fd_sc_mcu7t5v0__fillcap_8
XFILLER_177_691 VDD VSS VDD VSS gf180mcu_fd_sc_mcu7t5v0__fillcap_8
XFILLER_183_116 VDD VSS VDD VSS gf180mcu_fd_sc_mcu7t5v0__fillcap_8
XFILLER_133_772 VDD VSS VDD VSS gf180mcu_fd_sc_mcu7t5v0__fillcap_64
XFILLER_132_293 VDD VSS VDD VSS gf180mcu_fd_sc_mcu7t5v0__fillcap_4
XFILLER_94_807 VDD VSS VDD VSS gf180mcu_fd_sc_mcu7t5v0__fillcap_64
XFILLER_222_518 VDD VSS VDD VSS gf180mcu_fd_sc_mcu7t5v0__fillcap_4
XFILLER_261_142 VDD VSS VDD VSS gf180mcu_fd_sc_mcu7t5v0__fillcap_64
XFILLER_62_737 VDD VSS VDD VSS gf180mcu_fd_sc_mcu7t5v0__fillcap_64
XFILLER_74_597 VDD VSS VDD VSS gf180mcu_fd_sc_mcu7t5v0__fillcap_64
XFILLER_187_422 VDD VSS VDD VSS gf180mcu_fd_sc_mcu7t5v0__fillcap_4
XFILLER_30_667 VDD VSS VDD VSS gf180mcu_fd_sc_mcu7t5v0__fillcap_64
XFILLER_155_352 VDD VSS VDD VSS gf180mcu_fd_sc_mcu7t5v0__fillcap_32
XFILLER_7_874 VDD VSS VDD VSS gf180mcu_fd_sc_mcu7t5v0__fillcap_16
X_3460_ _3586_/S VDD VSS _3460_/Z _4091_/Q _4083_/Q VDD VSS gf180mcu_fd_sc_mcu7t5v0__mux2_2
X_3391_ VDD VSS _4435_/D wire56/I _3391_/A2 VDD VSS gf180mcu_fd_sc_mcu7t5v0__nand2_1
X_2411_ _2413_/S VDD VSS _4047_/D wire154/Z _4047_/Q VDD VSS gf180mcu_fd_sc_mcu7t5v0__mux2_2
X_2342_ VDD VSS _3218_/C2 _3007_/A1 _2780_/B VDD VSS gf180mcu_fd_sc_mcu7t5v0__nor2_1
XFILLER_111_422 VDD VSS VDD VSS gf180mcu_fd_sc_mcu7t5v0__fillcap_16
XFILLER_97_623 VDD VSS VDD VSS gf180mcu_fd_sc_mcu7t5v0__fillcap_4
XFILLER_28_2 VDD VSS VDD VSS gf180mcu_fd_sc_mcu7t5v0__fillcap_32
X_2273_ _2269_/Z _2273_/A4 VDD VSS _4577_/D _2273_/A1 _2273_/A2 VDD VSS gf180mcu_fd_sc_mcu7t5v0__nor4_1
XFILLER_84_317 VDD VSS VDD VSS gf180mcu_fd_sc_mcu7t5v0__fillcap_64
X_4012_ VDD _4012_/Q _4028_/CLK VSS _4012_/D VDD VSS gf180mcu_fd_sc_mcu7t5v0__dffq_1
XFILLER_253_632 VDD VSS VDD VSS gf180mcu_fd_sc_mcu7t5v0__fillcap_64
XFILLER_265_492 VDD VSS VDD VSS gf180mcu_fd_sc_mcu7t5v0__fillcap_64
XFILLER_178_400 VDD VSS VDD VSS gf180mcu_fd_sc_mcu7t5v0__fillcap_4
XFILLER_52_247 VDD VSS VDD VSS gf180mcu_fd_sc_mcu7t5v0__fillcap_64
XFILLER_221_562 VDD VSS VDD VSS gf180mcu_fd_sc_mcu7t5v0__fillcap_8
XFILLER_178_499 VDD VSS VDD VSS gf180mcu_fd_sc_mcu7t5v0__fillcap_8
X_3727_ _3728_/S VDD VSS _3904_/D _3904_/Q _3766_/I0 VDD VSS gf180mcu_fd_sc_mcu7t5v0__mux2_2
XFILLER_147_842 VDD VSS VDD VSS gf180mcu_fd_sc_mcu7t5v0__fillcap_4
X_1988_ VDD VSS _4245_/Q _2701_/A1 VDD VSS gf180mcu_fd_sc_mcu7t5v0__clkinv_1
XFILLER_20_177 VDD VSS VDD VSS gf180mcu_fd_sc_mcu7t5v0__fillcap_64
XFILLER_174_661 VDD VSS VDD VSS gf180mcu_fd_sc_mcu7t5v0__fillcap_4
XFILLER_173_160 VDD VSS VDD VSS gf180mcu_fd_sc_mcu7t5v0__fillcap_32
XFILLER_107_728 VDD VSS VDD VSS gf180mcu_fd_sc_mcu7t5v0__fillcap_16
XFILLER_134_547 VDD VSS VDD VSS gf180mcu_fd_sc_mcu7t5v0__fillcap_4
X_3658_ VDD VSS _3660_/A2 _4183_/Q _3677_/B1 VDD VSS gf180mcu_fd_sc_mcu7t5v0__nand2_1
X_2609_ _2604_/Z VDD VSS _2609_/Z _4208_/Q _2586_/Z VDD VSS gf180mcu_fd_sc_mcu7t5v0__and3_1
X_3589_ _3589_/A3 VDD VSS _3590_/B _3515_/C _3589_/A2 VDD VSS gf180mcu_fd_sc_mcu7t5v0__nand3_1
XFILLER_115_772 VDD VSS VDD VSS gf180mcu_fd_sc_mcu7t5v0__fillcap_16
XFILLER_76_807 VDD VSS VDD VSS gf180mcu_fd_sc_mcu7t5v0__fillcap_64
XFILLER_88_667 VDD VSS VDD VSS gf180mcu_fd_sc_mcu7t5v0__fillcap_64
XFILLER_189_6 VDD VSS VDD VSS gf180mcu_fd_sc_mcu7t5v0__fillcap_64
XFILLER_243_142 VDD VSS VDD VSS gf180mcu_fd_sc_mcu7t5v0__fillcap_64
XFILLER_56_597 VDD VSS VDD VSS gf180mcu_fd_sc_mcu7t5v0__fillcap_64
XFILLER_44_737 VDD VSS VDD VSS gf180mcu_fd_sc_mcu7t5v0__fillcap_64
XFILLER_71_556 VDD VSS VDD VSS gf180mcu_fd_sc_mcu7t5v0__fillcap_4
XFILLER_169_422 VDD VSS VDD VSS gf180mcu_fd_sc_mcu7t5v0__fillcap_16
XFILLER_240_871 VDD VSS VDD VSS gf180mcu_fd_sc_mcu7t5v0__fillcap_4
XFILLER_169_477 VDD VSS VDD VSS gf180mcu_fd_sc_mcu7t5v0__fillcap_4
XFILLER_157_617 VDD VSS VDD VSS gf180mcu_fd_sc_mcu7t5v0__fillcap_8
XFILLER_200_713 VDD VSS VDD VSS gf180mcu_fd_sc_mcu7t5v0__fillcap_16
XFILLER_196_230 VDD VSS VDD VSS gf180mcu_fd_sc_mcu7t5v0__fillcap_8
XFILLER_196_263 VDD VSS VDD VSS gf180mcu_fd_sc_mcu7t5v0__fillcap_8
XFILLER_132_2 VDD VSS VDD VSS gf180mcu_fd_sc_mcu7t5v0__fillcap_32
XFILLER_12_667 VDD VSS VDD VSS gf180mcu_fd_sc_mcu7t5v0__fillcap_64
XFILLER_137_352 VDD VSS VDD VSS gf180mcu_fd_sc_mcu7t5v0__fillcap_8
XFILLER_4_877 VDD VSS VDD VSS gf180mcu_fd_sc_mcu7t5v0__fillcap_8
XFILLER_98_77 VDD VSS VDD VSS gf180mcu_fd_sc_mcu7t5v0__fillcap_8
XFILLER_267_702 VDD VSS VDD VSS gf180mcu_fd_sc_mcu7t5v0__fillcap_64
XFILLER_105_282 VDD VSS VDD VSS gf180mcu_fd_sc_mcu7t5v0__fillcap_8
XFILLER_78_177 VDD VSS VDD VSS gf180mcu_fd_sc_mcu7t5v0__fillcap_64
XFILLER_66_317 VDD VSS VDD VSS gf180mcu_fd_sc_mcu7t5v0__fillcap_64
XFILLER_94_659 VDD VSS VDD VSS gf180mcu_fd_sc_mcu7t5v0__fillcap_4
XFILLER_93_136 VDD VSS VDD VSS gf180mcu_fd_sc_mcu7t5v0__fillcap_4
XFILLER_247_492 VDD VSS VDD VSS gf180mcu_fd_sc_mcu7t5v0__fillcap_64
XFILLER_262_451 VDD VSS VDD VSS gf180mcu_fd_sc_mcu7t5v0__fillcap_4
XFILLER_170_71 VDD VSS VDD VSS gf180mcu_fd_sc_mcu7t5v0__fillcap_8
XFILLER_34_247 VDD VSS VDD VSS gf180mcu_fd_sc_mcu7t5v0__fillcap_64
X_2960_ _2960_/B1 _4341_/Q VDD VSS _2961_/I _4316_/Q _2829_/C VDD VSS gf180mcu_fd_sc_mcu7t5v0__aoi22_1
XFILLER_203_562 VDD VSS VDD VSS gf180mcu_fd_sc_mcu7t5v0__fillcap_16
X_2891_ _2891_/B VDD VSS _2895_/A4 _2898_/A2 _2891_/A2 VDD VSS gf180mcu_fd_sc_mcu7t5v0__aoi21_1
X_1911_ VDD VSS _1911_/I _2991_/C VDD VSS gf180mcu_fd_sc_mcu7t5v0__clkinv_1
XFILLER_230_381 VDD VSS VDD VSS gf180mcu_fd_sc_mcu7t5v0__fillcap_4
X_4561_ _4561_/D _4561_/Q wire187/Z VSS _4562_/CLK VDD VDD VSS gf180mcu_fd_sc_mcu7t5v0__dffrnq_1
XFILLER_144_801 VDD VSS VDD VSS gf180mcu_fd_sc_mcu7t5v0__fillcap_4
XFILLER_144_823 VDD VSS VDD VSS gf180mcu_fd_sc_mcu7t5v0__fillcap_4
XFILLER_129_886 VDD VSS VDD VSS gf180mcu_fd_sc_mcu7t5v0__fillcap_4
XFILLER_156_683 VDD VSS VDD VSS gf180mcu_fd_sc_mcu7t5v0__fillcap_8
XFILLER_143_333 VDD VSS VDD VSS gf180mcu_fd_sc_mcu7t5v0__fillcap_16
X_4492_ _4492_/D _4492_/Q _4498_/RN VSS _4492_/CLK VDD VDD VSS gf180mcu_fd_sc_mcu7t5v0__dffrnq_1
X_3512_ VDD VSS _3517_/A2 _3596_/A1 _3511_/Z VDD VSS gf180mcu_fd_sc_mcu7t5v0__nand2_1
XFILLER_171_664 VDD VSS VDD VSS gf180mcu_fd_sc_mcu7t5v0__fillcap_4
X_3443_ VDD VSS _3457_/B1 _3546_/B _3442_/Z VDD VSS gf180mcu_fd_sc_mcu7t5v0__nor2_1
XFILLER_257_212 VDD VSS VDD VSS gf180mcu_fd_sc_mcu7t5v0__fillcap_64
X_3374_ wire20/Z VDD VSS _4421_/D _4413_/Q _4421_/Q VDD VSS gf180mcu_fd_sc_mcu7t5v0__mux2_2
XFILLER_58_807 VDD VSS VDD VSS gf180mcu_fd_sc_mcu7t5v0__fillcap_64
X_2325_ VDD VSS wire51/I _4566_/Q _2854_/B VDD VSS gf180mcu_fd_sc_mcu7t5v0__nand2_1
XFILLER_97_486 VDD VSS VDD VSS gf180mcu_fd_sc_mcu7t5v0__fillcap_4
X_2256_ VDD VSS _2258_/A3 _4568_/Q _4544_/D VDD VSS gf180mcu_fd_sc_mcu7t5v0__xnor2_1
X_2187_ VDD VSS _2696_/A1 _2693_/A1 _2211_/A2 VDD VSS gf180mcu_fd_sc_mcu7t5v0__nor2_1
XFILLER_225_142 VDD VSS VDD VSS gf180mcu_fd_sc_mcu7t5v0__fillcap_64
XFILLER_38_597 VDD VSS VDD VSS gf180mcu_fd_sc_mcu7t5v0__fillcap_64
XFILLER_26_737 VDD VSS VDD VSS gf180mcu_fd_sc_mcu7t5v0__fillcap_64
XFILLER_240_101 VDD VSS VDD VSS gf180mcu_fd_sc_mcu7t5v0__fillcap_4
XFILLER_53_556 VDD VSS VDD VSS gf180mcu_fd_sc_mcu7t5v0__fillcap_4
XFILLER_222_871 VDD VSS VDD VSS gf180mcu_fd_sc_mcu7t5v0__fillcap_4
XFILLER_21_486 VDD VSS VDD VSS gf180mcu_fd_sc_mcu7t5v0__fillcap_4
XFILLER_239_72 VDD VSS VDD VSS gf180mcu_fd_sc_mcu7t5v0__fillcap_64
XFILLER_146_171 VDD VSS VDD VSS gf180mcu_fd_sc_mcu7t5v0__fillcap_4
XFILLER_108_10 VDD VSS VDD VSS gf180mcu_fd_sc_mcu7t5v0__fillcap_4
XFILLER_4_107 VDD VSS VDD VSS gf180mcu_fd_sc_mcu7t5v0__fillcap_64
XFILLER_107_569 VDD VSS VDD VSS gf180mcu_fd_sc_mcu7t5v0__fillcap_16
XFILLER_249_702 VDD VSS VDD VSS gf180mcu_fd_sc_mcu7t5v0__fillcap_64
XFILLER_1_836 VDD VSS VDD VSS gf180mcu_fd_sc_mcu7t5v0__fillcap_4
XFILLER_102_241 VDD VSS VDD VSS gf180mcu_fd_sc_mcu7t5v0__fillcap_4
XFILLER_48_317 VDD VSS VDD VSS gf180mcu_fd_sc_mcu7t5v0__fillcap_64
XFILLER_75_136 VDD VSS VDD VSS gf180mcu_fd_sc_mcu7t5v0__fillcap_4
XFILLER_217_632 VDD VSS VDD VSS gf180mcu_fd_sc_mcu7t5v0__fillcap_8
XFILLER_244_451 VDD VSS VDD VSS gf180mcu_fd_sc_mcu7t5v0__fillcap_4
XFILLER_232_613 VDD VSS VDD VSS gf180mcu_fd_sc_mcu7t5v0__fillcap_8
XFILLER_16_247 VDD VSS VDD VSS gf180mcu_fd_sc_mcu7t5v0__fillcap_64
XFILLER_31_206 VDD VSS VDD VSS gf180mcu_fd_sc_mcu7t5v0__fillcap_4
XFILLER_197_550 VDD VSS VDD VSS gf180mcu_fd_sc_mcu7t5v0__fillcap_8
XFILLER_200_521 VDD VSS VDD VSS gf180mcu_fd_sc_mcu7t5v0__fillcap_4
XFILLER_212_381 VDD VSS VDD VSS gf180mcu_fd_sc_mcu7t5v0__fillcap_4
XFILLER_129_149 VDD VSS VDD VSS gf180mcu_fd_sc_mcu7t5v0__fillcap_8
XFILLER_33_72 VDD VSS VDD VSS gf180mcu_fd_sc_mcu7t5v0__fillcap_64
XFILLER_138_661 VDD VSS VDD VSS gf180mcu_fd_sc_mcu7t5v0__fillcap_4
XFILLER_8_457 VDD VSS VDD VSS gf180mcu_fd_sc_mcu7t5v0__fillcap_64
XFILLER_165_480 VDD VSS VDD VSS gf180mcu_fd_sc_mcu7t5v0__fillcap_8
XFILLER_153_664 VDD VSS VDD VSS gf180mcu_fd_sc_mcu7t5v0__fillcap_16
XFILLER_180_450 VDD VSS VDD VSS gf180mcu_fd_sc_mcu7t5v0__fillcap_4
XFILLER_141_826 VDD VSS VDD VSS gf180mcu_fd_sc_mcu7t5v0__fillcap_8
XFILLER_125_366 VDD VSS VDD VSS gf180mcu_fd_sc_mcu7t5v0__fillcap_16
XFILLER_239_212 VDD VSS VDD VSS gf180mcu_fd_sc_mcu7t5v0__fillcap_64
XFILLER_106_591 VDD VSS VDD VSS gf180mcu_fd_sc_mcu7t5v0__fillcap_4
XFILLER_67_626 VDD VSS VDD VSS gf180mcu_fd_sc_mcu7t5v0__fillcap_4
X_3090_ VDD VSS _3109_/B _4334_/Q wire13/Z VDD VSS gf180mcu_fd_sc_mcu7t5v0__nand2_1
X_2110_ VDD VSS _4546_/D _4565_/D _3849_/A1 VDD VSS gf180mcu_fd_sc_mcu7t5v0__xnor2_1
XFILLER_79_486 VDD VSS VDD VSS gf180mcu_fd_sc_mcu7t5v0__fillcap_4
X_2041_ VDD _2041_/B _3453_/A2 _3426_/A4 _2035_/Z VSS VDD VSS gf180mcu_fd_sc_mcu7t5v0__oai21_1
XFILLER_222_101 VDD VSS VDD VSS gf180mcu_fd_sc_mcu7t5v0__fillcap_4
XFILLER_35_556 VDD VSS VDD VSS gf180mcu_fd_sc_mcu7t5v0__fillcap_4
X_3992_ VDD _3992_/Q _4001_/CLK VSS _3992_/D VDD VSS gf180mcu_fd_sc_mcu7t5v0__dffq_1
XFILLER_204_871 VDD VSS VDD VSS gf180mcu_fd_sc_mcu7t5v0__fillcap_4
X_2943_ VDD VSS _2943_/Z _4333_/Q _4365_/Q VDD VSS gf180mcu_fd_sc_mcu7t5v0__xor2_1
XFILLER_210_307 VDD VSS VDD VSS gf180mcu_fd_sc_mcu7t5v0__fillcap_8
X_2874_ _4370_/Q VDD VSS _2874_/Z _4197_/Q _4365_/Q VDD VSS gf180mcu_fd_sc_mcu7t5v0__mux2_2
XFILLER_148_436 VDD VSS VDD VSS gf180mcu_fd_sc_mcu7t5v0__fillcap_4
X_4613_ _4613_/D _4613_/Q _4613_/RN VSS _4616_/CLK VDD VDD VSS gf180mcu_fd_sc_mcu7t5v0__dffrnq_1
X_4544_ _4544_/D _4562_/D _4573_/RN VSS _4573_/CLK VDD VDD VSS gf180mcu_fd_sc_mcu7t5v0__dffrnq_1
XFILLER_116_333 VDD VSS VDD VSS gf180mcu_fd_sc_mcu7t5v0__fillcap_8
X_4475_ _4475_/D _4475_/Q wire193/Z VSS _4476_/CLK VDD VDD VSS gf180mcu_fd_sc_mcu7t5v0__dffrnq_1
XFILLER_104_517 VDD VSS VDD VSS gf180mcu_fd_sc_mcu7t5v0__fillcap_8
XFILLER_132_815 VDD VSS VDD VSS gf180mcu_fd_sc_mcu7t5v0__fillcap_4
XFILLER_89_206 VDD VSS VDD VSS gf180mcu_fd_sc_mcu7t5v0__fillcap_4
XFILLER_143_196 VDD VSS VDD VSS gf180mcu_fd_sc_mcu7t5v0__fillcap_8
X_3426_ _3426_/A3 _3426_/A4 VDD VSS _3546_/B _3859_/Q _3853_/Q VDD VSS gf180mcu_fd_sc_mcu7t5v0__nand4_1
XFILLER_258_521 VDD VSS VDD VSS gf180mcu_fd_sc_mcu7t5v0__fillcap_4
X_3357_ wire21/Z VDD VSS _4404_/D _4396_/Q _4404_/Q VDD VSS gf180mcu_fd_sc_mcu7t5v0__mux2_2
X_2308_ _2885_/C _2304_/Z VDD VSS _2831_/B _4529_/D _2796_/A2 VDD VSS gf180mcu_fd_sc_mcu7t5v0__nor4_1
XFILLER_100_745 VDD VSS VDD VSS gf180mcu_fd_sc_mcu7t5v0__fillcap_4
X_3288_ _4380_/Q VDD VSS _3291_/A2 _4488_/Q _3334_/A2 VDD VSS gf180mcu_fd_sc_mcu7t5v0__aoi21_1
XFILLER_57_136 VDD VSS VDD VSS gf180mcu_fd_sc_mcu7t5v0__fillcap_4
XFILLER_226_451 VDD VSS VDD VSS gf180mcu_fd_sc_mcu7t5v0__fillcap_4
X_2239_ _4158_/Q _4137_/Q VDD VSS _2242_/A2 _4132_/Q _4153_/Q VDD VSS gf180mcu_fd_sc_mcu7t5v0__aoi22_1
XFILLER_226_473 VDD VSS VDD VSS gf180mcu_fd_sc_mcu7t5v0__fillcap_8
XFILLER_198_325 VDD VSS VDD VSS gf180mcu_fd_sc_mcu7t5v0__fillcap_4
XFILLER_13_206 VDD VSS VDD VSS gf180mcu_fd_sc_mcu7t5v0__fillcap_4
XFILLER_213_189 VDD VSS VDD VSS gf180mcu_fd_sc_mcu7t5v0__fillcap_4
XFILLER_70_37 VDD VSS VDD VSS gf180mcu_fd_sc_mcu7t5v0__fillcap_64
XFILLER_210_885 VDD VSS VDD VSS gf180mcu_fd_sc_mcu7t5v0__fillcap_4
XFILLER_186_37 VDD VSS VDD VSS gf180mcu_fd_sc_mcu7t5v0__fillcap_64
XFILLER_166_299 VDD VSS VDD VSS gf180mcu_fd_sc_mcu7t5v0__fillcap_16
XFILLER_107_311 VDD VSS VDD VSS gf180mcu_fd_sc_mcu7t5v0__fillcap_4
XFILLER_119_160 VDD VSS VDD VSS gf180mcu_fd_sc_mcu7t5v0__fillcap_16
XFILLER_5_416 VDD VSS VDD VSS gf180mcu_fd_sc_mcu7t5v0__fillcap_4
XFILLER_150_634 VDD VSS VDD VSS gf180mcu_fd_sc_mcu7t5v0__fillcap_16
XFILLER_150_667 VDD VSS VDD VSS gf180mcu_fd_sc_mcu7t5v0__fillcap_8
XFILLER_122_358 VDD VSS VDD VSS gf180mcu_fd_sc_mcu7t5v0__fillcap_4
XFILLER_49_626 VDD VSS VDD VSS gf180mcu_fd_sc_mcu7t5v0__fillcap_4
XFILLER_204_101 VDD VSS VDD VSS gf180mcu_fd_sc_mcu7t5v0__fillcap_4
XFILLER_151_95 VDD VSS VDD VSS gf180mcu_fd_sc_mcu7t5v0__fillcap_4
XFILLER_17_556 VDD VSS VDD VSS gf180mcu_fd_sc_mcu7t5v0__fillcap_4
XFILLER_232_498 VDD VSS VDD VSS gf180mcu_fd_sc_mcu7t5v0__fillcap_16
XFILLER_157_200 VDD VSS VDD VSS gf180mcu_fd_sc_mcu7t5v0__fillcap_8
XFILLER_201_874 VDD VSS VDD VSS gf180mcu_fd_sc_mcu7t5v0__fillcap_16
XFILLER_185_531 VDD VSS VDD VSS gf180mcu_fd_sc_mcu7t5v0__fillcap_16
XFILLER_158_789 VDD VSS VDD VSS gf180mcu_fd_sc_mcu7t5v0__fillcap_16
XFILLER_200_362 VDD VSS VDD VSS gf180mcu_fd_sc_mcu7t5v0__fillcap_4
XFILLER_9_766 VDD VSS VDD VSS gf180mcu_fd_sc_mcu7t5v0__fillcap_4
XFILLER_172_225 VDD VSS VDD VSS gf180mcu_fd_sc_mcu7t5v0__fillcap_16
X_2590_ _2590_/B VDD VSS _4203_/D _4203_/Q _2586_/Z VDD VSS gf180mcu_fd_sc_mcu7t5v0__aoi21_1
X_4260_ _4260_/D _4260_/Q _4371_/RN VSS _4278_/CLK VDD VDD VSS gf180mcu_fd_sc_mcu7t5v0__dffrnq_1
XFILLER_268_852 VDD VSS VDD VSS gf180mcu_fd_sc_mcu7t5v0__fillcap_32
XFILLER_140_155 VDD VSS VDD VSS gf180mcu_fd_sc_mcu7t5v0__fillcap_4
X_3211_ VDD _3211_/B _3211_/A2 _4344_/D _3211_/A1 VSS VDD VSS gf180mcu_fd_sc_mcu7t5v0__oai21_1
X_4191_ _4191_/D _4191_/Q wire212/Z VSS clkload7/I VDD VDD VSS gf180mcu_fd_sc_mcu7t5v0__dffrnq_1
X_3142_ VDD VSS _3143_/B _3185_/S _3966_/Q VDD VSS gf180mcu_fd_sc_mcu7t5v0__nor2_1
XFILLER_140_177 VDD VSS VDD VSS gf180mcu_fd_sc_mcu7t5v0__fillcap_32
XFILLER_10_2 VDD VSS VDD VSS gf180mcu_fd_sc_mcu7t5v0__fillcap_32
XFILLER_39_136 VDD VSS VDD VSS gf180mcu_fd_sc_mcu7t5v0__fillcap_4
X_3073_ VDD wire97/I _3875_/Q _3076_/A2 _3157_/A1 VSS VDD VSS gf180mcu_fd_sc_mcu7t5v0__oai21_1
X_2024_ VDD VSS _3960_/Q _3801_/A1 VDD VSS gf180mcu_fd_sc_mcu7t5v0__clkinv_1
X_3975_ VDD _3975_/Q _3998_/CLK VSS _3975_/D VDD VSS gf180mcu_fd_sc_mcu7t5v0__dffq_1
XFILLER_189_881 VDD VSS VDD VSS gf180mcu_fd_sc_mcu7t5v0__fillcap_8
X_2926_ _2926_/A3 _2926_/A4 VDD VSS _2936_/B _2942_/A1 _4331_/Q VDD VSS gf180mcu_fd_sc_mcu7t5v0__or4_1
XFILLER_210_137 VDD VSS VDD VSS gf180mcu_fd_sc_mcu7t5v0__fillcap_32
XFILLER_188_380 VDD VSS VDD VSS gf180mcu_fd_sc_mcu7t5v0__fillcap_4
XFILLER_164_715 VDD VSS VDD VSS gf180mcu_fd_sc_mcu7t5v0__fillcap_16
X_2857_ _3169_/B _2856_/Z VDD VSS _2858_/A2 wire141/Z _4231_/Q VDD VSS gf180mcu_fd_sc_mcu7t5v0__aoi22_1
XFILLER_176_597 VDD VSS VDD VSS gf180mcu_fd_sc_mcu7t5v0__fillcap_8
XFILLER_164_737 VDD VSS VDD VSS gf180mcu_fd_sc_mcu7t5v0__fillcap_16
X_2788_ _2977_/A2 VDD VSS _2788_/Z _2789_/A1 _2789_/A2 VDD VSS gf180mcu_fd_sc_mcu7t5v0__and3_1
X_4527_ _4527_/D _4527_/Q _4527_/RN VSS _4536_/CLK VDD VDD VSS gf180mcu_fd_sc_mcu7t5v0__dffrnq_1
Xhold254 _4569_/D VSS _4574_/Q VDD VDD VSS gf180mcu_fd_sc_mcu7t5v0__dlyc_1
Xhold265 _4557_/D VSS _4562_/Q VDD VDD VSS gf180mcu_fd_sc_mcu7t5v0__dlyc_1
X_4458_ _4458_/D _4458_/Q wire207/Z VSS _4459_/CLK VDD VDD VSS gf180mcu_fd_sc_mcu7t5v0__dffrnq_1
X_3409_ _3424_/S VDD VSS _4452_/D _4410_/Q _4452_/Q VDD VSS gf180mcu_fd_sc_mcu7t5v0__mux2_2
XFILLER_120_807 VDD VSS VDD VSS gf180mcu_fd_sc_mcu7t5v0__fillcap_32
XFILLER_132_667 VDD VSS VDD VSS gf180mcu_fd_sc_mcu7t5v0__fillcap_16
XFILLER_259_874 VDD VSS VDD VSS gf180mcu_fd_sc_mcu7t5v0__fillcap_16
X_4389_ _4389_/D _4389_/Q wire196/Z VSS _4430_/CLK VDD VDD VSS gf180mcu_fd_sc_mcu7t5v0__dffrnq_1
XFILLER_219_749 VDD VSS VDD VSS gf180mcu_fd_sc_mcu7t5v0__fillcap_16
XFILLER_199_612 VDD VSS VDD VSS gf180mcu_fd_sc_mcu7t5v0__fillcap_16
XFILLER_81_492 VDD VSS VDD VSS gf180mcu_fd_sc_mcu7t5v0__fillcap_16
XFILLER_198_177 VDD VSS VDD VSS gf180mcu_fd_sc_mcu7t5v0__fillcap_4
XFILLER_186_306 VDD VSS VDD VSS gf180mcu_fd_sc_mcu7t5v0__fillcap_8
XFILLER_186_317 VDD VSS VDD VSS gf180mcu_fd_sc_mcu7t5v0__fillcap_8
XFILLER_210_660 VDD VSS VDD VSS gf180mcu_fd_sc_mcu7t5v0__fillcap_4
XFILLER_212_2 VDD VSS VDD VSS gf180mcu_fd_sc_mcu7t5v0__fillcap_32
XFILLER_268_104 VDD VSS VDD VSS gf180mcu_fd_sc_mcu7t5v0__fillcap_32
XFILLER_162_291 VDD VSS VDD VSS gf180mcu_fd_sc_mcu7t5v0__fillcap_16
XFILLER_110_317 VDD VSS VDD VSS gf180mcu_fd_sc_mcu7t5v0__fillcap_16
XFILLER_122_177 VDD VSS VDD VSS gf180mcu_fd_sc_mcu7t5v0__fillcap_16
XFILLER_104_881 VDD VSS VDD VSS gf180mcu_fd_sc_mcu7t5v0__fillcap_8
XFILLER_225_708 VDD VSS VDD VSS gf180mcu_fd_sc_mcu7t5v0__fillcap_16
XFILLER_162_94 VDD VSS VDD VSS gf180mcu_fd_sc_mcu7t5v0__fillcap_8
XFILLER_264_387 VDD VSS VDD VSS gf180mcu_fd_sc_mcu7t5v0__fillcap_64
XFILLER_252_527 VDD VSS VDD VSS gf180mcu_fd_sc_mcu7t5v0__fillcap_64
XFILLER_91_212 VDD VSS VDD VSS gf180mcu_fd_sc_mcu7t5v0__fillcap_64
XFILLER_233_741 VDD VSS VDD VSS gf180mcu_fd_sc_mcu7t5v0__fillcap_4
XFILLER_205_465 VDD VSS VDD VSS gf180mcu_fd_sc_mcu7t5v0__fillcap_16
XFILLER_178_807 VDD VSS VDD VSS gf180mcu_fd_sc_mcu7t5v0__fillcap_16
X_3760_ _3767_/S VDD VSS _3930_/D _3841_/I0 _3930_/Q VDD VSS gf180mcu_fd_sc_mcu7t5v0__mux2_2
XFILLER_220_457 VDD VSS VDD VSS gf180mcu_fd_sc_mcu7t5v0__fillcap_8
XFILLER_189_199 VDD VSS VDD VSS gf180mcu_fd_sc_mcu7t5v0__fillcap_8
X_2711_ _2713_/B1 _4282_/Q VDD VSS _2712_/I _4250_/Q _2226_/B VDD VSS gf180mcu_fd_sc_mcu7t5v0__aoi22_1
X_3691_ VDD _3691_/B _3696_/S _3877_/D _3691_/A1 VSS VDD VSS gf180mcu_fd_sc_mcu7t5v0__oai21_1
XFILLER_146_737 VDD VSS VDD VSS gf180mcu_fd_sc_mcu7t5v0__fillcap_8
X_2642_ _4532_/D VDD VSS _4223_/D _4223_/Q _4309_/Q VDD VSS gf180mcu_fd_sc_mcu7t5v0__mux2_2
X_2573_ _4435_/Q _3685_/B1 VDD VSS wire27/I _3859_/Q _4436_/Q VDD VSS gf180mcu_fd_sc_mcu7t5v0__nand4_1
XFILLER_58_2 VDD VSS VDD VSS gf180mcu_fd_sc_mcu7t5v0__fillcap_32
X_4312_ VDD _4312_/Q _4366_/CLK VSS _4312_/D VDD VSS gf180mcu_fd_sc_mcu7t5v0__dffq_1
X_4243_ _4243_/D _4243_/Q _4530_/RN VSS _4554_/CLK VDD VDD VSS gf180mcu_fd_sc_mcu7t5v0__dffrnq_1
XFILLER_102_807 VDD VSS VDD VSS gf180mcu_fd_sc_mcu7t5v0__fillcap_64
XFILLER_268_682 VDD VSS VDD VSS gf180mcu_fd_sc_mcu7t5v0__fillcap_32
X_4174_ _4174_/D _4174_/Q _4527_/RN VSS _4448_/CLK VDD VDD VSS gf180mcu_fd_sc_mcu7t5v0__dffrnq_1
XFILLER_256_877 VDD VSS VDD VSS gf180mcu_fd_sc_mcu7t5v0__fillcap_8
X_3125_ _3125_/B wire71/Z VDD VSS _3126_/A3 _3143_/C _3122_/Z VDD VSS gf180mcu_fd_sc_mcu7t5v0__aoi211_1
Xclkbuf_leaf_5_clk_i _4496_/CLK VSS VDD clkload1/I VDD VSS gf180mcu_fd_sc_mcu7t5v0__clkbuf_2
XFILLER_95_562 VDD VSS VDD VSS gf180mcu_fd_sc_mcu7t5v0__fillcap_8
XFILLER_83_702 VDD VSS VDD VSS gf180mcu_fd_sc_mcu7t5v0__fillcap_4
X_3056_ _3056_/B wire93/Z VDD VSS _3063_/B wire96/Z _3050_/Z VDD VSS gf180mcu_fd_sc_mcu7t5v0__oai211_1
X_2007_ VDD VSS _4477_/Q _3620_/A1 VDD VSS gf180mcu_fd_sc_mcu7t5v0__clkinv_1
XFILLER_63_492 VDD VSS VDD VSS gf180mcu_fd_sc_mcu7t5v0__fillcap_64
XFILLER_51_632 VDD VSS VDD VSS gf180mcu_fd_sc_mcu7t5v0__fillcap_64
XFILLER_168_317 VDD VSS VDD VSS gf180mcu_fd_sc_mcu7t5v0__fillcap_16
X_3958_ VDD _3958_/Q _3967_/CLK VSS _3958_/D VDD VSS gf180mcu_fd_sc_mcu7t5v0__dffq_1
X_2909_ VDD VSS _2910_/B wire168/I _2919_/S VDD VSS gf180mcu_fd_sc_mcu7t5v0__nand2_1
X_3889_ VDD _3889_/Q _4574_/CLK VSS _3889_/D VDD VSS gf180mcu_fd_sc_mcu7t5v0__dffq_1
XFILLER_136_247 VDD VSS VDD VSS gf180mcu_fd_sc_mcu7t5v0__fillcap_16
XFILLER_247_72 VDD VSS VDD VSS gf180mcu_fd_sc_mcu7t5v0__fillcap_64
XFILLER_105_623 VDD VSS VDD VSS gf180mcu_fd_sc_mcu7t5v0__fillcap_4
XFILLER_116_98 VDD VSS VDD VSS gf180mcu_fd_sc_mcu7t5v0__fillcap_4
XFILLER_246_387 VDD VSS VDD VSS gf180mcu_fd_sc_mcu7t5v0__fillcap_64
XFILLER_73_212 VDD VSS VDD VSS gf180mcu_fd_sc_mcu7t5v0__fillcap_64
XFILLER_100_394 VDD VSS VDD VSS gf180mcu_fd_sc_mcu7t5v0__fillcap_32
XFILLER_261_346 VDD VSS VDD VSS gf180mcu_fd_sc_mcu7t5v0__fillcap_4
XFILLER_162_2 VDD VSS VDD VSS gf180mcu_fd_sc_mcu7t5v0__fillcap_32
XFILLER_215_796 VDD VSS VDD VSS gf180mcu_fd_sc_mcu7t5v0__fillcap_8
XFILLER_159_306 VDD VSS VDD VSS gf180mcu_fd_sc_mcu7t5v0__fillcap_4
XFILLER_202_457 VDD VSS VDD VSS gf180mcu_fd_sc_mcu7t5v0__fillcap_4
XFILLER_41_142 VDD VSS VDD VSS gf180mcu_fd_sc_mcu7t5v0__fillcap_64
XFILLER_230_799 VDD VSS VDD VSS gf180mcu_fd_sc_mcu7t5v0__fillcap_4
XFILLER_128_737 VDD VSS VDD VSS gf180mcu_fd_sc_mcu7t5v0__fillcap_64
XFILLER_155_556 VDD VSS VDD VSS gf180mcu_fd_sc_mcu7t5v0__fillcap_4
XFILLER_41_72 VDD VSS VDD VSS gf180mcu_fd_sc_mcu7t5v0__fillcap_64
XFILLER_143_718 VDD VSS VDD VSS gf180mcu_fd_sc_mcu7t5v0__fillcap_4
XFILLER_157_72 VDD VSS VDD VSS gf180mcu_fd_sc_mcu7t5v0__fillcap_8
XFILLER_170_559 VDD VSS VDD VSS gf180mcu_fd_sc_mcu7t5v0__fillcap_16
XFILLER_123_486 VDD VSS VDD VSS gf180mcu_fd_sc_mcu7t5v0__fillcap_4
XFILLER_256_107 VDD VSS VDD VSS gf180mcu_fd_sc_mcu7t5v0__fillcap_64
XFILLER_1_282 VDD VSS VDD VSS gf180mcu_fd_sc_mcu7t5v0__fillcap_64
XFILLER_238_877 VDD VSS VDD VSS gf180mcu_fd_sc_mcu7t5v0__fillcap_8
XFILLER_65_702 VDD VSS VDD VSS gf180mcu_fd_sc_mcu7t5v0__fillcap_64
XFILLER_77_562 VDD VSS VDD VSS gf180mcu_fd_sc_mcu7t5v0__fillcap_64
XFILLER_253_836 VDD VSS VDD VSS gf180mcu_fd_sc_mcu7t5v0__fillcap_4
XFILLER_265_696 VDD VSS VDD VSS gf180mcu_fd_sc_mcu7t5v0__fillcap_4
XFILLER_45_492 VDD VSS VDD VSS gf180mcu_fd_sc_mcu7t5v0__fillcap_64
XFILLER_33_632 VDD VSS VDD VSS gf180mcu_fd_sc_mcu7t5v0__fillcap_64
XFILLER_221_766 VDD VSS VDD VSS gf180mcu_fd_sc_mcu7t5v0__fillcap_4
XFILLER_178_648 VDD VSS VDD VSS gf180mcu_fd_sc_mcu7t5v0__fillcap_16
X_3812_ VDD VSS _3840_/A2 _4540_/Q _4541_/Q VDD VSS gf180mcu_fd_sc_mcu7t5v0__nor2_1
XFILLER_60_451 VDD VSS VDD VSS gf180mcu_fd_sc_mcu7t5v0__fillcap_4
X_3743_ _3747_/S VDD VSS _3917_/D _3763_/I0 _3917_/Q VDD VSS gf180mcu_fd_sc_mcu7t5v0__mux2_2
XFILLER_118_247 VDD VSS VDD VSS gf180mcu_fd_sc_mcu7t5v0__fillcap_64
X_3674_ VDD VSS _3674_/I _4495_/D VDD VSS gf180mcu_fd_sc_mcu7t5v0__clkinv_1
X_2625_ VDD VSS _2628_/A2 _2620_/B _2625_/A2 VDD VSS gf180mcu_fd_sc_mcu7t5v0__nand2_1
XFILLER_133_206 VDD VSS VDD VSS gf180mcu_fd_sc_mcu7t5v0__fillcap_4
XFILLER_161_537 VDD VSS VDD VSS gf180mcu_fd_sc_mcu7t5v0__fillcap_16
XFILLER_133_228 VDD VSS VDD VSS gf180mcu_fd_sc_mcu7t5v0__fillcap_8
X_2556_ wire29/Z VDD VSS _4179_/D _4453_/Q _4179_/Q VDD VSS gf180mcu_fd_sc_mcu7t5v0__mux2_2
XFILLER_99_142 VDD VSS VDD VSS gf180mcu_fd_sc_mcu7t5v0__fillcap_16
X_2487_ _2491_/S VDD VSS _4109_/D _2505_/I0 _4109_/Q VDD VSS gf180mcu_fd_sc_mcu7t5v0__mux2_2
X_4226_ _4226_/D _4226_/Q _4530_/RN VSS _4337_/CLK VDD VDD VSS gf180mcu_fd_sc_mcu7t5v0__dffrnq_1
XFILLER_101_136 VDD VSS VDD VSS gf180mcu_fd_sc_mcu7t5v0__fillcap_4
XFILLER_99_197 VDD VSS VDD VSS gf180mcu_fd_sc_mcu7t5v0__fillcap_8
X_4157_ _4157_/D _4157_/Q wire184/Z VSS _4526_/CLK VDD VDD VSS gf180mcu_fd_sc_mcu7t5v0__dffrnq_1
XFILLER_96_871 VDD VSS VDD VSS gf180mcu_fd_sc_mcu7t5v0__fillcap_4
X_3108_ VDD VSS _3109_/A3 _4333_/Q _3170_/B VDD VSS gf180mcu_fd_sc_mcu7t5v0__nor2_1
XFILLER_55_212 VDD VSS VDD VSS gf180mcu_fd_sc_mcu7t5v0__fillcap_64
XFILLER_228_387 VDD VSS VDD VSS gf180mcu_fd_sc_mcu7t5v0__fillcap_64
X_4088_ VDD _4088_/Q _4096_/CLK VSS _4088_/D VDD VSS gf180mcu_fd_sc_mcu7t5v0__dffq_1
X_3039_ VDD _3039_/B _3038_/B _4329_/D _3039_/A1 VSS VDD VSS gf180mcu_fd_sc_mcu7t5v0__oai21_1
XFILLER_243_346 VDD VSS VDD VSS gf180mcu_fd_sc_mcu7t5v0__fillcap_4
XFILLER_212_722 VDD VSS VDD VSS gf180mcu_fd_sc_mcu7t5v0__fillcap_8
XFILLER_169_626 VDD VSS VDD VSS gf180mcu_fd_sc_mcu7t5v0__fillcap_4
XFILLER_23_142 VDD VSS VDD VSS gf180mcu_fd_sc_mcu7t5v0__fillcap_64
XFILLER_212_777 VDD VSS VDD VSS gf180mcu_fd_sc_mcu7t5v0__fillcap_8
XFILLER_211_276 VDD VSS VDD VSS gf180mcu_fd_sc_mcu7t5v0__fillcap_4
Xwire206 wire206/Z wire207/Z VDD VSS VDD VSS gf180mcu_fd_sc_mcu7t5v0__buf_8
XFILLER_20_871 VDD VSS VDD VSS gf180mcu_fd_sc_mcu7t5v0__fillcap_4
XFILLER_165_876 VDD VSS VDD VSS gf180mcu_fd_sc_mcu7t5v0__fillcap_8
XFILLER_194_37 VDD VSS VDD VSS gf180mcu_fd_sc_mcu7t5v0__fillcap_4
XFILLER_164_375 VDD VSS VDD VSS gf180mcu_fd_sc_mcu7t5v0__fillcap_8
XFILLER_105_486 VDD VSS VDD VSS gf180mcu_fd_sc_mcu7t5v0__fillcap_4
XFILLER_238_107 VDD VSS VDD VSS gf180mcu_fd_sc_mcu7t5v0__fillcap_64
XFILLER_59_562 VDD VSS VDD VSS gf180mcu_fd_sc_mcu7t5v0__fillcap_64
XFILLER_47_702 VDD VSS VDD VSS gf180mcu_fd_sc_mcu7t5v0__fillcap_64
XFILLER_86_381 VDD VSS VDD VSS gf180mcu_fd_sc_mcu7t5v0__fillcap_4
XFILLER_74_521 VDD VSS VDD VSS gf180mcu_fd_sc_mcu7t5v0__fillcap_4
XFILLER_247_696 VDD VSS VDD VSS gf180mcu_fd_sc_mcu7t5v0__fillcap_4
XFILLER_199_250 VDD VSS VDD VSS gf180mcu_fd_sc_mcu7t5v0__fillcap_16
XFILLER_27_492 VDD VSS VDD VSS gf180mcu_fd_sc_mcu7t5v0__fillcap_64
XFILLER_15_632 VDD VSS VDD VSS gf180mcu_fd_sc_mcu7t5v0__fillcap_64
XFILLER_42_451 VDD VSS VDD VSS gf180mcu_fd_sc_mcu7t5v0__fillcap_4
XFILLER_187_478 VDD VSS VDD VSS gf180mcu_fd_sc_mcu7t5v0__fillcap_8
XFILLER_159_136 VDD VSS VDD VSS gf180mcu_fd_sc_mcu7t5v0__fillcap_4
XFILLER_159_158 VDD VSS VDD VSS gf180mcu_fd_sc_mcu7t5v0__fillcap_4
XFILLER_7_842 VDD VSS VDD VSS gf180mcu_fd_sc_mcu7t5v0__fillcap_32
XFILLER_183_684 VDD VSS VDD VSS gf180mcu_fd_sc_mcu7t5v0__fillcap_8
XFILLER_116_729 VDD VSS VDD VSS gf180mcu_fd_sc_mcu7t5v0__fillcap_4
XFILLER_10_381 VDD VSS VDD VSS gf180mcu_fd_sc_mcu7t5v0__fillcap_4
X_2410_ _2413_/S VDD VSS _4046_/D _2506_/I0 _4046_/Q VDD VSS gf180mcu_fd_sc_mcu7t5v0__mux2_2
X_3390_ VDD _4435_/Q _3390_/A2 _3391_/A2 _3390_/A1 VSS VDD VSS gf180mcu_fd_sc_mcu7t5v0__oai21_1
XFILLER_97_602 VDD VSS VDD VSS gf180mcu_fd_sc_mcu7t5v0__fillcap_4
X_2341_ VDD VSS _2780_/B _4328_/Q _2341_/A2 VDD VSS gf180mcu_fd_sc_mcu7t5v0__nand2_1
X_2272_ VDD VSS _2273_/A4 _2272_/A1 _2272_/A2 VDD VSS gf180mcu_fd_sc_mcu7t5v0__nand2_1
XFILLER_257_416 VDD VSS VDD VSS gf180mcu_fd_sc_mcu7t5v0__fillcap_4
XFILLER_2_591 VDD VSS VDD VSS gf180mcu_fd_sc_mcu7t5v0__fillcap_4
Xclkbuf_leaf_70_clk_i _4028_/CLK VSS VDD clkbuf_3_2__f_clk_i/Z VDD VSS gf180mcu_fd_sc_mcu7t5v0__clkbuf_2
XFILLER_78_871 VDD VSS VDD VSS gf180mcu_fd_sc_mcu7t5v0__fillcap_4
X_4011_ VDD _4011_/Q _4612_/CLK VSS _4011_/D VDD VSS gf180mcu_fd_sc_mcu7t5v0__dffq_1
XFILLER_37_212 VDD VSS VDD VSS gf180mcu_fd_sc_mcu7t5v0__fillcap_64
XFILLER_225_346 VDD VSS VDD VSS gf180mcu_fd_sc_mcu7t5v0__fillcap_4
XFILLER_203_66 VDD VSS VDD VSS gf180mcu_fd_sc_mcu7t5v0__fillcap_4
Xclkbuf_leaf_85_clk_i _4270_/CLK VSS VDD clkload2/I VDD VSS gf180mcu_fd_sc_mcu7t5v0__clkbuf_2
XFILLER_93_885 VDD VSS VDD VSS gf180mcu_fd_sc_mcu7t5v0__fillcap_4
XFILLER_20_101 VDD VSS VDD VSS gf180mcu_fd_sc_mcu7t5v0__fillcap_4
X_1987_ VDD VSS _4508_/Q _2230_/B VDD VSS gf180mcu_fd_sc_mcu7t5v0__clkinv_1
XFILLER_138_309 VDD VSS VDD VSS gf180mcu_fd_sc_mcu7t5v0__fillcap_4
X_3726_ _3728_/S VDD VSS _3903_/D _3903_/Q _3765_/I0 VDD VSS gf180mcu_fd_sc_mcu7t5v0__mux2_2
XFILLER_193_448 VDD VSS VDD VSS gf180mcu_fd_sc_mcu7t5v0__fillcap_32
Xclkbuf_leaf_23_clk_i _4535_/CLK VSS VDD clkload3/I VDD VSS gf180mcu_fd_sc_mcu7t5v0__clkbuf_2
X_3657_ VDD VSS _3657_/I _4488_/D VDD VSS gf180mcu_fd_sc_mcu7t5v0__clkinv_1
X_2608_ VDD _4208_/D _2608_/B _4208_/Q _2634_/A3 VSS _2608_/A3 VDD VSS gf180mcu_fd_sc_mcu7t5v0__oai31_1
X_3588_ VDD VSS _3589_/A3 _3586_/S _4072_/Q VDD VSS gf180mcu_fd_sc_mcu7t5v0__nand2_1
XFILLER_161_389 VDD VSS VDD VSS gf180mcu_fd_sc_mcu7t5v0__fillcap_16
X_2539_ _4435_/Q _3616_/A2 VDD VSS wire28/I _3859_/Q _4436_/Q VDD VSS gf180mcu_fd_sc_mcu7t5v0__nand4_2
XFILLER_102_423 VDD VSS VDD VSS gf180mcu_fd_sc_mcu7t5v0__fillcap_32
Xclkbuf_leaf_38_clk_i _4529_/CLK VSS VDD clkload4/I VDD VSS gf180mcu_fd_sc_mcu7t5v0__clkbuf_2
XFILLER_29_702 VDD VSS VDD VSS gf180mcu_fd_sc_mcu7t5v0__fillcap_64
X_4209_ _4209_/D _4209_/Q _4212_/RN VSS _4210_/CLK VDD VDD VSS gf180mcu_fd_sc_mcu7t5v0__dffrnq_1
XFILLER_68_381 VDD VSS VDD VSS gf180mcu_fd_sc_mcu7t5v0__fillcap_4
XFILLER_56_521 VDD VSS VDD VSS gf180mcu_fd_sc_mcu7t5v0__fillcap_4
XFILLER_102_489 VDD VSS VDD VSS gf180mcu_fd_sc_mcu7t5v0__fillcap_4
XFILLER_84_885 VDD VSS VDD VSS gf180mcu_fd_sc_mcu7t5v0__fillcap_4
XFILLER_204_519 VDD VSS VDD VSS gf180mcu_fd_sc_mcu7t5v0__fillcap_4
Xwire71 wire71/Z VSS VDD wire71/I VDD VSS gf180mcu_fd_sc_mcu7t5v0__clkbuf_2
Xwire93 VSS wire93/Z wire93/I VDD VDD VSS gf180mcu_fd_sc_mcu7t5v0__buf_2
XFILLER_169_412 VDD VSS VDD VSS gf180mcu_fd_sc_mcu7t5v0__fillcap_8
XFILLER_24_451 VDD VSS VDD VSS gf180mcu_fd_sc_mcu7t5v0__fillcap_4
Xwire82 VSS wire82/Z wire82/I VDD VDD VSS gf180mcu_fd_sc_mcu7t5v0__buf_3
XFILLER_197_798 VDD VSS VDD VSS gf180mcu_fd_sc_mcu7t5v0__fillcap_4
XFILLER_156_139 VDD VSS VDD VSS gf180mcu_fd_sc_mcu7t5v0__fillcap_16
XFILLER_125_2 VDD VSS VDD VSS gf180mcu_fd_sc_mcu7t5v0__fillcap_16
XFILLER_138_30 VDD VSS VDD VSS gf180mcu_fd_sc_mcu7t5v0__fillcap_4
XFILLER_4_801 VDD VSS VDD VSS gf180mcu_fd_sc_mcu7t5v0__fillcap_4
XFILLER_192_492 VDD VSS VDD VSS gf180mcu_fd_sc_mcu7t5v0__fillcap_32
XFILLER_78_101 VDD VSS VDD VSS gf180mcu_fd_sc_mcu7t5v0__fillcap_4
XFILLER_239_416 VDD VSS VDD VSS gf180mcu_fd_sc_mcu7t5v0__fillcap_4
XFILLER_133_592 VDD VSS VDD VSS gf180mcu_fd_sc_mcu7t5v0__fillcap_8
XFILLER_94_616 VDD VSS VDD VSS gf180mcu_fd_sc_mcu7t5v0__fillcap_32
XFILLER_19_212 VDD VSS VDD VSS gf180mcu_fd_sc_mcu7t5v0__fillcap_64
XFILLER_75_874 VDD VSS VDD VSS gf180mcu_fd_sc_mcu7t5v0__fillcap_16
XFILLER_207_368 VDD VSS VDD VSS gf180mcu_fd_sc_mcu7t5v0__fillcap_8
XFILLER_90_855 VDD VSS VDD VSS gf180mcu_fd_sc_mcu7t5v0__fillcap_4
XFILLER_90_877 VDD VSS VDD VSS gf180mcu_fd_sc_mcu7t5v0__fillcap_8
X_2890_ VDD VSS _2891_/A2 _2985_/C _2985_/A2 VDD VSS gf180mcu_fd_sc_mcu7t5v0__nand2_1
X_1910_ VDD VSS _4328_/Q _3226_/A1 VDD VSS gf180mcu_fd_sc_mcu7t5v0__clkinv_1
XFILLER_187_275 VDD VSS VDD VSS gf180mcu_fd_sc_mcu7t5v0__fillcap_4
X_4560_ _4560_/D _4560_/Q wire187/Z VSS _4565_/CLK VDD VDD VSS gf180mcu_fd_sc_mcu7t5v0__dffrnq_1
XFILLER_171_632 VDD VSS VDD VSS gf180mcu_fd_sc_mcu7t5v0__fillcap_32
XFILLER_183_492 VDD VSS VDD VSS gf180mcu_fd_sc_mcu7t5v0__fillcap_4
X_4491_ _4491_/D _4491_/Q wire209/Z VSS _4494_/CLK VDD VDD VSS gf180mcu_fd_sc_mcu7t5v0__dffrnq_1
X_3511_ _4125_/Q VSS VDD _4109_/Q _4117_/Q _3597_/S _4101_/Q wire82/Z _3511_/Z VDD
+ VSS gf180mcu_fd_sc_mcu7t5v0__mux4_1
XFILLER_6_171 VDD VSS VDD VSS gf180mcu_fd_sc_mcu7t5v0__fillcap_4
Xmax_length190 _4580_/RN _4534_/RN VDD VSS VDD VSS gf180mcu_fd_sc_mcu7t5v0__buf_4
XFILLER_144_868 VDD VSS VDD VSS gf180mcu_fd_sc_mcu7t5v0__fillcap_4
X_3442_ wire42/Z VDD VSS _3442_/Z _3442_/A1 _3442_/A2 VDD VSS gf180mcu_fd_sc_mcu7t5v0__and3_1
XFILLER_171_687 VDD VSS VDD VSS gf180mcu_fd_sc_mcu7t5v0__fillcap_4
X_3373_ wire20/Z VDD VSS _4420_/D _4412_/Q _4420_/Q VDD VSS gf180mcu_fd_sc_mcu7t5v0__mux2_2
XFILLER_40_2 VDD VSS VDD VSS gf180mcu_fd_sc_mcu7t5v0__fillcap_32
X_2324_ VDD VSS _2854_/B _4346_/Q _4341_/Q VDD VSS gf180mcu_fd_sc_mcu7t5v0__nor2_1
XFILLER_112_721 VDD VSS VDD VSS gf180mcu_fd_sc_mcu7t5v0__fillcap_8
X_2255_ VDD VSS _2258_/A2 _4567_/Q _4543_/D VDD VSS gf180mcu_fd_sc_mcu7t5v0__xnor2_1
XFILLER_38_521 VDD VSS VDD VSS gf180mcu_fd_sc_mcu7t5v0__fillcap_4
X_2186_ VDD VSS _2211_/A2 _4242_/Q _2691_/A1 VDD VSS gf180mcu_fd_sc_mcu7t5v0__nor2_1
XFILLER_66_885 VDD VSS VDD VSS gf180mcu_fd_sc_mcu7t5v0__fillcap_4
XFILLER_81_833 VDD VSS VDD VSS gf180mcu_fd_sc_mcu7t5v0__fillcap_4
XFILLER_213_316 VDD VSS VDD VSS gf180mcu_fd_sc_mcu7t5v0__fillcap_32
XFILLER_80_387 VDD VSS VDD VSS gf180mcu_fd_sc_mcu7t5v0__fillcap_64
XFILLER_194_713 VDD VSS VDD VSS gf180mcu_fd_sc_mcu7t5v0__fillcap_16
XFILLER_194_768 VDD VSS VDD VSS gf180mcu_fd_sc_mcu7t5v0__fillcap_32
XFILLER_193_212 VDD VSS VDD VSS gf180mcu_fd_sc_mcu7t5v0__fillcap_8
X_3709_ _3718_/S VDD VSS _3890_/D _3890_/Q _4289_/Q VDD VSS gf180mcu_fd_sc_mcu7t5v0__mux2_2
XFILLER_175_39 VDD VSS VDD VSS gf180mcu_fd_sc_mcu7t5v0__fillcap_16
XFILLER_161_142 VDD VSS VDD VSS gf180mcu_fd_sc_mcu7t5v0__fillcap_8
XFILLER_150_838 VDD VSS VDD VSS gf180mcu_fd_sc_mcu7t5v0__fillcap_32
XFILLER_255_72 VDD VSS VDD VSS gf180mcu_fd_sc_mcu7t5v0__fillcap_64
XFILLER_68_37 VDD VSS VDD VSS gf180mcu_fd_sc_mcu7t5v0__fillcap_64
XFILLER_103_754 VDD VSS VDD VSS gf180mcu_fd_sc_mcu7t5v0__fillcap_16
XFILLER_90_107 VDD VSS VDD VSS gf180mcu_fd_sc_mcu7t5v0__fillcap_64
XFILLER_57_874 VDD VSS VDD VSS gf180mcu_fd_sc_mcu7t5v0__fillcap_16
XFILLER_72_877 VDD VSS VDD VSS gf180mcu_fd_sc_mcu7t5v0__fillcap_8
XFILLER_185_702 VDD VSS VDD VSS gf180mcu_fd_sc_mcu7t5v0__fillcap_64
XFILLER_169_264 VDD VSS VDD VSS gf180mcu_fd_sc_mcu7t5v0__fillcap_16
XFILLER_149_95 VDD VSS VDD VSS gf180mcu_fd_sc_mcu7t5v0__fillcap_4
XFILLER_153_632 VDD VSS VDD VSS gf180mcu_fd_sc_mcu7t5v0__fillcap_32
XFILLER_165_492 VDD VSS VDD VSS gf180mcu_fd_sc_mcu7t5v0__fillcap_4
XFILLER_165_72 VDD VSS VDD VSS gf180mcu_fd_sc_mcu7t5v0__fillcap_16
XFILLER_165_94 VDD VSS VDD VSS gf180mcu_fd_sc_mcu7t5v0__fillcap_32
XFILLER_121_562 VDD VSS VDD VSS gf180mcu_fd_sc_mcu7t5v0__fillcap_16
XFILLER_208_633 VDD VSS VDD VSS gf180mcu_fd_sc_mcu7t5v0__fillcap_4
X_2040_ VDD VSS _2040_/Z _4429_/Q _2035_/Z VDD VSS gf180mcu_fd_sc_mcu7t5v0__and2_1
XFILLER_94_457 VDD VSS VDD VSS gf180mcu_fd_sc_mcu7t5v0__fillcap_64
XFILLER_12_6 VDD VSS VDD VSS gf180mcu_fd_sc_mcu7t5v0__fillcap_16
XFILLER_48_885 VDD VSS VDD VSS gf180mcu_fd_sc_mcu7t5v0__fillcap_4
XFILLER_263_772 VDD VSS VDD VSS gf180mcu_fd_sc_mcu7t5v0__fillcap_64
XFILLER_208_699 VDD VSS VDD VSS gf180mcu_fd_sc_mcu7t5v0__fillcap_32
XFILLER_223_625 VDD VSS VDD VSS gf180mcu_fd_sc_mcu7t5v0__fillcap_4
X_3991_ VDD _3991_/Q _4001_/CLK VSS _3991_/D VDD VSS gf180mcu_fd_sc_mcu7t5v0__dffq_1
XFILLER_62_387 VDD VSS VDD VSS gf180mcu_fd_sc_mcu7t5v0__fillcap_64
X_2942_ _2942_/B _2942_/C VDD VSS _2945_/A2 _2942_/A1 _4364_/Q VDD VSS gf180mcu_fd_sc_mcu7t5v0__oai211_1
XFILLER_50_527 VDD VSS VDD VSS gf180mcu_fd_sc_mcu7t5v0__fillcap_64
XFILLER_188_584 VDD VSS VDD VSS gf180mcu_fd_sc_mcu7t5v0__fillcap_8
XFILLER_175_212 VDD VSS VDD VSS gf180mcu_fd_sc_mcu7t5v0__fillcap_64
X_2873_ _3015_/B _4324_/Q VDD VSS _2883_/A2 _4370_/Q _4368_/Q VDD VSS gf180mcu_fd_sc_mcu7t5v0__aoi211_1
X_4612_ _4612_/D _4612_/Q _4613_/RN VSS _4612_/CLK VDD VDD VSS gf180mcu_fd_sc_mcu7t5v0__dffrnq_1
X_4543_ _4543_/D _4561_/D wire187/Z VSS _4573_/CLK VDD VDD VSS gf180mcu_fd_sc_mcu7t5v0__dffrnq_1
XFILLER_117_879 VDD VSS VDD VSS gf180mcu_fd_sc_mcu7t5v0__fillcap_8
XFILLER_171_462 VDD VSS VDD VSS gf180mcu_fd_sc_mcu7t5v0__fillcap_4
XFILLER_143_142 VDD VSS VDD VSS gf180mcu_fd_sc_mcu7t5v0__fillcap_4
XFILLER_116_367 VDD VSS VDD VSS gf180mcu_fd_sc_mcu7t5v0__fillcap_8
X_4474_ _4474_/D _4474_/Q wire193/Z VSS _4476_/CLK VDD VDD VSS gf180mcu_fd_sc_mcu7t5v0__dffrnq_1
X_3425_ _3425_/S VDD VSS _4468_/D _4426_/Q _4468_/Q VDD VSS gf180mcu_fd_sc_mcu7t5v0__mux2_2
XFILLER_140_871 VDD VSS VDD VSS gf180mcu_fd_sc_mcu7t5v0__fillcap_4
X_3356_ wire20/Z VDD VSS _4403_/D _4395_/Q _4403_/Q VDD VSS gf180mcu_fd_sc_mcu7t5v0__mux2_2
X_2307_ VDD VSS _3024_/A2 _2795_/A1 _4529_/Q VDD VSS gf180mcu_fd_sc_mcu7t5v0__nand2_1
X_3287_ VSS VDD _4480_/Q _3278_/Z _4496_/Q _3302_/A2 _2280_/I _4472_/Q _3291_/A1 VDD
+ VSS gf180mcu_fd_sc_mcu7t5v0__aoi222_1
XFILLER_112_584 VDD VSS VDD VSS gf180mcu_fd_sc_mcu7t5v0__fillcap_8
X_2238_ _4161_/Q _4140_/Q VDD VSS _2242_/A1 _4138_/Q _4159_/Q VDD VSS gf180mcu_fd_sc_mcu7t5v0__aoi22_1
XFILLER_72_107 VDD VSS VDD VSS gf180mcu_fd_sc_mcu7t5v0__fillcap_64
XFILLER_39_874 VDD VSS VDD VSS gf180mcu_fd_sc_mcu7t5v0__fillcap_16
X_2169_ _2171_/A3 VDD VSS _2169_/Z _2679_/A1 _4240_/Q VDD VSS gf180mcu_fd_sc_mcu7t5v0__and3_1
XFILLER_241_422 VDD VSS VDD VSS gf180mcu_fd_sc_mcu7t5v0__fillcap_64
XFILLER_253_282 VDD VSS VDD VSS gf180mcu_fd_sc_mcu7t5v0__fillcap_64
XFILLER_54_877 VDD VSS VDD VSS gf180mcu_fd_sc_mcu7t5v0__fillcap_8
XFILLER_167_702 VDD VSS VDD VSS gf180mcu_fd_sc_mcu7t5v0__fillcap_64
XFILLER_119_10 VDD VSS VDD VSS gf180mcu_fd_sc_mcu7t5v0__fillcap_4
XFILLER_214_6 VDD VSS VDD VSS gf180mcu_fd_sc_mcu7t5v0__fillcap_16
XFILLER_134_131 VDD VSS VDD VSS gf180mcu_fd_sc_mcu7t5v0__fillcap_4
XFILLER_134_186 VDD VSS VDD VSS gf180mcu_fd_sc_mcu7t5v0__fillcap_16
XFILLER_268_308 VDD VSS VDD VSS gf180mcu_fd_sc_mcu7t5v0__fillcap_32
XFILLER_103_540 VDD VSS VDD VSS gf180mcu_fd_sc_mcu7t5v0__fillcap_8
XFILLER_192_2 VDD VSS VDD VSS gf180mcu_fd_sc_mcu7t5v0__fillcap_32
XFILLER_130_381 VDD VSS VDD VSS gf180mcu_fd_sc_mcu7t5v0__fillcap_4
XFILLER_76_457 VDD VSS VDD VSS gf180mcu_fd_sc_mcu7t5v0__fillcap_64
XFILLER_91_416 VDD VSS VDD VSS gf180mcu_fd_sc_mcu7t5v0__fillcap_4
XFILLER_245_772 VDD VSS VDD VSS gf180mcu_fd_sc_mcu7t5v0__fillcap_64
XFILLER_260_731 VDD VSS VDD VSS gf180mcu_fd_sc_mcu7t5v0__fillcap_4
XFILLER_44_387 VDD VSS VDD VSS gf180mcu_fd_sc_mcu7t5v0__fillcap_64
XFILLER_32_527 VDD VSS VDD VSS gf180mcu_fd_sc_mcu7t5v0__fillcap_64
XFILLER_198_871 VDD VSS VDD VSS gf180mcu_fd_sc_mcu7t5v0__fillcap_4
XFILLER_201_842 VDD VSS VDD VSS gf180mcu_fd_sc_mcu7t5v0__fillcap_32
XFILLER_157_212 VDD VSS VDD VSS gf180mcu_fd_sc_mcu7t5v0__fillcap_64
XFILLER_153_462 VDD VSS VDD VSS gf180mcu_fd_sc_mcu7t5v0__fillcap_4
XFILLER_99_516 VDD VSS VDD VSS gf180mcu_fd_sc_mcu7t5v0__fillcap_4
XFILLER_140_101 VDD VSS VDD VSS gf180mcu_fd_sc_mcu7t5v0__fillcap_4
XFILLER_113_337 VDD VSS VDD VSS gf180mcu_fd_sc_mcu7t5v0__fillcap_8
XFILLER_5_66 VDD VSS VDD VSS gf180mcu_fd_sc_mcu7t5v0__fillcap_4
X_3210_ _3209_/B _3211_/A2 _3210_/B2 VDD VSS _4343_/D _4371_/Q _3210_/A2 VDD VSS gf180mcu_fd_sc_mcu7t5v0__oai32_1
X_4190_ _4190_/D _4190_/Q wire210/Z VSS _4496_/CLK VDD VDD VSS gf180mcu_fd_sc_mcu7t5v0__dffrnq_1
XFILLER_268_886 VDD VSS VDD VSS gf180mcu_fd_sc_mcu7t5v0__fillcap_4
X_3141_ VDD VSS _3146_/A2 wire94/Z _3140_/Z VDD VSS gf180mcu_fd_sc_mcu7t5v0__nor2_1
XFILLER_267_352 VDD VSS VDD VSS gf180mcu_fd_sc_mcu7t5v0__fillcap_64
XFILLER_122_871 VDD VSS VDD VSS gf180mcu_fd_sc_mcu7t5v0__fillcap_4
X_3072_ VDD VSS _3076_/A1 _4551_/Q _3883_/Q VDD VSS gf180mcu_fd_sc_mcu7t5v0__nor2_1
XFILLER_54_107 VDD VSS VDD VSS gf180mcu_fd_sc_mcu7t5v0__fillcap_64
X_2023_ VDD VSS _4229_/Q _3170_/A2 VDD VSS gf180mcu_fd_sc_mcu7t5v0__clkinv_1
XFILLER_223_422 VDD VSS VDD VSS gf180mcu_fd_sc_mcu7t5v0__fillcap_64
XFILLER_235_282 VDD VSS VDD VSS gf180mcu_fd_sc_mcu7t5v0__fillcap_64
XFILLER_36_877 VDD VSS VDD VSS gf180mcu_fd_sc_mcu7t5v0__fillcap_8
XFILLER_250_241 VDD VSS VDD VSS gf180mcu_fd_sc_mcu7t5v0__fillcap_4
XFILLER_211_66 VDD VSS VDD VSS gf180mcu_fd_sc_mcu7t5v0__fillcap_4
XFILLER_51_836 VDD VSS VDD VSS gf180mcu_fd_sc_mcu7t5v0__fillcap_4
XFILLER_63_696 VDD VSS VDD VSS gf180mcu_fd_sc_mcu7t5v0__fillcap_4
X_3974_ VDD _3974_/Q _3998_/CLK VSS _3974_/D VDD VSS gf180mcu_fd_sc_mcu7t5v0__dffq_1
X_2925_ VDD _2925_/B wire45/Z _4314_/D _2925_/A1 VSS VDD VSS gf180mcu_fd_sc_mcu7t5v0__oai21_1
X_2856_ _4508_/Q VDD VSS _2856_/Z _4254_/Q _4262_/Q VDD VSS gf180mcu_fd_sc_mcu7t5v0__mux2_2
XFILLER_144_440 VDD VSS VDD VSS gf180mcu_fd_sc_mcu7t5v0__fillcap_8
X_2787_ VDD VSS _2977_/A2 _2799_/A3 _3004_/A2 VDD VSS gf180mcu_fd_sc_mcu7t5v0__nand2_1
XFILLER_129_492 VDD VSS VDD VSS gf180mcu_fd_sc_mcu7t5v0__fillcap_16
XFILLER_117_632 VDD VSS VDD VSS gf180mcu_fd_sc_mcu7t5v0__fillcap_16
X_4526_ _4526_/D _4526_/Q wire183/Z VSS _4526_/CLK VDD VDD VSS gf180mcu_fd_sc_mcu7t5v0__dffrnq_1
XFILLER_132_613 VDD VSS VDD VSS gf180mcu_fd_sc_mcu7t5v0__fillcap_8
Xhold266 _4556_/D VSS _4561_/Q VDD VDD VSS gf180mcu_fd_sc_mcu7t5v0__dlyc_1
Xhold255 _3872_/D VSS _3871_/Q VDD VDD VSS gf180mcu_fd_sc_mcu7t5v0__dlyc_1
X_4457_ _4457_/D _4457_/Q wire196/I VSS clkload7/I VDD VDD VSS gf180mcu_fd_sc_mcu7t5v0__dffrnq_1
XFILLER_259_842 VDD VSS VDD VSS gf180mcu_fd_sc_mcu7t5v0__fillcap_32
X_3408_ _3424_/S VDD VSS _4451_/D _4409_/Q _4451_/Q VDD VSS gf180mcu_fd_sc_mcu7t5v0__mux2_2
XFILLER_219_717 VDD VSS VDD VSS gf180mcu_fd_sc_mcu7t5v0__fillcap_32
X_4388_ _4388_/D _4388_/Q wire196/Z VSS _4430_/CLK VDD VDD VSS gf180mcu_fd_sc_mcu7t5v0__dffrnq_1
XFILLER_98_571 VDD VSS VDD VSS gf180mcu_fd_sc_mcu7t5v0__fillcap_16
X_3339_ _3346_/S VDD VSS _4387_/D _3856_/Q _4387_/Q VDD VSS gf180mcu_fd_sc_mcu7t5v0__mux2_2
XFILLER_58_457 VDD VSS VDD VSS gf180mcu_fd_sc_mcu7t5v0__fillcap_64
XFILLER_100_521 VDD VSS VDD VSS gf180mcu_fd_sc_mcu7t5v0__fillcap_4
XFILLER_85_276 VDD VSS VDD VSS gf180mcu_fd_sc_mcu7t5v0__fillcap_4
XFILLER_73_416 VDD VSS VDD VSS gf180mcu_fd_sc_mcu7t5v0__fillcap_4
XFILLER_227_772 VDD VSS VDD VSS gf180mcu_fd_sc_mcu7t5v0__fillcap_16
XFILLER_242_731 VDD VSS VDD VSS gf180mcu_fd_sc_mcu7t5v0__fillcap_4
XFILLER_254_591 VDD VSS VDD VSS gf180mcu_fd_sc_mcu7t5v0__fillcap_4
XFILLER_198_101 VDD VSS VDD VSS gf180mcu_fd_sc_mcu7t5v0__fillcap_4
XFILLER_26_387 VDD VSS VDD VSS gf180mcu_fd_sc_mcu7t5v0__fillcap_64
XFILLER_198_123 VDD VSS VDD VSS gf180mcu_fd_sc_mcu7t5v0__fillcap_4
XFILLER_14_527 VDD VSS VDD VSS gf180mcu_fd_sc_mcu7t5v0__fillcap_64
XFILLER_187_819 VDD VSS VDD VSS gf180mcu_fd_sc_mcu7t5v0__fillcap_16
XFILLER_121_88 VDD VSS VDD VSS gf180mcu_fd_sc_mcu7t5v0__fillcap_8
XFILLER_41_346 VDD VSS VDD VSS gf180mcu_fd_sc_mcu7t5v0__fillcap_4
XFILLER_179_392 VDD VSS VDD VSS gf180mcu_fd_sc_mcu7t5v0__fillcap_16
XFILLER_195_874 VDD VSS VDD VSS gf180mcu_fd_sc_mcu7t5v0__fillcap_16
XFILLER_194_395 VDD VSS VDD VSS gf180mcu_fd_sc_mcu7t5v0__fillcap_4
XFILLER_6_737 VDD VSS VDD VSS gf180mcu_fd_sc_mcu7t5v0__fillcap_64
XFILLER_205_2 VDD VSS VDD VSS gf180mcu_fd_sc_mcu7t5v0__fillcap_64
XFILLER_107_142 VDD VSS VDD VSS gf180mcu_fd_sc_mcu7t5v0__fillcap_8
XFILLER_190_590 VDD VSS VDD VSS gf180mcu_fd_sc_mcu7t5v0__fillcap_4
XFILLER_268_138 VDD VSS VDD VSS gf180mcu_fd_sc_mcu7t5v0__fillcap_32
XFILLER_96_519 VDD VSS VDD VSS gf180mcu_fd_sc_mcu7t5v0__fillcap_4
XFILLER_249_352 VDD VSS VDD VSS gf180mcu_fd_sc_mcu7t5v0__fillcap_64
XFILLER_1_486 VDD VSS VDD VSS gf180mcu_fd_sc_mcu7t5v0__fillcap_4
XFILLER_264_311 VDD VSS VDD VSS gf180mcu_fd_sc_mcu7t5v0__fillcap_4
XFILLER_162_62 VDD VSS VDD VSS gf180mcu_fd_sc_mcu7t5v0__fillcap_32
XFILLER_77_766 VDD VSS VDD VSS gf180mcu_fd_sc_mcu7t5v0__fillcap_4
XFILLER_39_72 VDD VSS VDD VSS gf180mcu_fd_sc_mcu7t5v0__fillcap_64
XFILLER_92_725 VDD VSS VDD VSS gf180mcu_fd_sc_mcu7t5v0__fillcap_8
XFILLER_36_107 VDD VSS VDD VSS gf180mcu_fd_sc_mcu7t5v0__fillcap_64
XFILLER_205_422 VDD VSS VDD VSS gf180mcu_fd_sc_mcu7t5v0__fillcap_32
XFILLER_217_282 VDD VSS VDD VSS gf180mcu_fd_sc_mcu7t5v0__fillcap_64
XFILLER_18_877 VDD VSS VDD VSS gf180mcu_fd_sc_mcu7t5v0__fillcap_8
XFILLER_232_241 VDD VSS VDD VSS gf180mcu_fd_sc_mcu7t5v0__fillcap_4
XFILLER_33_836 VDD VSS VDD VSS gf180mcu_fd_sc_mcu7t5v0__fillcap_4
XFILLER_45_696 VDD VSS VDD VSS gf180mcu_fd_sc_mcu7t5v0__fillcap_4
XFILLER_158_521 VDD VSS VDD VSS gf180mcu_fd_sc_mcu7t5v0__fillcap_4
XFILLER_201_650 VDD VSS VDD VSS gf180mcu_fd_sc_mcu7t5v0__fillcap_16
XFILLER_158_543 VDD VSS VDD VSS gf180mcu_fd_sc_mcu7t5v0__fillcap_4
X_2710_ VDD VSS _2710_/I _4249_/D VDD VSS gf180mcu_fd_sc_mcu7t5v0__clkinv_1
X_3690_ VDD VSS _3691_/B _3763_/I0 _3696_/S VDD VSS gf180mcu_fd_sc_mcu7t5v0__nand2_1
XFILLER_158_576 VDD VSS VDD VSS gf180mcu_fd_sc_mcu7t5v0__fillcap_8
XFILLER_186_885 VDD VSS VDD VSS gf180mcu_fd_sc_mcu7t5v0__fillcap_4
X_2641_ _4532_/D VDD VSS _4222_/D _4222_/Q _4306_/Q VDD VSS gf180mcu_fd_sc_mcu7t5v0__mux2_2
X_2572_ VDD VSS _3685_/B1 _3451_/A1 _3637_/A3 VDD VSS gf180mcu_fd_sc_mcu7t5v0__nor2_1
X_4311_ VDD _4311_/Q _4366_/CLK VSS _4311_/D VDD VSS gf180mcu_fd_sc_mcu7t5v0__dffq_1
XFILLER_141_454 VDD VSS VDD VSS gf180mcu_fd_sc_mcu7t5v0__fillcap_8
X_4242_ _4242_/D _4242_/Q wire187/Z VSS _4562_/CLK VDD VDD VSS gf180mcu_fd_sc_mcu7t5v0__dffrnq_1
XFILLER_99_368 VDD VSS VDD VSS gf180mcu_fd_sc_mcu7t5v0__fillcap_4
XFILLER_256_801 VDD VSS VDD VSS gf180mcu_fd_sc_mcu7t5v0__fillcap_4
X_4173_ _4173_/D _4173_/Q wire184/Z VSS _4500_/CLK VDD VDD VSS gf180mcu_fd_sc_mcu7t5v0__dffrnq_1
X_3124_ _3124_/B _3143_/C VDD VSS _3125_/B _3124_/A1 _3795_/A1 VDD VSS gf180mcu_fd_sc_mcu7t5v0__aoi211_1
XFILLER_67_276 VDD VSS VDD VSS gf180mcu_fd_sc_mcu7t5v0__fillcap_4
XFILLER_110_885 VDD VSS VDD VSS gf180mcu_fd_sc_mcu7t5v0__fillcap_4
XFILLER_55_416 VDD VSS VDD VSS gf180mcu_fd_sc_mcu7t5v0__fillcap_4
XFILLER_209_772 VDD VSS VDD VSS gf180mcu_fd_sc_mcu7t5v0__fillcap_16
X_3055_ _3055_/B1 wire96/Z VDD VSS _3056_/B _3055_/A1 _3055_/A2 _3055_/B2 VDD VSS
+ gf180mcu_fd_sc_mcu7t5v0__oai221_1
X_2006_ VDD VSS _4469_/Q _3457_/A1 VDD VSS gf180mcu_fd_sc_mcu7t5v0__clkinv_1
XFILLER_23_346 VDD VSS VDD VSS gf180mcu_fd_sc_mcu7t5v0__fillcap_4
X_3957_ VDD _3957_/Q _3965_/CLK VSS _3957_/D VDD VSS gf180mcu_fd_sc_mcu7t5v0__dffq_1
XFILLER_195_104 VDD VSS VDD VSS gf180mcu_fd_sc_mcu7t5v0__fillcap_8
X_2908_ VDD VSS _2919_/S _4530_/RN _2960_/B1 VDD VSS gf180mcu_fd_sc_mcu7t5v0__nand2_1
X_3888_ VDD _3888_/Q _3937_/CLK VSS _3888_/D VDD VSS gf180mcu_fd_sc_mcu7t5v0__dffq_1
XFILLER_109_407 VDD VSS VDD VSS gf180mcu_fd_sc_mcu7t5v0__fillcap_8
X_2839_ VDD VSS _2840_/B _3122_/S _3969_/Q VDD VSS gf180mcu_fd_sc_mcu7t5v0__or2_1
XFILLER_192_877 VDD VSS VDD VSS gf180mcu_fd_sc_mcu7t5v0__fillcap_8
X_4509_ VSS _4554_/CLK VDD _4509_/D _4509_/Q wire187/Z VDD VSS gf180mcu_fd_sc_mcu7t5v0__dffsnq_1
XFILLER_263_72 VDD VSS VDD VSS gf180mcu_fd_sc_mcu7t5v0__fillcap_64
XFILLER_120_627 VDD VSS VDD VSS gf180mcu_fd_sc_mcu7t5v0__fillcap_8
XFILLER_246_311 VDD VSS VDD VSS gf180mcu_fd_sc_mcu7t5v0__fillcap_4
XFILLER_258_171 VDD VSS VDD VSS gf180mcu_fd_sc_mcu7t5v0__fillcap_4
XFILLER_59_766 VDD VSS VDD VSS gf180mcu_fd_sc_mcu7t5v0__fillcap_4
XFILLER_76_37 VDD VSS VDD VSS gf180mcu_fd_sc_mcu7t5v0__fillcap_64
XFILLER_101_874 VDD VSS VDD VSS gf180mcu_fd_sc_mcu7t5v0__fillcap_16
XFILLER_18_107 VDD VSS VDD VSS gf180mcu_fd_sc_mcu7t5v0__fillcap_64
XFILLER_100_373 VDD VSS VDD VSS gf180mcu_fd_sc_mcu7t5v0__fillcap_8
XFILLER_214_230 VDD VSS VDD VSS gf180mcu_fd_sc_mcu7t5v0__fillcap_8
XFILLER_132_98 VDD VSS VDD VSS gf180mcu_fd_sc_mcu7t5v0__fillcap_4
XFILLER_15_836 VDD VSS VDD VSS gf180mcu_fd_sc_mcu7t5v0__fillcap_4
XFILLER_27_696 VDD VSS VDD VSS gf180mcu_fd_sc_mcu7t5v0__fillcap_4
XFILLER_155_2 VDD VSS VDD VSS gf180mcu_fd_sc_mcu7t5v0__fillcap_8
XFILLER_230_767 VDD VSS VDD VSS gf180mcu_fd_sc_mcu7t5v0__fillcap_32
XFILLER_168_852 VDD VSS VDD VSS gf180mcu_fd_sc_mcu7t5v0__fillcap_16
XFILLER_168_885 VDD VSS VDD VSS gf180mcu_fd_sc_mcu7t5v0__fillcap_4
XFILLER_167_384 VDD VSS VDD VSS gf180mcu_fd_sc_mcu7t5v0__fillcap_4
XFILLER_127_204 VDD VSS VDD VSS gf180mcu_fd_sc_mcu7t5v0__fillcap_4
XFILLER_182_310 VDD VSS VDD VSS gf180mcu_fd_sc_mcu7t5v0__fillcap_4
XFILLER_182_387 VDD VSS VDD VSS gf180mcu_fd_sc_mcu7t5v0__fillcap_64
XFILLER_170_527 VDD VSS VDD VSS gf180mcu_fd_sc_mcu7t5v0__fillcap_16
XFILLER_108_495 VDD VSS VDD VSS gf180mcu_fd_sc_mcu7t5v0__fillcap_16
XFILLER_238_801 VDD VSS VDD VSS gf180mcu_fd_sc_mcu7t5v0__fillcap_4
XFILLER_49_276 VDD VSS VDD VSS gf180mcu_fd_sc_mcu7t5v0__fillcap_4
XFILLER_37_416 VDD VSS VDD VSS gf180mcu_fd_sc_mcu7t5v0__fillcap_4
XFILLER_218_591 VDD VSS VDD VSS gf180mcu_fd_sc_mcu7t5v0__fillcap_4
XFILLER_80_728 VDD VSS VDD VSS gf180mcu_fd_sc_mcu7t5v0__fillcap_4
X_3811_ wire15/I VDD VSS _3969_/D _3848_/I0 _3969_/Q VDD VSS gf180mcu_fd_sc_mcu7t5v0__mux2_2
XFILLER_193_619 VDD VSS VDD VSS gf180mcu_fd_sc_mcu7t5v0__fillcap_8
X_3742_ _3747_/S VDD VSS _3916_/D wire177/Z _3916_/Q VDD VSS gf180mcu_fd_sc_mcu7t5v0__mux2_2
XFILLER_192_107 VDD VSS VDD VSS gf180mcu_fd_sc_mcu7t5v0__fillcap_4
XFILLER_70_2 VDD VSS VDD VSS gf180mcu_fd_sc_mcu7t5v0__fillcap_32
XFILLER_173_310 VDD VSS VDD VSS gf180mcu_fd_sc_mcu7t5v0__fillcap_32
X_3673_ _3677_/B1 _4189_/Q VDD VSS _3674_/I _4495_/Q _3682_/A2 VDD VSS gf180mcu_fd_sc_mcu7t5v0__aoi22_1
X_2624_ VDD VSS _2625_/A2 _2586_/Z _2629_/A2 VDD VSS gf180mcu_fd_sc_mcu7t5v0__nand2_1
XFILLER_142_730 VDD VSS VDD VSS gf180mcu_fd_sc_mcu7t5v0__fillcap_4
XFILLER_114_421 VDD VSS VDD VSS gf180mcu_fd_sc_mcu7t5v0__fillcap_4
XFILLER_127_793 VDD VSS VDD VSS gf180mcu_fd_sc_mcu7t5v0__fillcap_32
XFILLER_114_432 VDD VSS VDD VSS gf180mcu_fd_sc_mcu7t5v0__fillcap_16
X_2555_ wire28/Z VDD VSS _4178_/D _4452_/Q _4178_/Q VDD VSS gf180mcu_fd_sc_mcu7t5v0__mux2_2
X_2486_ _2491_/S VDD VSS _4108_/D wire161/Z _4108_/Q VDD VSS gf180mcu_fd_sc_mcu7t5v0__mux2_2
X_4225_ _4225_/D _4225_/Q _4530_/RN VSS _4369_/CLK VDD VDD VSS gf180mcu_fd_sc_mcu7t5v0__dffrnq_1
X_4156_ _4156_/D _4156_/Q wire184/Z VSS _4526_/CLK VDD VDD VSS gf180mcu_fd_sc_mcu7t5v0__dffrnq_1
XFILLER_228_311 VDD VSS VDD VSS gf180mcu_fd_sc_mcu7t5v0__fillcap_4
X_3107_ _3169_/B _3107_/C VDD VSS _3109_/A2 _2854_/B _3107_/A2 wire66/Z VDD VSS gf180mcu_fd_sc_mcu7t5v0__aoi221_1
Xmax_cap19 _3619_/C _3546_/B VDD VSS VDD VSS gf180mcu_fd_sc_mcu7t5v0__buf_4
X_4087_ VDD _4087_/Q _4532_/CLK VSS _4087_/D VDD VSS gf180mcu_fd_sc_mcu7t5v0__dffq_1
X_3038_ _3038_/B _3038_/C VDD VSS _3039_/B _3218_/B1 _3038_/A2 VDD VSS gf180mcu_fd_sc_mcu7t5v0__oai211_1
XFILLER_196_457 VDD VSS VDD VSS gf180mcu_fd_sc_mcu7t5v0__fillcap_16
XFILLER_149_340 VDD VSS VDD VSS gf180mcu_fd_sc_mcu7t5v0__fillcap_8
Xwire207 wire207/Z VSS VDD wire209/Z VDD VSS gf180mcu_fd_sc_mcu7t5v0__clkbuf_8
XFILLER_152_527 VDD VSS VDD VSS gf180mcu_fd_sc_mcu7t5v0__fillcap_8
XFILLER_164_387 VDD VSS VDD VSS gf180mcu_fd_sc_mcu7t5v0__fillcap_8
XFILLER_100_170 VDD VSS VDD VSS gf180mcu_fd_sc_mcu7t5v0__fillcap_4
XFILLER_101_693 VDD VSS VDD VSS gf180mcu_fd_sc_mcu7t5v0__fillcap_4
XFILLER_19_416 VDD VSS VDD VSS gf180mcu_fd_sc_mcu7t5v0__fillcap_4
XFILLER_262_667 VDD VSS VDD VSS gf180mcu_fd_sc_mcu7t5v0__fillcap_64
XFILLER_250_807 VDD VSS VDD VSS gf180mcu_fd_sc_mcu7t5v0__fillcap_64
XFILLER_203_734 VDD VSS VDD VSS gf180mcu_fd_sc_mcu7t5v0__fillcap_16
XFILLER_230_597 VDD VSS VDD VSS gf180mcu_fd_sc_mcu7t5v0__fillcap_64
XFILLER_174_107 VDD VSS VDD VSS gf180mcu_fd_sc_mcu7t5v0__fillcap_16
XFILLER_156_877 VDD VSS VDD VSS gf180mcu_fd_sc_mcu7t5v0__fillcap_8
Xclkbuf_leaf_4_clk_i _4494_/CLK VSS VDD clkload1/I VDD VSS gf180mcu_fd_sc_mcu7t5v0__clkbuf_2
XFILLER_124_752 VDD VSS VDD VSS gf180mcu_fd_sc_mcu7t5v0__fillcap_16
XFILLER_124_730 VDD VSS VDD VSS gf180mcu_fd_sc_mcu7t5v0__fillcap_4
X_2340_ VDD VSS _3036_/B _4328_/Q _2341_/A2 VDD VSS gf180mcu_fd_sc_mcu7t5v0__and2_1
X_2271_ VDD VSS _2272_/A2 _4608_/Q _4584_/D VDD VSS gf180mcu_fd_sc_mcu7t5v0__xnor2_1
XFILLER_97_669 VDD VSS VDD VSS gf180mcu_fd_sc_mcu7t5v0__fillcap_16
X_4010_ VDD _4010_/Q _4047_/CLK VSS _4010_/D VDD VSS gf180mcu_fd_sc_mcu7t5v0__dffq_1
XFILLER_226_815 VDD VSS VDD VSS gf180mcu_fd_sc_mcu7t5v0__fillcap_4
XFILLER_93_831 VDD VSS VDD VSS gf180mcu_fd_sc_mcu7t5v0__fillcap_8
XFILLER_226_848 VDD VSS VDD VSS gf180mcu_fd_sc_mcu7t5v0__fillcap_16
XFILLER_93_853 VDD VSS VDD VSS gf180mcu_fd_sc_mcu7t5v0__fillcap_32
XFILLER_206_583 VDD VSS VDD VSS gf180mcu_fd_sc_mcu7t5v0__fillcap_8
XFILLER_252_177 VDD VSS VDD VSS gf180mcu_fd_sc_mcu7t5v0__fillcap_64
XFILLER_240_317 VDD VSS VDD VSS gf180mcu_fd_sc_mcu7t5v0__fillcap_64
XFILLER_61_772 VDD VSS VDD VSS gf180mcu_fd_sc_mcu7t5v0__fillcap_64
XFILLER_178_479 VDD VSS VDD VSS gf180mcu_fd_sc_mcu7t5v0__fillcap_8
X_1986_ VDD VSS _4506_/Q _2230_/A2 VDD VSS gf180mcu_fd_sc_mcu7t5v0__clkinv_1
X_3725_ _3728_/S VDD VSS _3902_/D _3902_/Q wire174/Z VDD VSS gf180mcu_fd_sc_mcu7t5v0__mux2_2
XFILLER_158_192 VDD VSS VDD VSS gf180mcu_fd_sc_mcu7t5v0__fillcap_32
XFILLER_193_438 VDD VSS VDD VSS gf180mcu_fd_sc_mcu7t5v0__fillcap_4
XFILLER_146_387 VDD VSS VDD VSS gf180mcu_fd_sc_mcu7t5v0__fillcap_64
XFILLER_106_218 VDD VSS VDD VSS gf180mcu_fd_sc_mcu7t5v0__fillcap_4
X_3656_ _3682_/B1 _4182_/Q VDD VSS _3657_/I _4488_/Q _3682_/A2 VDD VSS gf180mcu_fd_sc_mcu7t5v0__aoi22_1
X_2607_ _2620_/B _4208_/Q VDD VSS _2608_/B _2637_/A2 _2608_/A3 VDD VSS gf180mcu_fd_sc_mcu7t5v0__oai211_1
X_3587_ VDD VSS _3589_/A2 wire75/Z _4080_/Q VDD VSS gf180mcu_fd_sc_mcu7t5v0__nand2_1
X_2538_ VDD VSS _3616_/A2 _3637_/A1 _3637_/A3 VDD VSS gf180mcu_fd_sc_mcu7t5v0__nor2_1
XFILLER_114_262 VDD VSS VDD VSS gf180mcu_fd_sc_mcu7t5v0__fillcap_4
XFILLER_115_763 VDD VSS VDD VSS gf180mcu_fd_sc_mcu7t5v0__fillcap_4
XFILLER_130_700 VDD VSS VDD VSS gf180mcu_fd_sc_mcu7t5v0__fillcap_8
X_4208_ _4208_/D _4208_/Q _4212_/RN VSS _4514_/CLK VDD VDD VSS gf180mcu_fd_sc_mcu7t5v0__dffrnq_1
XFILLER_102_457 VDD VSS VDD VSS gf180mcu_fd_sc_mcu7t5v0__fillcap_32
X_2469_ _2472_/S VDD VSS _4094_/D wire157/Z _4094_/Q VDD VSS gf180mcu_fd_sc_mcu7t5v0__mux2_2
X_4139_ _4139_/D _4139_/Q _4527_/RN VSS _4536_/CLK VDD VDD VSS gf180mcu_fd_sc_mcu7t5v0__dffrnq_1
XFILLER_244_667 VDD VSS VDD VSS gf180mcu_fd_sc_mcu7t5v0__fillcap_64
XFILLER_83_352 VDD VSS VDD VSS gf180mcu_fd_sc_mcu7t5v0__fillcap_64
Xwire72 VSS wire72/Z wire72/I VDD VDD VSS gf180mcu_fd_sc_mcu7t5v0__buf_2
Xwire94 wire94/Z VSS VDD wire96/Z VDD VSS gf180mcu_fd_sc_mcu7t5v0__clkbuf_3
Xwire83 VSS wire83/Z wire83/I VDD VDD VSS gf180mcu_fd_sc_mcu7t5v0__buf_2
XFILLER_51_282 VDD VSS VDD VSS gf180mcu_fd_sc_mcu7t5v0__fillcap_64
XFILLER_200_737 VDD VSS VDD VSS gf180mcu_fd_sc_mcu7t5v0__fillcap_8
XFILLER_138_800 VDD VSS VDD VSS gf180mcu_fd_sc_mcu7t5v0__fillcap_4
XFILLER_156_107 VDD VSS VDD VSS gf180mcu_fd_sc_mcu7t5v0__fillcap_32
XFILLER_138_877 VDD VSS VDD VSS gf180mcu_fd_sc_mcu7t5v0__fillcap_8
XFILLER_153_836 VDD VSS VDD VSS gf180mcu_fd_sc_mcu7t5v0__fillcap_4
XFILLER_118_2 VDD VSS VDD VSS gf180mcu_fd_sc_mcu7t5v0__fillcap_16
XFILLER_180_699 VDD VSS VDD VSS gf180mcu_fd_sc_mcu7t5v0__fillcap_16
XFILLER_120_221 VDD VSS VDD VSS gf180mcu_fd_sc_mcu7t5v0__fillcap_16
XFILLER_266_247 VDD VSS VDD VSS gf180mcu_fd_sc_mcu7t5v0__fillcap_64
XFILLER_207_314 VDD VSS VDD VSS gf180mcu_fd_sc_mcu7t5v0__fillcap_8
XFILLER_75_842 VDD VSS VDD VSS gf180mcu_fd_sc_mcu7t5v0__fillcap_32
XFILLER_47_72 VDD VSS VDD VSS gf180mcu_fd_sc_mcu7t5v0__fillcap_64
XFILLER_234_177 VDD VSS VDD VSS gf180mcu_fd_sc_mcu7t5v0__fillcap_64
XFILLER_222_317 VDD VSS VDD VSS gf180mcu_fd_sc_mcu7t5v0__fillcap_64
XFILLER_170_95 VDD VSS VDD VSS gf180mcu_fd_sc_mcu7t5v0__fillcap_4
XFILLER_43_772 VDD VSS VDD VSS gf180mcu_fd_sc_mcu7t5v0__fillcap_64
XFILLER_187_243 VDD VSS VDD VSS gf180mcu_fd_sc_mcu7t5v0__fillcap_32
XFILLER_70_591 VDD VSS VDD VSS gf180mcu_fd_sc_mcu7t5v0__fillcap_4
X_3510_ _3510_/A3 VDD VSS _3518_/A2 wire78/Z _3510_/A2 VDD VSS gf180mcu_fd_sc_mcu7t5v0__nand3_1
XFILLER_144_836 VDD VSS VDD VSS gf180mcu_fd_sc_mcu7t5v0__fillcap_32
XFILLER_128_387 VDD VSS VDD VSS gf180mcu_fd_sc_mcu7t5v0__fillcap_16
X_4490_ _4490_/D _4490_/Q _4498_/RN VSS _4494_/CLK VDD VDD VSS gf180mcu_fd_sc_mcu7t5v0__dffrnq_1
Xmax_length191 _4534_/RN wire192/Z VDD VSS VDD VSS gf180mcu_fd_sc_mcu7t5v0__buf_12
Xmax_length180 VSS _3841_/I0 _4289_/Q VDD VDD VSS gf180mcu_fd_sc_mcu7t5v0__buf_2
XFILLER_155_184 VDD VSS VDD VSS gf180mcu_fd_sc_mcu7t5v0__fillcap_16
X_3441_ _3441_/A3 _3447_/A1 VDD VSS wire42/I _4431_/Q wire76/Z VDD VSS gf180mcu_fd_sc_mcu7t5v0__nor4_1
X_3372_ wire20/Z VDD VSS _4419_/D _4411_/Q _4419_/Q VDD VSS gf180mcu_fd_sc_mcu7t5v0__mux2_2
XFILLER_97_422 VDD VSS VDD VSS gf180mcu_fd_sc_mcu7t5v0__fillcap_64
X_2323_ _4348_/Q _2799_/A3 VDD VSS _2858_/B _3043_/A1 _4329_/Q VDD VSS gf180mcu_fd_sc_mcu7t5v0__nand4_1
XFILLER_33_2 VDD VSS VDD VSS gf180mcu_fd_sc_mcu7t5v0__fillcap_64
XFILLER_258_737 VDD VSS VDD VSS gf180mcu_fd_sc_mcu7t5v0__fillcap_64
XFILLER_214_22 VDD VSS VDD VSS gf180mcu_fd_sc_mcu7t5v0__fillcap_8
X_2254_ VDD VSS _2254_/Z _4571_/Q _4542_/D VDD VSS gf180mcu_fd_sc_mcu7t5v0__xor2_1
X_2185_ _2699_/A1 VDD VSS _2691_/A1 _4241_/Q _4243_/Q VDD VSS gf180mcu_fd_sc_mcu7t5v0__nand3_1
XFILLER_226_667 VDD VSS VDD VSS gf180mcu_fd_sc_mcu7t5v0__fillcap_4
XFILLER_214_807 VDD VSS VDD VSS gf180mcu_fd_sc_mcu7t5v0__fillcap_64
XFILLER_65_352 VDD VSS VDD VSS gf180mcu_fd_sc_mcu7t5v0__fillcap_64
XFILLER_241_626 VDD VSS VDD VSS gf180mcu_fd_sc_mcu7t5v0__fillcap_4
XFILLER_253_486 VDD VSS VDD VSS gf180mcu_fd_sc_mcu7t5v0__fillcap_4
XFILLER_198_519 VDD VSS VDD VSS gf180mcu_fd_sc_mcu7t5v0__fillcap_4
XFILLER_80_311 VDD VSS VDD VSS gf180mcu_fd_sc_mcu7t5v0__fillcap_4
XFILLER_92_171 VDD VSS VDD VSS gf180mcu_fd_sc_mcu7t5v0__fillcap_4
XFILLER_21_422 VDD VSS VDD VSS gf180mcu_fd_sc_mcu7t5v0__fillcap_64
XFILLER_138_107 VDD VSS VDD VSS gf180mcu_fd_sc_mcu7t5v0__fillcap_64
XFILLER_166_416 VDD VSS VDD VSS gf180mcu_fd_sc_mcu7t5v0__fillcap_16
XFILLER_33_282 VDD VSS VDD VSS gf180mcu_fd_sc_mcu7t5v0__fillcap_64
X_1969_ VDD VSS _4196_/Q _2934_/A2 VDD VSS gf180mcu_fd_sc_mcu7t5v0__clkinv_1
X_3708_ _3831_/A1 VDD VSS _3718_/S _4540_/Q _4541_/Q VDD VSS gf180mcu_fd_sc_mcu7t5v0__and3_1
XFILLER_147_696 VDD VSS VDD VSS gf180mcu_fd_sc_mcu7t5v0__fillcap_4
X_3639_ VDD VSS _3639_/I _4481_/D VDD VSS gf180mcu_fd_sc_mcu7t5v0__clkinv_1
XFILLER_134_379 VDD VSS VDD VSS gf180mcu_fd_sc_mcu7t5v0__fillcap_4
XFILLER_162_699 VDD VSS VDD VSS gf180mcu_fd_sc_mcu7t5v0__fillcap_8
XFILLER_161_165 VDD VSS VDD VSS gf180mcu_fd_sc_mcu7t5v0__fillcap_16
XFILLER_115_593 VDD VSS VDD VSS gf180mcu_fd_sc_mcu7t5v0__fillcap_16
XFILLER_103_722 VDD VSS VDD VSS gf180mcu_fd_sc_mcu7t5v0__fillcap_32
XFILLER_248_247 VDD VSS VDD VSS gf180mcu_fd_sc_mcu7t5v0__fillcap_64
XFILLER_103_788 VDD VSS VDD VSS gf180mcu_fd_sc_mcu7t5v0__fillcap_8
XFILLER_263_206 VDD VSS VDD VSS gf180mcu_fd_sc_mcu7t5v0__fillcap_4
XFILLER_124_77 VDD VSS VDD VSS gf180mcu_fd_sc_mcu7t5v0__fillcap_4
XFILLER_124_88 VDD VSS VDD VSS gf180mcu_fd_sc_mcu7t5v0__fillcap_16
XFILLER_57_842 VDD VSS VDD VSS gf180mcu_fd_sc_mcu7t5v0__fillcap_32
XFILLER_84_37 VDD VSS VDD VSS gf180mcu_fd_sc_mcu7t5v0__fillcap_64
XFILLER_72_801 VDD VSS VDD VSS gf180mcu_fd_sc_mcu7t5v0__fillcap_4
XFILLER_216_177 VDD VSS VDD VSS gf180mcu_fd_sc_mcu7t5v0__fillcap_16
XFILLER_231_136 VDD VSS VDD VSS gf180mcu_fd_sc_mcu7t5v0__fillcap_4
XFILLER_169_232 VDD VSS VDD VSS gf180mcu_fd_sc_mcu7t5v0__fillcap_32
XFILLER_25_772 VDD VSS VDD VSS gf180mcu_fd_sc_mcu7t5v0__fillcap_64
XFILLER_235_2 VDD VSS VDD VSS gf180mcu_fd_sc_mcu7t5v0__fillcap_64
XFILLER_52_591 VDD VSS VDD VSS gf180mcu_fd_sc_mcu7t5v0__fillcap_4
XFILLER_40_731 VDD VSS VDD VSS gf180mcu_fd_sc_mcu7t5v0__fillcap_4
XFILLER_169_298 VDD VSS VDD VSS gf180mcu_fd_sc_mcu7t5v0__fillcap_4
XFILLER_200_578 VDD VSS VDD VSS gf180mcu_fd_sc_mcu7t5v0__fillcap_16
XFILLER_149_63 VDD VSS VDD VSS gf180mcu_fd_sc_mcu7t5v0__fillcap_4
XFILLER_192_290 VDD VSS VDD VSS gf180mcu_fd_sc_mcu7t5v0__fillcap_8
XFILLER_125_346 VDD VSS VDD VSS gf180mcu_fd_sc_mcu7t5v0__fillcap_4
Xclkbuf_leaf_84_clk_i _4096_/CLK VSS VDD clkload2/I VDD VSS gf180mcu_fd_sc_mcu7t5v0__clkbuf_2
XFILLER_153_688 VDD VSS VDD VSS gf180mcu_fd_sc_mcu7t5v0__fillcap_4
XFILLER_3_142 VDD VSS VDD VSS gf180mcu_fd_sc_mcu7t5v0__fillcap_64
XFILLER_79_422 VDD VSS VDD VSS gf180mcu_fd_sc_mcu7t5v0__fillcap_64
XFILLER_267_556 VDD VSS VDD VSS gf180mcu_fd_sc_mcu7t5v0__fillcap_4
XFILLER_181_72 VDD VSS VDD VSS gf180mcu_fd_sc_mcu7t5v0__fillcap_16
XFILLER_47_352 VDD VSS VDD VSS gf180mcu_fd_sc_mcu7t5v0__fillcap_64
XFILLER_208_667 VDD VSS VDD VSS gf180mcu_fd_sc_mcu7t5v0__fillcap_16
Xclkbuf_leaf_22_clk_i _4508_/CLK VSS VDD clkload3/I VDD VSS gf180mcu_fd_sc_mcu7t5v0__clkbuf_2
XFILLER_62_311 VDD VSS VDD VSS gf180mcu_fd_sc_mcu7t5v0__fillcap_4
XFILLER_74_171 VDD VSS VDD VSS gf180mcu_fd_sc_mcu7t5v0__fillcap_4
X_3990_ VDD _3990_/Q _3998_/CLK VSS _3990_/D VDD VSS gf180mcu_fd_sc_mcu7t5v0__dffq_1
X_2941_ VDD VSS _2942_/C wire143/Z _4367_/Q VDD VSS gf180mcu_fd_sc_mcu7t5v0__xnor2_1
Xclkbuf_leaf_37_clk_i _4521_/CLK VSS VDD clkload4/I VDD VSS gf180mcu_fd_sc_mcu7t5v0__clkbuf_2
XFILLER_15_282 VDD VSS VDD VSS gf180mcu_fd_sc_mcu7t5v0__fillcap_64
X_4611_ _4611_/D _4611_/Q _4616_/RN VSS _4616_/CLK VDD VDD VSS gf180mcu_fd_sc_mcu7t5v0__dffrnq_1
X_2872_ VDD VSS _2883_/A1 _3270_/A1 _4200_/Q VDD VSS gf180mcu_fd_sc_mcu7t5v0__nand2_1
XFILLER_30_241 VDD VSS VDD VSS gf180mcu_fd_sc_mcu7t5v0__fillcap_4
X_4542_ _4542_/D _4565_/D wire187/Z VSS _4595_/CLK VDD VDD VSS gf180mcu_fd_sc_mcu7t5v0__dffrnq_1
XFILLER_190_227 VDD VSS VDD VSS gf180mcu_fd_sc_mcu7t5v0__fillcap_8
XFILLER_209_66 VDD VSS VDD VSS gf180mcu_fd_sc_mcu7t5v0__fillcap_4
XFILLER_183_290 VDD VSS VDD VSS gf180mcu_fd_sc_mcu7t5v0__fillcap_4
XFILLER_7_492 VDD VSS VDD VSS gf180mcu_fd_sc_mcu7t5v0__fillcap_64
X_4473_ _4473_/D _4473_/Q _4473_/RN VSS _4473_/CLK VDD VDD VSS gf180mcu_fd_sc_mcu7t5v0__dffrnq_1
X_3424_ _3424_/S VDD VSS _4467_/D _4425_/Q _4467_/Q VDD VSS gf180mcu_fd_sc_mcu7t5v0__mux2_2
XFILLER_98_720 VDD VSS VDD VSS gf180mcu_fd_sc_mcu7t5v0__fillcap_8
X_3355_ wire20/I VDD VSS _4402_/D _4379_/Q _4402_/Q VDD VSS gf180mcu_fd_sc_mcu7t5v0__mux2_2
X_2306_ VDD VSS _2898_/A2 _4529_/D _2796_/A2 VDD VSS gf180mcu_fd_sc_mcu7t5v0__nor2_1
X_3286_ VDD VSS _3290_/A2 _4487_/Q _3334_/A2 VDD VSS gf180mcu_fd_sc_mcu7t5v0__nand2_1
XFILLER_98_797 VDD VSS VDD VSS gf180mcu_fd_sc_mcu7t5v0__fillcap_8
XFILLER_245_206 VDD VSS VDD VSS gf180mcu_fd_sc_mcu7t5v0__fillcap_4
X_2237_ VSS VDD _4141_/Q _4162_/Q _4139_/Q _4160_/Q _4154_/Q _4133_/Q _2243_/A1 VDD
+ VSS gf180mcu_fd_sc_mcu7t5v0__aoi222_1
XFILLER_39_842 VDD VSS VDD VSS gf180mcu_fd_sc_mcu7t5v0__fillcap_32
XFILLER_241_42 VDD VSS VDD VSS gf180mcu_fd_sc_mcu7t5v0__fillcap_16
XFILLER_66_661 VDD VSS VDD VSS gf180mcu_fd_sc_mcu7t5v0__fillcap_4
XFILLER_54_801 VDD VSS VDD VSS gf180mcu_fd_sc_mcu7t5v0__fillcap_4
X_2168_ _2171_/A3 _2201_/A1 VDD VSS _2168_/Z _4237_/Q _4240_/Q VDD VSS gf180mcu_fd_sc_mcu7t5v0__and4_1
X_2099_ VDD VSS _4589_/D wire72/I _2099_/A2 VDD VSS gf180mcu_fd_sc_mcu7t5v0__xor2_1
XFILLER_34_591 VDD VSS VDD VSS gf180mcu_fd_sc_mcu7t5v0__fillcap_4
XFILLER_22_731 VDD VSS VDD VSS gf180mcu_fd_sc_mcu7t5v0__fillcap_4
XFILLER_179_585 VDD VSS VDD VSS gf180mcu_fd_sc_mcu7t5v0__fillcap_4
XFILLER_166_279 VDD VSS VDD VSS gf180mcu_fd_sc_mcu7t5v0__fillcap_8
XFILLER_108_858 VDD VSS VDD VSS gf180mcu_fd_sc_mcu7t5v0__fillcap_16
XFILLER_88_241 VDD VSS VDD VSS gf180mcu_fd_sc_mcu7t5v0__fillcap_4
XFILLER_237_718 VDD VSS VDD VSS gf180mcu_fd_sc_mcu7t5v0__fillcap_4
XFILLER_249_556 VDD VSS VDD VSS gf180mcu_fd_sc_mcu7t5v0__fillcap_4
XFILLER_103_585 VDD VSS VDD VSS gf180mcu_fd_sc_mcu7t5v0__fillcap_4
XFILLER_185_2 VDD VSS VDD VSS gf180mcu_fd_sc_mcu7t5v0__fillcap_64
XFILLER_29_352 VDD VSS VDD VSS gf180mcu_fd_sc_mcu7t5v0__fillcap_64
XFILLER_44_311 VDD VSS VDD VSS gf180mcu_fd_sc_mcu7t5v0__fillcap_4
XFILLER_56_171 VDD VSS VDD VSS gf180mcu_fd_sc_mcu7t5v0__fillcap_4
XFILLER_217_486 VDD VSS VDD VSS gf180mcu_fd_sc_mcu7t5v0__fillcap_4
XFILLER_197_360 VDD VSS VDD VSS gf180mcu_fd_sc_mcu7t5v0__fillcap_4
XFILLER_9_702 VDD VSS VDD VSS gf180mcu_fd_sc_mcu7t5v0__fillcap_64
XFILLER_12_241 VDD VSS VDD VSS gf180mcu_fd_sc_mcu7t5v0__fillcap_4
XFILLER_185_555 VDD VSS VDD VSS gf180mcu_fd_sc_mcu7t5v0__fillcap_4
XFILLER_4_451 VDD VSS VDD VSS gf180mcu_fd_sc_mcu7t5v0__fillcap_4
XFILLER_141_625 VDD VSS VDD VSS gf180mcu_fd_sc_mcu7t5v0__fillcap_4
XFILLER_114_839 VDD VSS VDD VSS gf180mcu_fd_sc_mcu7t5v0__fillcap_16
X_3140_ _3998_/Q VSS VDD _3982_/Q _3990_/Q _3113_/S _3974_/Q _3117_/B _3140_/Z VDD
+ VSS gf180mcu_fd_sc_mcu7t5v0__mux4_1
XFILLER_227_206 VDD VSS VDD VSS gf180mcu_fd_sc_mcu7t5v0__fillcap_4
XFILLER_121_382 VDD VSS VDD VSS gf180mcu_fd_sc_mcu7t5v0__fillcap_16
X_3071_ _3931_/Q VSS VDD _3915_/Q _3923_/Q _3176_/S _3907_/Q _3180_/B _3071_/Z VDD
+ VSS gf180mcu_fd_sc_mcu7t5v0__mux4_1
XFILLER_48_661 VDD VSS VDD VSS gf180mcu_fd_sc_mcu7t5v0__fillcap_4
XFILLER_36_801 VDD VSS VDD VSS gf180mcu_fd_sc_mcu7t5v0__fillcap_4
X_2022_ VDD VSS _3959_/Q _3799_/A1 VDD VSS gf180mcu_fd_sc_mcu7t5v0__clkinv_1
X_3973_ VDD _3973_/Q _3989_/CLK VSS _3973_/D VDD VSS gf180mcu_fd_sc_mcu7t5v0__dffq_1
XFILLER_16_591 VDD VSS VDD VSS gf180mcu_fd_sc_mcu7t5v0__fillcap_4
X_2924_ VDD VSS _2925_/B _3214_/A1 _2960_/B1 VDD VSS gf180mcu_fd_sc_mcu7t5v0__nand2_1
X_2855_ VDD VSS _3169_/B _2983_/A1 wire141/Z VDD VSS gf180mcu_fd_sc_mcu7t5v0__nor2_1
XFILLER_136_419 VDD VSS VDD VSS gf180mcu_fd_sc_mcu7t5v0__fillcap_8
X_4525_ _4525_/D _4525_/Q _4525_/RN VSS _4525_/CLK VDD VDD VSS gf180mcu_fd_sc_mcu7t5v0__dffrnq_1
X_2786_ _4330_/Q _3039_/A1 VDD VSS _2789_/A2 _4328_/Q _2991_/C VDD VSS gf180mcu_fd_sc_mcu7t5v0__nand4_1
Xclkbuf_3_1__f_clk_i VDD VSS clkload1/I clkbuf_0_clk_i/Z VDD VSS gf180mcu_fd_sc_mcu7t5v0__clkbuf_16
XFILLER_117_688 VDD VSS VDD VSS gf180mcu_fd_sc_mcu7t5v0__fillcap_8
Xhold267 _4608_/D VSS _4613_/Q VDD VDD VSS gf180mcu_fd_sc_mcu7t5v0__dlyc_1
XFILLER_171_282 VDD VSS VDD VSS gf180mcu_fd_sc_mcu7t5v0__fillcap_16
X_4456_ _4456_/D _4456_/Q wire210/Z VSS _4499_/CLK VDD VDD VSS gf180mcu_fd_sc_mcu7t5v0__dffrnq_1
Xhold256 _4607_/D VSS _4612_/Q VDD VDD VSS gf180mcu_fd_sc_mcu7t5v0__dlyc_1
X_3407_ _3425_/S VDD VSS _4450_/D _4408_/Q _4450_/Q VDD VSS gf180mcu_fd_sc_mcu7t5v0__mux2_2
X_4387_ _4387_/D _4387_/Q wire186/Z VSS _4427_/CLK VDD VDD VSS gf180mcu_fd_sc_mcu7t5v0__dffrnq_1
X_3338_ _3347_/B VDD VSS _3346_/S _4383_/Q _3338_/A2 VDD VSS gf180mcu_fd_sc_mcu7t5v0__nand3_1
X_3269_ VDD VSS _3269_/I _4369_/D VDD VSS gf180mcu_fd_sc_mcu7t5v0__clkinv_1
XFILLER_218_228 VDD VSS VDD VSS gf180mcu_fd_sc_mcu7t5v0__fillcap_16
XFILLER_26_311 VDD VSS VDD VSS gf180mcu_fd_sc_mcu7t5v0__fillcap_4
XFILLER_38_171 VDD VSS VDD VSS gf180mcu_fd_sc_mcu7t5v0__fillcap_4
XFILLER_195_842 VDD VSS VDD VSS gf180mcu_fd_sc_mcu7t5v0__fillcap_32
XFILLER_154_238 VDD VSS VDD VSS gf180mcu_fd_sc_mcu7t5v0__fillcap_4
XFILLER_163_772 VDD VSS VDD VSS gf180mcu_fd_sc_mcu7t5v0__fillcap_8
XFILLER_135_441 VDD VSS VDD VSS gf180mcu_fd_sc_mcu7t5v0__fillcap_4
XFILLER_107_132 VDD VSS VDD VSS gf180mcu_fd_sc_mcu7t5v0__fillcap_8
XFILLER_100_2 VDD VSS VDD VSS gf180mcu_fd_sc_mcu7t5v0__fillcap_32
XFILLER_123_647 VDD VSS VDD VSS gf180mcu_fd_sc_mcu7t5v0__fillcap_16
XFILLER_108_699 VDD VSS VDD VSS gf180mcu_fd_sc_mcu7t5v0__fillcap_8
XFILLER_122_157 VDD VSS VDD VSS gf180mcu_fd_sc_mcu7t5v0__fillcap_8
XFILLER_107_198 VDD VSS VDD VSS gf180mcu_fd_sc_mcu7t5v0__fillcap_8
XFILLER_103_360 VDD VSS VDD VSS gf180mcu_fd_sc_mcu7t5v0__fillcap_16
XFILLER_18_801 VDD VSS VDD VSS gf180mcu_fd_sc_mcu7t5v0__fillcap_4
XFILLER_55_72 VDD VSS VDD VSS gf180mcu_fd_sc_mcu7t5v0__fillcap_64
XFILLER_186_831 VDD VSS VDD VSS gf180mcu_fd_sc_mcu7t5v0__fillcap_4
XFILLER_60_667 VDD VSS VDD VSS gf180mcu_fd_sc_mcu7t5v0__fillcap_64
XFILLER_201_695 VDD VSS VDD VSS gf180mcu_fd_sc_mcu7t5v0__fillcap_4
X_2640_ _4534_/D VDD VSS _4221_/D _4221_/Q _4309_/Q VDD VSS gf180mcu_fd_sc_mcu7t5v0__mux2_2
X_2571_ wire29/I VDD VSS _4194_/D _4468_/Q _4194_/Q VDD VSS gf180mcu_fd_sc_mcu7t5v0__mux2_2
XFILLER_141_422 VDD VSS VDD VSS gf180mcu_fd_sc_mcu7t5v0__fillcap_32
X_4310_ VDD _4310_/Q _4366_/CLK VSS _4310_/D VDD VSS gf180mcu_fd_sc_mcu7t5v0__dffq_1
XFILLER_153_282 VDD VSS VDD VSS gf180mcu_fd_sc_mcu7t5v0__fillcap_32
X_4241_ _4241_/D _4241_/Q wire187/Z VSS _4553_/CLK VDD VDD VSS gf180mcu_fd_sc_mcu7t5v0__dffrnq_1
X_4172_ _4172_/D _4172_/Q _4527_/RN VSS _4536_/CLK VDD VDD VSS gf180mcu_fd_sc_mcu7t5v0__dffrnq_1
XFILLER_110_853 VDD VSS VDD VSS gf180mcu_fd_sc_mcu7t5v0__fillcap_4
XFILLER_110_831 VDD VSS VDD VSS gf180mcu_fd_sc_mcu7t5v0__fillcap_4
X_3123_ VDD VSS _3124_/B _3124_/A1 _3965_/Q VDD VSS gf180mcu_fd_sc_mcu7t5v0__nor2_1
XFILLER_209_751 VDD VSS VDD VSS gf180mcu_fd_sc_mcu7t5v0__fillcap_16
X_3054_ VDD _3158_/B _3898_/Q _3055_/B2 _3122_/S VSS VDD VSS gf180mcu_fd_sc_mcu7t5v0__oai21_1
XFILLER_208_283 VDD VSS VDD VSS gf180mcu_fd_sc_mcu7t5v0__fillcap_32
XFILLER_82_247 VDD VSS VDD VSS gf180mcu_fd_sc_mcu7t5v0__fillcap_64
X_2005_ VDD VSS _4470_/Q _3480_/A1 VDD VSS gf180mcu_fd_sc_mcu7t5v0__clkinv_1
XFILLER_251_562 VDD VSS VDD VSS gf180mcu_fd_sc_mcu7t5v0__fillcap_64
X_3956_ VDD _3956_/Q _3965_/CLK VSS _3956_/D VDD VSS gf180mcu_fd_sc_mcu7t5v0__dffq_1
XFILLER_177_842 VDD VSS VDD VSS gf180mcu_fd_sc_mcu7t5v0__fillcap_16
X_2907_ _2957_/A2 VDD VSS _2960_/B1 _2829_/C _3037_/A2 VDD VSS gf180mcu_fd_sc_mcu7t5v0__nor3_1
XFILLER_50_177 VDD VSS VDD VSS gf180mcu_fd_sc_mcu7t5v0__fillcap_64
X_3887_ VDD _3887_/Q _3937_/CLK VSS _3887_/D VDD VSS gf180mcu_fd_sc_mcu7t5v0__dffq_1
XFILLER_192_801 VDD VSS VDD VSS gf180mcu_fd_sc_mcu7t5v0__fillcap_4
X_2838_ _3122_/S VDD VSS _2838_/Z _3953_/Q _3945_/Q VDD VSS gf180mcu_fd_sc_mcu7t5v0__mux2_2
XFILLER_145_772 VDD VSS VDD VSS gf180mcu_fd_sc_mcu7t5v0__fillcap_16
X_2769_ _4518_/Q VDD VSS _2771_/A2 _4518_/D _4517_/D VDD VSS gf180mcu_fd_sc_mcu7t5v0__nand3_1
XFILLER_191_366 VDD VSS VDD VSS gf180mcu_fd_sc_mcu7t5v0__fillcap_4
X_4508_ _4508_/D _4508_/Q wire206/Z VSS _4508_/CLK VDD VDD VSS gf180mcu_fd_sc_mcu7t5v0__dffrnq_1
XFILLER_104_113 VDD VSS VDD VSS gf180mcu_fd_sc_mcu7t5v0__fillcap_16
XFILLER_132_433 VDD VSS VDD VSS gf180mcu_fd_sc_mcu7t5v0__fillcap_16
X_4439_ _4439_/D _4439_/Q wire186/Z VSS _4478_/CLK VDD VDD VSS gf180mcu_fd_sc_mcu7t5v0__dffrnq_1
XFILLER_101_842 VDD VSS VDD VSS gf180mcu_fd_sc_mcu7t5v0__fillcap_32
XFILLER_86_597 VDD VSS VDD VSS gf180mcu_fd_sc_mcu7t5v0__fillcap_8
XFILLER_74_737 VDD VSS VDD VSS gf180mcu_fd_sc_mcu7t5v0__fillcap_64
XFILLER_199_411 VDD VSS VDD VSS gf180mcu_fd_sc_mcu7t5v0__fillcap_8
XFILLER_92_37 VDD VSS VDD VSS gf180mcu_fd_sc_mcu7t5v0__fillcap_8
XFILLER_30_807 VDD VSS VDD VSS gf180mcu_fd_sc_mcu7t5v0__fillcap_64
XFILLER_42_667 VDD VSS VDD VSS gf180mcu_fd_sc_mcu7t5v0__fillcap_64
XFILLER_183_834 VDD VSS VDD VSS gf180mcu_fd_sc_mcu7t5v0__fillcap_4
XFILLER_183_878 VDD VSS VDD VSS gf180mcu_fd_sc_mcu7t5v0__fillcap_8
XFILLER_182_344 VDD VSS VDD VSS gf180mcu_fd_sc_mcu7t5v0__fillcap_32
XFILLER_10_597 VDD VSS VDD VSS gf180mcu_fd_sc_mcu7t5v0__fillcap_64
XFILLER_135_260 VDD VSS VDD VSS gf180mcu_fd_sc_mcu7t5v0__fillcap_8
XFILLER_108_463 VDD VSS VDD VSS gf180mcu_fd_sc_mcu7t5v0__fillcap_32
XFILLER_123_422 VDD VSS VDD VSS gf180mcu_fd_sc_mcu7t5v0__fillcap_64
XFILLER_151_764 VDD VSS VDD VSS gf180mcu_fd_sc_mcu7t5v0__fillcap_4
XFILLER_96_317 VDD VSS VDD VSS gf180mcu_fd_sc_mcu7t5v0__fillcap_16
XFILLER_173_95 VDD VSS VDD VSS gf180mcu_fd_sc_mcu7t5v0__fillcap_4
XFILLER_104_680 VDD VSS VDD VSS gf180mcu_fd_sc_mcu7t5v0__fillcap_8
XFILLER_265_632 VDD VSS VDD VSS gf180mcu_fd_sc_mcu7t5v0__fillcap_64
XFILLER_206_710 VDD VSS VDD VSS gf180mcu_fd_sc_mcu7t5v0__fillcap_16
XFILLER_92_556 VDD VSS VDD VSS gf180mcu_fd_sc_mcu7t5v0__fillcap_4
XFILLER_64_247 VDD VSS VDD VSS gf180mcu_fd_sc_mcu7t5v0__fillcap_64
XFILLER_221_702 VDD VSS VDD VSS gf180mcu_fd_sc_mcu7t5v0__fillcap_64
XFILLER_206_798 VDD VSS VDD VSS gf180mcu_fd_sc_mcu7t5v0__fillcap_4
XFILLER_233_562 VDD VSS VDD VSS gf180mcu_fd_sc_mcu7t5v0__fillcap_8
X_3810_ wire15/Z VDD VSS _3968_/D wire172/Z _3968_/Q VDD VSS gf180mcu_fd_sc_mcu7t5v0__mux2_2
XFILLER_260_381 VDD VSS VDD VSS gf180mcu_fd_sc_mcu7t5v0__fillcap_4
X_3741_ _3747_/S VDD VSS _3915_/D wire178/Z _3915_/Q VDD VSS gf180mcu_fd_sc_mcu7t5v0__mux2_2
XFILLER_159_842 VDD VSS VDD VSS gf180mcu_fd_sc_mcu7t5v0__fillcap_8
XFILLER_158_330 VDD VSS VDD VSS gf180mcu_fd_sc_mcu7t5v0__fillcap_8
XFILLER_32_177 VDD VSS VDD VSS gf180mcu_fd_sc_mcu7t5v0__fillcap_64
XFILLER_20_317 VDD VSS VDD VSS gf180mcu_fd_sc_mcu7t5v0__fillcap_64
XFILLER_201_470 VDD VSS VDD VSS gf180mcu_fd_sc_mcu7t5v0__fillcap_4
XFILLER_201_492 VDD VSS VDD VSS gf180mcu_fd_sc_mcu7t5v0__fillcap_16
X_3672_ _3672_/A3 VDD VSS _4494_/D _3681_/A1 _3672_/A2 VDD VSS gf180mcu_fd_sc_mcu7t5v0__nand3_1
X_2623_ _2623_/A3 VDD VSS _2629_/A2 _2623_/A1 _2623_/A2 VDD VSS gf180mcu_fd_sc_mcu7t5v0__nor3_1
XFILLER_127_750 VDD VSS VDD VSS gf180mcu_fd_sc_mcu7t5v0__fillcap_4
X_2554_ wire29/Z VDD VSS _4177_/D _4451_/Q _4177_/Q VDD VSS gf180mcu_fd_sc_mcu7t5v0__mux2_2
XFILLER_127_772 VDD VSS VDD VSS gf180mcu_fd_sc_mcu7t5v0__fillcap_4
XFILLER_88_807 VDD VSS VDD VSS gf180mcu_fd_sc_mcu7t5v0__fillcap_8
X_2485_ _2491_/S VDD VSS _4107_/D wire164/Z _4107_/Q VDD VSS gf180mcu_fd_sc_mcu7t5v0__mux2_2
X_4224_ _4224_/D _4224_/Q _4530_/RN VSS _4337_/CLK VDD VDD VSS gf180mcu_fd_sc_mcu7t5v0__dffrnq_1
X_4155_ _4155_/D _4155_/Q wire192/Z VSS _4265_/CLK VDD VDD VSS gf180mcu_fd_sc_mcu7t5v0__dffrnq_1
XFILLER_110_661 VDD VSS VDD VSS gf180mcu_fd_sc_mcu7t5v0__fillcap_4
X_3106_ VDD _3170_/B _3106_/A2 _3107_/C _3214_/A1 VSS VDD VSS gf180mcu_fd_sc_mcu7t5v0__oai21_1
XFILLER_255_142 VDD VSS VDD VSS gf180mcu_fd_sc_mcu7t5v0__fillcap_64
XFILLER_56_737 VDD VSS VDD VSS gf180mcu_fd_sc_mcu7t5v0__fillcap_64
XFILLER_68_597 VDD VSS VDD VSS gf180mcu_fd_sc_mcu7t5v0__fillcap_64
XFILLER_110_683 VDD VSS VDD VSS gf180mcu_fd_sc_mcu7t5v0__fillcap_8
X_4086_ VDD _4086_/Q _4096_/CLK VSS _4086_/D VDD VSS gf180mcu_fd_sc_mcu7t5v0__dffq_1
XFILLER_83_556 VDD VSS VDD VSS gf180mcu_fd_sc_mcu7t5v0__fillcap_4
X_3037_ _3037_/A3 VDD VSS _3038_/A2 _3037_/A1 _3037_/A2 VDD VSS gf180mcu_fd_sc_mcu7t5v0__nand3_1
XFILLER_252_871 VDD VSS VDD VSS gf180mcu_fd_sc_mcu7t5v0__fillcap_4
XFILLER_211_212 VDD VSS VDD VSS gf180mcu_fd_sc_mcu7t5v0__fillcap_64
XFILLER_12_807 VDD VSS VDD VSS gf180mcu_fd_sc_mcu7t5v0__fillcap_64
XFILLER_24_667 VDD VSS VDD VSS gf180mcu_fd_sc_mcu7t5v0__fillcap_64
XFILLER_51_486 VDD VSS VDD VSS gf180mcu_fd_sc_mcu7t5v0__fillcap_4
X_3939_ VDD _3939_/Q _3967_/CLK VSS _3939_/D VDD VSS gf180mcu_fd_sc_mcu7t5v0__dffq_1
XFILLER_149_352 VDD VSS VDD VSS gf180mcu_fd_sc_mcu7t5v0__fillcap_16
XFILLER_176_193 VDD VSS VDD VSS gf180mcu_fd_sc_mcu7t5v0__fillcap_8
XFILLER_180_815 VDD VSS VDD VSS gf180mcu_fd_sc_mcu7t5v0__fillcap_4
XFILLER_105_422 VDD VSS VDD VSS gf180mcu_fd_sc_mcu7t5v0__fillcap_64
XFILLER_117_282 VDD VSS VDD VSS gf180mcu_fd_sc_mcu7t5v0__fillcap_32
XFILLER_127_55 VDD VSS VDD VSS gf180mcu_fd_sc_mcu7t5v0__fillcap_8
XFILLER_160_561 VDD VSS VDD VSS gf180mcu_fd_sc_mcu7t5v0__fillcap_16
XFILLER_78_317 VDD VSS VDD VSS gf180mcu_fd_sc_mcu7t5v0__fillcap_64
XFILLER_127_99 VDD VSS VDD VSS gf180mcu_fd_sc_mcu7t5v0__fillcap_8
XFILLER_133_764 VDD VSS VDD VSS gf180mcu_fd_sc_mcu7t5v0__fillcap_4
XFILLER_132_285 VDD VSS VDD VSS gf180mcu_fd_sc_mcu7t5v0__fillcap_8
XFILLER_247_632 VDD VSS VDD VSS gf180mcu_fd_sc_mcu7t5v0__fillcap_64
XFILLER_259_492 VDD VSS VDD VSS gf180mcu_fd_sc_mcu7t5v0__fillcap_64
XFILLER_100_193 VDD VSS VDD VSS gf180mcu_fd_sc_mcu7t5v0__fillcap_8
XFILLER_46_247 VDD VSS VDD VSS gf180mcu_fd_sc_mcu7t5v0__fillcap_64
XFILLER_265_2 VDD VSS VDD VSS gf180mcu_fd_sc_mcu7t5v0__fillcap_64
XFILLER_61_206 VDD VSS VDD VSS gf180mcu_fd_sc_mcu7t5v0__fillcap_4
XFILLER_203_702 VDD VSS VDD VSS gf180mcu_fd_sc_mcu7t5v0__fillcap_32
XFILLER_242_381 VDD VSS VDD VSS gf180mcu_fd_sc_mcu7t5v0__fillcap_4
XFILLER_14_177 VDD VSS VDD VSS gf180mcu_fd_sc_mcu7t5v0__fillcap_64
XFILLER_202_278 VDD VSS VDD VSS gf180mcu_fd_sc_mcu7t5v0__fillcap_32
XFILLER_156_856 VDD VSS VDD VSS gf180mcu_fd_sc_mcu7t5v0__fillcap_16
XFILLER_155_344 VDD VSS VDD VSS gf180mcu_fd_sc_mcu7t5v0__fillcap_4
XFILLER_6_387 VDD VSS VDD VSS gf180mcu_fd_sc_mcu7t5v0__fillcap_64
XFILLER_170_325 VDD VSS VDD VSS gf180mcu_fd_sc_mcu7t5v0__fillcap_4
XFILLER_155_399 VDD VSS VDD VSS gf180mcu_fd_sc_mcu7t5v0__fillcap_16
XFILLER_109_772 VDD VSS VDD VSS gf180mcu_fd_sc_mcu7t5v0__fillcap_64
XFILLER_151_594 VDD VSS VDD VSS gf180mcu_fd_sc_mcu7t5v0__fillcap_16
X_2270_ VDD VSS _2272_/A1 _4607_/Q _4583_/D VDD VSS gf180mcu_fd_sc_mcu7t5v0__xnor2_1
XFILLER_35_6 VDD VSS VDD VSS gf180mcu_fd_sc_mcu7t5v0__fillcap_64
XFILLER_237_142 VDD VSS VDD VSS gf180mcu_fd_sc_mcu7t5v0__fillcap_64
XFILLER_38_737 VDD VSS VDD VSS gf180mcu_fd_sc_mcu7t5v0__fillcap_64
XFILLER_252_101 VDD VSS VDD VSS gf180mcu_fd_sc_mcu7t5v0__fillcap_4
XFILLER_65_556 VDD VSS VDD VSS gf180mcu_fd_sc_mcu7t5v0__fillcap_4
XFILLER_234_860 VDD VSS VDD VSS gf180mcu_fd_sc_mcu7t5v0__fillcap_8
XFILLER_178_447 VDD VSS VDD VSS gf180mcu_fd_sc_mcu7t5v0__fillcap_8
XFILLER_33_486 VDD VSS VDD VSS gf180mcu_fd_sc_mcu7t5v0__fillcap_4
XFILLER_21_626 VDD VSS VDD VSS gf180mcu_fd_sc_mcu7t5v0__fillcap_4
X_1985_ VDD VSS _4322_/Q _2983_/B2 VDD VSS gf180mcu_fd_sc_mcu7t5v0__clkinv_1
X_3724_ _3728_/S VDD VSS _3901_/D _3901_/Q _3763_/I0 VDD VSS gf180mcu_fd_sc_mcu7t5v0__mux2_2
XFILLER_146_333 VDD VSS VDD VSS gf180mcu_fd_sc_mcu7t5v0__fillcap_4
X_3655_ VDD VSS _3655_/I _4487_/D VDD VSS gf180mcu_fd_sc_mcu7t5v0__clkinv_1
X_2606_ _2606_/B _2606_/C VDD VSS _4207_/D _2586_/Z _2604_/Z VDD VSS gf180mcu_fd_sc_mcu7t5v0__aoi211_1
X_3586_ _3586_/S VDD VSS _3586_/Z _4096_/Q _4088_/Q VDD VSS gf180mcu_fd_sc_mcu7t5v0__mux2_2
XFILLER_142_561 VDD VSS VDD VSS gf180mcu_fd_sc_mcu7t5v0__fillcap_16
X_2537_ VDD VSS _3637_/A3 _3386_/A1 _3453_/A2 VDD VSS gf180mcu_fd_sc_mcu7t5v0__nand2_1
XFILLER_114_230 VDD VSS VDD VSS gf180mcu_fd_sc_mcu7t5v0__fillcap_8
X_2468_ _2472_/S VDD VSS _4093_/D wire160/Z _4093_/Q VDD VSS gf180mcu_fd_sc_mcu7t5v0__mux2_2
XFILLER_87_136 VDD VSS VDD VSS gf180mcu_fd_sc_mcu7t5v0__fillcap_4
XFILLER_229_632 VDD VSS VDD VSS gf180mcu_fd_sc_mcu7t5v0__fillcap_16
X_4207_ _4207_/D _4207_/Q _4212_/RN VSS _4514_/CLK VDD VDD VSS gf180mcu_fd_sc_mcu7t5v0__dffrnq_1
XFILLER_256_451 VDD VSS VDD VSS gf180mcu_fd_sc_mcu7t5v0__fillcap_4
X_2399_ _2403_/S VDD VSS _4037_/D _4037_/Q wire158/Z VDD VSS gf180mcu_fd_sc_mcu7t5v0__mux2_2
X_4138_ _4138_/D _4138_/Q wire193/Z VSS _4265_/CLK VDD VDD VSS gf180mcu_fd_sc_mcu7t5v0__dffrnq_1
XFILLER_28_247 VDD VSS VDD VSS gf180mcu_fd_sc_mcu7t5v0__fillcap_64
X_4069_ VDD _4069_/Q _4469_/CLK VSS _4069_/D VDD VSS gf180mcu_fd_sc_mcu7t5v0__dffq_1
XFILLER_43_206 VDD VSS VDD VSS gf180mcu_fd_sc_mcu7t5v0__fillcap_4
Xwire51 VSS wire51/Z wire51/I VDD VDD VSS gf180mcu_fd_sc_mcu7t5v0__clkbuf_1
XFILLER_224_381 VDD VSS VDD VSS gf180mcu_fd_sc_mcu7t5v0__fillcap_4
XFILLER_240_885 VDD VSS VDD VSS gf180mcu_fd_sc_mcu7t5v0__fillcap_4
XFILLER_11_136 VDD VSS VDD VSS gf180mcu_fd_sc_mcu7t5v0__fillcap_4
XFILLER_180_667 VDD VSS VDD VSS gf180mcu_fd_sc_mcu7t5v0__fillcap_32
XFILLER_152_325 VDD VSS VDD VSS gf180mcu_fd_sc_mcu7t5v0__fillcap_4
XFILLER_3_346 VDD VSS VDD VSS gf180mcu_fd_sc_mcu7t5v0__fillcap_4
XFILLER_79_626 VDD VSS VDD VSS gf180mcu_fd_sc_mcu7t5v0__fillcap_4
XFILLER_154_97 VDD VSS VDD VSS gf180mcu_fd_sc_mcu7t5v0__fillcap_8
XFILLER_219_142 VDD VSS VDD VSS gf180mcu_fd_sc_mcu7t5v0__fillcap_64
XFILLER_234_101 VDD VSS VDD VSS gf180mcu_fd_sc_mcu7t5v0__fillcap_4
XFILLER_120_299 VDD VSS VDD VSS gf180mcu_fd_sc_mcu7t5v0__fillcap_4
XFILLER_47_556 VDD VSS VDD VSS gf180mcu_fd_sc_mcu7t5v0__fillcap_4
XFILLER_231_874 VDD VSS VDD VSS gf180mcu_fd_sc_mcu7t5v0__fillcap_16
XFILLER_15_486 VDD VSS VDD VSS gf180mcu_fd_sc_mcu7t5v0__fillcap_4
XFILLER_63_72 VDD VSS VDD VSS gf180mcu_fd_sc_mcu7t5v0__fillcap_64
XFILLER_179_72 VDD VSS VDD VSS gf180mcu_fd_sc_mcu7t5v0__fillcap_16
XFILLER_128_311 VDD VSS VDD VSS gf180mcu_fd_sc_mcu7t5v0__fillcap_4
XFILLER_183_461 VDD VSS VDD VSS gf180mcu_fd_sc_mcu7t5v0__fillcap_4
Xmax_length181 _4573_/RN VSS VDD _4530_/RN VDD VSS gf180mcu_fd_sc_mcu7t5v0__clkbuf_8
Xmax_length170 VSS _3848_/I0 _4296_/Q VDD VDD VSS gf180mcu_fd_sc_mcu7t5v0__buf_2
XFILLER_7_696 VDD VSS VDD VSS gf180mcu_fd_sc_mcu7t5v0__fillcap_4
X_3440_ _3440_/A3 VDD VSS _3442_/A2 wire72/Z _3440_/A2 VDD VSS gf180mcu_fd_sc_mcu7t5v0__nand3_1
X_3371_ wire21/Z VDD VSS _4418_/D _4410_/Q _4418_/Q VDD VSS gf180mcu_fd_sc_mcu7t5v0__mux2_2
XFILLER_143_369 VDD VSS VDD VSS gf180mcu_fd_sc_mcu7t5v0__fillcap_16
XFILLER_170_199 VDD VSS VDD VSS gf180mcu_fd_sc_mcu7t5v0__fillcap_8
X_2322_ _2321_/Z VDD VSS _3004_/C _4330_/Q _3039_/A1 VDD VSS gf180mcu_fd_sc_mcu7t5v0__nor3_1
XFILLER_112_745 VDD VSS VDD VSS gf180mcu_fd_sc_mcu7t5v0__fillcap_4
XFILLER_69_136 VDD VSS VDD VSS gf180mcu_fd_sc_mcu7t5v0__fillcap_4
XFILLER_238_451 VDD VSS VDD VSS gf180mcu_fd_sc_mcu7t5v0__fillcap_4
X_2253_ VDD VSS _4542_/D _4565_/D _3696_/S VDD VSS gf180mcu_fd_sc_mcu7t5v0__xor2_1
XFILLER_26_2 VDD VSS VDD VSS gf180mcu_fd_sc_mcu7t5v0__fillcap_32
X_2184_ VDD VSS _2188_/B _4318_/Q _2693_/A1 VDD VSS gf180mcu_fd_sc_mcu7t5v0__nor2_1
XFILLER_25_206 VDD VSS VDD VSS gf180mcu_fd_sc_mcu7t5v0__fillcap_4
XFILLER_206_381 VDD VSS VDD VSS gf180mcu_fd_sc_mcu7t5v0__fillcap_4
XFILLER_179_734 VDD VSS VDD VSS gf180mcu_fd_sc_mcu7t5v0__fillcap_16
XFILLER_222_885 VDD VSS VDD VSS gf180mcu_fd_sc_mcu7t5v0__fillcap_4
XFILLER_178_266 VDD VSS VDD VSS gf180mcu_fd_sc_mcu7t5v0__fillcap_4
XFILLER_193_203 VDD VSS VDD VSS gf180mcu_fd_sc_mcu7t5v0__fillcap_4
X_1968_ VDD VSS _4195_/Q _2928_/A2 VDD VSS gf180mcu_fd_sc_mcu7t5v0__clkinv_1
X_3707_ VDD VSS _3707_/Z _3707_/A1 _2090_/Z VDD VSS gf180mcu_fd_sc_mcu7t5v0__and2_1
X_3638_ _3677_/B1 _4175_/Q VDD VSS _3639_/I _4481_/Q _3682_/A2 VDD VSS gf180mcu_fd_sc_mcu7t5v0__aoi22_1
XFILLER_162_667 VDD VSS VDD VSS gf180mcu_fd_sc_mcu7t5v0__fillcap_32
XFILLER_150_807 VDD VSS VDD VSS gf180mcu_fd_sc_mcu7t5v0__fillcap_16
X_3569_ _3569_/A3 VDD VSS _3570_/A3 wire78/Z _3569_/A2 VDD VSS gf180mcu_fd_sc_mcu7t5v0__nand3_1
XFILLER_130_597 VDD VSS VDD VSS gf180mcu_fd_sc_mcu7t5v0__fillcap_8
XFILLER_216_101 VDD VSS VDD VSS gf180mcu_fd_sc_mcu7t5v0__fillcap_4
XFILLER_217_657 VDD VSS VDD VSS gf180mcu_fd_sc_mcu7t5v0__fillcap_4
XFILLER_216_123 VDD VSS VDD VSS gf180mcu_fd_sc_mcu7t5v0__fillcap_8
XFILLER_29_556 VDD VSS VDD VSS gf180mcu_fd_sc_mcu7t5v0__fillcap_4
XFILLER_216_167 VDD VSS VDD VSS gf180mcu_fd_sc_mcu7t5v0__fillcap_8
Xclkbuf_leaf_3_clk_i _4427_/CLK VSS VDD clkload0/I VDD VSS gf180mcu_fd_sc_mcu7t5v0__clkbuf_2
XFILLER_232_638 VDD VSS VDD VSS gf180mcu_fd_sc_mcu7t5v0__fillcap_16
XFILLER_213_874 VDD VSS VDD VSS gf180mcu_fd_sc_mcu7t5v0__fillcap_16
XFILLER_200_535 VDD VSS VDD VSS gf180mcu_fd_sc_mcu7t5v0__fillcap_4
XFILLER_130_2 VDD VSS VDD VSS gf180mcu_fd_sc_mcu7t5v0__fillcap_16
XFILLER_228_2 VDD VSS VDD VSS gf180mcu_fd_sc_mcu7t5v0__fillcap_32
XFILLER_184_247 VDD VSS VDD VSS gf180mcu_fd_sc_mcu7t5v0__fillcap_4
XFILLER_180_442 VDD VSS VDD VSS gf180mcu_fd_sc_mcu7t5v0__fillcap_8
XFILLER_152_133 VDD VSS VDD VSS gf180mcu_fd_sc_mcu7t5v0__fillcap_8
XFILLER_137_196 VDD VSS VDD VSS gf180mcu_fd_sc_mcu7t5v0__fillcap_8
XFILLER_152_177 VDD VSS VDD VSS gf180mcu_fd_sc_mcu7t5v0__fillcap_16
XFILLER_106_583 VDD VSS VDD VSS gf180mcu_fd_sc_mcu7t5v0__fillcap_8
XFILLER_208_613 VDD VSS VDD VSS gf180mcu_fd_sc_mcu7t5v0__fillcap_4
XFILLER_235_454 VDD VSS VDD VSS gf180mcu_fd_sc_mcu7t5v0__fillcap_16
XFILLER_204_863 VDD VSS VDD VSS gf180mcu_fd_sc_mcu7t5v0__fillcap_8
XFILLER_250_457 VDD VSS VDD VSS gf180mcu_fd_sc_mcu7t5v0__fillcap_64
X_2940_ _2944_/B1 _1945_/I VDD VSS _2942_/B _2942_/A1 _4364_/Q VDD VSS gf180mcu_fd_sc_mcu7t5v0__aoi22_1
XFILLER_90_698 VDD VSS VDD VSS gf180mcu_fd_sc_mcu7t5v0__fillcap_8
XFILLER_204_885 VDD VSS VDD VSS gf180mcu_fd_sc_mcu7t5v0__fillcap_4
X_2871_ _4370_/Q VDD VSS _2871_/Z _4201_/Q _4369_/Q VDD VSS gf180mcu_fd_sc_mcu7t5v0__mux2_2
XFILLER_188_597 VDD VSS VDD VSS gf180mcu_fd_sc_mcu7t5v0__fillcap_4
XFILLER_176_737 VDD VSS VDD VSS gf180mcu_fd_sc_mcu7t5v0__fillcap_64
X_4610_ _4610_/D _4610_/Q _4616_/RN VSS _4615_/CLK VDD VDD VSS gf180mcu_fd_sc_mcu7t5v0__dffrnq_1
XFILLER_148_428 VDD VSS VDD VSS gf180mcu_fd_sc_mcu7t5v0__fillcap_8
XFILLER_144_612 VDD VSS VDD VSS gf180mcu_fd_sc_mcu7t5v0__fillcap_8
X_4541_ _4541_/D _4541_/Q _4573_/RN VSS _4541_/CLK VDD VDD VSS gf180mcu_fd_sc_mcu7t5v0__dffrnq_1
XFILLER_116_303 VDD VSS VDD VSS gf180mcu_fd_sc_mcu7t5v0__fillcap_4
XFILLER_117_804 VDD VSS VDD VSS gf180mcu_fd_sc_mcu7t5v0__fillcap_16
XFILLER_129_664 VDD VSS VDD VSS gf180mcu_fd_sc_mcu7t5v0__fillcap_16
XFILLER_143_122 VDD VSS VDD VSS gf180mcu_fd_sc_mcu7t5v0__fillcap_16
X_4472_ _4472_/D _4472_/Q wire193/I VSS _4477_/CLK VDD VDD VSS gf180mcu_fd_sc_mcu7t5v0__dffrnq_1
XFILLER_144_667 VDD VSS VDD VSS gf180mcu_fd_sc_mcu7t5v0__fillcap_16
X_3423_ _3425_/S VDD VSS _4466_/D _4424_/Q _4466_/Q VDD VSS gf180mcu_fd_sc_mcu7t5v0__mux2_2
XFILLER_132_807 VDD VSS VDD VSS gf180mcu_fd_sc_mcu7t5v0__fillcap_8
Xclkbuf_4_11_0_host_clk_i _3998_/CLK VSS VDD clkbuf_0_host_clk_i/Z VDD VSS gf180mcu_fd_sc_mcu7t5v0__clkbuf_2
XFILLER_225_66 VDD VSS VDD VSS gf180mcu_fd_sc_mcu7t5v0__fillcap_4
X_3354_ wire20/I VDD VSS _4401_/D _4378_/Q _4401_/Q VDD VSS gf180mcu_fd_sc_mcu7t5v0__mux2_2
X_2305_ VDD VSS _2804_/A1 _2885_/C _2304_/Z VDD VSS gf180mcu_fd_sc_mcu7t5v0__nor2_1
X_3285_ _4380_/Q _4382_/Q VDD VSS _3308_/A2 _3285_/A1 _3285_/A2 _3284_/Z VDD VSS gf180mcu_fd_sc_mcu7t5v0__aoi221_1
X_2236_ _2236_/A3 VDD VSS _4509_/D wire58/Z _2682_/S VDD VSS gf180mcu_fd_sc_mcu7t5v0__nand3_1
XFILLER_241_10 VDD VSS VDD VSS gf180mcu_fd_sc_mcu7t5v0__fillcap_32
XFILLER_112_597 VDD VSS VDD VSS gf180mcu_fd_sc_mcu7t5v0__fillcap_4
XFILLER_100_737 VDD VSS VDD VSS gf180mcu_fd_sc_mcu7t5v0__fillcap_8
X_2167_ _4235_/Q _4236_/Q VDD VSS _2201_/A1 _4233_/Q _4234_/Q VDD VSS gf180mcu_fd_sc_mcu7t5v0__nor4_1
XFILLER_81_632 VDD VSS VDD VSS gf180mcu_fd_sc_mcu7t5v0__fillcap_16
XFILLER_198_317 VDD VSS VDD VSS gf180mcu_fd_sc_mcu7t5v0__fillcap_8
X_2098_ VDD VSS _4588_/D wire74/I _2098_/A2 VDD VSS gf180mcu_fd_sc_mcu7t5v0__xor2_1
XFILLER_210_800 VDD VSS VDD VSS gf180mcu_fd_sc_mcu7t5v0__fillcap_4
XFILLER_210_877 VDD VSS VDD VSS gf180mcu_fd_sc_mcu7t5v0__fillcap_8
XFILLER_166_247 VDD VSS VDD VSS gf180mcu_fd_sc_mcu7t5v0__fillcap_32
XFILLER_119_130 VDD VSS VDD VSS gf180mcu_fd_sc_mcu7t5v0__fillcap_8
XFILLER_162_486 VDD VSS VDD VSS gf180mcu_fd_sc_mcu7t5v0__fillcap_4
XFILLER_89_710 VDD VSS VDD VSS gf180mcu_fd_sc_mcu7t5v0__fillcap_4
XFILLER_135_88 VDD VSS VDD VSS gf180mcu_fd_sc_mcu7t5v0__fillcap_4
XFILLER_131_884 VDD VSS VDD VSS gf180mcu_fd_sc_mcu7t5v0__fillcap_4
XFILLER_264_527 VDD VSS VDD VSS gf180mcu_fd_sc_mcu7t5v0__fillcap_64
XFILLER_178_2 VDD VSS VDD VSS gf180mcu_fd_sc_mcu7t5v0__fillcap_32
XFILLER_71_142 VDD VSS VDD VSS gf180mcu_fd_sc_mcu7t5v0__fillcap_64
XFILLER_232_457 VDD VSS VDD VSS gf180mcu_fd_sc_mcu7t5v0__fillcap_16
XFILLER_158_737 VDD VSS VDD VSS gf180mcu_fd_sc_mcu7t5v0__fillcap_4
XFILLER_200_387 VDD VSS VDD VSS gf180mcu_fd_sc_mcu7t5v0__fillcap_16
XFILLER_114_807 VDD VSS VDD VSS gf180mcu_fd_sc_mcu7t5v0__fillcap_32
XFILLER_122_862 VDD VSS VDD VSS gf180mcu_fd_sc_mcu7t5v0__fillcap_4
X_3070_ VDD VSS _3089_/B _4333_/Q wire13/Z VDD VSS gf180mcu_fd_sc_mcu7t5v0__nand2_1
X_2021_ VDD VSS _4228_/Q _3149_/A2 VDD VSS gf180mcu_fd_sc_mcu7t5v0__clkinv_1
XFILLER_63_632 VDD VSS VDD VSS gf180mcu_fd_sc_mcu7t5v0__fillcap_64
XFILLER_90_451 VDD VSS VDD VSS gf180mcu_fd_sc_mcu7t5v0__fillcap_4
XFILLER_75_492 VDD VSS VDD VSS gf180mcu_fd_sc_mcu7t5v0__fillcap_64
XFILLER_251_766 VDD VSS VDD VSS gf180mcu_fd_sc_mcu7t5v0__fillcap_4
X_3972_ VDD _3972_/Q _3989_/CLK VSS _3972_/D VDD VSS gf180mcu_fd_sc_mcu7t5v0__dffq_1
XFILLER_204_660 VDD VSS VDD VSS gf180mcu_fd_sc_mcu7t5v0__fillcap_4
XFILLER_210_107 VDD VSS VDD VSS gf180mcu_fd_sc_mcu7t5v0__fillcap_8
XFILLER_93_2 VDD VSS VDD VSS gf180mcu_fd_sc_mcu7t5v0__fillcap_16
X_2923_ VDD _2923_/B _2919_/S _4313_/D _2939_/A1 VSS VDD VSS gf180mcu_fd_sc_mcu7t5v0__oai21_1
XFILLER_31_562 VDD VSS VDD VSS gf180mcu_fd_sc_mcu7t5v0__fillcap_64
X_2854_ VDD _2854_/B _2854_/A2 _2858_/A1 _2854_/A1 VSS VDD VSS gf180mcu_fd_sc_mcu7t5v0__oai21_1
XFILLER_148_247 VDD VSS VDD VSS gf180mcu_fd_sc_mcu7t5v0__fillcap_64
X_2785_ _3043_/A1 _4329_/Q VDD VSS _2789_/A1 _4328_/Q _4327_/Q VDD VSS gf180mcu_fd_sc_mcu7t5v0__nand4_1
X_4524_ VSS _4525_/CLK VDD _4524_/D _4524_/Q _4525_/RN VDD VSS gf180mcu_fd_sc_mcu7t5v0__dffsnq_1
XFILLER_163_228 VDD VSS VDD VSS gf180mcu_fd_sc_mcu7t5v0__fillcap_8
Xhold268 _4599_/D VSS _4604_/Q VDD VDD VSS gf180mcu_fd_sc_mcu7t5v0__dlyc_1
Xhold257 _4611_/D VSS _4616_/Q VDD VDD VSS gf180mcu_fd_sc_mcu7t5v0__dlyc_1
XFILLER_116_177 VDD VSS VDD VSS gf180mcu_fd_sc_mcu7t5v0__fillcap_64
XFILLER_104_317 VDD VSS VDD VSS gf180mcu_fd_sc_mcu7t5v0__fillcap_64
X_4455_ _4455_/D _4455_/Q wire210/Z VSS _4496_/CLK VDD VDD VSS gf180mcu_fd_sc_mcu7t5v0__dffrnq_1
X_4386_ _4386_/D _4386_/Q wire196/Z VSS _4402_/CLK VDD VDD VSS gf180mcu_fd_sc_mcu7t5v0__dffrnq_1
XFILLER_132_659 VDD VSS VDD VSS gf180mcu_fd_sc_mcu7t5v0__fillcap_4
X_3406_ wire53/Z VDD VSS _4449_/D _4407_/Q _4449_/Q VDD VSS gf180mcu_fd_sc_mcu7t5v0__mux2_2
X_3337_ _3337_/S VDD VSS _4386_/D _4379_/Q _4386_/Q VDD VSS gf180mcu_fd_sc_mcu7t5v0__mux2_2
XFILLER_258_387 VDD VSS VDD VSS gf180mcu_fd_sc_mcu7t5v0__fillcap_64
XFILLER_246_527 VDD VSS VDD VSS gf180mcu_fd_sc_mcu7t5v0__fillcap_64
XFILLER_85_212 VDD VSS VDD VSS gf180mcu_fd_sc_mcu7t5v0__fillcap_64
X_3268_ _3268_/B1 _4369_/Q VDD VSS _3269_/I _4362_/Q _4526_/D VDD VSS gf180mcu_fd_sc_mcu7t5v0__aoi22_1
X_2219_ VDD _2219_/B _2230_/B _4508_/D _4322_/Q VSS VDD VSS gf180mcu_fd_sc_mcu7t5v0__oai21_1
X_3199_ VDD VSS _3200_/A3 _3270_/A1 _2963_/B VDD VSS gf180mcu_fd_sc_mcu7t5v0__nor2_1
Xclkbuf_leaf_83_clk_i _4081_/CLK VSS VDD clkbuf_3_2__f_clk_i/Z VDD VSS gf180mcu_fd_sc_mcu7t5v0__clkbuf_2
XFILLER_53_142 VDD VSS VDD VSS gf180mcu_fd_sc_mcu7t5v0__fillcap_64
XFILLER_241_276 VDD VSS VDD VSS gf180mcu_fd_sc_mcu7t5v0__fillcap_4
XFILLER_197_39 VDD VSS VDD VSS gf180mcu_fd_sc_mcu7t5v0__fillcap_16
XFILLER_50_871 VDD VSS VDD VSS gf180mcu_fd_sc_mcu7t5v0__fillcap_4
Xclkbuf_leaf_98_clk_i _4449_/CLK VSS VDD clkload0/I VDD VSS gf180mcu_fd_sc_mcu7t5v0__clkbuf_2
Xclkbuf_leaf_21_clk_i _4345_/CLK VSS VDD clkload3/I VDD VSS gf180mcu_fd_sc_mcu7t5v0__clkbuf_2
XFILLER_108_667 VDD VSS VDD VSS gf180mcu_fd_sc_mcu7t5v0__fillcap_32
XFILLER_107_166 VDD VSS VDD VSS gf180mcu_fd_sc_mcu7t5v0__fillcap_32
XFILLER_1_422 VDD VSS VDD VSS gf180mcu_fd_sc_mcu7t5v0__fillcap_64
XFILLER_89_562 VDD VSS VDD VSS gf180mcu_fd_sc_mcu7t5v0__fillcap_64
XFILLER_77_702 VDD VSS VDD VSS gf180mcu_fd_sc_mcu7t5v0__fillcap_64
XFILLER_265_836 VDD VSS VDD VSS gf180mcu_fd_sc_mcu7t5v0__fillcap_4
Xclkbuf_leaf_36_clk_i _4354_/CLK VSS VDD clkload4/I VDD VSS gf180mcu_fd_sc_mcu7t5v0__clkbuf_2
XFILLER_233_733 VDD VSS VDD VSS gf180mcu_fd_sc_mcu7t5v0__fillcap_8
XFILLER_57_492 VDD VSS VDD VSS gf180mcu_fd_sc_mcu7t5v0__fillcap_64
XFILLER_45_632 VDD VSS VDD VSS gf180mcu_fd_sc_mcu7t5v0__fillcap_64
XFILLER_189_136 VDD VSS VDD VSS gf180mcu_fd_sc_mcu7t5v0__fillcap_4
XFILLER_72_451 VDD VSS VDD VSS gf180mcu_fd_sc_mcu7t5v0__fillcap_4
XFILLER_13_562 VDD VSS VDD VSS gf180mcu_fd_sc_mcu7t5v0__fillcap_64
XFILLER_71_72 VDD VSS VDD VSS gf180mcu_fd_sc_mcu7t5v0__fillcap_64
XFILLER_40_381 VDD VSS VDD VSS gf180mcu_fd_sc_mcu7t5v0__fillcap_4
XFILLER_201_674 VDD VSS VDD VSS gf180mcu_fd_sc_mcu7t5v0__fillcap_4
XFILLER_187_72 VDD VSS VDD VSS gf180mcu_fd_sc_mcu7t5v0__fillcap_64
XFILLER_200_151 VDD VSS VDD VSS gf180mcu_fd_sc_mcu7t5v0__fillcap_4
XFILLER_145_206 VDD VSS VDD VSS gf180mcu_fd_sc_mcu7t5v0__fillcap_4
XFILLER_126_431 VDD VSS VDD VSS gf180mcu_fd_sc_mcu7t5v0__fillcap_16
X_2570_ wire29/Z VDD VSS _4193_/D _4467_/Q _4193_/Q VDD VSS gf180mcu_fd_sc_mcu7t5v0__mux2_2
XFILLER_5_772 VDD VSS VDD VSS gf180mcu_fd_sc_mcu7t5v0__fillcap_64
X_4240_ _4240_/D _4240_/Q wire187/Z VSS _4554_/CLK VDD VDD VSS gf180mcu_fd_sc_mcu7t5v0__dffrnq_1
X_4171_ _4171_/D _4171_/Q wire184/Z VSS _4171_/CLK VDD VDD VSS gf180mcu_fd_sc_mcu7t5v0__dffrnq_1
X_3122_ _3122_/S VDD VSS _3122_/Z _3949_/Q _3941_/Q VDD VSS gf180mcu_fd_sc_mcu7t5v0__mux2_2
XFILLER_67_212 VDD VSS VDD VSS gf180mcu_fd_sc_mcu7t5v0__fillcap_64
X_3053_ VDD VSS _3055_/B1 _3157_/A1 _3890_/Q VDD VSS gf180mcu_fd_sc_mcu7t5v0__nor2_1
XFILLER_255_346 VDD VSS VDD VSS gf180mcu_fd_sc_mcu7t5v0__fillcap_4
X_2004_ VDD VSS _4471_/Q _3503_/A1 VDD VSS gf180mcu_fd_sc_mcu7t5v0__clkinv_1
XFILLER_35_142 VDD VSS VDD VSS gf180mcu_fd_sc_mcu7t5v0__fillcap_64
XFILLER_223_276 VDD VSS VDD VSS gf180mcu_fd_sc_mcu7t5v0__fillcap_4
XFILLER_211_416 VDD VSS VDD VSS gf180mcu_fd_sc_mcu7t5v0__fillcap_4
XFILLER_50_101 VDD VSS VDD VSS gf180mcu_fd_sc_mcu7t5v0__fillcap_4
X_3955_ VDD _3955_/Q _3965_/CLK VSS _3955_/D VDD VSS gf180mcu_fd_sc_mcu7t5v0__dffq_1
XFILLER_149_556 VDD VSS VDD VSS gf180mcu_fd_sc_mcu7t5v0__fillcap_4
X_2906_ VDD VSS _2957_/A2 _3212_/A2 _2949_/A1 VDD VSS gf180mcu_fd_sc_mcu7t5v0__nand2_1
XFILLER_32_871 VDD VSS VDD VSS gf180mcu_fd_sc_mcu7t5v0__fillcap_4
X_3886_ VDD _3886_/Q _4541_/CLK VSS _3886_/D VDD VSS gf180mcu_fd_sc_mcu7t5v0__dffq_1
X_2837_ VDD _4303_/Q _2894_/A1 _2888_/B _2888_/A1 VSS VDD VSS gf180mcu_fd_sc_mcu7t5v0__oai21_1
XFILLER_136_239 VDD VSS VDD VSS gf180mcu_fd_sc_mcu7t5v0__fillcap_4
X_2768_ VDD VSS _4299_/D _4535_/Q _4299_/Q VDD VSS gf180mcu_fd_sc_mcu7t5v0__xor2_1
X_2699_ VDD VSS _2699_/Z _2699_/A1 _2699_/A2 VDD VSS gf180mcu_fd_sc_mcu7t5v0__xor2_1
X_4507_ _4507_/D _4507_/Q wire206/Z VSS _4508_/CLK VDD VDD VSS gf180mcu_fd_sc_mcu7t5v0__dffrnq_1
XFILLER_105_615 VDD VSS VDD VSS gf180mcu_fd_sc_mcu7t5v0__fillcap_8
X_4438_ _4438_/D _4438_/Q _4536_/RN VSS _4446_/CLK VDD VDD VSS gf180mcu_fd_sc_mcu7t5v0__dffrnq_1
XFILLER_59_702 VDD VSS VDD VSS gf180mcu_fd_sc_mcu7t5v0__fillcap_64
X_4369_ _4369_/D _4369_/Q wire183/Z VSS _4369_/CLK VDD VDD VSS gf180mcu_fd_sc_mcu7t5v0__dffrnq_1
XFILLER_86_521 VDD VSS VDD VSS gf180mcu_fd_sc_mcu7t5v0__fillcap_4
XFILLER_113_692 VDD VSS VDD VSS gf180mcu_fd_sc_mcu7t5v0__fillcap_8
XFILLER_247_836 VDD VSS VDD VSS gf180mcu_fd_sc_mcu7t5v0__fillcap_4
XFILLER_259_696 VDD VSS VDD VSS gf180mcu_fd_sc_mcu7t5v0__fillcap_4
XFILLER_219_549 VDD VSS VDD VSS gf180mcu_fd_sc_mcu7t5v0__fillcap_8
XFILLER_86_543 VDD VSS VDD VSS gf180mcu_fd_sc_mcu7t5v0__fillcap_8
XFILLER_39_492 VDD VSS VDD VSS gf180mcu_fd_sc_mcu7t5v0__fillcap_64
XFILLER_27_632 VDD VSS VDD VSS gf180mcu_fd_sc_mcu7t5v0__fillcap_64
XFILLER_215_766 VDD VSS VDD VSS gf180mcu_fd_sc_mcu7t5v0__fillcap_4
XFILLER_54_451 VDD VSS VDD VSS gf180mcu_fd_sc_mcu7t5v0__fillcap_4
XFILLER_10_521 VDD VSS VDD VSS gf180mcu_fd_sc_mcu7t5v0__fillcap_4
XFILLER_128_718 VDD VSS VDD VSS gf180mcu_fd_sc_mcu7t5v0__fillcap_16
XFILLER_22_381 VDD VSS VDD VSS gf180mcu_fd_sc_mcu7t5v0__fillcap_4
XFILLER_195_695 VDD VSS VDD VSS gf180mcu_fd_sc_mcu7t5v0__fillcap_4
XFILLER_210_2 VDD VSS VDD VSS gf180mcu_fd_sc_mcu7t5v0__fillcap_32
XFILLER_182_334 VDD VSS VDD VSS gf180mcu_fd_sc_mcu7t5v0__fillcap_4
XFILLER_123_401 VDD VSS VDD VSS gf180mcu_fd_sc_mcu7t5v0__fillcap_16
XFILLER_2_731 VDD VSS VDD VSS gf180mcu_fd_sc_mcu7t5v0__fillcap_4
XFILLER_49_212 VDD VSS VDD VSS gf180mcu_fd_sc_mcu7t5v0__fillcap_64
XFILLER_110_139 VDD VSS VDD VSS gf180mcu_fd_sc_mcu7t5v0__fillcap_4
XFILLER_237_346 VDD VSS VDD VSS gf180mcu_fd_sc_mcu7t5v0__fillcap_4
XFILLER_17_142 VDD VSS VDD VSS gf180mcu_fd_sc_mcu7t5v0__fillcap_64
XFILLER_206_766 VDD VSS VDD VSS gf180mcu_fd_sc_mcu7t5v0__fillcap_32
XFILLER_32_101 VDD VSS VDD VSS gf180mcu_fd_sc_mcu7t5v0__fillcap_4
XFILLER_205_276 VDD VSS VDD VSS gf180mcu_fd_sc_mcu7t5v0__fillcap_4
XFILLER_205_298 VDD VSS VDD VSS gf180mcu_fd_sc_mcu7t5v0__fillcap_8
X_3740_ _3747_/S VDD VSS _3914_/D _3841_/I0 _3914_/Q VDD VSS gf180mcu_fd_sc_mcu7t5v0__mux2_2
XFILLER_14_871 VDD VSS VDD VSS gf180mcu_fd_sc_mcu7t5v0__fillcap_4
XFILLER_158_342 VDD VSS VDD VSS gf180mcu_fd_sc_mcu7t5v0__fillcap_16
XFILLER_9_352 VDD VSS VDD VSS gf180mcu_fd_sc_mcu7t5v0__fillcap_64
X_3671_ VDD VSS _3672_/A3 _4494_/Q _3682_/A2 VDD VSS gf180mcu_fd_sc_mcu7t5v0__nand2_1
X_2622_ _4213_/Q VDD VSS _2626_/A1 _4212_/Q _2622_/A2 VDD VSS gf180mcu_fd_sc_mcu7t5v0__aoi21_1
XFILLER_154_570 VDD VSS VDD VSS gf180mcu_fd_sc_mcu7t5v0__fillcap_4
X_2553_ wire29/Z VDD VSS _4176_/D _4450_/Q _4176_/Q VDD VSS gf180mcu_fd_sc_mcu7t5v0__mux2_2
XFILLER_56_2 VDD VSS VDD VSS gf180mcu_fd_sc_mcu7t5v0__fillcap_32
XFILLER_99_123 VDD VSS VDD VSS gf180mcu_fd_sc_mcu7t5v0__fillcap_16
X_2484_ _2491_/S VDD VSS _4106_/D wire168/Z _4106_/Q VDD VSS gf180mcu_fd_sc_mcu7t5v0__mux2_2
X_4223_ _4223_/D _4223_/Q _4534_/RN VSS _4510_/CLK VDD VDD VSS gf180mcu_fd_sc_mcu7t5v0__dffrnq_1
XFILLER_68_521 VDD VSS VDD VSS gf180mcu_fd_sc_mcu7t5v0__fillcap_4
XFILLER_114_489 VDD VSS VDD VSS gf180mcu_fd_sc_mcu7t5v0__fillcap_16
XFILLER_102_629 VDD VSS VDD VSS gf180mcu_fd_sc_mcu7t5v0__fillcap_16
XFILLER_229_836 VDD VSS VDD VSS gf180mcu_fd_sc_mcu7t5v0__fillcap_4
X_4154_ _4154_/D _4154_/Q _4527_/RN VSS _4198_/CLK VDD VDD VSS gf180mcu_fd_sc_mcu7t5v0__dffrnq_1
XFILLER_233_66 VDD VSS VDD VSS gf180mcu_fd_sc_mcu7t5v0__fillcap_4
X_3105_ _4508_/Q VDD VSS wire66/I _4249_/Q _4257_/Q VDD VSS gf180mcu_fd_sc_mcu7t5v0__mux2_2
X_4085_ VDD _4085_/Q _4476_/CLK VSS _4085_/D VDD VSS gf180mcu_fd_sc_mcu7t5v0__dffq_1
XFILLER_96_885 VDD VSS VDD VSS gf180mcu_fd_sc_mcu7t5v0__fillcap_4
X_3036_ VDD _3036_/B _3036_/A2 _3037_/A3 _3216_/A2 VSS VDD VSS gf180mcu_fd_sc_mcu7t5v0__oai21_1
XFILLER_102_37 VDD VSS VDD VSS gf180mcu_fd_sc_mcu7t5v0__fillcap_64
XFILLER_36_451 VDD VSS VDD VSS gf180mcu_fd_sc_mcu7t5v0__fillcap_4
X_3938_ VDD _3938_/Q _3967_/CLK VSS _3938_/D VDD VSS gf180mcu_fd_sc_mcu7t5v0__dffq_1
Xwire209 wire209/Z wire212/Z VDD VSS VDD VSS gf180mcu_fd_sc_mcu7t5v0__buf_8
X_3869_ VSS _4171_/CLK VDD wire76/Z _3870_/D wire193/Z VDD VSS gf180mcu_fd_sc_mcu7t5v0__dffsnq_1
XFILLER_20_885 VDD VSS VDD VSS gf180mcu_fd_sc_mcu7t5v0__fillcap_4
XFILLER_152_507 VDD VSS VDD VSS gf180mcu_fd_sc_mcu7t5v0__fillcap_4
XFILLER_191_142 VDD VSS VDD VSS gf180mcu_fd_sc_mcu7t5v0__fillcap_4
XFILLER_105_401 VDD VSS VDD VSS gf180mcu_fd_sc_mcu7t5v0__fillcap_8
XFILLER_143_44 VDD VSS VDD VSS gf180mcu_fd_sc_mcu7t5v0__fillcap_16
XFILLER_219_346 VDD VSS VDD VSS gf180mcu_fd_sc_mcu7t5v0__fillcap_4
XFILLER_199_220 VDD VSS VDD VSS gf180mcu_fd_sc_mcu7t5v0__fillcap_4
XFILLER_258_2 VDD VSS VDD VSS gf180mcu_fd_sc_mcu7t5v0__fillcap_32
XFILLER_160_2 VDD VSS VDD VSS gf180mcu_fd_sc_mcu7t5v0__fillcap_32
XFILLER_14_101 VDD VSS VDD VSS gf180mcu_fd_sc_mcu7t5v0__fillcap_4
XFILLER_203_758 VDD VSS VDD VSS gf180mcu_fd_sc_mcu7t5v0__fillcap_4
XFILLER_211_780 VDD VSS VDD VSS gf180mcu_fd_sc_mcu7t5v0__fillcap_4
XFILLER_156_824 VDD VSS VDD VSS gf180mcu_fd_sc_mcu7t5v0__fillcap_32
XFILLER_11_874 VDD VSS VDD VSS gf180mcu_fd_sc_mcu7t5v0__fillcap_16
XFILLER_6_311 VDD VSS VDD VSS gf180mcu_fd_sc_mcu7t5v0__fillcap_4
XFILLER_171_816 VDD VSS VDD VSS gf180mcu_fd_sc_mcu7t5v0__fillcap_8
XFILLER_151_562 VDD VSS VDD VSS gf180mcu_fd_sc_mcu7t5v0__fillcap_32
XFILLER_96_115 VDD VSS VDD VSS gf180mcu_fd_sc_mcu7t5v0__fillcap_4
XFILLER_78_885 VDD VSS VDD VSS gf180mcu_fd_sc_mcu7t5v0__fillcap_4
XFILLER_18_451 VDD VSS VDD VSS gf180mcu_fd_sc_mcu7t5v0__fillcap_4
XFILLER_92_387 VDD VSS VDD VSS gf180mcu_fd_sc_mcu7t5v0__fillcap_64
XFILLER_80_527 VDD VSS VDD VSS gf180mcu_fd_sc_mcu7t5v0__fillcap_64
XFILLER_159_640 VDD VSS VDD VSS gf180mcu_fd_sc_mcu7t5v0__fillcap_16
X_1984_ VDD VSS _4244_/Q _2699_/A1 VDD VSS gf180mcu_fd_sc_mcu7t5v0__clkinv_1
X_3723_ _3728_/S VDD VSS _3900_/D _3900_/Q _4291_/Q VDD VSS gf180mcu_fd_sc_mcu7t5v0__mux2_2
XFILLER_119_526 VDD VSS VDD VSS gf180mcu_fd_sc_mcu7t5v0__fillcap_16
X_3654_ _3677_/B1 _4181_/Q VDD VSS _3655_/I _4487_/Q _3682_/A2 VDD VSS gf180mcu_fd_sc_mcu7t5v0__aoi22_1
X_2605_ VDD VSS _2608_/A3 _4207_/Q _2602_/Z VDD VSS gf180mcu_fd_sc_mcu7t5v0__nand2_1
X_3585_ VDD VSS _3591_/A2 _3596_/A1 _3584_/Z VDD VSS gf180mcu_fd_sc_mcu7t5v0__nand2_1
X_2536_ _2536_/S VDD VSS _4162_/D _4162_/Q _4448_/Q VDD VSS gf180mcu_fd_sc_mcu7t5v0__mux2_2
XFILLER_130_724 VDD VSS VDD VSS gf180mcu_fd_sc_mcu7t5v0__fillcap_8
X_2467_ _2472_/S VDD VSS _4092_/D _2467_/I0 _4092_/Q VDD VSS gf180mcu_fd_sc_mcu7t5v0__mux2_2
X_4206_ _4206_/D _4206_/Q wire199/I VSS _4214_/CLK VDD VDD VSS gf180mcu_fd_sc_mcu7t5v0__dffrnq_1
XFILLER_130_779 VDD VSS VDD VSS gf180mcu_fd_sc_mcu7t5v0__fillcap_8
XFILLER_229_666 VDD VSS VDD VSS gf180mcu_fd_sc_mcu7t5v0__fillcap_32
XFILLER_69_874 VDD VSS VDD VSS gf180mcu_fd_sc_mcu7t5v0__fillcap_16
X_2398_ _2403_/S VDD VSS _4036_/D _4036_/Q wire161/Z VDD VSS gf180mcu_fd_sc_mcu7t5v0__mux2_2
XFILLER_113_14 VDD VSS VDD VSS gf180mcu_fd_sc_mcu7t5v0__fillcap_4
XFILLER_110_470 VDD VSS VDD VSS gf180mcu_fd_sc_mcu7t5v0__fillcap_32
X_4137_ _4137_/D _4137_/Q wire193/Z VSS _4532_/CLK VDD VDD VSS gf180mcu_fd_sc_mcu7t5v0__dffrnq_1
X_4068_ VDD _4068_/Q _4076_/CLK VSS _4068_/D VDD VSS gf180mcu_fd_sc_mcu7t5v0__dffq_1
XFILLER_84_877 VDD VSS VDD VSS gf180mcu_fd_sc_mcu7t5v0__fillcap_8
X_3019_ _3019_/A3 VDD VSS _3019_/Z _3208_/A2 _3019_/A2 VDD VSS gf180mcu_fd_sc_mcu7t5v0__and3_1
Xwire63 VDD wire63/I VSS wire63/Z VDD VSS gf180mcu_fd_sc_mcu7t5v0__dlyb_1
Xwire96 VSS wire96/Z wire96/I VDD VDD VSS gf180mcu_fd_sc_mcu7t5v0__buf_2
Xwire74 VSS wire74/Z wire74/I VDD VDD VSS gf180mcu_fd_sc_mcu7t5v0__buf_2
XFILLER_177_492 VDD VSS VDD VSS gf180mcu_fd_sc_mcu7t5v0__fillcap_32
XFILLER_165_632 VDD VSS VDD VSS gf180mcu_fd_sc_mcu7t5v0__fillcap_16
XFILLER_138_22 VDD VSS VDD VSS gf180mcu_fd_sc_mcu7t5v0__fillcap_8
XFILLER_121_702 VDD VSS VDD VSS gf180mcu_fd_sc_mcu7t5v0__fillcap_8
XFILLER_160_392 VDD VSS VDD VSS gf180mcu_fd_sc_mcu7t5v0__fillcap_8
XFILLER_101_492 VDD VSS VDD VSS gf180mcu_fd_sc_mcu7t5v0__fillcap_32
XFILLER_74_387 VDD VSS VDD VSS gf180mcu_fd_sc_mcu7t5v0__fillcap_64
XFILLER_62_527 VDD VSS VDD VSS gf180mcu_fd_sc_mcu7t5v0__fillcap_64
XFILLER_90_847 VDD VSS VDD VSS gf180mcu_fd_sc_mcu7t5v0__fillcap_8
XFILLER_231_842 VDD VSS VDD VSS gf180mcu_fd_sc_mcu7t5v0__fillcap_32
XFILLER_203_555 VDD VSS VDD VSS gf180mcu_fd_sc_mcu7t5v0__fillcap_4
XFILLER_187_212 VDD VSS VDD VSS gf180mcu_fd_sc_mcu7t5v0__fillcap_8
XFILLER_168_470 VDD VSS VDD VSS gf180mcu_fd_sc_mcu7t5v0__fillcap_16
XFILLER_30_457 VDD VSS VDD VSS gf180mcu_fd_sc_mcu7t5v0__fillcap_64
XFILLER_129_846 VDD VSS VDD VSS gf180mcu_fd_sc_mcu7t5v0__fillcap_4
XFILLER_195_72 VDD VSS VDD VSS gf180mcu_fd_sc_mcu7t5v0__fillcap_32
XFILLER_155_142 VDD VSS VDD VSS gf180mcu_fd_sc_mcu7t5v0__fillcap_8
Xmax_length171 VSS _3766_/I0 wire172/Z VDD VDD VSS gf180mcu_fd_sc_mcu7t5v0__buf_2
Xmax_length182 _4530_/RN wire183/Z VDD VSS VDD VSS gf180mcu_fd_sc_mcu7t5v0__buf_12
X_3370_ wire21/Z VDD VSS _4417_/D _4409_/Q _4417_/Q VDD VSS gf180mcu_fd_sc_mcu7t5v0__mux2_2
X_2321_ VDD VSS _2321_/Z _4328_/Q _1911_/I VDD VSS gf180mcu_fd_sc_mcu7t5v0__or2_1
XFILLER_111_212 VDD VSS VDD VSS gf180mcu_fd_sc_mcu7t5v0__fillcap_32
X_2252_ _2102_/Z VDD VSS _3696_/S _4540_/Q _4541_/Q VDD VSS gf180mcu_fd_sc_mcu7t5v0__and3_1
XFILLER_84_107 VDD VSS VDD VSS gf180mcu_fd_sc_mcu7t5v0__fillcap_64
XFILLER_112_779 VDD VSS VDD VSS gf180mcu_fd_sc_mcu7t5v0__fillcap_8
X_2183_ VDD VSS _2693_/A1 _4504_/Q wire58/Z VDD VSS gf180mcu_fd_sc_mcu7t5v0__nand2_1
XFILLER_19_2 VDD VSS VDD VSS gf180mcu_fd_sc_mcu7t5v0__fillcap_64
XFILLER_253_422 VDD VSS VDD VSS gf180mcu_fd_sc_mcu7t5v0__fillcap_64
XFILLER_265_282 VDD VSS VDD VSS gf180mcu_fd_sc_mcu7t5v0__fillcap_64
XFILLER_66_877 VDD VSS VDD VSS gf180mcu_fd_sc_mcu7t5v0__fillcap_8
XFILLER_179_702 VDD VSS VDD VSS gf180mcu_fd_sc_mcu7t5v0__fillcap_32
XFILLER_221_352 VDD VSS VDD VSS gf180mcu_fd_sc_mcu7t5v0__fillcap_64
XFILLER_166_407 VDD VSS VDD VSS gf180mcu_fd_sc_mcu7t5v0__fillcap_4
XFILLER_147_632 VDD VSS VDD VSS gf180mcu_fd_sc_mcu7t5v0__fillcap_64
XFILLER_159_492 VDD VSS VDD VSS gf180mcu_fd_sc_mcu7t5v0__fillcap_32
X_1967_ VDD VSS _4368_/Q _2944_/B1 VDD VSS gf180mcu_fd_sc_mcu7t5v0__clkinv_1
X_3706_ _3706_/S VDD VSS _3889_/D _3889_/Q _4296_/Q VDD VSS gf180mcu_fd_sc_mcu7t5v0__mux2_2
X_3637_ _3637_/A3 _3479_/C VDD VSS _3640_/B1 _3637_/A1 _2522_/B VDD VSS gf180mcu_fd_sc_mcu7t5v0__nor4_1
X_3568_ _3568_/B wire74/Z VDD VSS _3569_/A3 wire82/I _3564_/Z VDD VSS gf180mcu_fd_sc_mcu7t5v0__oai211_1
X_2519_ _2730_/S VDD VSS _4148_/D _4148_/Q wire120/Z VDD VSS gf180mcu_fd_sc_mcu7t5v0__mux2_2
XFILLER_115_562 VDD VSS VDD VSS gf180mcu_fd_sc_mcu7t5v0__fillcap_16
X_3499_ VDD VSS _3628_/C _3637_/A1 _3499_/A2 VDD VSS gf180mcu_fd_sc_mcu7t5v0__nor2_1
XFILLER_88_457 VDD VSS VDD VSS gf180mcu_fd_sc_mcu7t5v0__fillcap_64
XFILLER_257_772 VDD VSS VDD VSS gf180mcu_fd_sc_mcu7t5v0__fillcap_64
XFILLER_56_387 VDD VSS VDD VSS gf180mcu_fd_sc_mcu7t5v0__fillcap_64
XFILLER_44_527 VDD VSS VDD VSS gf180mcu_fd_sc_mcu7t5v0__fillcap_64
XFILLER_84_685 VDD VSS VDD VSS gf180mcu_fd_sc_mcu7t5v0__fillcap_16
XFILLER_71_346 VDD VSS VDD VSS gf180mcu_fd_sc_mcu7t5v0__fillcap_4
XFILLER_17_66 VDD VSS VDD VSS gf180mcu_fd_sc_mcu7t5v0__fillcap_4
XFILLER_213_842 VDD VSS VDD VSS gf180mcu_fd_sc_mcu7t5v0__fillcap_32
XFILLER_197_521 VDD VSS VDD VSS gf180mcu_fd_sc_mcu7t5v0__fillcap_4
XFILLER_169_212 VDD VSS VDD VSS gf180mcu_fd_sc_mcu7t5v0__fillcap_8
XFILLER_240_661 VDD VSS VDD VSS gf180mcu_fd_sc_mcu7t5v0__fillcap_4
XFILLER_12_457 VDD VSS VDD VSS gf180mcu_fd_sc_mcu7t5v0__fillcap_64
XFILLER_200_558 VDD VSS VDD VSS gf180mcu_fd_sc_mcu7t5v0__fillcap_4
XFILLER_149_87 VDD VSS VDD VSS gf180mcu_fd_sc_mcu7t5v0__fillcap_8
XFILLER_180_410 VDD VSS VDD VSS gf180mcu_fd_sc_mcu7t5v0__fillcap_32
XFILLER_165_42 VDD VSS VDD VSS gf180mcu_fd_sc_mcu7t5v0__fillcap_16
XFILLER_4_667 VDD VSS VDD VSS gf180mcu_fd_sc_mcu7t5v0__fillcap_64
XFILLER_134_871 VDD VSS VDD VSS gf180mcu_fd_sc_mcu7t5v0__fillcap_4
XFILLER_66_107 VDD VSS VDD VSS gf180mcu_fd_sc_mcu7t5v0__fillcap_64
XFILLER_235_422 VDD VSS VDD VSS gf180mcu_fd_sc_mcu7t5v0__fillcap_32
XFILLER_208_625 VDD VSS VDD VSS gf180mcu_fd_sc_mcu7t5v0__fillcap_8
XFILLER_247_282 VDD VSS VDD VSS gf180mcu_fd_sc_mcu7t5v0__fillcap_64
XFILLER_48_877 VDD VSS VDD VSS gf180mcu_fd_sc_mcu7t5v0__fillcap_8
XFILLER_262_241 VDD VSS VDD VSS gf180mcu_fd_sc_mcu7t5v0__fillcap_4
XFILLER_63_836 VDD VSS VDD VSS gf180mcu_fd_sc_mcu7t5v0__fillcap_4
XFILLER_75_696 VDD VSS VDD VSS gf180mcu_fd_sc_mcu7t5v0__fillcap_4
XFILLER_231_683 VDD VSS VDD VSS gf180mcu_fd_sc_mcu7t5v0__fillcap_16
XFILLER_203_352 VDD VSS VDD VSS gf180mcu_fd_sc_mcu7t5v0__fillcap_16
XFILLER_200_37 VDD VSS VDD VSS gf180mcu_fd_sc_mcu7t5v0__fillcap_64
X_2870_ _4199_/Q VSS VDD _4367_/Q _4198_/Q _3008_/B2 _4366_/Q _4370_/Q _2870_/Z VDD
+ VSS gf180mcu_fd_sc_mcu7t5v0__mux4_1
XFILLER_230_171 VDD VSS VDD VSS gf180mcu_fd_sc_mcu7t5v0__fillcap_4
XFILLER_31_766 VDD VSS VDD VSS gf180mcu_fd_sc_mcu7t5v0__fillcap_4
XFILLER_129_632 VDD VSS VDD VSS gf180mcu_fd_sc_mcu7t5v0__fillcap_32
XFILLER_156_451 VDD VSS VDD VSS gf180mcu_fd_sc_mcu7t5v0__fillcap_4
XFILLER_156_473 VDD VSS VDD VSS gf180mcu_fd_sc_mcu7t5v0__fillcap_8
X_4540_ _4540_/D _4540_/Q _4573_/RN VSS _4541_/CLK VDD VDD VSS gf180mcu_fd_sc_mcu7t5v0__dffrnq_1
X_4471_ _4471_/D _4471_/Q _4473_/RN VSS _4477_/CLK VDD VDD VSS gf180mcu_fd_sc_mcu7t5v0__dffrnq_1
X_3422_ wire53/Z VDD VSS _4465_/D _4423_/Q _4465_/Q VDD VSS gf180mcu_fd_sc_mcu7t5v0__mux2_2
XFILLER_124_381 VDD VSS VDD VSS gf180mcu_fd_sc_mcu7t5v0__fillcap_4
X_3353_ wire21/I VDD VSS _4400_/D _4377_/Q _4400_/Q VDD VSS gf180mcu_fd_sc_mcu7t5v0__mux2_2
XFILLER_112_521 VDD VSS VDD VSS gf180mcu_fd_sc_mcu7t5v0__fillcap_4
XFILLER_98_766 VDD VSS VDD VSS gf180mcu_fd_sc_mcu7t5v0__fillcap_16
XFILLER_140_885 VDD VSS VDD VSS gf180mcu_fd_sc_mcu7t5v0__fillcap_4
X_2304_ _4325_/Q VDD VSS _2304_/Z _3008_/B2 _4324_/Q VDD VSS gf180mcu_fd_sc_mcu7t5v0__or3_1
XFILLER_97_276 VDD VSS VDD VSS gf180mcu_fd_sc_mcu7t5v0__fillcap_4
XFILLER_85_416 VDD VSS VDD VSS gf180mcu_fd_sc_mcu7t5v0__fillcap_4
X_3284_ VDD VSS _3284_/Z _3284_/A1 _3284_/A2 VDD VSS gf180mcu_fd_sc_mcu7t5v0__and2_1
XFILLER_239_772 VDD VSS VDD VSS gf180mcu_fd_sc_mcu7t5v0__fillcap_64
X_2235_ VDD _2236_/A3 _4509_/Q _4501_/Q _2235_/A2 VSS _2348_/A3 VDD VSS gf180mcu_fd_sc_mcu7t5v0__oai31_1
XFILLER_254_731 VDD VSS VDD VSS gf180mcu_fd_sc_mcu7t5v0__fillcap_4
XFILLER_266_591 VDD VSS VDD VSS gf180mcu_fd_sc_mcu7t5v0__fillcap_4
X_2166_ _2171_/A3 VDD VSS _2181_/A1 _4237_/Q _4240_/Q VDD VSS gf180mcu_fd_sc_mcu7t5v0__nand3_1
XFILLER_38_387 VDD VSS VDD VSS gf180mcu_fd_sc_mcu7t5v0__fillcap_64
XFILLER_241_66 VDD VSS VDD VSS gf180mcu_fd_sc_mcu7t5v0__fillcap_4
XFILLER_26_527 VDD VSS VDD VSS gf180mcu_fd_sc_mcu7t5v0__fillcap_64
XFILLER_198_307 VDD VSS VDD VSS gf180mcu_fd_sc_mcu7t5v0__fillcap_8
X_2097_ VDD VSS _4587_/D _4592_/Q _2097_/A2 VDD VSS gf180mcu_fd_sc_mcu7t5v0__xnor2_1
XFILLER_53_346 VDD VSS VDD VSS gf180mcu_fd_sc_mcu7t5v0__fillcap_4
XFILLER_179_532 VDD VSS VDD VSS gf180mcu_fd_sc_mcu7t5v0__fillcap_16
XFILLER_81_677 VDD VSS VDD VSS gf180mcu_fd_sc_mcu7t5v0__fillcap_16
XFILLER_110_37 VDD VSS VDD VSS gf180mcu_fd_sc_mcu7t5v0__fillcap_64
XFILLER_179_598 VDD VSS VDD VSS gf180mcu_fd_sc_mcu7t5v0__fillcap_32
X_2999_ _3019_/A3 VDD VSS _3021_/B3 _3209_/B _3019_/A2 VDD VSS gf180mcu_fd_sc_mcu7t5v0__nand3_1
XFILLER_21_276 VDD VSS VDD VSS gf180mcu_fd_sc_mcu7t5v0__fillcap_4
XFILLER_119_142 VDD VSS VDD VSS gf180mcu_fd_sc_mcu7t5v0__fillcap_8
XFILLER_134_123 VDD VSS VDD VSS gf180mcu_fd_sc_mcu7t5v0__fillcap_8
XFILLER_162_465 VDD VSS VDD VSS gf180mcu_fd_sc_mcu7t5v0__fillcap_4
XFILLER_190_785 VDD VSS VDD VSS gf180mcu_fd_sc_mcu7t5v0__fillcap_4
XFILLER_1_626 VDD VSS VDD VSS gf180mcu_fd_sc_mcu7t5v0__fillcap_4
XFILLER_89_744 VDD VSS VDD VSS gf180mcu_fd_sc_mcu7t5v0__fillcap_16
XFILLER_48_107 VDD VSS VDD VSS gf180mcu_fd_sc_mcu7t5v0__fillcap_64
XFILLER_217_422 VDD VSS VDD VSS gf180mcu_fd_sc_mcu7t5v0__fillcap_64
XFILLER_229_282 VDD VSS VDD VSS gf180mcu_fd_sc_mcu7t5v0__fillcap_64
XFILLER_244_241 VDD VSS VDD VSS gf180mcu_fd_sc_mcu7t5v0__fillcap_4
XFILLER_45_836 VDD VSS VDD VSS gf180mcu_fd_sc_mcu7t5v0__fillcap_4
XFILLER_57_696 VDD VSS VDD VSS gf180mcu_fd_sc_mcu7t5v0__fillcap_4
XFILLER_198_863 VDD VSS VDD VSS gf180mcu_fd_sc_mcu7t5v0__fillcap_8
XFILLER_158_705 VDD VSS VDD VSS gf180mcu_fd_sc_mcu7t5v0__fillcap_4
XFILLER_198_885 VDD VSS VDD VSS gf180mcu_fd_sc_mcu7t5v0__fillcap_4
XFILLER_158_716 VDD VSS VDD VSS gf180mcu_fd_sc_mcu7t5v0__fillcap_4
XFILLER_212_171 VDD VSS VDD VSS gf180mcu_fd_sc_mcu7t5v0__fillcap_4
XFILLER_200_311 VDD VSS VDD VSS gf180mcu_fd_sc_mcu7t5v0__fillcap_4
XFILLER_13_766 VDD VSS VDD VSS gf180mcu_fd_sc_mcu7t5v0__fillcap_4
XFILLER_158_749 VDD VSS VDD VSS gf180mcu_fd_sc_mcu7t5v0__fillcap_4
XFILLER_8_247 VDD VSS VDD VSS gf180mcu_fd_sc_mcu7t5v0__fillcap_64
XFILLER_125_112 VDD VSS VDD VSS gf180mcu_fd_sc_mcu7t5v0__fillcap_16
XFILLER_126_613 VDD VSS VDD VSS gf180mcu_fd_sc_mcu7t5v0__fillcap_4
XFILLER_153_432 VDD VSS VDD VSS gf180mcu_fd_sc_mcu7t5v0__fillcap_4
XFILLER_180_284 VDD VSS VDD VSS gf180mcu_fd_sc_mcu7t5v0__fillcap_16
XFILLER_125_189 VDD VSS VDD VSS gf180mcu_fd_sc_mcu7t5v0__fillcap_4
XFILLER_69_72 VDD VSS VDD VSS gf180mcu_fd_sc_mcu7t5v0__fillcap_64
XFILLER_67_416 VDD VSS VDD VSS gf180mcu_fd_sc_mcu7t5v0__fillcap_4
XFILLER_79_276 VDD VSS VDD VSS gf180mcu_fd_sc_mcu7t5v0__fillcap_4
XFILLER_122_885 VDD VSS VDD VSS gf180mcu_fd_sc_mcu7t5v0__fillcap_4
XFILLER_248_591 VDD VSS VDD VSS gf180mcu_fd_sc_mcu7t5v0__fillcap_4
X_2020_ VDD VSS _3958_/Q _3797_/A1 VDD VSS gf180mcu_fd_sc_mcu7t5v0__clkinv_1
XFILLER_35_346 VDD VSS VDD VSS gf180mcu_fd_sc_mcu7t5v0__fillcap_4
X_3971_ VDD _3971_/Q _3989_/CLK VSS _3971_/D VDD VSS gf180mcu_fd_sc_mcu7t5v0__dffq_1
X_2922_ VDD VSS _2923_/B wire150/I _2919_/S VDD VSS gf180mcu_fd_sc_mcu7t5v0__nand2_1
XFILLER_176_557 VDD VSS VDD VSS gf180mcu_fd_sc_mcu7t5v0__fillcap_4
X_2853_ _2853_/B2 _2853_/C VDD VSS _2854_/A2 _2853_/A1 _2853_/A2 _2853_/B1 VDD VSS
+ gf180mcu_fd_sc_mcu7t5v0__aoi221_1
XFILLER_188_395 VDD VSS VDD VSS gf180mcu_fd_sc_mcu7t5v0__fillcap_4
XFILLER_86_2 VDD VSS VDD VSS gf180mcu_fd_sc_mcu7t5v0__fillcap_32
XFILLER_176_579 VDD VSS VDD VSS gf180mcu_fd_sc_mcu7t5v0__fillcap_4
X_2784_ _3004_/A2 VDD VSS _3201_/A2 _3226_/A1 _4327_/Q VDD VSS gf180mcu_fd_sc_mcu7t5v0__nand3_1
X_4523_ VSS _4523_/CLK VDD _4523_/D _4523_/Q _4512_/RN VDD VSS gf180mcu_fd_sc_mcu7t5v0__dffsnq_1
XFILLER_129_473 VDD VSS VDD VSS gf180mcu_fd_sc_mcu7t5v0__fillcap_8
Xclkbuf_leaf_2_clk_i clkload9/I VSS VDD clkload0/I VDD VSS gf180mcu_fd_sc_mcu7t5v0__clkbuf_2
XFILLER_144_465 VDD VSS VDD VSS gf180mcu_fd_sc_mcu7t5v0__fillcap_4
Xhold258 _4610_/D VSS _4615_/Q VDD VDD VSS gf180mcu_fd_sc_mcu7t5v0__dlyc_1
Xhold269 _4598_/D VSS _4603_/Q VDD VDD VSS gf180mcu_fd_sc_mcu7t5v0__dlyc_1
X_4454_ _4454_/D _4454_/Q wire210/Z VSS _4467_/CLK VDD VDD VSS gf180mcu_fd_sc_mcu7t5v0__dffrnq_1
XFILLER_132_605 VDD VSS VDD VSS gf180mcu_fd_sc_mcu7t5v0__fillcap_4
XFILLER_132_638 VDD VSS VDD VSS gf180mcu_fd_sc_mcu7t5v0__fillcap_4
XFILLER_258_311 VDD VSS VDD VSS gf180mcu_fd_sc_mcu7t5v0__fillcap_4
X_3405_ _3425_/S VDD VSS _4448_/D _4406_/Q _4448_/Q VDD VSS gf180mcu_fd_sc_mcu7t5v0__mux2_2
XFILLER_131_126 VDD VSS VDD VSS gf180mcu_fd_sc_mcu7t5v0__fillcap_4
XFILLER_125_690 VDD VSS VDD VSS gf180mcu_fd_sc_mcu7t5v0__fillcap_8
X_4385_ _4385_/D _4385_/Q wire196/Z VSS _4407_/CLK VDD VDD VSS gf180mcu_fd_sc_mcu7t5v0__dffrnq_1
X_3336_ _3347_/B VDD VSS _3337_/S _3336_/A1 _3338_/A2 VDD VSS gf180mcu_fd_sc_mcu7t5v0__nand3_1
X_3267_ VDD VSS _3267_/I _4368_/D VDD VSS gf180mcu_fd_sc_mcu7t5v0__clkinv_1
XFILLER_227_753 VDD VSS VDD VSS gf180mcu_fd_sc_mcu7t5v0__fillcap_16
XFILLER_226_241 VDD VSS VDD VSS gf180mcu_fd_sc_mcu7t5v0__fillcap_4
X_2218_ _4506_/Q VDD VSS _2219_/B _4246_/Q _4322_/Q VDD VSS gf180mcu_fd_sc_mcu7t5v0__nand3_1
X_3198_ VDD _4340_/Q _3198_/A2 _3200_/B wire59/I VSS VDD VSS gf180mcu_fd_sc_mcu7t5v0__oai21_1
XFILLER_39_696 VDD VSS VDD VSS gf180mcu_fd_sc_mcu7t5v0__fillcap_4
XFILLER_27_836 VDD VSS VDD VSS gf180mcu_fd_sc_mcu7t5v0__fillcap_4
X_2149_ VDD VSS _2149_/I _4139_/D VDD VSS gf180mcu_fd_sc_mcu7t5v0__clkinv_1
XFILLER_195_822 VDD VSS VDD VSS gf180mcu_fd_sc_mcu7t5v0__fillcap_16
XFILLER_194_343 VDD VSS VDD VSS gf180mcu_fd_sc_mcu7t5v0__fillcap_16
XFILLER_210_675 VDD VSS VDD VSS gf180mcu_fd_sc_mcu7t5v0__fillcap_8
XFILLER_182_527 VDD VSS VDD VSS gf180mcu_fd_sc_mcu7t5v0__fillcap_32
XFILLER_194_387 VDD VSS VDD VSS gf180mcu_fd_sc_mcu7t5v0__fillcap_8
XFILLER_5_206 VDD VSS VDD VSS gf180mcu_fd_sc_mcu7t5v0__fillcap_4
XFILLER_190_582 VDD VSS VDD VSS gf180mcu_fd_sc_mcu7t5v0__fillcap_8
XFILLER_89_541 VDD VSS VDD VSS gf180mcu_fd_sc_mcu7t5v0__fillcap_4
XFILLER_49_416 VDD VSS VDD VSS gf180mcu_fd_sc_mcu7t5v0__fillcap_4
XFILLER_209_219 VDD VSS VDD VSS gf180mcu_fd_sc_mcu7t5v0__fillcap_16
XFILLER_17_346 VDD VSS VDD VSS gf180mcu_fd_sc_mcu7t5v0__fillcap_4
XFILLER_260_597 VDD VSS VDD VSS gf180mcu_fd_sc_mcu7t5v0__fillcap_64
XFILLER_185_321 VDD VSS VDD VSS gf180mcu_fd_sc_mcu7t5v0__fillcap_4
XFILLER_186_877 VDD VSS VDD VSS gf180mcu_fd_sc_mcu7t5v0__fillcap_8
XFILLER_139_760 VDD VSS VDD VSS gf180mcu_fd_sc_mcu7t5v0__fillcap_8
XFILLER_9_556 VDD VSS VDD VSS gf180mcu_fd_sc_mcu7t5v0__fillcap_4
XFILLER_114_605 VDD VSS VDD VSS gf180mcu_fd_sc_mcu7t5v0__fillcap_4
XFILLER_114_638 VDD VSS VDD VSS gf180mcu_fd_sc_mcu7t5v0__fillcap_16
XFILLER_107_690 VDD VSS VDD VSS gf180mcu_fd_sc_mcu7t5v0__fillcap_8
X_4170_ _4170_/D _4170_/Q wire184/Z VSS _4171_/CLK VDD VDD VSS gf180mcu_fd_sc_mcu7t5v0__dffrnq_1
X_3121_ VDD VSS _3126_/A2 wire94/Z _3120_/Z VDD VSS gf180mcu_fd_sc_mcu7t5v0__nor2_1
XFILLER_228_506 VDD VSS VDD VSS gf180mcu_fd_sc_mcu7t5v0__fillcap_4
XFILLER_110_877 VDD VSS VDD VSS gf180mcu_fd_sc_mcu7t5v0__fillcap_8
X_3052_ VDD wire97/I _3874_/Q _3055_/A2 _3157_/A1 VSS VDD VSS gf180mcu_fd_sc_mcu7t5v0__oai21_1
X_2003_ VDD VSS _4472_/Q _3525_/A1 VDD VSS gf180mcu_fd_sc_mcu7t5v0__clkinv_1
X_3954_ VDD _3954_/Q _3965_/CLK VSS _3954_/D VDD VSS gf180mcu_fd_sc_mcu7t5v0__dffq_1
X_3885_ VDD _3885_/Q _3968_/CLK VSS _3885_/D VDD VSS gf180mcu_fd_sc_mcu7t5v0__dffq_1
X_2905_ VDD VSS _3271_/B _3212_/A2 _2949_/A1 VDD VSS gf180mcu_fd_sc_mcu7t5v0__and2_1
X_2836_ _2836_/B VDD VSS _2894_/A1 _3208_/A2 _3040_/A2 VDD VSS gf180mcu_fd_sc_mcu7t5v0__aoi21_1
XFILLER_164_527 VDD VSS VDD VSS gf180mcu_fd_sc_mcu7t5v0__fillcap_64
XFILLER_176_387 VDD VSS VDD VSS gf180mcu_fd_sc_mcu7t5v0__fillcap_16
X_2767_ VDD VSS _4298_/D _4298_/Q _2767_/A2 VDD VSS gf180mcu_fd_sc_mcu7t5v0__xnor2_1
X_2698_ _2698_/B VDD VSS _2700_/A1 _4504_/Q wire58/Z VDD VSS gf180mcu_fd_sc_mcu7t5v0__aoi21_1
X_4506_ _4506_/D _4506_/Q wire206/Z VSS _4508_/CLK VDD VDD VSS gf180mcu_fd_sc_mcu7t5v0__dffrnq_1
X_4437_ _4437_/D _4437_/Q wire209/Z VSS _4451_/CLK VDD VDD VSS gf180mcu_fd_sc_mcu7t5v0__dffrnq_1
XFILLER_132_457 VDD VSS VDD VSS gf180mcu_fd_sc_mcu7t5v0__fillcap_64
X_4368_ _4368_/D _4368_/Q wire183/Z VSS _4371_/CLK VDD VDD VSS gf180mcu_fd_sc_mcu7t5v0__dffrnq_1
X_4299_ _4299_/D _4299_/Q _4535_/RN VSS _4605_/CLK VDD VDD VSS gf180mcu_fd_sc_mcu7t5v0__dffrnq_1
XFILLER_86_566 VDD VSS VDD VSS gf180mcu_fd_sc_mcu7t5v0__fillcap_16
X_3319_ VDD VSS _3329_/B _3319_/A1 _3319_/A2 VDD VSS gf180mcu_fd_sc_mcu7t5v0__nand2_1
XFILLER_262_807 VDD VSS VDD VSS gf180mcu_fd_sc_mcu7t5v0__fillcap_64
XFILLER_81_282 VDD VSS VDD VSS gf180mcu_fd_sc_mcu7t5v0__fillcap_64
XFILLER_242_597 VDD VSS VDD VSS gf180mcu_fd_sc_mcu7t5v0__fillcap_64
XFILLER_186_107 VDD VSS VDD VSS gf180mcu_fd_sc_mcu7t5v0__fillcap_64
XFILLER_25_66 VDD VSS VDD VSS gf180mcu_fd_sc_mcu7t5v0__fillcap_4
XFILLER_168_877 VDD VSS VDD VSS gf180mcu_fd_sc_mcu7t5v0__fillcap_8
XFILLER_182_302 VDD VSS VDD VSS gf180mcu_fd_sc_mcu7t5v0__fillcap_8
XFILLER_167_376 VDD VSS VDD VSS gf180mcu_fd_sc_mcu7t5v0__fillcap_8
XFILLER_136_796 VDD VSS VDD VSS gf180mcu_fd_sc_mcu7t5v0__fillcap_8
XFILLER_203_2 VDD VSS VDD VSS gf180mcu_fd_sc_mcu7t5v0__fillcap_64
XFILLER_110_107 VDD VSS VDD VSS gf180mcu_fd_sc_mcu7t5v0__fillcap_32
XFILLER_2_37 VDD VSS VDD VSS gf180mcu_fd_sc_mcu7t5v0__fillcap_64
XFILLER_264_177 VDD VSS VDD VSS gf180mcu_fd_sc_mcu7t5v0__fillcap_64
XFILLER_252_317 VDD VSS VDD VSS gf180mcu_fd_sc_mcu7t5v0__fillcap_64
XFILLER_73_772 VDD VSS VDD VSS gf180mcu_fd_sc_mcu7t5v0__fillcap_64
XFILLER_220_247 VDD VSS VDD VSS gf180mcu_fd_sc_mcu7t5v0__fillcap_64
XFILLER_146_527 VDD VSS VDD VSS gf180mcu_fd_sc_mcu7t5v0__fillcap_16
XFILLER_158_387 VDD VSS VDD VSS gf180mcu_fd_sc_mcu7t5v0__fillcap_8
X_3670_ VDD VSS _3672_/A2 _4188_/Q _3682_/B1 VDD VSS gf180mcu_fd_sc_mcu7t5v0__nand2_1
X_2621_ VDD _4212_/D _2621_/B _4212_/Q _2634_/A3 VSS _2621_/A3 VDD VSS gf180mcu_fd_sc_mcu7t5v0__oai31_1
XFILLER_126_240 VDD VSS VDD VSS gf180mcu_fd_sc_mcu7t5v0__fillcap_4
X_2552_ wire28/Z VDD VSS _4175_/D wire116/Z _4175_/Q VDD VSS gf180mcu_fd_sc_mcu7t5v0__mux2_2
XFILLER_142_722 VDD VSS VDD VSS gf180mcu_fd_sc_mcu7t5v0__fillcap_8
Xclkbuf_leaf_82_clk_i _4469_/CLK VSS VDD clkbuf_3_2__f_clk_i/Z VDD VSS gf180mcu_fd_sc_mcu7t5v0__clkbuf_2
XFILLER_49_2 VDD VSS VDD VSS gf180mcu_fd_sc_mcu7t5v0__fillcap_64
X_4222_ _4222_/D _4222_/Q _4534_/RN VSS _4532_/CLK VDD VDD VSS gf180mcu_fd_sc_mcu7t5v0__dffrnq_1
XFILLER_114_457 VDD VSS VDD VSS gf180mcu_fd_sc_mcu7t5v0__fillcap_32
X_2483_ VDD VSS _2491_/S _2483_/A1 _2501_/A2 VDD VSS gf180mcu_fd_sc_mcu7t5v0__nand2_1
XFILLER_99_168 VDD VSS VDD VSS gf180mcu_fd_sc_mcu7t5v0__fillcap_8
X_4153_ _4153_/D _4153_/Q wire184/Z VSS _4171_/CLK VDD VDD VSS gf180mcu_fd_sc_mcu7t5v0__dffrnq_1
XFILLER_256_667 VDD VSS VDD VSS gf180mcu_fd_sc_mcu7t5v0__fillcap_64
XFILLER_244_807 VDD VSS VDD VSS gf180mcu_fd_sc_mcu7t5v0__fillcap_64
X_3104_ VDD _3107_/A2 _3104_/B wire93/Z _3104_/A2 VSS _3104_/A3 VDD VSS gf180mcu_fd_sc_mcu7t5v0__oai31_1
XFILLER_95_352 VDD VSS VDD VSS gf180mcu_fd_sc_mcu7t5v0__fillcap_64
X_4084_ VDD _4084_/Q _4580_/CLK VSS _4084_/D VDD VSS gf180mcu_fd_sc_mcu7t5v0__dffq_1
Xclkbuf_leaf_97_clk_i _4407_/CLK VSS VDD clkload0/I VDD VSS gf180mcu_fd_sc_mcu7t5v0__clkbuf_2
X_3035_ _3035_/B VDD VSS _3036_/A2 _4371_/Q _3035_/A2 VDD VSS gf180mcu_fd_sc_mcu7t5v0__aoi21_1
XFILLER_224_520 VDD VSS VDD VSS gf180mcu_fd_sc_mcu7t5v0__fillcap_4
XFILLER_51_422 VDD VSS VDD VSS gf180mcu_fd_sc_mcu7t5v0__fillcap_64
Xclkbuf_leaf_20_clk_i _4278_/CLK VSS VDD clkload3/I VDD VSS gf180mcu_fd_sc_mcu7t5v0__clkbuf_2
XFILLER_63_282 VDD VSS VDD VSS gf180mcu_fd_sc_mcu7t5v0__fillcap_64
X_3937_ VDD _3937_/Q _3937_/CLK VSS _3937_/D VDD VSS gf180mcu_fd_sc_mcu7t5v0__dffq_1
XFILLER_196_427 VDD VSS VDD VSS gf180mcu_fd_sc_mcu7t5v0__fillcap_4
Xclkbuf_leaf_35_clk_i _4214_/CLK VSS VDD clkload4/I VDD VSS gf180mcu_fd_sc_mcu7t5v0__clkbuf_2
X_3868_ _3868_/D _3868_/Q _4535_/RN VSS _4604_/CLK VDD VDD VSS gf180mcu_fd_sc_mcu7t5v0__dffrnq_1
X_3799_ _3799_/B VDD VSS _3959_/D _3799_/A1 wire16/Z VDD VSS gf180mcu_fd_sc_mcu7t5v0__aoi21_1
X_2819_ _3035_/B VDD VSS _3040_/A2 _2975_/A1 _2331_/Z VDD VSS gf180mcu_fd_sc_mcu7t5v0__nor3_1
XFILLER_118_752 VDD VSS VDD VSS gf180mcu_fd_sc_mcu7t5v0__fillcap_16
XFILLER_191_198 VDD VSS VDD VSS gf180mcu_fd_sc_mcu7t5v0__fillcap_8
XFILLER_160_585 VDD VSS VDD VSS gf180mcu_fd_sc_mcu7t5v0__fillcap_4
XFILLER_101_685 VDD VSS VDD VSS gf180mcu_fd_sc_mcu7t5v0__fillcap_8
XFILLER_246_177 VDD VSS VDD VSS gf180mcu_fd_sc_mcu7t5v0__fillcap_64
XFILLER_234_317 VDD VSS VDD VSS gf180mcu_fd_sc_mcu7t5v0__fillcap_64
XFILLER_36_10 VDD VSS VDD VSS gf180mcu_fd_sc_mcu7t5v0__fillcap_16
XFILLER_261_136 VDD VSS VDD VSS gf180mcu_fd_sc_mcu7t5v0__fillcap_4
XFILLER_55_772 VDD VSS VDD VSS gf180mcu_fd_sc_mcu7t5v0__fillcap_64
XFILLER_70_731 VDD VSS VDD VSS gf180mcu_fd_sc_mcu7t5v0__fillcap_4
XFILLER_230_501 VDD VSS VDD VSS gf180mcu_fd_sc_mcu7t5v0__fillcap_16
XFILLER_153_2 VDD VSS VDD VSS gf180mcu_fd_sc_mcu7t5v0__fillcap_16
XFILLER_202_247 VDD VSS VDD VSS gf180mcu_fd_sc_mcu7t5v0__fillcap_8
XFILLER_230_589 VDD VSS VDD VSS gf180mcu_fd_sc_mcu7t5v0__fillcap_4
XFILLER_11_842 VDD VSS VDD VSS gf180mcu_fd_sc_mcu7t5v0__fillcap_32
XFILLER_168_674 VDD VSS VDD VSS gf180mcu_fd_sc_mcu7t5v0__fillcap_8
XFILLER_168_97 VDD VSS VDD VSS gf180mcu_fd_sc_mcu7t5v0__fillcap_4
XFILLER_143_508 VDD VSS VDD VSS gf180mcu_fd_sc_mcu7t5v0__fillcap_8
XFILLER_123_232 VDD VSS VDD VSS gf180mcu_fd_sc_mcu7t5v0__fillcap_4
XFILLER_111_416 VDD VSS VDD VSS gf180mcu_fd_sc_mcu7t5v0__fillcap_4
XFILLER_77_72 VDD VSS VDD VSS gf180mcu_fd_sc_mcu7t5v0__fillcap_64
XFILLER_238_667 VDD VSS VDD VSS gf180mcu_fd_sc_mcu7t5v0__fillcap_64
XFILLER_226_807 VDD VSS VDD VSS gf180mcu_fd_sc_mcu7t5v0__fillcap_8
XFILLER_77_352 VDD VSS VDD VSS gf180mcu_fd_sc_mcu7t5v0__fillcap_64
XFILLER_253_626 VDD VSS VDD VSS gf180mcu_fd_sc_mcu7t5v0__fillcap_4
XFILLER_265_486 VDD VSS VDD VSS gf180mcu_fd_sc_mcu7t5v0__fillcap_4
XFILLER_92_311 VDD VSS VDD VSS gf180mcu_fd_sc_mcu7t5v0__fillcap_4
XFILLER_33_422 VDD VSS VDD VSS gf180mcu_fd_sc_mcu7t5v0__fillcap_64
XFILLER_206_597 VDD VSS VDD VSS gf180mcu_fd_sc_mcu7t5v0__fillcap_32
XFILLER_45_282 VDD VSS VDD VSS gf180mcu_fd_sc_mcu7t5v0__fillcap_64
XFILLER_221_556 VDD VSS VDD VSS gf180mcu_fd_sc_mcu7t5v0__fillcap_4
XFILLER_60_241 VDD VSS VDD VSS gf180mcu_fd_sc_mcu7t5v0__fillcap_4
X_1983_ VDD VSS _4243_/Q _2695_/B VDD VSS gf180mcu_fd_sc_mcu7t5v0__clkinv_1
X_3722_ _3728_/S VDD VSS _3899_/D _3899_/Q wire178/Z VDD VSS gf180mcu_fd_sc_mcu7t5v0__mux2_2
X_3653_ _3653_/A3 VDD VSS _4486_/D _3681_/A1 _3653_/A2 VDD VSS gf180mcu_fd_sc_mcu7t5v0__nand3_1
X_2604_ VDD VSS _2604_/Z _4207_/Q _2602_/Z VDD VSS gf180mcu_fd_sc_mcu7t5v0__and2_1
XFILLER_146_379 VDD VSS VDD VSS gf180mcu_fd_sc_mcu7t5v0__fillcap_4
X_3584_ _4128_/Q VSS VDD _4112_/Q _4120_/Q wire88/I _4104_/Q wire82/Z _3584_/Z VDD
+ VSS gf180mcu_fd_sc_mcu7t5v0__mux4_1
X_2535_ _2535_/S VDD VSS _4161_/D _4161_/Q _4447_/Q VDD VSS gf180mcu_fd_sc_mcu7t5v0__mux2_2
XFILLER_115_755 VDD VSS VDD VSS gf180mcu_fd_sc_mcu7t5v0__fillcap_8
X_2466_ _2472_/S VDD VSS _4091_/D _2466_/I0 _4091_/Q VDD VSS gf180mcu_fd_sc_mcu7t5v0__mux2_2
X_4205_ _4205_/D _4205_/Q _4212_/RN VSS _4210_/CLK VDD VDD VSS gf180mcu_fd_sc_mcu7t5v0__dffrnq_1
XFILLER_69_842 VDD VSS VDD VSS gf180mcu_fd_sc_mcu7t5v0__fillcap_32
XFILLER_229_656 VDD VSS VDD VSS gf180mcu_fd_sc_mcu7t5v0__fillcap_4
X_4136_ _4136_/D _4136_/Q wire183/Z VSS _4265_/CLK VDD VDD VSS gf180mcu_fd_sc_mcu7t5v0__dffrnq_1
X_2397_ _2403_/S VDD VSS _4035_/D _4035_/Q wire164/Z VDD VSS gf180mcu_fd_sc_mcu7t5v0__mux2_2
XFILLER_228_177 VDD VSS VDD VSS gf180mcu_fd_sc_mcu7t5v0__fillcap_64
XFILLER_216_317 VDD VSS VDD VSS gf180mcu_fd_sc_mcu7t5v0__fillcap_64
XFILLER_243_136 VDD VSS VDD VSS gf180mcu_fd_sc_mcu7t5v0__fillcap_4
Xwire20 wire20/Z VSS VDD wire20/I VDD VSS gf180mcu_fd_sc_mcu7t5v0__clkbuf_8
X_4067_ VDD _4067_/Q _4076_/CLK VSS _4067_/D VDD VSS gf180mcu_fd_sc_mcu7t5v0__dffq_1
X_3018_ _3018_/A3 _2998_/Z _3018_/B2 VDD VSS _4325_/D _3021_/B3 _3018_/A2 VDD VSS
+ gf180mcu_fd_sc_mcu7t5v0__oai32_1
XFILLER_37_772 VDD VSS VDD VSS gf180mcu_fd_sc_mcu7t5v0__fillcap_64
Xwire42 VSS wire42/Z wire42/I VDD VDD VSS gf180mcu_fd_sc_mcu7t5v0__buf_2
Xwire53 VSS wire53/Z wire56/I VDD VDD VSS gf180mcu_fd_sc_mcu7t5v0__buf_3
Xwire64 VDD wire64/I VSS wire64/Z VDD VSS gf180mcu_fd_sc_mcu7t5v0__dlyb_1
XFILLER_64_591 VDD VSS VDD VSS gf180mcu_fd_sc_mcu7t5v0__fillcap_4
XFILLER_52_731 VDD VSS VDD VSS gf180mcu_fd_sc_mcu7t5v0__fillcap_4
Xwire75 VSS wire75/Z wire75/I VDD VDD VSS gf180mcu_fd_sc_mcu7t5v0__buf_2
Xwire97 VSS wire97/Z wire97/I VDD VDD VSS gf180mcu_fd_sc_mcu7t5v0__buf_2
XFILLER_169_438 VDD VSS VDD VSS gf180mcu_fd_sc_mcu7t5v0__fillcap_4
XFILLER_212_567 VDD VSS VDD VSS gf180mcu_fd_sc_mcu7t5v0__fillcap_16
XFILLER_200_729 VDD VSS VDD VSS gf180mcu_fd_sc_mcu7t5v0__fillcap_4
XFILLER_20_661 VDD VSS VDD VSS gf180mcu_fd_sc_mcu7t5v0__fillcap_4
XFILLER_138_78 VDD VSS VDD VSS gf180mcu_fd_sc_mcu7t5v0__fillcap_16
XFILLER_133_541 VDD VSS VDD VSS gf180mcu_fd_sc_mcu7t5v0__fillcap_16
XFILLER_154_55 VDD VSS VDD VSS gf180mcu_fd_sc_mcu7t5v0__fillcap_8
XFILLER_121_747 VDD VSS VDD VSS gf180mcu_fd_sc_mcu7t5v0__fillcap_16
XFILLER_59_352 VDD VSS VDD VSS gf180mcu_fd_sc_mcu7t5v0__fillcap_64
XFILLER_208_818 VDD VSS VDD VSS gf180mcu_fd_sc_mcu7t5v0__fillcap_32
XFILLER_208_807 VDD VSS VDD VSS gf180mcu_fd_sc_mcu7t5v0__fillcap_4
XFILLER_74_311 VDD VSS VDD VSS gf180mcu_fd_sc_mcu7t5v0__fillcap_4
XFILLER_86_171 VDD VSS VDD VSS gf180mcu_fd_sc_mcu7t5v0__fillcap_4
XFILLER_247_486 VDD VSS VDD VSS gf180mcu_fd_sc_mcu7t5v0__fillcap_4
XFILLER_15_422 VDD VSS VDD VSS gf180mcu_fd_sc_mcu7t5v0__fillcap_64
XFILLER_27_282 VDD VSS VDD VSS gf180mcu_fd_sc_mcu7t5v0__fillcap_64
XFILLER_188_725 VDD VSS VDD VSS gf180mcu_fd_sc_mcu7t5v0__fillcap_8
XFILLER_42_241 VDD VSS VDD VSS gf180mcu_fd_sc_mcu7t5v0__fillcap_4
XFILLER_203_578 VDD VSS VDD VSS gf180mcu_fd_sc_mcu7t5v0__fillcap_8
XFILLER_7_632 VDD VSS VDD VSS gf180mcu_fd_sc_mcu7t5v0__fillcap_64
XFILLER_128_379 VDD VSS VDD VSS gf180mcu_fd_sc_mcu7t5v0__fillcap_4
XFILLER_10_171 VDD VSS VDD VSS gf180mcu_fd_sc_mcu7t5v0__fillcap_4
Xmax_length194 _4473_/RN wire193/I VDD VSS VDD VSS gf180mcu_fd_sc_mcu7t5v0__buf_8
X_2320_ VDD VSS _2799_/A3 _4328_/Q _4327_/Q VDD VSS gf180mcu_fd_sc_mcu7t5v0__nor2_1
X_2251_ VDD VSS _2259_/A1 _4570_/Q _4546_/D VDD VSS gf180mcu_fd_sc_mcu7t5v0__xnor2_1
XFILLER_257_206 VDD VSS VDD VSS gf180mcu_fd_sc_mcu7t5v0__fillcap_4
XFILLER_2_381 VDD VSS VDD VSS gf180mcu_fd_sc_mcu7t5v0__fillcap_4
XFILLER_78_661 VDD VSS VDD VSS gf180mcu_fd_sc_mcu7t5v0__fillcap_4
XFILLER_66_801 VDD VSS VDD VSS gf180mcu_fd_sc_mcu7t5v0__fillcap_4
X_2182_ _2182_/B VDD VSS _2203_/A1 _4317_/Q _2193_/A2 VDD VSS gf180mcu_fd_sc_mcu7t5v0__aoi21_1
XFILLER_225_136 VDD VSS VDD VSS gf180mcu_fd_sc_mcu7t5v0__fillcap_4
XFILLER_19_772 VDD VSS VDD VSS gf180mcu_fd_sc_mcu7t5v0__fillcap_64
XFILLER_46_591 VDD VSS VDD VSS gf180mcu_fd_sc_mcu7t5v0__fillcap_4
XFILLER_34_731 VDD VSS VDD VSS gf180mcu_fd_sc_mcu7t5v0__fillcap_4
XFILLER_179_758 VDD VSS VDD VSS gf180mcu_fd_sc_mcu7t5v0__fillcap_4
X_1966_ VDD VSS _4331_/Q _3244_/A2 VDD VSS gf180mcu_fd_sc_mcu7t5v0__clkinv_1
XFILLER_159_460 VDD VSS VDD VSS gf180mcu_fd_sc_mcu7t5v0__fillcap_4
X_3705_ _3706_/S VDD VSS _3888_/D _3888_/Q _3766_/I0 VDD VSS gf180mcu_fd_sc_mcu7t5v0__mux2_2
XFILLER_239_66 VDD VSS VDD VSS gf180mcu_fd_sc_mcu7t5v0__fillcap_4
XFILLER_119_324 VDD VSS VDD VSS gf180mcu_fd_sc_mcu7t5v0__fillcap_16
XFILLER_134_305 VDD VSS VDD VSS gf180mcu_fd_sc_mcu7t5v0__fillcap_8
XFILLER_119_357 VDD VSS VDD VSS gf180mcu_fd_sc_mcu7t5v0__fillcap_8
X_3636_ VDD VSS _3636_/I _4480_/D VDD VSS gf180mcu_fd_sc_mcu7t5v0__clkinv_1
XFILLER_127_390 VDD VSS VDD VSS gf180mcu_fd_sc_mcu7t5v0__fillcap_8
XFILLER_108_37 VDD VSS VDD VSS gf180mcu_fd_sc_mcu7t5v0__fillcap_16
X_3567_ _3567_/A3 VDD VSS _3568_/B wire82/I _3567_/A2 VDD VSS gf180mcu_fd_sc_mcu7t5v0__nand3_1
X_2518_ _2736_/S VDD VSS _4147_/D _4147_/Q wire123/Z VDD VSS gf180mcu_fd_sc_mcu7t5v0__mux2_2
X_3498_ VDD VSS _3501_/A2 _4132_/Q _2039_/Z VDD VSS gf180mcu_fd_sc_mcu7t5v0__nand2_1
X_2449_ VDD VSS _2450_/B _2505_/I0 _2454_/S VDD VSS gf180mcu_fd_sc_mcu7t5v0__nor2_1
XFILLER_56_311 VDD VSS VDD VSS gf180mcu_fd_sc_mcu7t5v0__fillcap_4
XFILLER_68_171 VDD VSS VDD VSS gf180mcu_fd_sc_mcu7t5v0__fillcap_4
XFILLER_229_486 VDD VSS VDD VSS gf180mcu_fd_sc_mcu7t5v0__fillcap_4
XFILLER_217_626 VDD VSS VDD VSS gf180mcu_fd_sc_mcu7t5v0__fillcap_4
X_4119_ VDD _4119_/Q _4128_/CLK VSS _4119_/D VDD VSS gf180mcu_fd_sc_mcu7t5v0__dffq_1
XFILLER_24_241 VDD VSS VDD VSS gf180mcu_fd_sc_mcu7t5v0__fillcap_4
XFILLER_178_780 VDD VSS VDD VSS gf180mcu_fd_sc_mcu7t5v0__fillcap_16
XFILLER_33_66 VDD VSS VDD VSS gf180mcu_fd_sc_mcu7t5v0__fillcap_4
XFILLER_193_772 VDD VSS VDD VSS gf180mcu_fd_sc_mcu7t5v0__fillcap_32
XFILLER_153_625 VDD VSS VDD VSS gf180mcu_fd_sc_mcu7t5v0__fillcap_4
XFILLER_165_10 VDD VSS VDD VSS gf180mcu_fd_sc_mcu7t5v0__fillcap_32
XFILLER_125_338 VDD VSS VDD VSS gf180mcu_fd_sc_mcu7t5v0__fillcap_8
XFILLER_125_316 VDD VSS VDD VSS gf180mcu_fd_sc_mcu7t5v0__fillcap_4
XFILLER_116_2 VDD VSS VDD VSS gf180mcu_fd_sc_mcu7t5v0__fillcap_32
XFILLER_126_839 VDD VSS VDD VSS gf180mcu_fd_sc_mcu7t5v0__fillcap_16
XFILLER_140_308 VDD VSS VDD VSS gf180mcu_fd_sc_mcu7t5v0__fillcap_4
XFILLER_121_500 VDD VSS VDD VSS gf180mcu_fd_sc_mcu7t5v0__fillcap_4
XFILLER_239_206 VDD VSS VDD VSS gf180mcu_fd_sc_mcu7t5v0__fillcap_4
XFILLER_133_382 VDD VSS VDD VSS gf180mcu_fd_sc_mcu7t5v0__fillcap_32
XFILLER_48_801 VDD VSS VDD VSS gf180mcu_fd_sc_mcu7t5v0__fillcap_4
XFILLER_0_852 VDD VSS VDD VSS gf180mcu_fd_sc_mcu7t5v0__fillcap_32
XFILLER_101_290 VDD VSS VDD VSS gf180mcu_fd_sc_mcu7t5v0__fillcap_4
XFILLER_90_612 VDD VSS VDD VSS gf180mcu_fd_sc_mcu7t5v0__fillcap_16
XFILLER_28_591 VDD VSS VDD VSS gf180mcu_fd_sc_mcu7t5v0__fillcap_4
XFILLER_16_731 VDD VSS VDD VSS gf180mcu_fd_sc_mcu7t5v0__fillcap_4
XFILLER_231_640 VDD VSS VDD VSS gf180mcu_fd_sc_mcu7t5v0__fillcap_4
XFILLER_231_651 VDD VSS VDD VSS gf180mcu_fd_sc_mcu7t5v0__fillcap_32
XFILLER_176_717 VDD VSS VDD VSS gf180mcu_fd_sc_mcu7t5v0__fillcap_16
XFILLER_88_6 VDD VSS VDD VSS gf180mcu_fd_sc_mcu7t5v0__fillcap_16
XFILLER_184_794 VDD VSS VDD VSS gf180mcu_fd_sc_mcu7t5v0__fillcap_8
XFILLER_171_422 VDD VSS VDD VSS gf180mcu_fd_sc_mcu7t5v0__fillcap_16
X_4470_ _4470_/D _4470_/Q wire186/Z VSS _4498_/CLK VDD VDD VSS gf180mcu_fd_sc_mcu7t5v0__dffrnq_1
X_3421_ wire53/Z VDD VSS _4464_/D _4422_/Q _4464_/Q VDD VSS gf180mcu_fd_sc_mcu7t5v0__mux2_2
X_3352_ wire21/I VDD VSS _4399_/D _4376_/Q _4399_/Q VDD VSS gf180mcu_fd_sc_mcu7t5v0__mux2_2
X_2303_ VDD VSS _2303_/Z _3008_/B2 _4324_/Q VDD VSS gf180mcu_fd_sc_mcu7t5v0__or2_1
XFILLER_31_2 VDD VSS VDD VSS gf180mcu_fd_sc_mcu7t5v0__fillcap_64
X_3283_ _3278_/Z _4483_/Q VDD VSS _3284_/A2 _4499_/Q _3302_/A2 VDD VSS gf180mcu_fd_sc_mcu7t5v0__aoi22_1
X_2234_ VDD VSS _2234_/I _4505_/D VDD VSS gf180mcu_fd_sc_mcu7t5v0__clkinv_1
XFILLER_38_311 VDD VSS VDD VSS gf180mcu_fd_sc_mcu7t5v0__fillcap_4
X_2165_ VDD VSS _2171_/A3 _4238_/Q _4239_/Q VDD VSS gf180mcu_fd_sc_mcu7t5v0__nor2_1
X_2096_ VDD VSS _4586_/D _4605_/D _2096_/A2 VDD VSS gf180mcu_fd_sc_mcu7t5v0__xnor2_1
XFILLER_0_70 VDD VSS VDD VSS gf180mcu_fd_sc_mcu7t5v0__fillcap_32
XFILLER_179_522 VDD VSS VDD VSS gf180mcu_fd_sc_mcu7t5v0__fillcap_4
XFILLER_80_177 VDD VSS VDD VSS gf180mcu_fd_sc_mcu7t5v0__fillcap_64
XFILLER_194_558 VDD VSS VDD VSS gf180mcu_fd_sc_mcu7t5v0__fillcap_32
X_2998_ VDD VSS _2998_/Z _3019_/A2 _3019_/A3 VDD VSS gf180mcu_fd_sc_mcu7t5v0__and2_1
XFILLER_182_709 VDD VSS VDD VSS gf180mcu_fd_sc_mcu7t5v0__fillcap_8
XFILLER_175_772 VDD VSS VDD VSS gf180mcu_fd_sc_mcu7t5v0__fillcap_4
X_1949_ VDD VSS _4344_/Q _3211_/A1 VDD VSS gf180mcu_fd_sc_mcu7t5v0__clkinv_1
XFILLER_190_720 VDD VSS VDD VSS gf180mcu_fd_sc_mcu7t5v0__fillcap_8
XFILLER_174_282 VDD VSS VDD VSS gf180mcu_fd_sc_mcu7t5v0__fillcap_16
XFILLER_108_839 VDD VSS VDD VSS gf180mcu_fd_sc_mcu7t5v0__fillcap_8
X_3619_ _3619_/B2 _3619_/C VDD VSS _3620_/B _3870_/Q _3619_/A2 _3619_/B1 VDD VSS gf180mcu_fd_sc_mcu7t5v0__aoi221_1
X_4599_ _4599_/D _4599_/Q _4616_/RN VSS _4604_/CLK VDD VDD VSS gf180mcu_fd_sc_mcu7t5v0__dffrnq_1
XFILLER_0_104 VDD VSS VDD VSS gf180mcu_fd_sc_mcu7t5v0__fillcap_32
XFILLER_103_577 VDD VSS VDD VSS gf180mcu_fd_sc_mcu7t5v0__fillcap_8
XFILLER_95_39 VDD VSS VDD VSS gf180mcu_fd_sc_mcu7t5v0__fillcap_8
XFILLER_60_807 VDD VSS VDD VSS gf180mcu_fd_sc_mcu7t5v0__fillcap_64
XFILLER_72_667 VDD VSS VDD VSS gf180mcu_fd_sc_mcu7t5v0__fillcap_64
XFILLER_201_835 VDD VSS VDD VSS gf180mcu_fd_sc_mcu7t5v0__fillcap_4
XFILLER_233_2 VDD VSS VDD VSS gf180mcu_fd_sc_mcu7t5v0__fillcap_64
XFILLER_197_352 VDD VSS VDD VSS gf180mcu_fd_sc_mcu7t5v0__fillcap_8
XFILLER_185_547 VDD VSS VDD VSS gf180mcu_fd_sc_mcu7t5v0__fillcap_8
XFILLER_40_597 VDD VSS VDD VSS gf180mcu_fd_sc_mcu7t5v0__fillcap_64
XFILLER_165_282 VDD VSS VDD VSS gf180mcu_fd_sc_mcu7t5v0__fillcap_4
XFILLER_153_422 VDD VSS VDD VSS gf180mcu_fd_sc_mcu7t5v0__fillcap_4
XFILLER_180_241 VDD VSS VDD VSS gf180mcu_fd_sc_mcu7t5v0__fillcap_4
XFILLER_126_647 VDD VSS VDD VSS gf180mcu_fd_sc_mcu7t5v0__fillcap_16
XFILLER_141_617 VDD VSS VDD VSS gf180mcu_fd_sc_mcu7t5v0__fillcap_8
XFILLER_107_872 VDD VSS VDD VSS gf180mcu_fd_sc_mcu7t5v0__fillcap_16
XFILLER_106_371 VDD VSS VDD VSS gf180mcu_fd_sc_mcu7t5v0__fillcap_4
XFILLER_121_352 VDD VSS VDD VSS gf180mcu_fd_sc_mcu7t5v0__fillcap_4
XFILLER_0_682 VDD VSS VDD VSS gf180mcu_fd_sc_mcu7t5v0__fillcap_32
XFILLER_95_759 VDD VSS VDD VSS gf180mcu_fd_sc_mcu7t5v0__fillcap_8
XFILLER_85_72 VDD VSS VDD VSS gf180mcu_fd_sc_mcu7t5v0__fillcap_64
XFILLER_236_798 VDD VSS VDD VSS gf180mcu_fd_sc_mcu7t5v0__fillcap_4
XFILLER_251_702 VDD VSS VDD VSS gf180mcu_fd_sc_mcu7t5v0__fillcap_64
XFILLER_263_562 VDD VSS VDD VSS gf180mcu_fd_sc_mcu7t5v0__fillcap_64
X_3970_ VDD _3970_/Q _3989_/CLK VSS _3970_/D VDD VSS gf180mcu_fd_sc_mcu7t5v0__dffq_1
X_2921_ VDD _2921_/B _2919_/S _4312_/D _2932_/B2 VSS VDD VSS gf180mcu_fd_sc_mcu7t5v0__oai21_1
XFILLER_62_177 VDD VSS VDD VSS gf180mcu_fd_sc_mcu7t5v0__fillcap_64
XFILLER_50_317 VDD VSS VDD VSS gf180mcu_fd_sc_mcu7t5v0__fillcap_64
XFILLER_231_492 VDD VSS VDD VSS gf180mcu_fd_sc_mcu7t5v0__fillcap_32
X_2852_ wire71/I VDD VSS _2853_/B1 wire97/I _2843_/Z VDD VSS gf180mcu_fd_sc_mcu7t5v0__aoi21_1
X_2783_ VDD VSS _3271_/C _3043_/A1 _2783_/A2 VDD VSS gf180mcu_fd_sc_mcu7t5v0__and2_1
XFILLER_79_2 VDD VSS VDD VSS gf180mcu_fd_sc_mcu7t5v0__fillcap_64
X_4522_ VSS _4522_/CLK VDD _4522_/D _4523_/D _4512_/RN VDD VSS gf180mcu_fd_sc_mcu7t5v0__dffsnq_1
XFILLER_184_591 VDD VSS VDD VSS gf180mcu_fd_sc_mcu7t5v0__fillcap_4
XFILLER_172_742 VDD VSS VDD VSS gf180mcu_fd_sc_mcu7t5v0__fillcap_16
X_4453_ _4453_/D _4453_/Q wire210/Z VSS _4462_/CLK VDD VDD VSS gf180mcu_fd_sc_mcu7t5v0__dffrnq_1
X_3404_ wire56/Z VDD VSS _4447_/D _4405_/Q _4447_/Q VDD VSS gf180mcu_fd_sc_mcu7t5v0__mux2_2
Xhold259 _3851_/D VSS _3850_/Q VDD VDD VSS gf180mcu_fd_sc_mcu7t5v0__dlyc_1
XFILLER_131_116 VDD VSS VDD VSS gf180mcu_fd_sc_mcu7t5v0__fillcap_4
XFILLER_98_520 VDD VSS VDD VSS gf180mcu_fd_sc_mcu7t5v0__fillcap_4
X_4384_ _4384_/D _4384_/Q wire196/Z VSS _4407_/CLK VDD VDD VSS gf180mcu_fd_sc_mcu7t5v0__dffrnq_1
X_3335_ VDD VSS _3335_/I _4385_/D VDD VSS gf180mcu_fd_sc_mcu7t5v0__clkinv_1
X_3266_ _3268_/B1 _4368_/Q VDD VSS _3267_/I _4361_/Q _4526_/D VDD VSS gf180mcu_fd_sc_mcu7t5v0__aoi22_1
XFILLER_140_683 VDD VSS VDD VSS gf180mcu_fd_sc_mcu7t5v0__fillcap_8
XFILLER_98_597 VDD VSS VDD VSS gf180mcu_fd_sc_mcu7t5v0__fillcap_4
XFILLER_86_737 VDD VSS VDD VSS gf180mcu_fd_sc_mcu7t5v0__fillcap_64
XFILLER_227_721 VDD VSS VDD VSS gf180mcu_fd_sc_mcu7t5v0__fillcap_32
X_2217_ _2217_/A3 VDD VSS _4501_/D _2210_/Z _2214_/Z VDD VSS gf180mcu_fd_sc_mcu7t5v0__nand3_1
X_3197_ _3213_/B VDD VSS _3198_/A2 _3271_/C _3271_/B VDD VSS gf180mcu_fd_sc_mcu7t5v0__aoi21_1
X_2148_ _4527_/Q VDD VSS _2149_/I _4139_/Q _2148_/A2 VDD VSS gf180mcu_fd_sc_mcu7t5v0__aoi21_1
X_2079_ VDD VSS _4554_/D wire93/I _2074_/Z VDD VSS gf180mcu_fd_sc_mcu7t5v0__xor2_1
XFILLER_241_212 VDD VSS VDD VSS gf180mcu_fd_sc_mcu7t5v0__fillcap_64
XFILLER_42_807 VDD VSS VDD VSS gf180mcu_fd_sc_mcu7t5v0__fillcap_64
XFILLER_54_667 VDD VSS VDD VSS gf180mcu_fd_sc_mcu7t5v0__fillcap_64
XFILLER_81_486 VDD VSS VDD VSS gf180mcu_fd_sc_mcu7t5v0__fillcap_4
XFILLER_179_352 VDD VSS VDD VSS gf180mcu_fd_sc_mcu7t5v0__fillcap_16
XFILLER_194_311 VDD VSS VDD VSS gf180mcu_fd_sc_mcu7t5v0__fillcap_4
XFILLER_22_597 VDD VSS VDD VSS gf180mcu_fd_sc_mcu7t5v0__fillcap_64
XFILLER_10_737 VDD VSS VDD VSS gf180mcu_fd_sc_mcu7t5v0__fillcap_64
XFILLER_135_455 VDD VSS VDD VSS gf180mcu_fd_sc_mcu7t5v0__fillcap_32
XFILLER_163_764 VDD VSS VDD VSS gf180mcu_fd_sc_mcu7t5v0__fillcap_4
XFILLER_147_282 VDD VSS VDD VSS gf180mcu_fd_sc_mcu7t5v0__fillcap_16
XFILLER_135_433 VDD VSS VDD VSS gf180mcu_fd_sc_mcu7t5v0__fillcap_8
XFILLER_150_403 VDD VSS VDD VSS gf180mcu_fd_sc_mcu7t5v0__fillcap_4
XFILLER_130_171 VDD VSS VDD VSS gf180mcu_fd_sc_mcu7t5v0__fillcap_4
XFILLER_76_247 VDD VSS VDD VSS gf180mcu_fd_sc_mcu7t5v0__fillcap_64
XFILLER_183_2 VDD VSS VDD VSS gf180mcu_fd_sc_mcu7t5v0__fillcap_64
XFILLER_91_206 VDD VSS VDD VSS gf180mcu_fd_sc_mcu7t5v0__fillcap_4
XFILLER_245_562 VDD VSS VDD VSS gf180mcu_fd_sc_mcu7t5v0__fillcap_64
XFILLER_260_521 VDD VSS VDD VSS gf180mcu_fd_sc_mcu7t5v0__fillcap_4
XFILLER_44_177 VDD VSS VDD VSS gf180mcu_fd_sc_mcu7t5v0__fillcap_64
XFILLER_32_317 VDD VSS VDD VSS gf180mcu_fd_sc_mcu7t5v0__fillcap_64
XFILLER_186_823 VDD VSS VDD VSS gf180mcu_fd_sc_mcu7t5v0__fillcap_8
XFILLER_111_92 VDD VSS VDD VSS gf180mcu_fd_sc_mcu7t5v0__fillcap_32
XFILLER_197_160 VDD VSS VDD VSS gf180mcu_fd_sc_mcu7t5v0__fillcap_8
XFILLER_200_131 VDD VSS VDD VSS gf180mcu_fd_sc_mcu7t5v0__fillcap_4
XFILLER_185_333 VDD VSS VDD VSS gf180mcu_fd_sc_mcu7t5v0__fillcap_16
XFILLER_71_63 VDD VSS VDD VSS gf180mcu_fd_sc_mcu7t5v0__fillcap_4
XFILLER_139_772 VDD VSS VDD VSS gf180mcu_fd_sc_mcu7t5v0__fillcap_32
XFILLER_166_591 VDD VSS VDD VSS gf180mcu_fd_sc_mcu7t5v0__fillcap_4
XFILLER_99_328 VDD VSS VDD VSS gf180mcu_fd_sc_mcu7t5v0__fillcap_16
XFILLER_206_37 VDD VSS VDD VSS gf180mcu_fd_sc_mcu7t5v0__fillcap_64
XFILLER_122_661 VDD VSS VDD VSS gf180mcu_fd_sc_mcu7t5v0__fillcap_4
X_3120_ _3997_/Q VSS VDD _3981_/Q _3989_/Q _3124_/A1 _3973_/Q _3143_/C _3120_/Z VDD
+ VSS gf180mcu_fd_sc_mcu7t5v0__mux4_1
XFILLER_267_142 VDD VSS VDD VSS gf180mcu_fd_sc_mcu7t5v0__fillcap_64
XFILLER_110_823 VDD VSS VDD VSS gf180mcu_fd_sc_mcu7t5v0__fillcap_8
XFILLER_68_737 VDD VSS VDD VSS gf180mcu_fd_sc_mcu7t5v0__fillcap_64
XFILLER_95_556 VDD VSS VDD VSS gf180mcu_fd_sc_mcu7t5v0__fillcap_4
X_3051_ VDD VSS _3055_/A1 _3122_/S _3882_/Q VDD VSS gf180mcu_fd_sc_mcu7t5v0__nor2_1
XFILLER_264_871 VDD VSS VDD VSS gf180mcu_fd_sc_mcu7t5v0__fillcap_4
X_2002_ VDD VSS _4473_/Q _3547_/A1 VDD VSS gf180mcu_fd_sc_mcu7t5v0__clkinv_1
XFILLER_223_212 VDD VSS VDD VSS gf180mcu_fd_sc_mcu7t5v0__fillcap_64
XFILLER_24_807 VDD VSS VDD VSS gf180mcu_fd_sc_mcu7t5v0__fillcap_64
XFILLER_36_667 VDD VSS VDD VSS gf180mcu_fd_sc_mcu7t5v0__fillcap_64
XFILLER_51_626 VDD VSS VDD VSS gf180mcu_fd_sc_mcu7t5v0__fillcap_4
XFILLER_63_486 VDD VSS VDD VSS gf180mcu_fd_sc_mcu7t5v0__fillcap_4
X_3953_ VDD _3953_/Q _3967_/CLK VSS _3953_/D VDD VSS gf180mcu_fd_sc_mcu7t5v0__dffq_1
X_3884_ VDD _3884_/Q _3969_/CLK VSS _3884_/D VDD VSS gf180mcu_fd_sc_mcu7t5v0__dffq_1
XFILLER_188_171 VDD VSS VDD VSS gf180mcu_fd_sc_mcu7t5v0__fillcap_4
X_2904_ VDD VSS _2949_/A1 _2883_/C _3024_/A3 VDD VSS gf180mcu_fd_sc_mcu7t5v0__nor2_1
X_2835_ VDD VSS _2836_/B _3036_/B _2835_/A2 VDD VSS gf180mcu_fd_sc_mcu7t5v0__nand2_1
XFILLER_191_314 VDD VSS VDD VSS gf180mcu_fd_sc_mcu7t5v0__fillcap_16
XFILLER_145_753 VDD VSS VDD VSS gf180mcu_fd_sc_mcu7t5v0__fillcap_4
XFILLER_247_66 VDD VSS VDD VSS gf180mcu_fd_sc_mcu7t5v0__fillcap_4
XFILLER_117_422 VDD VSS VDD VSS gf180mcu_fd_sc_mcu7t5v0__fillcap_16
X_2766_ _4435_/Q _3619_/A2 VDD VSS _2767_/A2 _3859_/Q _3426_/A3 VDD VSS gf180mcu_fd_sc_mcu7t5v0__nand4_1
XFILLER_129_282 VDD VSS VDD VSS gf180mcu_fd_sc_mcu7t5v0__fillcap_32
X_2697_ VDD VSS _4243_/D _2699_/A2 _2697_/A2 VDD VSS gf180mcu_fd_sc_mcu7t5v0__nor2_1
X_4505_ VSS _4508_/CLK VDD _4505_/D _4505_/Q wire206/Z VDD VSS gf180mcu_fd_sc_mcu7t5v0__dffsnq_1
X_4436_ _4436_/D _4436_/Q wire193/I VSS _4436_/CLK VDD VDD VSS gf180mcu_fd_sc_mcu7t5v0__dffrnq_1
X_4367_ _4367_/D _4367_/Q wire184/Z VSS _4526_/CLK VDD VDD VSS gf180mcu_fd_sc_mcu7t5v0__dffrnq_1
XFILLER_259_632 VDD VSS VDD VSS gf180mcu_fd_sc_mcu7t5v0__fillcap_64
XFILLER_116_37 VDD VSS VDD VSS gf180mcu_fd_sc_mcu7t5v0__fillcap_16
X_3318_ VDD _3318_/B _3852_/Q _3319_/A2 _3318_/A1 VSS VDD VSS gf180mcu_fd_sc_mcu7t5v0__oai21_1
XFILLER_100_333 VDD VSS VDD VSS gf180mcu_fd_sc_mcu7t5v0__fillcap_4
X_4298_ _4298_/D _4298_/Q _4473_/RN VSS _4469_/CLK VDD VDD VSS gf180mcu_fd_sc_mcu7t5v0__dffrnq_1
XFILLER_58_247 VDD VSS VDD VSS gf180mcu_fd_sc_mcu7t5v0__fillcap_64
X_3249_ wire23/Z VDD VSS _4357_/D _4332_/Q _4357_/Q VDD VSS gf180mcu_fd_sc_mcu7t5v0__mux2_2
XFILLER_73_206 VDD VSS VDD VSS gf180mcu_fd_sc_mcu7t5v0__fillcap_4
XFILLER_215_702 VDD VSS VDD VSS gf180mcu_fd_sc_mcu7t5v0__fillcap_64
XFILLER_227_562 VDD VSS VDD VSS gf180mcu_fd_sc_mcu7t5v0__fillcap_16
XFILLER_132_58 VDD VSS VDD VSS gf180mcu_fd_sc_mcu7t5v0__fillcap_32
XFILLER_242_521 VDD VSS VDD VSS gf180mcu_fd_sc_mcu7t5v0__fillcap_4
XFILLER_254_381 VDD VSS VDD VSS gf180mcu_fd_sc_mcu7t5v0__fillcap_4
XFILLER_26_177 VDD VSS VDD VSS gf180mcu_fd_sc_mcu7t5v0__fillcap_64
XFILLER_14_317 VDD VSS VDD VSS gf180mcu_fd_sc_mcu7t5v0__fillcap_64
XFILLER_199_469 VDD VSS VDD VSS gf180mcu_fd_sc_mcu7t5v0__fillcap_16
XFILLER_168_801 VDD VSS VDD VSS gf180mcu_fd_sc_mcu7t5v0__fillcap_4
XFILLER_41_136 VDD VSS VDD VSS gf180mcu_fd_sc_mcu7t5v0__fillcap_4
XFILLER_168_823 VDD VSS VDD VSS gf180mcu_fd_sc_mcu7t5v0__fillcap_4
XFILLER_6_527 VDD VSS VDD VSS gf180mcu_fd_sc_mcu7t5v0__fillcap_64
XFILLER_41_66 VDD VSS VDD VSS gf180mcu_fd_sc_mcu7t5v0__fillcap_4
XFILLER_157_66 VDD VSS VDD VSS gf180mcu_fd_sc_mcu7t5v0__fillcap_4
XFILLER_9_2 VDD VSS VDD VSS gf180mcu_fd_sc_mcu7t5v0__fillcap_64
XFILLER_111_609 VDD VSS VDD VSS gf180mcu_fd_sc_mcu7t5v0__fillcap_4
XFILLER_249_142 VDD VSS VDD VSS gf180mcu_fd_sc_mcu7t5v0__fillcap_64
XFILLER_173_87 VDD VSS VDD VSS gf180mcu_fd_sc_mcu7t5v0__fillcap_8
XFILLER_1_276 VDD VSS VDD VSS gf180mcu_fd_sc_mcu7t5v0__fillcap_4
XFILLER_264_101 VDD VSS VDD VSS gf180mcu_fd_sc_mcu7t5v0__fillcap_4
XFILLER_77_556 VDD VSS VDD VSS gf180mcu_fd_sc_mcu7t5v0__fillcap_4
XFILLER_246_871 VDD VSS VDD VSS gf180mcu_fd_sc_mcu7t5v0__fillcap_4
XFILLER_205_212 VDD VSS VDD VSS gf180mcu_fd_sc_mcu7t5v0__fillcap_64
XFILLER_18_667 VDD VSS VDD VSS gf180mcu_fd_sc_mcu7t5v0__fillcap_64
XFILLER_261_874 VDD VSS VDD VSS gf180mcu_fd_sc_mcu7t5v0__fillcap_16
Xclkbuf_leaf_1_clk_i clkload8/I VSS VDD clkload0/I VDD VSS gf180mcu_fd_sc_mcu7t5v0__clkbuf_2
XFILLER_33_626 VDD VSS VDD VSS gf180mcu_fd_sc_mcu7t5v0__fillcap_4
XFILLER_45_486 VDD VSS VDD VSS gf180mcu_fd_sc_mcu7t5v0__fillcap_4
XFILLER_177_119 VDD VSS VDD VSS gf180mcu_fd_sc_mcu7t5v0__fillcap_16
XFILLER_158_311 VDD VSS VDD VSS gf180mcu_fd_sc_mcu7t5v0__fillcap_4
X_2620_ _2620_/B _4212_/Q VDD VSS _2621_/B _2637_/A2 _2621_/A3 VDD VSS gf180mcu_fd_sc_mcu7t5v0__oai211_1
XFILLER_114_403 VDD VSS VDD VSS gf180mcu_fd_sc_mcu7t5v0__fillcap_4
X_2551_ wire29/I VDD VSS _4174_/D _4448_/Q _4174_/Q VDD VSS gf180mcu_fd_sc_mcu7t5v0__mux2_2
X_2482_ _2482_/S VDD VSS _4105_/D _4105_/Q wire150/Z VDD VSS gf180mcu_fd_sc_mcu7t5v0__mux2_2
X_4221_ _4221_/D _4221_/Q _4534_/RN VSS _4510_/CLK VDD VDD VSS gf180mcu_fd_sc_mcu7t5v0__dffrnq_1
XFILLER_99_158 VDD VSS VDD VSS gf180mcu_fd_sc_mcu7t5v0__fillcap_4
X_4152_ _4152_/D _4152_/Q wire184/Z VSS _4198_/CLK VDD VDD VSS gf180mcu_fd_sc_mcu7t5v0__dffrnq_1
X_3103_ _3103_/B wire71/Z VDD VSS _3104_/A3 wire97/Z _3102_/Z VDD VSS gf180mcu_fd_sc_mcu7t5v0__aoi211_1
X_4083_ VDD _4083_/Q _4580_/CLK VSS _4083_/D VDD VSS gf180mcu_fd_sc_mcu7t5v0__dffq_1
XFILLER_55_206 VDD VSS VDD VSS gf180mcu_fd_sc_mcu7t5v0__fillcap_4
XFILLER_209_562 VDD VSS VDD VSS gf180mcu_fd_sc_mcu7t5v0__fillcap_8
X_3034_ VDD _3034_/B _3038_/B _4328_/D _3226_/A1 VSS VDD VSS gf180mcu_fd_sc_mcu7t5v0__oai21_1
XFILLER_236_381 VDD VSS VDD VSS gf180mcu_fd_sc_mcu7t5v0__fillcap_4
XFILLER_252_885 VDD VSS VDD VSS gf180mcu_fd_sc_mcu7t5v0__fillcap_4
XFILLER_23_136 VDD VSS VDD VSS gf180mcu_fd_sc_mcu7t5v0__fillcap_4
X_3936_ VDD _3936_/Q _3936_/CLK VSS _3936_/D VDD VSS gf180mcu_fd_sc_mcu7t5v0__dffq_1
X_3867_ _3867_/D _3867_/Q _4535_/RN VSS _4605_/CLK VDD VDD VSS gf180mcu_fd_sc_mcu7t5v0__dffrnq_1
X_3798_ VDD VSS _3799_/B _4294_/Q wire16/Z VDD VSS gf180mcu_fd_sc_mcu7t5v0__nor2_1
XFILLER_180_807 VDD VSS VDD VSS gf180mcu_fd_sc_mcu7t5v0__fillcap_8
X_2818_ _2818_/A3 _2818_/A4 VDD VSS _2827_/A1 _2818_/A1 _2818_/A2 VDD VSS gf180mcu_fd_sc_mcu7t5v0__nor4_1
XFILLER_192_667 VDD VSS VDD VSS gf180mcu_fd_sc_mcu7t5v0__fillcap_64
XFILLER_191_166 VDD VSS VDD VSS gf180mcu_fd_sc_mcu7t5v0__fillcap_32
X_2749_ _2754_/S VDD VSS _4283_/D _4283_/Q wire112/Z VDD VSS gf180mcu_fd_sc_mcu7t5v0__mux2_2
XFILLER_145_594 VDD VSS VDD VSS gf180mcu_fd_sc_mcu7t5v0__fillcap_16
XFILLER_160_597 VDD VSS VDD VSS gf180mcu_fd_sc_mcu7t5v0__fillcap_8
X_4419_ _4419_/D _4419_/Q wire210/Z VSS _4485_/CLK VDD VDD VSS gf180mcu_fd_sc_mcu7t5v0__dffrnq_1
XFILLER_246_101 VDD VSS VDD VSS gf180mcu_fd_sc_mcu7t5v0__fillcap_4
XFILLER_59_556 VDD VSS VDD VSS gf180mcu_fd_sc_mcu7t5v0__fillcap_4
XFILLER_99_692 VDD VSS VDD VSS gf180mcu_fd_sc_mcu7t5v0__fillcap_8
XFILLER_228_871 VDD VSS VDD VSS gf180mcu_fd_sc_mcu7t5v0__fillcap_4
XFILLER_243_874 VDD VSS VDD VSS gf180mcu_fd_sc_mcu7t5v0__fillcap_16
XFILLER_27_486 VDD VSS VDD VSS gf180mcu_fd_sc_mcu7t5v0__fillcap_4
XFILLER_15_626 VDD VSS VDD VSS gf180mcu_fd_sc_mcu7t5v0__fillcap_4
XFILLER_202_237 VDD VSS VDD VSS gf180mcu_fd_sc_mcu7t5v0__fillcap_8
XFILLER_146_2 VDD VSS VDD VSS gf180mcu_fd_sc_mcu7t5v0__fillcap_16
XFILLER_168_653 VDD VSS VDD VSS gf180mcu_fd_sc_mcu7t5v0__fillcap_4
XFILLER_195_483 VDD VSS VDD VSS gf180mcu_fd_sc_mcu7t5v0__fillcap_4
XFILLER_128_506 VDD VSS VDD VSS gf180mcu_fd_sc_mcu7t5v0__fillcap_8
XFILLER_155_336 VDD VSS VDD VSS gf180mcu_fd_sc_mcu7t5v0__fillcap_8
XFILLER_7_836 VDD VSS VDD VSS gf180mcu_fd_sc_mcu7t5v0__fillcap_4
XFILLER_108_241 VDD VSS VDD VSS gf180mcu_fd_sc_mcu7t5v0__fillcap_4
XFILLER_170_317 VDD VSS VDD VSS gf180mcu_fd_sc_mcu7t5v0__fillcap_8
XFILLER_111_406 VDD VSS VDD VSS gf180mcu_fd_sc_mcu7t5v0__fillcap_4
XFILLER_37_206 VDD VSS VDD VSS gf180mcu_fd_sc_mcu7t5v0__fillcap_4
XFILLER_206_510 VDD VSS VDD VSS gf180mcu_fd_sc_mcu7t5v0__fillcap_8
XFILLER_218_381 VDD VSS VDD VSS gf180mcu_fd_sc_mcu7t5v0__fillcap_4
XFILLER_93_72 VDD VSS VDD VSS gf180mcu_fd_sc_mcu7t5v0__fillcap_64
XFILLER_234_885 VDD VSS VDD VSS gf180mcu_fd_sc_mcu7t5v0__fillcap_4
X_1982_ VDD VSS _4383_/Q _3336_/A1 VDD VSS gf180mcu_fd_sc_mcu7t5v0__clkinv_1
X_3721_ _3728_/S VDD VSS _3898_/D _3898_/Q _4289_/Q VDD VSS gf180mcu_fd_sc_mcu7t5v0__mux2_2
XFILLER_159_675 VDD VSS VDD VSS gf180mcu_fd_sc_mcu7t5v0__fillcap_16
XFILLER_201_292 VDD VSS VDD VSS gf180mcu_fd_sc_mcu7t5v0__fillcap_32
X_3652_ VDD VSS _3653_/A3 _4486_/Q _3682_/A2 VDD VSS gf180mcu_fd_sc_mcu7t5v0__nand2_1
XFILLER_162_807 VDD VSS VDD VSS gf180mcu_fd_sc_mcu7t5v0__fillcap_16
X_2603_ _4207_/Q VDD VSS _2606_/B _2586_/Z _2602_/Z VDD VSS gf180mcu_fd_sc_mcu7t5v0__aoi21_1
X_3583_ _3583_/A3 VDD VSS _3592_/A2 wire78/Z _3583_/A2 VDD VSS gf180mcu_fd_sc_mcu7t5v0__nand3_1
XFILLER_61_2 VDD VSS VDD VSS gf180mcu_fd_sc_mcu7t5v0__fillcap_64
X_2534_ _2536_/S VDD VSS _4160_/D _4160_/Q _4446_/Q VDD VSS gf180mcu_fd_sc_mcu7t5v0__mux2_2
XFILLER_161_339 VDD VSS VDD VSS gf180mcu_fd_sc_mcu7t5v0__fillcap_8
XFILLER_170_851 VDD VSS VDD VSS gf180mcu_fd_sc_mcu7t5v0__fillcap_16
X_2465_ _2472_/S VDD VSS _4090_/D wire168/I _4090_/Q VDD VSS gf180mcu_fd_sc_mcu7t5v0__mux2_2
X_4204_ _4204_/D _4204_/Q _4212_/RN VSS _4210_/CLK VDD VDD VSS gf180mcu_fd_sc_mcu7t5v0__dffrnq_1
X_2396_ _2403_/S VDD VSS _4034_/D _4034_/Q wire167/Z VDD VSS gf180mcu_fd_sc_mcu7t5v0__mux2_2
X_4135_ _4135_/D _4135_/Q wire183/Z VSS _4265_/CLK VDD VDD VSS gf180mcu_fd_sc_mcu7t5v0__dffrnq_1
XFILLER_228_101 VDD VSS VDD VSS gf180mcu_fd_sc_mcu7t5v0__fillcap_4
X_4066_ VDD _4066_/Q _4473_/CLK VSS _4066_/D VDD VSS gf180mcu_fd_sc_mcu7t5v0__dffq_1
X_3017_ _3017_/B1 _4325_/Q VDD VSS _3018_/A3 _3024_/A3 _3017_/A2 VDD VSS gf180mcu_fd_sc_mcu7t5v0__aoi22_1
Xwire21 wire21/Z VSS VDD wire21/I VDD VSS gf180mcu_fd_sc_mcu7t5v0__clkbuf_8
XFILLER_225_874 VDD VSS VDD VSS gf180mcu_fd_sc_mcu7t5v0__fillcap_16
Xwire65 VDD wire65/I VSS wire65/Z VDD VSS gf180mcu_fd_sc_mcu7t5v0__dlyb_1
Xwire76 VSS wire76/Z wire77/Z VDD VDD VSS gf180mcu_fd_sc_mcu7t5v0__clkbuf_1
XFILLER_240_877 VDD VSS VDD VSS gf180mcu_fd_sc_mcu7t5v0__fillcap_8
XFILLER_196_247 VDD VSS VDD VSS gf180mcu_fd_sc_mcu7t5v0__fillcap_16
X_3919_ VDD _3919_/Q _3936_/CLK VSS _3919_/D VDD VSS gf180mcu_fd_sc_mcu7t5v0__dffq_1
XFILLER_165_623 VDD VSS VDD VSS gf180mcu_fd_sc_mcu7t5v0__fillcap_4
XFILLER_164_177 VDD VSS VDD VSS gf180mcu_fd_sc_mcu7t5v0__fillcap_16
XFILLER_152_317 VDD VSS VDD VSS gf180mcu_fd_sc_mcu7t5v0__fillcap_8
XFILLER_161_884 VDD VSS VDD VSS gf180mcu_fd_sc_mcu7t5v0__fillcap_4
XFILLER_121_715 VDD VSS VDD VSS gf180mcu_fd_sc_mcu7t5v0__fillcap_32
XFILLER_120_247 VDD VSS VDD VSS gf180mcu_fd_sc_mcu7t5v0__fillcap_8
XFILLER_19_206 VDD VSS VDD VSS gf180mcu_fd_sc_mcu7t5v0__fillcap_4
XFILLER_262_457 VDD VSS VDD VSS gf180mcu_fd_sc_mcu7t5v0__fillcap_64
XFILLER_263_2 VDD VSS VDD VSS gf180mcu_fd_sc_mcu7t5v0__fillcap_64
XFILLER_216_885 VDD VSS VDD VSS gf180mcu_fd_sc_mcu7t5v0__fillcap_4
Xclkbuf_leaf_81_clk_i _4473_/CLK VSS VDD clkbuf_3_2__f_clk_i/Z VDD VSS gf180mcu_fd_sc_mcu7t5v0__clkbuf_2
XFILLER_230_387 VDD VSS VDD VSS gf180mcu_fd_sc_mcu7t5v0__fillcap_64
XFILLER_8_37 VDD VSS VDD VSS gf180mcu_fd_sc_mcu7t5v0__fillcap_64
XFILLER_156_645 VDD VSS VDD VSS gf180mcu_fd_sc_mcu7t5v0__fillcap_8
XFILLER_196_792 VDD VSS VDD VSS gf180mcu_fd_sc_mcu7t5v0__fillcap_4
Xclkbuf_leaf_96_clk_i _4402_/CLK VSS VDD clkload0/I VDD VSS gf180mcu_fd_sc_mcu7t5v0__clkbuf_2
XFILLER_156_667 VDD VSS VDD VSS gf180mcu_fd_sc_mcu7t5v0__fillcap_8
Xmax_length151 VSS wire150/I _4313_/Q VDD VDD VSS gf180mcu_fd_sc_mcu7t5v0__clkbuf_1
XFILLER_144_807 VDD VSS VDD VSS gf180mcu_fd_sc_mcu7t5v0__fillcap_16
Xmax_length173 VSS _3765_/I0 _4294_/Q VDD VDD VSS gf180mcu_fd_sc_mcu7t5v0__buf_2
XFILLER_171_626 VDD VSS VDD VSS gf180mcu_fd_sc_mcu7t5v0__fillcap_4
XFILLER_109_594 VDD VSS VDD VSS gf180mcu_fd_sc_mcu7t5v0__fillcap_8
Xmax_length162 VSS _2467_/I0 wire163/Z VDD VDD VSS gf180mcu_fd_sc_mcu7t5v0__buf_2
Xmax_length195 wire193/I wire196/Z VDD VSS VDD VSS gf180mcu_fd_sc_mcu7t5v0__buf_8
XFILLER_124_542 VDD VSS VDD VSS gf180mcu_fd_sc_mcu7t5v0__fillcap_16
X_2250_ _2250_/A3 VDD VSS _4566_/D _2244_/Z _2245_/Z VDD VSS gf180mcu_fd_sc_mcu7t5v0__nor3_1
XFILLER_124_597 VDD VSS VDD VSS gf180mcu_fd_sc_mcu7t5v0__fillcap_16
XFILLER_112_737 VDD VSS VDD VSS gf180mcu_fd_sc_mcu7t5v0__fillcap_8
XFILLER_214_37 VDD VSS VDD VSS gf180mcu_fd_sc_mcu7t5v0__fillcap_64
X_2181_ VDD VSS _2193_/A2 _2181_/A1 _2192_/B VDD VSS gf180mcu_fd_sc_mcu7t5v0__nor2_1
Xclkbuf_leaf_34_clk_i _4210_/CLK VSS VDD clkload4/I VDD VSS gf180mcu_fd_sc_mcu7t5v0__clkbuf_2
XFILLER_93_632 VDD VSS VDD VSS gf180mcu_fd_sc_mcu7t5v0__fillcap_16
XFILLER_207_874 VDD VSS VDD VSS gf180mcu_fd_sc_mcu7t5v0__fillcap_16
XFILLER_240_107 VDD VSS VDD VSS gf180mcu_fd_sc_mcu7t5v0__fillcap_64
Xclkbuf_4_2_0_host_clk_i _3969_/CLK VSS VDD clkbuf_0_host_clk_i/Z VDD VSS gf180mcu_fd_sc_mcu7t5v0__clkbuf_2
Xclkbuf_leaf_49_clk_i _4562_/CLK VSS VDD clkload5/I VDD VSS gf180mcu_fd_sc_mcu7t5v0__clkbuf_2
XFILLER_61_562 VDD VSS VDD VSS gf180mcu_fd_sc_mcu7t5v0__fillcap_64
XFILLER_222_877 VDD VSS VDD VSS gf180mcu_fd_sc_mcu7t5v0__fillcap_8
XFILLER_178_247 VDD VSS VDD VSS gf180mcu_fd_sc_mcu7t5v0__fillcap_4
XFILLER_194_729 VDD VSS VDD VSS gf180mcu_fd_sc_mcu7t5v0__fillcap_4
X_1965_ VDD VSS _4348_/Q _3064_/A1 VDD VSS gf180mcu_fd_sc_mcu7t5v0__clkinv_1
X_3704_ _3706_/S VDD VSS _3887_/D _3887_/Q _3765_/I0 VDD VSS gf180mcu_fd_sc_mcu7t5v0__mux2_2
XFILLER_202_590 VDD VSS VDD VSS gf180mcu_fd_sc_mcu7t5v0__fillcap_4
XFILLER_186_280 VDD VSS VDD VSS gf180mcu_fd_sc_mcu7t5v0__fillcap_4
XFILLER_146_177 VDD VSS VDD VSS gf180mcu_fd_sc_mcu7t5v0__fillcap_8
X_3635_ _3644_/A2 _3635_/B2 VDD VSS _3636_/I _4480_/Q _3479_/C VDD VSS gf180mcu_fd_sc_mcu7t5v0__aoi22_1
XFILLER_161_136 VDD VSS VDD VSS gf180mcu_fd_sc_mcu7t5v0__fillcap_4
X_3566_ VDD VSS _3567_/A3 _3564_/S _4039_/Q VDD VSS gf180mcu_fd_sc_mcu7t5v0__nand2_1
X_2517_ _2730_/S VDD VSS _4146_/D _4146_/Q wire125/Z VDD VSS gf180mcu_fd_sc_mcu7t5v0__mux2_2
Xclkbuf_3_4__f_clk_i VDD VSS clkload3/I clkbuf_0_clk_i/Z VDD VSS gf180mcu_fd_sc_mcu7t5v0__clkbuf_16
XFILLER_255_66 VDD VSS VDD VSS gf180mcu_fd_sc_mcu7t5v0__fillcap_4
X_3497_ VSS VDD _3633_/C1 _3497_/C1 _4365_/Q _3685_/C2 _3685_/B1 _4197_/Q _3501_/A1
+ VDD VSS gf180mcu_fd_sc_mcu7t5v0__aoi222_1
XFILLER_0_308 VDD VSS VDD VSS gf180mcu_fd_sc_mcu7t5v0__fillcap_32
X_2448_ _2448_/B VDD VSS _4076_/D _3485_/A2 _2454_/S VDD VSS gf180mcu_fd_sc_mcu7t5v0__aoi21_1
XFILLER_124_37 VDD VSS VDD VSS gf180mcu_fd_sc_mcu7t5v0__fillcap_8
XFILLER_130_578 VDD VSS VDD VSS gf180mcu_fd_sc_mcu7t5v0__fillcap_16
X_2379_ _2383_/S VDD VSS _4021_/D _4021_/Q wire158/Z VDD VSS gf180mcu_fd_sc_mcu7t5v0__mux2_2
X_4118_ VDD _4118_/Q _4126_/CLK VSS _4118_/D VDD VSS gf180mcu_fd_sc_mcu7t5v0__dffq_1
XFILLER_83_142 VDD VSS VDD VSS gf180mcu_fd_sc_mcu7t5v0__fillcap_64
XFILLER_244_457 VDD VSS VDD VSS gf180mcu_fd_sc_mcu7t5v0__fillcap_64
X_4049_ VDD _4049_/Q _4065_/CLK VSS _4049_/D VDD VSS gf180mcu_fd_sc_mcu7t5v0__dffq_1
XFILLER_169_203 VDD VSS VDD VSS gf180mcu_fd_sc_mcu7t5v0__fillcap_4
XFILLER_80_871 VDD VSS VDD VSS gf180mcu_fd_sc_mcu7t5v0__fillcap_4
XFILLER_212_387 VDD VSS VDD VSS gf180mcu_fd_sc_mcu7t5v0__fillcap_64
XFILLER_200_527 VDD VSS VDD VSS gf180mcu_fd_sc_mcu7t5v0__fillcap_8
XFILLER_138_667 VDD VSS VDD VSS gf180mcu_fd_sc_mcu7t5v0__fillcap_64
XFILLER_165_464 VDD VSS VDD VSS gf180mcu_fd_sc_mcu7t5v0__fillcap_16
XFILLER_126_807 VDD VSS VDD VSS gf180mcu_fd_sc_mcu7t5v0__fillcap_32
XFILLER_180_478 VDD VSS VDD VSS gf180mcu_fd_sc_mcu7t5v0__fillcap_4
XFILLER_165_66 VDD VSS VDD VSS gf180mcu_fd_sc_mcu7t5v0__fillcap_4
XFILLER_121_578 VDD VSS VDD VSS gf180mcu_fd_sc_mcu7t5v0__fillcap_8
XFILLER_0_886 VDD VSS VDD VSS gf180mcu_fd_sc_mcu7t5v0__fillcap_4
XFILLER_87_492 VDD VSS VDD VSS gf180mcu_fd_sc_mcu7t5v0__fillcap_64
XFILLER_75_632 VDD VSS VDD VSS gf180mcu_fd_sc_mcu7t5v0__fillcap_64
XFILLER_263_766 VDD VSS VDD VSS gf180mcu_fd_sc_mcu7t5v0__fillcap_4
XFILLER_222_107 VDD VSS VDD VSS gf180mcu_fd_sc_mcu7t5v0__fillcap_64
XFILLER_43_562 VDD VSS VDD VSS gf180mcu_fd_sc_mcu7t5v0__fillcap_64
XFILLER_31_702 VDD VSS VDD VSS gf180mcu_fd_sc_mcu7t5v0__fillcap_64
XFILLER_204_877 VDD VSS VDD VSS gf180mcu_fd_sc_mcu7t5v0__fillcap_8
XFILLER_70_381 VDD VSS VDD VSS gf180mcu_fd_sc_mcu7t5v0__fillcap_4
XFILLER_11_492 VDD VSS VDD VSS gf180mcu_fd_sc_mcu7t5v0__fillcap_64
XFILLER_116_317 VDD VSS VDD VSS gf180mcu_fd_sc_mcu7t5v0__fillcap_16
X_3420_ wire53/Z VDD VSS _4463_/D _4421_/Q _4463_/Q VDD VSS gf180mcu_fd_sc_mcu7t5v0__mux2_2
X_3351_ wire21/I VDD VSS _4398_/D _4375_/Q _4398_/Q VDD VSS gf180mcu_fd_sc_mcu7t5v0__mux2_2
XFILLER_258_527 VDD VSS VDD VSS gf180mcu_fd_sc_mcu7t5v0__fillcap_64
X_2302_ VDD VSS _4526_/D _4531_/Q _3270_/A2 VDD VSS gf180mcu_fd_sc_mcu7t5v0__nor2_1
X_3282_ _3334_/A2 _4491_/Q VDD VSS _3284_/A1 _4475_/Q _2280_/I VDD VSS gf180mcu_fd_sc_mcu7t5v0__aoi22_1
XFILLER_112_545 VDD VSS VDD VSS gf180mcu_fd_sc_mcu7t5v0__fillcap_4
XFILLER_100_718 VDD VSS VDD VSS gf180mcu_fd_sc_mcu7t5v0__fillcap_16
X_2233_ _4535_/D _2233_/C VDD VSS _2234_/I _4505_/Q _2233_/A2 VDD VSS gf180mcu_fd_sc_mcu7t5v0__aoi211_1
XFILLER_24_2 VDD VSS VDD VSS gf180mcu_fd_sc_mcu7t5v0__fillcap_32
X_2164_ VDD VSS _2213_/A1 _4503_/Q wire58/Z VDD VSS gf180mcu_fd_sc_mcu7t5v0__nand2_1
XFILLER_226_457 VDD VSS VDD VSS gf180mcu_fd_sc_mcu7t5v0__fillcap_16
XFILLER_65_142 VDD VSS VDD VSS gf180mcu_fd_sc_mcu7t5v0__fillcap_64
XFILLER_241_416 VDD VSS VDD VSS gf180mcu_fd_sc_mcu7t5v0__fillcap_4
XFILLER_253_276 VDD VSS VDD VSS gf180mcu_fd_sc_mcu7t5v0__fillcap_4
X_2095_ VDD VSS _4585_/D _2432_/A2 _2095_/A2 VDD VSS gf180mcu_fd_sc_mcu7t5v0__xor2_1
XFILLER_80_101 VDD VSS VDD VSS gf180mcu_fd_sc_mcu7t5v0__fillcap_4
XFILLER_62_871 VDD VSS VDD VSS gf180mcu_fd_sc_mcu7t5v0__fillcap_4
XFILLER_179_556 VDD VSS VDD VSS gf180mcu_fd_sc_mcu7t5v0__fillcap_4
XFILLER_21_212 VDD VSS VDD VSS gf180mcu_fd_sc_mcu7t5v0__fillcap_64
XFILLER_194_515 VDD VSS VDD VSS gf180mcu_fd_sc_mcu7t5v0__fillcap_8
X_2997_ VDD _3019_/A3 _3209_/B _2997_/A1 _2997_/A2 VSS _3029_/A1 VDD VSS gf180mcu_fd_sc_mcu7t5v0__oai31_1
XFILLER_166_228 VDD VSS VDD VSS gf180mcu_fd_sc_mcu7t5v0__fillcap_16
XFILLER_175_762 VDD VSS VDD VSS gf180mcu_fd_sc_mcu7t5v0__fillcap_8
X_1948_ VDD VSS _4345_/Q _2344_/B VDD VSS gf180mcu_fd_sc_mcu7t5v0__clkinv_1
XFILLER_108_807 VDD VSS VDD VSS gf180mcu_fd_sc_mcu7t5v0__fillcap_32
X_3618_ VDD VSS _3619_/B2 _3618_/A1 _3618_/A2 VDD VSS gf180mcu_fd_sc_mcu7t5v0__nand2_1
XFILLER_134_169 VDD VSS VDD VSS gf180mcu_fd_sc_mcu7t5v0__fillcap_4
X_4598_ _4598_/D _4598_/Q _4613_/RN VSS _4605_/CLK VDD VDD VSS gf180mcu_fd_sc_mcu7t5v0__dffrnq_1
XFILLER_89_702 VDD VSS VDD VSS gf180mcu_fd_sc_mcu7t5v0__fillcap_8
X_3549_ VSS VDD _3685_/C2 _4368_/Q _4200_/Q _3685_/B1 _3685_/A2 _4168_/Q _3550_/A2
+ VDD VSS gf180mcu_fd_sc_mcu7t5v0__aoi222_1
XFILLER_0_138 VDD VSS VDD VSS gf180mcu_fd_sc_mcu7t5v0__fillcap_32
XFILLER_69_492 VDD VSS VDD VSS gf180mcu_fd_sc_mcu7t5v0__fillcap_64
XFILLER_57_632 VDD VSS VDD VSS gf180mcu_fd_sc_mcu7t5v0__fillcap_64
XFILLER_245_766 VDD VSS VDD VSS gf180mcu_fd_sc_mcu7t5v0__fillcap_4
XFILLER_84_451 VDD VSS VDD VSS gf180mcu_fd_sc_mcu7t5v0__fillcap_4
XFILLER_205_619 VDD VSS VDD VSS gf180mcu_fd_sc_mcu7t5v0__fillcap_8
XFILLER_204_107 VDD VSS VDD VSS gf180mcu_fd_sc_mcu7t5v0__fillcap_64
XFILLER_198_821 VDD VSS VDD VSS gf180mcu_fd_sc_mcu7t5v0__fillcap_16
XFILLER_13_702 VDD VSS VDD VSS gf180mcu_fd_sc_mcu7t5v0__fillcap_64
XFILLER_40_521 VDD VSS VDD VSS gf180mcu_fd_sc_mcu7t5v0__fillcap_4
XFILLER_25_562 VDD VSS VDD VSS gf180mcu_fd_sc_mcu7t5v0__fillcap_64
XFILLER_213_696 VDD VSS VDD VSS gf180mcu_fd_sc_mcu7t5v0__fillcap_4
XFILLER_197_375 VDD VSS VDD VSS gf180mcu_fd_sc_mcu7t5v0__fillcap_4
XFILLER_52_381 VDD VSS VDD VSS gf180mcu_fd_sc_mcu7t5v0__fillcap_4
XFILLER_197_386 VDD VSS VDD VSS gf180mcu_fd_sc_mcu7t5v0__fillcap_32
XFILLER_125_136 VDD VSS VDD VSS gf180mcu_fd_sc_mcu7t5v0__fillcap_4
XFILLER_140_139 VDD VSS VDD VSS gf180mcu_fd_sc_mcu7t5v0__fillcap_16
XFILLER_79_212 VDD VSS VDD VSS gf180mcu_fd_sc_mcu7t5v0__fillcap_64
XFILLER_267_346 VDD VSS VDD VSS gf180mcu_fd_sc_mcu7t5v0__fillcap_4
XFILLER_94_226 VDD VSS VDD VSS gf180mcu_fd_sc_mcu7t5v0__fillcap_4
XFILLER_95_727 VDD VSS VDD VSS gf180mcu_fd_sc_mcu7t5v0__fillcap_32
XFILLER_236_711 VDD VSS VDD VSS gf180mcu_fd_sc_mcu7t5v0__fillcap_8
XFILLER_236_766 VDD VSS VDD VSS gf180mcu_fd_sc_mcu7t5v0__fillcap_32
XFILLER_47_142 VDD VSS VDD VSS gf180mcu_fd_sc_mcu7t5v0__fillcap_64
XFILLER_235_276 VDD VSS VDD VSS gf180mcu_fd_sc_mcu7t5v0__fillcap_4
XFILLER_223_416 VDD VSS VDD VSS gf180mcu_fd_sc_mcu7t5v0__fillcap_4
XFILLER_62_101 VDD VSS VDD VSS gf180mcu_fd_sc_mcu7t5v0__fillcap_4
XFILLER_204_652 VDD VSS VDD VSS gf180mcu_fd_sc_mcu7t5v0__fillcap_8
X_2920_ VDD VSS _2921_/B _4312_/Q _2919_/S VDD VSS gf180mcu_fd_sc_mcu7t5v0__nand2_1
XFILLER_189_865 VDD VSS VDD VSS gf180mcu_fd_sc_mcu7t5v0__fillcap_16
XFILLER_44_871 VDD VSS VDD VSS gf180mcu_fd_sc_mcu7t5v0__fillcap_4
XFILLER_176_504 VDD VSS VDD VSS gf180mcu_fd_sc_mcu7t5v0__fillcap_4
XFILLER_176_515 VDD VSS VDD VSS gf180mcu_fd_sc_mcu7t5v0__fillcap_4
X_2851_ _3159_/C VDD VSS _2853_/A2 _3180_/B _2846_/Z VDD VSS gf180mcu_fd_sc_mcu7t5v0__aoi21_1
XFILLER_129_431 VDD VSS VDD VSS gf180mcu_fd_sc_mcu7t5v0__fillcap_16
X_2782_ VDD VSS _2802_/A2 _3027_/A3 _2971_/A3 VDD VSS gf180mcu_fd_sc_mcu7t5v0__nand2_1
X_4521_ _4521_/D _4521_/Q wire199/Z VSS _4521_/CLK VDD VDD VSS gf180mcu_fd_sc_mcu7t5v0__dffrnq_1
X_4452_ _4452_/D _4452_/Q _4498_/RN VSS _4492_/CLK VDD VDD VSS gf180mcu_fd_sc_mcu7t5v0__dffrnq_1
XFILLER_117_648 VDD VSS VDD VSS gf180mcu_fd_sc_mcu7t5v0__fillcap_8
XFILLER_7_282 VDD VSS VDD VSS gf180mcu_fd_sc_mcu7t5v0__fillcap_64
X_3403_ _3425_/S VDD VSS _4446_/D _4404_/Q _4446_/Q VDD VSS gf180mcu_fd_sc_mcu7t5v0__mux2_2
XFILLER_171_275 VDD VSS VDD VSS gf180mcu_fd_sc_mcu7t5v0__fillcap_4
X_4383_ _4383_/D _4383_/Q wire196/Z VSS _4407_/CLK VDD VDD VSS gf180mcu_fd_sc_mcu7t5v0__dffrnq_1
XFILLER_259_836 VDD VSS VDD VSS gf180mcu_fd_sc_mcu7t5v0__fillcap_4
X_3334_ _3334_/B1 _4385_/Q VDD VSS _3335_/I _3347_/B _3334_/A2 VDD VSS gf180mcu_fd_sc_mcu7t5v0__aoi22_1
X_3265_ VDD VSS _3265_/I _4367_/D VDD VSS gf180mcu_fd_sc_mcu7t5v0__clkinv_1
XFILLER_98_587 VDD VSS VDD VSS gf180mcu_fd_sc_mcu7t5v0__fillcap_8
X_2216_ VDD VSS _2217_/A3 _4502_/Q _2206_/Z VDD VSS gf180mcu_fd_sc_mcu7t5v0__nand2_1
XFILLER_39_632 VDD VSS VDD VSS gf180mcu_fd_sc_mcu7t5v0__fillcap_64
X_3196_ VDD _3196_/B _3200_/A2 _4339_/D _3271_/A1 VSS VDD VSS gf180mcu_fd_sc_mcu7t5v0__oai21_1
XFILLER_66_451 VDD VSS VDD VSS gf180mcu_fd_sc_mcu7t5v0__fillcap_4
XFILLER_227_788 VDD VSS VDD VSS gf180mcu_fd_sc_mcu7t5v0__fillcap_8
X_2147_ VDD VSS _2148_/A2 _4446_/Q _2510_/A2 VDD VSS gf180mcu_fd_sc_mcu7t5v0__nand2_1
X_2078_ VDD VSS _2080_/A2 wire93/I _2074_/Z VDD VSS gf180mcu_fd_sc_mcu7t5v0__nand2_1
XFILLER_22_521 VDD VSS VDD VSS gf180mcu_fd_sc_mcu7t5v0__fillcap_4
XFILLER_34_381 VDD VSS VDD VSS gf180mcu_fd_sc_mcu7t5v0__fillcap_4
XFILLER_50_885 VDD VSS VDD VSS gf180mcu_fd_sc_mcu7t5v0__fillcap_4
XFILLER_194_367 VDD VSS VDD VSS gf180mcu_fd_sc_mcu7t5v0__fillcap_4
XFILLER_108_659 VDD VSS VDD VSS gf180mcu_fd_sc_mcu7t5v0__fillcap_4
XFILLER_131_640 VDD VSS VDD VSS gf180mcu_fd_sc_mcu7t5v0__fillcap_4
XFILLER_249_346 VDD VSS VDD VSS gf180mcu_fd_sc_mcu7t5v0__fillcap_4
XFILLER_131_695 VDD VSS VDD VSS gf180mcu_fd_sc_mcu7t5v0__fillcap_4
XFILLER_39_66 VDD VSS VDD VSS gf180mcu_fd_sc_mcu7t5v0__fillcap_4
XFILLER_29_142 VDD VSS VDD VSS gf180mcu_fd_sc_mcu7t5v0__fillcap_64
XFILLER_176_2 VDD VSS VDD VSS gf180mcu_fd_sc_mcu7t5v0__fillcap_32
XFILLER_44_101 VDD VSS VDD VSS gf180mcu_fd_sc_mcu7t5v0__fillcap_4
XFILLER_205_416 VDD VSS VDD VSS gf180mcu_fd_sc_mcu7t5v0__fillcap_4
XFILLER_26_871 VDD VSS VDD VSS gf180mcu_fd_sc_mcu7t5v0__fillcap_4
XFILLER_201_622 VDD VSS VDD VSS gf180mcu_fd_sc_mcu7t5v0__fillcap_8
XFILLER_197_150 VDD VSS VDD VSS gf180mcu_fd_sc_mcu7t5v0__fillcap_4
XFILLER_41_874 VDD VSS VDD VSS gf180mcu_fd_sc_mcu7t5v0__fillcap_16
XFILLER_201_666 VDD VSS VDD VSS gf180mcu_fd_sc_mcu7t5v0__fillcap_8
XFILLER_4_241 VDD VSS VDD VSS gf180mcu_fd_sc_mcu7t5v0__fillcap_4
X_3050_ _3930_/Q VSS VDD _3914_/Q _3922_/Q _3113_/S _3906_/Q _3117_/B _3050_/Z VDD
+ VSS gf180mcu_fd_sc_mcu7t5v0__mux4_1
XFILLER_208_232 VDD VSS VDD VSS gf180mcu_fd_sc_mcu7t5v0__fillcap_4
XFILLER_48_451 VDD VSS VDD VSS gf180mcu_fd_sc_mcu7t5v0__fillcap_4
X_2001_ VDD VSS _4474_/Q _3572_/A1 VDD VSS gf180mcu_fd_sc_mcu7t5v0__clkinv_1
XFILLER_222_37 VDD VSS VDD VSS gf180mcu_fd_sc_mcu7t5v0__fillcap_64
X_3952_ VDD _3952_/Q _3968_/CLK VSS _3952_/D VDD VSS gf180mcu_fd_sc_mcu7t5v0__dffq_1
XFILLER_16_381 VDD VSS VDD VSS gf180mcu_fd_sc_mcu7t5v0__fillcap_4
X_3883_ VDD _3883_/Q _4541_/CLK VSS _3883_/D VDD VSS gf180mcu_fd_sc_mcu7t5v0__dffq_1
X_2903_ _4325_/Q VDD VSS _3024_/A3 _3008_/B2 _4324_/Q VDD VSS gf180mcu_fd_sc_mcu7t5v0__nand3_1
XFILLER_32_885 VDD VSS VDD VSS gf180mcu_fd_sc_mcu7t5v0__fillcap_4
X_2834_ _3027_/A3 VDD VSS _2835_/A2 _4340_/Q _2831_/B VDD VSS gf180mcu_fd_sc_mcu7t5v0__nand3_1
XFILLER_176_378 VDD VSS VDD VSS gf180mcu_fd_sc_mcu7t5v0__fillcap_4
X_4504_ _4504_/D _4504_/Q wire187/Z VSS _4531_/CLK VDD VDD VSS gf180mcu_fd_sc_mcu7t5v0__dffrnq_1
X_2765_ _3447_/A1 VDD VSS _3619_/A2 _4431_/Q _3441_/A3 VDD VSS gf180mcu_fd_sc_mcu7t5v0__nor3_1
XFILLER_8_591 VDD VSS VDD VSS gf180mcu_fd_sc_mcu7t5v0__fillcap_4
X_2696_ VDD _2696_/B _2698_/B _2697_/A2 _2696_/A1 VSS VDD VSS gf180mcu_fd_sc_mcu7t5v0__oai21_1
XFILLER_160_724 VDD VSS VDD VSS gf180mcu_fd_sc_mcu7t5v0__fillcap_8
X_4435_ _4435_/D _4435_/Q _4473_/RN VSS _4477_/CLK VDD VDD VSS gf180mcu_fd_sc_mcu7t5v0__dffrnq_1
X_4366_ _4366_/D _4366_/Q wire183/Z VSS _4366_/CLK VDD VDD VSS gf180mcu_fd_sc_mcu7t5v0__dffrnq_1
XFILLER_99_874 VDD VSS VDD VSS gf180mcu_fd_sc_mcu7t5v0__fillcap_16
XFILLER_263_66 VDD VSS VDD VSS gf180mcu_fd_sc_mcu7t5v0__fillcap_4
XFILLER_98_351 VDD VSS VDD VSS gf180mcu_fd_sc_mcu7t5v0__fillcap_32
X_3317_ VDD VSS _3319_/A1 _3858_/D _3858_/Q VDD VSS gf180mcu_fd_sc_mcu7t5v0__nand2_1
X_4297_ _4297_/D _4297_/Q _4530_/RN VSS _4305_/CLK VDD VDD VSS gf180mcu_fd_sc_mcu7t5v0__dffrnq_1
XFILLER_101_835 VDD VSS VDD VSS gf180mcu_fd_sc_mcu7t5v0__fillcap_4
X_3248_ wire23/Z VDD VSS _4356_/D _4331_/Q _4356_/Q VDD VSS gf180mcu_fd_sc_mcu7t5v0__mux2_2
X_3179_ _3179_/B _3187_/C VDD VSS _3182_/A2 _3176_/S _3717_/A1 VDD VSS gf180mcu_fd_sc_mcu7t5v0__aoi211_1
XFILLER_26_101 VDD VSS VDD VSS gf180mcu_fd_sc_mcu7t5v0__fillcap_4
XFILLER_199_437 VDD VSS VDD VSS gf180mcu_fd_sc_mcu7t5v0__fillcap_32
XFILLER_82_796 VDD VSS VDD VSS gf180mcu_fd_sc_mcu7t5v0__fillcap_8
XFILLER_195_632 VDD VSS VDD VSS gf180mcu_fd_sc_mcu7t5v0__fillcap_8
XFILLER_23_874 VDD VSS VDD VSS gf180mcu_fd_sc_mcu7t5v0__fillcap_16
XFILLER_168_868 VDD VSS VDD VSS gf180mcu_fd_sc_mcu7t5v0__fillcap_4
XFILLER_195_687 VDD VSS VDD VSS gf180mcu_fd_sc_mcu7t5v0__fillcap_8
XFILLER_163_562 VDD VSS VDD VSS gf180mcu_fd_sc_mcu7t5v0__fillcap_8
XFILLER_151_702 VDD VSS VDD VSS gf180mcu_fd_sc_mcu7t5v0__fillcap_4
XFILLER_173_66 VDD VSS VDD VSS gf180mcu_fd_sc_mcu7t5v0__fillcap_4
XFILLER_131_492 VDD VSS VDD VSS gf180mcu_fd_sc_mcu7t5v0__fillcap_32
XFILLER_233_533 VDD VSS VDD VSS gf180mcu_fd_sc_mcu7t5v0__fillcap_16
XFILLER_261_842 VDD VSS VDD VSS gf180mcu_fd_sc_mcu7t5v0__fillcap_32
XFILLER_198_30 VDD VSS VDD VSS gf180mcu_fd_sc_mcu7t5v0__fillcap_4
XFILLER_186_610 VDD VSS VDD VSS gf180mcu_fd_sc_mcu7t5v0__fillcap_4
XFILLER_159_835 VDD VSS VDD VSS gf180mcu_fd_sc_mcu7t5v0__fillcap_4
Xclkbuf_4_7_0_host_clk_i _4595_/CLK VSS VDD clkbuf_0_host_clk_i/Z VDD VSS gf180mcu_fd_sc_mcu7t5v0__clkbuf_2
XFILLER_60_457 VDD VSS VDD VSS gf180mcu_fd_sc_mcu7t5v0__fillcap_64
XFILLER_14_885 VDD VSS VDD VSS gf180mcu_fd_sc_mcu7t5v0__fillcap_4
XFILLER_139_570 VDD VSS VDD VSS gf180mcu_fd_sc_mcu7t5v0__fillcap_4
XFILLER_185_142 VDD VSS VDD VSS gf180mcu_fd_sc_mcu7t5v0__fillcap_16
XFILLER_63_6 VDD VSS VDD VSS gf180mcu_fd_sc_mcu7t5v0__fillcap_64
X_2550_ wire28/I VDD VSS _4173_/D _4447_/Q _4173_/Q VDD VSS gf180mcu_fd_sc_mcu7t5v0__mux2_2
XFILLER_141_212 VDD VSS VDD VSS gf180mcu_fd_sc_mcu7t5v0__fillcap_8
X_2481_ _2482_/S VDD VSS _4104_/D _4104_/Q wire152/Z VDD VSS gf180mcu_fd_sc_mcu7t5v0__mux2_2
XFILLER_114_448 VDD VSS VDD VSS gf180mcu_fd_sc_mcu7t5v0__fillcap_4
X_4220_ _4220_/D _4220_/Q _4534_/RN VSS _4532_/CLK VDD VDD VSS gf180mcu_fd_sc_mcu7t5v0__dffrnq_1
X_4151_ _4151_/D _4151_/Q wire184/Z VSS _4198_/CLK VDD VDD VSS gf180mcu_fd_sc_mcu7t5v0__dffrnq_1
X_3102_ _3122_/S VDD VSS _3102_/Z _3948_/Q _3940_/Q VDD VSS gf180mcu_fd_sc_mcu7t5v0__mux2_2
X_4082_ VDD _4082_/Q _4476_/CLK VSS _4082_/D VDD VSS gf180mcu_fd_sc_mcu7t5v0__dffq_1
XFILLER_96_877 VDD VSS VDD VSS gf180mcu_fd_sc_mcu7t5v0__fillcap_8
X_3033_ _3038_/B _3038_/C VDD VSS _3034_/B _3024_/B _3033_/A2 VDD VSS gf180mcu_fd_sc_mcu7t5v0__oai211_1
XFILLER_224_588 VDD VSS VDD VSS gf180mcu_fd_sc_mcu7t5v0__fillcap_4
XFILLER_251_352 VDD VSS VDD VSS gf180mcu_fd_sc_mcu7t5v0__fillcap_64
X_3935_ VDD _3935_/Q _3936_/CLK VSS _3935_/D VDD VSS gf180mcu_fd_sc_mcu7t5v0__dffq_1
XFILLER_189_492 VDD VSS VDD VSS gf180mcu_fd_sc_mcu7t5v0__fillcap_4
XFILLER_20_877 VDD VSS VDD VSS gf180mcu_fd_sc_mcu7t5v0__fillcap_8
X_3866_ _3866_/D _3866_/Q _4613_/RN VSS _4606_/CLK VDD VDD VSS gf180mcu_fd_sc_mcu7t5v0__dffrnq_1
X_3797_ _3797_/B VDD VSS _3958_/D _3797_/A1 wire16/Z VDD VSS gf180mcu_fd_sc_mcu7t5v0__aoi21_1
XFILLER_192_646 VDD VSS VDD VSS gf180mcu_fd_sc_mcu7t5v0__fillcap_16
XFILLER_191_123 VDD VSS VDD VSS gf180mcu_fd_sc_mcu7t5v0__fillcap_16
X_2817_ _3224_/A2 _3037_/A1 VDD VSS _2818_/A4 _2156_/B _3024_/A2 VDD VSS gf180mcu_fd_sc_mcu7t5v0__aoi22_1
XFILLER_145_562 VDD VSS VDD VSS gf180mcu_fd_sc_mcu7t5v0__fillcap_32
X_2748_ _2748_/S VDD VSS _4282_/D _4282_/Q _4456_/Q VDD VSS gf180mcu_fd_sc_mcu7t5v0__mux2_2
X_2679_ VDD _2679_/B _4503_/D _4237_/D _2679_/A1 VSS VDD VSS gf180mcu_fd_sc_mcu7t5v0__oai21_1
X_4418_ _4418_/D _4418_/Q _4536_/RN VSS _4446_/CLK VDD VDD VSS gf180mcu_fd_sc_mcu7t5v0__dffrnq_1
XFILLER_120_407 VDD VSS VDD VSS gf180mcu_fd_sc_mcu7t5v0__fillcap_8
X_4349_ _4349_/D _4349_/Q wire199/I VSS _4523_/CLK VDD VDD VSS gf180mcu_fd_sc_mcu7t5v0__dffrnq_1
XFILLER_113_492 VDD VSS VDD VSS gf180mcu_fd_sc_mcu7t5v0__fillcap_4
XFILLER_86_387 VDD VSS VDD VSS gf180mcu_fd_sc_mcu7t5v0__fillcap_64
XFILLER_74_527 VDD VSS VDD VSS gf180mcu_fd_sc_mcu7t5v0__fillcap_64
XFILLER_243_842 VDD VSS VDD VSS gf180mcu_fd_sc_mcu7t5v0__fillcap_32
XFILLER_215_577 VDD VSS VDD VSS gf180mcu_fd_sc_mcu7t5v0__fillcap_32
XFILLER_42_457 VDD VSS VDD VSS gf180mcu_fd_sc_mcu7t5v0__fillcap_64
XFILLER_211_772 VDD VSS VDD VSS gf180mcu_fd_sc_mcu7t5v0__fillcap_8
XFILLER_195_451 VDD VSS VDD VSS gf180mcu_fd_sc_mcu7t5v0__fillcap_32
XFILLER_168_88 VDD VSS VDD VSS gf180mcu_fd_sc_mcu7t5v0__fillcap_4
XFILLER_182_123 VDD VSS VDD VSS gf180mcu_fd_sc_mcu7t5v0__fillcap_16
XFILLER_10_387 VDD VSS VDD VSS gf180mcu_fd_sc_mcu7t5v0__fillcap_64
XFILLER_183_668 VDD VSS VDD VSS gf180mcu_fd_sc_mcu7t5v0__fillcap_16
XFILLER_109_754 VDD VSS VDD VSS gf180mcu_fd_sc_mcu7t5v0__fillcap_4
XFILLER_109_765 VDD VSS VDD VSS gf180mcu_fd_sc_mcu7t5v0__fillcap_4
XFILLER_108_286 VDD VSS VDD VSS gf180mcu_fd_sc_mcu7t5v0__fillcap_16
XFILLER_124_768 VDD VSS VDD VSS gf180mcu_fd_sc_mcu7t5v0__fillcap_8
XFILLER_96_107 VDD VSS VDD VSS gf180mcu_fd_sc_mcu7t5v0__fillcap_8
XFILLER_2_597 VDD VSS VDD VSS gf180mcu_fd_sc_mcu7t5v0__fillcap_64
XFILLER_265_422 VDD VSS VDD VSS gf180mcu_fd_sc_mcu7t5v0__fillcap_64
XFILLER_78_877 VDD VSS VDD VSS gf180mcu_fd_sc_mcu7t5v0__fillcap_8
XFILLER_133_80 VDD VSS VDD VSS gf180mcu_fd_sc_mcu7t5v0__fillcap_4
XFILLER_233_352 VDD VSS VDD VSS gf180mcu_fd_sc_mcu7t5v0__fillcap_64
XFILLER_260_171 VDD VSS VDD VSS gf180mcu_fd_sc_mcu7t5v0__fillcap_4
XFILLER_61_766 VDD VSS VDD VSS gf180mcu_fd_sc_mcu7t5v0__fillcap_4
XFILLER_186_440 VDD VSS VDD VSS gf180mcu_fd_sc_mcu7t5v0__fillcap_8
X_3720_ _3840_/A1 VDD VSS _3728_/S _4540_/Q _4541_/Q VDD VSS gf180mcu_fd_sc_mcu7t5v0__and3_1
XFILLER_20_107 VDD VSS VDD VSS gf180mcu_fd_sc_mcu7t5v0__fillcap_64
X_1981_ VDD VSS _4384_/Q _3333_/A1 VDD VSS gf180mcu_fd_sc_mcu7t5v0__clkinv_1
XFILLER_202_772 VDD VSS VDD VSS gf180mcu_fd_sc_mcu7t5v0__fillcap_16
X_3651_ VDD VSS _3653_/A2 _4180_/Q _3682_/B1 VDD VSS gf180mcu_fd_sc_mcu7t5v0__nand2_1
X_2602_ _4206_/Q _4205_/Q VDD VSS _2602_/Z _4204_/Q _4203_/Q VDD VSS gf180mcu_fd_sc_mcu7t5v0__and4_1
X_3582_ _3582_/B _3590_/C VDD VSS _3583_/A3 _3515_/C _3578_/Z VDD VSS gf180mcu_fd_sc_mcu7t5v0__oai211_1
XFILLER_154_370 VDD VSS VDD VSS gf180mcu_fd_sc_mcu7t5v0__fillcap_8
XFILLER_114_201 VDD VSS VDD VSS gf180mcu_fd_sc_mcu7t5v0__fillcap_4
X_2533_ _2535_/S VDD VSS _4159_/D _4159_/Q wire117/Z VDD VSS gf180mcu_fd_sc_mcu7t5v0__mux2_2
XFILLER_127_562 VDD VSS VDD VSS gf180mcu_fd_sc_mcu7t5v0__fillcap_16
XFILLER_127_595 VDD VSS VDD VSS gf180mcu_fd_sc_mcu7t5v0__fillcap_32
XFILLER_54_2 VDD VSS VDD VSS gf180mcu_fd_sc_mcu7t5v0__fillcap_32
XFILLER_170_885 VDD VSS VDD VSS gf180mcu_fd_sc_mcu7t5v0__fillcap_4
X_2464_ VDD VSS _2472_/S _2501_/A1 _2432_/Z VDD VSS gf180mcu_fd_sc_mcu7t5v0__nand2_1
X_4203_ _4203_/D _4203_/Q _4212_/RN VSS _4210_/CLK VDD VDD VSS gf180mcu_fd_sc_mcu7t5v0__dffrnq_1
X_2395_ VDD VSS _2403_/S _2061_/Z _2423_/A2 VDD VSS gf180mcu_fd_sc_mcu7t5v0__and2_1
X_4134_ _4134_/D _4134_/Q _4536_/RN VSS _4536_/CLK VDD VDD VSS gf180mcu_fd_sc_mcu7t5v0__dffrnq_1
XFILLER_68_387 VDD VSS VDD VSS gf180mcu_fd_sc_mcu7t5v0__fillcap_64
XFILLER_56_527 VDD VSS VDD VSS gf180mcu_fd_sc_mcu7t5v0__fillcap_64
XFILLER_83_346 VDD VSS VDD VSS gf180mcu_fd_sc_mcu7t5v0__fillcap_4
X_4065_ VDD _4065_/Q _4065_/CLK VSS _4065_/D VDD VSS gf180mcu_fd_sc_mcu7t5v0__dffq_1
XFILLER_225_842 VDD VSS VDD VSS gf180mcu_fd_sc_mcu7t5v0__fillcap_32
X_3016_ VDD VSS _3018_/A2 _4325_/Q _3016_/A2 VDD VSS gf180mcu_fd_sc_mcu7t5v0__nor2_1
XFILLER_240_801 VDD VSS VDD VSS gf180mcu_fd_sc_mcu7t5v0__fillcap_4
XFILLER_252_661 VDD VSS VDD VSS gf180mcu_fd_sc_mcu7t5v0__fillcap_4
Xwire77 VSS wire77/Z wire77/I VDD VDD VSS gf180mcu_fd_sc_mcu7t5v0__clkbuf_1
Xwire66 VDD wire66/I VSS wire66/Z VDD VSS gf180mcu_fd_sc_mcu7t5v0__dlyb_1
XFILLER_24_457 VDD VSS VDD VSS gf180mcu_fd_sc_mcu7t5v0__fillcap_64
Xwire88 wire88/Z VSS VDD wire88/I VDD VSS gf180mcu_fd_sc_mcu7t5v0__clkbuf_3
XFILLER_51_276 VDD VSS VDD VSS gf180mcu_fd_sc_mcu7t5v0__fillcap_4
X_3918_ VDD _3918_/Q _3936_/CLK VSS _3918_/D VDD VSS gf180mcu_fd_sc_mcu7t5v0__dffq_1
X_3849_ VDD VSS _4541_/D _3849_/A1 _3696_/S VDD VSS gf180mcu_fd_sc_mcu7t5v0__nor2_1
XFILLER_137_337 VDD VSS VDD VSS gf180mcu_fd_sc_mcu7t5v0__fillcap_4
XFILLER_4_807 VDD VSS VDD VSS gf180mcu_fd_sc_mcu7t5v0__fillcap_64
Xclkbuf_leaf_0_clk_i clkload7/I VSS VDD clkload0/I VDD VSS gf180mcu_fd_sc_mcu7t5v0__clkbuf_2
XFILLER_78_107 VDD VSS VDD VSS gf180mcu_fd_sc_mcu7t5v0__fillcap_64
XFILLER_120_237 VDD VSS VDD VSS gf180mcu_fd_sc_mcu7t5v0__fillcap_8
XFILLER_247_422 VDD VSS VDD VSS gf180mcu_fd_sc_mcu7t5v0__fillcap_64
XFILLER_259_282 VDD VSS VDD VSS gf180mcu_fd_sc_mcu7t5v0__fillcap_64
XFILLER_75_836 VDD VSS VDD VSS gf180mcu_fd_sc_mcu7t5v0__fillcap_4
XFILLER_87_696 VDD VSS VDD VSS gf180mcu_fd_sc_mcu7t5v0__fillcap_4
XFILLER_47_66 VDD VSS VDD VSS gf180mcu_fd_sc_mcu7t5v0__fillcap_4
XFILLER_215_352 VDD VSS VDD VSS gf180mcu_fd_sc_mcu7t5v0__fillcap_64
XFILLER_256_2 VDD VSS VDD VSS gf180mcu_fd_sc_mcu7t5v0__fillcap_32
XFILLER_103_72 VDD VSS VDD VSS gf180mcu_fd_sc_mcu7t5v0__fillcap_16
XFILLER_230_311 VDD VSS VDD VSS gf180mcu_fd_sc_mcu7t5v0__fillcap_4
XFILLER_242_171 VDD VSS VDD VSS gf180mcu_fd_sc_mcu7t5v0__fillcap_4
XFILLER_43_766 VDD VSS VDD VSS gf180mcu_fd_sc_mcu7t5v0__fillcap_4
Xmax_length130 VSS wire129/I _4440_/Q VDD VDD VSS gf180mcu_fd_sc_mcu7t5v0__buf_2
XFILLER_11_696 VDD VSS VDD VSS gf180mcu_fd_sc_mcu7t5v0__fillcap_4
XFILLER_6_177 VDD VSS VDD VSS gf180mcu_fd_sc_mcu7t5v0__fillcap_64
Xmax_length185 _4527_/RN wire186/Z VDD VSS VDD VSS gf180mcu_fd_sc_mcu7t5v0__buf_8
XFILLER_109_562 VDD VSS VDD VSS gf180mcu_fd_sc_mcu7t5v0__fillcap_32
XFILLER_152_841 VDD VSS VDD VSS gf180mcu_fd_sc_mcu7t5v0__fillcap_8
XFILLER_124_521 VDD VSS VDD VSS gf180mcu_fd_sc_mcu7t5v0__fillcap_4
XFILLER_152_885 VDD VSS VDD VSS gf180mcu_fd_sc_mcu7t5v0__fillcap_4
XFILLER_97_416 VDD VSS VDD VSS gf180mcu_fd_sc_mcu7t5v0__fillcap_4
XFILLER_266_731 VDD VSS VDD VSS gf180mcu_fd_sc_mcu7t5v0__fillcap_4
X_2180_ _2675_/A1 _4236_/Q VDD VSS _2192_/B _2671_/A1 _4234_/Q VDD VSS gf180mcu_fd_sc_mcu7t5v0__nand4_1
XFILLER_38_527 VDD VSS VDD VSS gf180mcu_fd_sc_mcu7t5v0__fillcap_64
XFILLER_65_346 VDD VSS VDD VSS gf180mcu_fd_sc_mcu7t5v0__fillcap_4
XFILLER_207_842 VDD VSS VDD VSS gf180mcu_fd_sc_mcu7t5v0__fillcap_32
XFILLER_230_37 VDD VSS VDD VSS gf180mcu_fd_sc_mcu7t5v0__fillcap_64
XFILLER_21_416 VDD VSS VDD VSS gf180mcu_fd_sc_mcu7t5v0__fillcap_4
XFILLER_33_276 VDD VSS VDD VSS gf180mcu_fd_sc_mcu7t5v0__fillcap_4
X_1964_ VDD VSS _4504_/Q _2684_/A1 VDD VSS gf180mcu_fd_sc_mcu7t5v0__clkinv_1
X_3703_ _3706_/S VDD VSS _3886_/D _3886_/Q wire174/Z VDD VSS gf180mcu_fd_sc_mcu7t5v0__mux2_2
XFILLER_174_410 VDD VSS VDD VSS gf180mcu_fd_sc_mcu7t5v0__fillcap_8
X_3634_ VDD VSS _3635_/B2 _3634_/A1 _3634_/A2 VDD VSS gf180mcu_fd_sc_mcu7t5v0__nand2_1
XFILLER_128_871 VDD VSS VDD VSS gf180mcu_fd_sc_mcu7t5v0__fillcap_4
X_3565_ VDD VSS _3567_/A2 wire75/Z _4047_/Q VDD VSS gf180mcu_fd_sc_mcu7t5v0__nand2_1
X_3496_ VDD VSS _3503_/B1 _3546_/B _3495_/Z VDD VSS gf180mcu_fd_sc_mcu7t5v0__nor2_1
X_2516_ _2730_/S VDD VSS _4145_/D _4145_/Q wire129/Z VDD VSS gf180mcu_fd_sc_mcu7t5v0__mux2_2
XFILLER_115_554 VDD VSS VDD VSS gf180mcu_fd_sc_mcu7t5v0__fillcap_4
X_2447_ VDD VSS _2448_/B wire163/Z _2454_/S VDD VSS gf180mcu_fd_sc_mcu7t5v0__nor2_1
XFILLER_229_422 VDD VSS VDD VSS gf180mcu_fd_sc_mcu7t5v0__fillcap_64
XFILLER_256_241 VDD VSS VDD VSS gf180mcu_fd_sc_mcu7t5v0__fillcap_4
XFILLER_57_836 VDD VSS VDD VSS gf180mcu_fd_sc_mcu7t5v0__fillcap_4
XFILLER_69_696 VDD VSS VDD VSS gf180mcu_fd_sc_mcu7t5v0__fillcap_4
X_2378_ _2383_/S VDD VSS _4020_/D _4020_/Q _2467_/I0 VDD VSS gf180mcu_fd_sc_mcu7t5v0__mux2_2
XFILLER_110_270 VDD VSS VDD VSS gf180mcu_fd_sc_mcu7t5v0__fillcap_32
X_4117_ VDD _4117_/Q _4473_/CLK VSS _4117_/D VDD VSS gf180mcu_fd_sc_mcu7t5v0__dffq_1
X_4048_ VDD _4048_/Q _4123_/CLK VSS _4048_/D VDD VSS gf180mcu_fd_sc_mcu7t5v0__dffq_1
XFILLER_140_37 VDD VSS VDD VSS gf180mcu_fd_sc_mcu7t5v0__fillcap_64
XFILLER_197_513 VDD VSS VDD VSS gf180mcu_fd_sc_mcu7t5v0__fillcap_8
XFILLER_224_171 VDD VSS VDD VSS gf180mcu_fd_sc_mcu7t5v0__fillcap_4
XFILLER_25_766 VDD VSS VDD VSS gf180mcu_fd_sc_mcu7t5v0__fillcap_4
XFILLER_125_329 VDD VSS VDD VSS gf180mcu_fd_sc_mcu7t5v0__fillcap_4
XFILLER_119_871 VDD VSS VDD VSS gf180mcu_fd_sc_mcu7t5v0__fillcap_16
XFILLER_134_885 VDD VSS VDD VSS gf180mcu_fd_sc_mcu7t5v0__fillcap_4
XFILLER_79_416 VDD VSS VDD VSS gf180mcu_fd_sc_mcu7t5v0__fillcap_4
XFILLER_3_136 VDD VSS VDD VSS gf180mcu_fd_sc_mcu7t5v0__fillcap_4
XFILLER_248_731 VDD VSS VDD VSS gf180mcu_fd_sc_mcu7t5v0__fillcap_4
XFILLER_181_66 VDD VSS VDD VSS gf180mcu_fd_sc_mcu7t5v0__fillcap_4
XFILLER_181_88 VDD VSS VDD VSS gf180mcu_fd_sc_mcu7t5v0__fillcap_8
XFILLER_101_270 VDD VSS VDD VSS gf180mcu_fd_sc_mcu7t5v0__fillcap_8
XFILLER_47_346 VDD VSS VDD VSS gf180mcu_fd_sc_mcu7t5v0__fillcap_4
XFILLER_223_609 VDD VSS VDD VSS gf180mcu_fd_sc_mcu7t5v0__fillcap_16
XFILLER_216_661 VDD VSS VDD VSS gf180mcu_fd_sc_mcu7t5v0__fillcap_4
XFILLER_90_658 VDD VSS VDD VSS gf180mcu_fd_sc_mcu7t5v0__fillcap_4
XFILLER_216_694 VDD VSS VDD VSS gf180mcu_fd_sc_mcu7t5v0__fillcap_32
XFILLER_204_823 VDD VSS VDD VSS gf180mcu_fd_sc_mcu7t5v0__fillcap_8
XFILLER_200_18 VDD VSS VDD VSS gf180mcu_fd_sc_mcu7t5v0__fillcap_16
XFILLER_15_276 VDD VSS VDD VSS gf180mcu_fd_sc_mcu7t5v0__fillcap_4
XFILLER_188_568 VDD VSS VDD VSS gf180mcu_fd_sc_mcu7t5v0__fillcap_16
XFILLER_183_251 VDD VSS VDD VSS gf180mcu_fd_sc_mcu7t5v0__fillcap_16
XFILLER_171_446 VDD VSS VDD VSS gf180mcu_fd_sc_mcu7t5v0__fillcap_16
XFILLER_7_486 VDD VSS VDD VSS gf180mcu_fd_sc_mcu7t5v0__fillcap_4
XFILLER_99_72 VDD VSS VDD VSS gf180mcu_fd_sc_mcu7t5v0__fillcap_16
X_3350_ wire21/I VDD VSS _4397_/D _4374_/Q _4397_/Q VDD VSS gf180mcu_fd_sc_mcu7t5v0__mux2_2
XFILLER_125_885 VDD VSS VDD VSS gf180mcu_fd_sc_mcu7t5v0__fillcap_4
X_2301_ _2301_/B VDD VSS _4511_/D _4532_/Q _4222_/Q VDD VSS gf180mcu_fd_sc_mcu7t5v0__aoi21_1
XFILLER_140_877 VDD VSS VDD VSS gf180mcu_fd_sc_mcu7t5v0__fillcap_8
XFILLER_151_181 VDD VSS VDD VSS gf180mcu_fd_sc_mcu7t5v0__fillcap_16
XFILLER_97_235 VDD VSS VDD VSS gf180mcu_fd_sc_mcu7t5v0__fillcap_8
X_3281_ VSS VDD _4492_/Q _3334_/A2 _4484_/Q _3278_/Z _2280_/I _4476_/Q _3285_/A2 VDD
+ VSS gf180mcu_fd_sc_mcu7t5v0__aoi222_1
XFILLER_238_241 VDD VSS VDD VSS gf180mcu_fd_sc_mcu7t5v0__fillcap_4
X_2232_ _2232_/A2 _2232_/B1 _2701_/A1 VDD VSS _2233_/C _4320_/Q VDD VSS gf180mcu_fd_sc_mcu7t5v0__oai22_1
XFILLER_39_836 VDD VSS VDD VSS gf180mcu_fd_sc_mcu7t5v0__fillcap_4
X_2163_ VDD VSS _3853_/D _2044_/I wire56/I VDD VSS gf180mcu_fd_sc_mcu7t5v0__nand2_1
XFILLER_17_2 VDD VSS VDD VSS gf180mcu_fd_sc_mcu7t5v0__fillcap_64
XFILLER_241_58 VDD VSS VDD VSS gf180mcu_fd_sc_mcu7t5v0__fillcap_8
XFILLER_81_603 VDD VSS VDD VSS gf180mcu_fd_sc_mcu7t5v0__fillcap_16
X_2094_ VDD VSS _4584_/D _4580_/Q _2094_/A2 VDD VSS gf180mcu_fd_sc_mcu7t5v0__xnor2_1
XFILLER_210_859 VDD VSS VDD VSS gf180mcu_fd_sc_mcu7t5v0__fillcap_16
X_2996_ VDD VSS _3029_/A1 _3224_/A2 _2996_/A2 VDD VSS gf180mcu_fd_sc_mcu7t5v0__nand2_1
X_1947_ VDD VSS _4371_/Q _2975_/A1 VDD VSS gf180mcu_fd_sc_mcu7t5v0__clkinv_1
X_4597_ _4602_/Q _4597_/Q _4613_/RN VSS _4606_/CLK VDD VDD VSS gf180mcu_fd_sc_mcu7t5v0__dffrnq_1
X_3617_ _2040_/Z _4159_/Q VDD VSS _3618_/A2 _4138_/Q _2039_/Z VDD VSS gf180mcu_fd_sc_mcu7t5v0__aoi22_1
X_3548_ _2040_/Z _4156_/Q VDD VSS _3550_/A1 _4135_/Q _2039_/Z VDD VSS gf180mcu_fd_sc_mcu7t5v0__aoi22_1
XFILLER_162_457 VDD VSS VDD VSS gf180mcu_fd_sc_mcu7t5v0__fillcap_8
XFILLER_143_693 VDD VSS VDD VSS gf180mcu_fd_sc_mcu7t5v0__fillcap_4
XFILLER_115_384 VDD VSS VDD VSS gf180mcu_fd_sc_mcu7t5v0__fillcap_16
Xclkbuf_leaf_80_clk_i _4129_/CLK VSS VDD clkbuf_3_2__f_clk_i/Z VDD VSS gf180mcu_fd_sc_mcu7t5v0__clkbuf_2
XFILLER_116_885 VDD VSS VDD VSS gf180mcu_fd_sc_mcu7t5v0__fillcap_4
X_3479_ _3479_/B _3479_/C VDD VSS _3480_/B _3619_/B1 _3479_/A2 VDD VSS gf180mcu_fd_sc_mcu7t5v0__aoi211_1
XFILLER_130_387 VDD VSS VDD VSS gf180mcu_fd_sc_mcu7t5v0__fillcap_8
XFILLER_29_346 VDD VSS VDD VSS gf180mcu_fd_sc_mcu7t5v0__fillcap_4
Xclkbuf_leaf_95_clk_i _4400_/CLK VSS VDD clkload0/I VDD VSS gf180mcu_fd_sc_mcu7t5v0__clkbuf_2
XFILLER_260_737 VDD VSS VDD VSS gf180mcu_fd_sc_mcu7t5v0__fillcap_64
XFILLER_198_877 VDD VSS VDD VSS gf180mcu_fd_sc_mcu7t5v0__fillcap_8
XFILLER_138_410 VDD VSS VDD VSS gf180mcu_fd_sc_mcu7t5v0__fillcap_4
Xclkbuf_leaf_33_clk_i _4514_/CLK VSS VDD clkload4/I VDD VSS gf180mcu_fd_sc_mcu7t5v0__clkbuf_2
XFILLER_219_2 VDD VSS VDD VSS gf180mcu_fd_sc_mcu7t5v0__fillcap_64
XFILLER_153_446 VDD VSS VDD VSS gf180mcu_fd_sc_mcu7t5v0__fillcap_16
XFILLER_134_660 VDD VSS VDD VSS gf180mcu_fd_sc_mcu7t5v0__fillcap_4
XFILLER_125_159 VDD VSS VDD VSS gf180mcu_fd_sc_mcu7t5v0__fillcap_4
Xclkbuf_leaf_48_clk_i _4553_/CLK VSS VDD clkload5/I VDD VSS gf180mcu_fd_sc_mcu7t5v0__clkbuf_2
XFILLER_140_107 VDD VSS VDD VSS gf180mcu_fd_sc_mcu7t5v0__fillcap_32
XFILLER_121_343 VDD VSS VDD VSS gf180mcu_fd_sc_mcu7t5v0__fillcap_4
XFILLER_106_395 VDD VSS VDD VSS gf180mcu_fd_sc_mcu7t5v0__fillcap_32
XFILLER_122_877 VDD VSS VDD VSS gf180mcu_fd_sc_mcu7t5v0__fillcap_8
XFILLER_95_717 VDD VSS VDD VSS gf180mcu_fd_sc_mcu7t5v0__fillcap_4
XFILLER_250_247 VDD VSS VDD VSS gf180mcu_fd_sc_mcu7t5v0__fillcap_64
XFILLER_188_310 VDD VSS VDD VSS gf180mcu_fd_sc_mcu7t5v0__fillcap_4
XFILLER_204_675 VDD VSS VDD VSS gf180mcu_fd_sc_mcu7t5v0__fillcap_4
X_2850_ _2850_/B wire93/Z VDD VSS _2854_/A1 _2850_/A1 _2850_/A2 VDD VSS gf180mcu_fd_sc_mcu7t5v0__aoi211_1
XFILLER_188_365 VDD VSS VDD VSS gf180mcu_fd_sc_mcu7t5v0__fillcap_4
XFILLER_188_387 VDD VSS VDD VSS gf180mcu_fd_sc_mcu7t5v0__fillcap_8
X_2781_ VDD VSS _3214_/A3 _3036_/B _3027_/A3 VDD VSS gf180mcu_fd_sc_mcu7t5v0__nand2_1
X_4520_ VSS _4522_/CLK VDD _4520_/D _4520_/Q wire199/I VDD VSS gf180mcu_fd_sc_mcu7t5v0__dffsnq_1
Xwire192 wire192/Z VSS VDD wire193/Z VDD VSS gf180mcu_fd_sc_mcu7t5v0__clkbuf_8
X_4451_ _4451_/D _4451_/Q wire207/Z VSS _4451_/CLK VDD VDD VSS gf180mcu_fd_sc_mcu7t5v0__dffrnq_1
XFILLER_144_457 VDD VSS VDD VSS gf180mcu_fd_sc_mcu7t5v0__fillcap_8
X_3402_ _3424_/S VDD VSS _4445_/D _4403_/Q _4445_/Q VDD VSS gf180mcu_fd_sc_mcu7t5v0__mux2_2
XFILLER_172_799 VDD VSS VDD VSS gf180mcu_fd_sc_mcu7t5v0__fillcap_4
X_4382_ _4382_/D _4382_/Q wire186/Z VSS _4427_/CLK VDD VDD VSS gf180mcu_fd_sc_mcu7t5v0__dffrnq_1
XFILLER_140_652 VDD VSS VDD VSS gf180mcu_fd_sc_mcu7t5v0__fillcap_4
X_3333_ _3333_/B1 _3333_/B2 VDD VSS _4384_/D _3333_/A1 _3333_/A2 VDD VSS gf180mcu_fd_sc_mcu7t5v0__aoi22_1
X_3264_ _3268_/B1 _4367_/Q VDD VSS _3265_/I _4360_/Q _4526_/D VDD VSS gf180mcu_fd_sc_mcu7t5v0__aoi22_1
XFILLER_100_527 VDD VSS VDD VSS gf180mcu_fd_sc_mcu7t5v0__fillcap_64
X_2215_ VDD VSS _2348_/A3 _4316_/Q _4502_/Q VDD VSS gf180mcu_fd_sc_mcu7t5v0__nand2_1
XFILLER_112_387 VDD VSS VDD VSS gf180mcu_fd_sc_mcu7t5v0__fillcap_8
X_3195_ VDD VSS _3196_/B _4339_/Q _3200_/A2 VDD VSS gf180mcu_fd_sc_mcu7t5v0__nand2_1
XFILLER_81_422 VDD VSS VDD VSS gf180mcu_fd_sc_mcu7t5v0__fillcap_64
XFILLER_93_282 VDD VSS VDD VSS gf180mcu_fd_sc_mcu7t5v0__fillcap_16
XFILLER_93_260 VDD VSS VDD VSS gf180mcu_fd_sc_mcu7t5v0__fillcap_16
X_2146_ VDD VSS _4138_/D _2146_/A1 _2146_/A2 VDD VSS gf180mcu_fd_sc_mcu7t5v0__nand2_1
XFILLER_242_737 VDD VSS VDD VSS gf180mcu_fd_sc_mcu7t5v0__fillcap_64
XFILLER_254_597 VDD VSS VDD VSS gf180mcu_fd_sc_mcu7t5v0__fillcap_64
X_2077_ VDD VSS _2114_/A2 wire93/I _2074_/Z VDD VSS gf180mcu_fd_sc_mcu7t5v0__nor2_1
XFILLER_198_107 VDD VSS VDD VSS gf180mcu_fd_sc_mcu7t5v0__fillcap_16
XFILLER_201_50 VDD VSS VDD VSS gf180mcu_fd_sc_mcu7t5v0__fillcap_16
XFILLER_201_72 VDD VSS VDD VSS gf180mcu_fd_sc_mcu7t5v0__fillcap_64
XFILLER_179_343 VDD VSS VDD VSS gf180mcu_fd_sc_mcu7t5v0__fillcap_4
XFILLER_14_37 VDD VSS VDD VSS gf180mcu_fd_sc_mcu7t5v0__fillcap_64
X_2979_ VDD VSS _3214_/A4 _1926_/I _3036_/B VDD VSS gf180mcu_fd_sc_mcu7t5v0__nand2_1
XFILLER_104_822 VDD VSS VDD VSS gf180mcu_fd_sc_mcu7t5v0__fillcap_16
XFILLER_150_449 VDD VSS VDD VSS gf180mcu_fd_sc_mcu7t5v0__fillcap_4
XFILLER_89_533 VDD VSS VDD VSS gf180mcu_fd_sc_mcu7t5v0__fillcap_8
XFILLER_104_844 VDD VSS VDD VSS gf180mcu_fd_sc_mcu7t5v0__fillcap_8
XFILLER_103_376 VDD VSS VDD VSS gf180mcu_fd_sc_mcu7t5v0__fillcap_4
XFILLER_264_317 VDD VSS VDD VSS gf180mcu_fd_sc_mcu7t5v0__fillcap_64
XFILLER_103_398 VDD VSS VDD VSS gf180mcu_fd_sc_mcu7t5v0__fillcap_16
XFILLER_218_745 VDD VSS VDD VSS gf180mcu_fd_sc_mcu7t5v0__fillcap_4
XFILLER_85_772 VDD VSS VDD VSS gf180mcu_fd_sc_mcu7t5v0__fillcap_8
XFILLER_217_233 VDD VSS VDD VSS gf180mcu_fd_sc_mcu7t5v0__fillcap_8
XFILLER_169_2 VDD VSS VDD VSS gf180mcu_fd_sc_mcu7t5v0__fillcap_32
XFILLER_55_66 VDD VSS VDD VSS gf180mcu_fd_sc_mcu7t5v0__fillcap_4
XFILLER_232_247 VDD VSS VDD VSS gf180mcu_fd_sc_mcu7t5v0__fillcap_64
XFILLER_111_50 VDD VSS VDD VSS gf180mcu_fd_sc_mcu7t5v0__fillcap_16
XFILLER_41_842 VDD VSS VDD VSS gf180mcu_fd_sc_mcu7t5v0__fillcap_32
XFILLER_111_72 VDD VSS VDD VSS gf180mcu_fd_sc_mcu7t5v0__fillcap_4
XFILLER_158_527 VDD VSS VDD VSS gf180mcu_fd_sc_mcu7t5v0__fillcap_16
XFILLER_200_199 VDD VSS VDD VSS gf180mcu_fd_sc_mcu7t5v0__fillcap_4
XFILLER_181_552 VDD VSS VDD VSS gf180mcu_fd_sc_mcu7t5v0__fillcap_8
XFILLER_154_788 VDD VSS VDD VSS gf180mcu_fd_sc_mcu7t5v0__fillcap_16
XFILLER_141_416 VDD VSS VDD VSS gf180mcu_fd_sc_mcu7t5v0__fillcap_4
XFILLER_256_807 VDD VSS VDD VSS gf180mcu_fd_sc_mcu7t5v0__fillcap_64
XFILLER_209_734 VDD VSS VDD VSS gf180mcu_fd_sc_mcu7t5v0__fillcap_4
X_2000_ VDD VSS _4475_/Q _3594_/A1 VDD VSS gf180mcu_fd_sc_mcu7t5v0__clkinv_1
XFILLER_63_422 VDD VSS VDD VSS gf180mcu_fd_sc_mcu7t5v0__fillcap_64
XFILLER_75_282 VDD VSS VDD VSS gf180mcu_fd_sc_mcu7t5v0__fillcap_64
XFILLER_224_737 VDD VSS VDD VSS gf180mcu_fd_sc_mcu7t5v0__fillcap_4
XFILLER_236_597 VDD VSS VDD VSS gf180mcu_fd_sc_mcu7t5v0__fillcap_16
XFILLER_90_241 VDD VSS VDD VSS gf180mcu_fd_sc_mcu7t5v0__fillcap_4
XFILLER_251_556 VDD VSS VDD VSS gf180mcu_fd_sc_mcu7t5v0__fillcap_4
X_3951_ VDD _3951_/Q _3967_/CLK VSS _3951_/D VDD VSS gf180mcu_fd_sc_mcu7t5v0__dffq_1
XFILLER_204_450 VDD VSS VDD VSS gf180mcu_fd_sc_mcu7t5v0__fillcap_4
X_2902_ VDD VSS _3013_/A2 _3008_/B2 _4324_/Q VDD VSS gf180mcu_fd_sc_mcu7t5v0__nand2_1
XFILLER_177_836 VDD VSS VDD VSS gf180mcu_fd_sc_mcu7t5v0__fillcap_4
X_3882_ VDD _3882_/Q _3969_/CLK VSS _3882_/D VDD VSS gf180mcu_fd_sc_mcu7t5v0__dffq_1
XFILLER_31_352 VDD VSS VDD VSS gf180mcu_fd_sc_mcu7t5v0__fillcap_64
XFILLER_176_335 VDD VSS VDD VSS gf180mcu_fd_sc_mcu7t5v0__fillcap_4
X_2833_ _2833_/A3 VDD VSS _2888_/A1 _3045_/C _2893_/A1 VDD VSS gf180mcu_fd_sc_mcu7t5v0__nand3_1
XFILLER_176_346 VDD VSS VDD VSS gf180mcu_fd_sc_mcu7t5v0__fillcap_4
XFILLER_84_2 VDD VSS VDD VSS gf180mcu_fd_sc_mcu7t5v0__fillcap_32
X_2764_ VDD VSS _4297_/D _4297_/Q _2763_/S VDD VSS gf180mcu_fd_sc_mcu7t5v0__xnor2_1
XFILLER_164_519 VDD VSS VDD VSS gf180mcu_fd_sc_mcu7t5v0__fillcap_4
X_4503_ _4503_/D _4503_/Q wire192/Z VSS _4586_/CLK VDD VDD VSS gf180mcu_fd_sc_mcu7t5v0__dffrnq_1
X_2695_ VDD _2695_/B _2695_/A2 _2696_/B _2698_/B VSS VDD VSS gf180mcu_fd_sc_mcu7t5v0__oai21_1
XFILLER_145_788 VDD VSS VDD VSS gf180mcu_fd_sc_mcu7t5v0__fillcap_4
XFILLER_144_287 VDD VSS VDD VSS gf180mcu_fd_sc_mcu7t5v0__fillcap_16
X_4434_ _4434_/D _4434_/Q _4473_/RN VSS _4441_/CLK VDD VDD VSS gf180mcu_fd_sc_mcu7t5v0__dffrnq_1
XFILLER_117_479 VDD VSS VDD VSS gf180mcu_fd_sc_mcu7t5v0__fillcap_8
X_4365_ _4365_/D _4365_/Q wire183/Z VSS _4365_/CLK VDD VDD VSS gf180mcu_fd_sc_mcu7t5v0__dffrnq_1
XFILLER_104_129 VDD VSS VDD VSS gf180mcu_fd_sc_mcu7t5v0__fillcap_4
XFILLER_132_449 VDD VSS VDD VSS gf180mcu_fd_sc_mcu7t5v0__fillcap_4
X_3316_ _3325_/B VDD VSS _4379_/D _4378_/Q _4379_/Q VDD VSS gf180mcu_fd_sc_mcu7t5v0__mux2_2
X_4296_ _4296_/D _4296_/Q _4530_/RN VSS _4305_/CLK VDD VDD VSS gf180mcu_fd_sc_mcu7t5v0__dffrnq_1
XFILLER_258_177 VDD VSS VDD VSS gf180mcu_fd_sc_mcu7t5v0__fillcap_64
XFILLER_246_317 VDD VSS VDD VSS gf180mcu_fd_sc_mcu7t5v0__fillcap_64
X_3247_ wire23/I VDD VSS _4355_/D _3246_/Z _4355_/Q VDD VSS gf180mcu_fd_sc_mcu7t5v0__mux2_2
X_3178_ VDD VSS _3179_/B _3176_/S _3904_/Q VDD VSS gf180mcu_fd_sc_mcu7t5v0__nor2_1
XFILLER_227_542 VDD VSS VDD VSS gf180mcu_fd_sc_mcu7t5v0__fillcap_16
XFILLER_67_772 VDD VSS VDD VSS gf180mcu_fd_sc_mcu7t5v0__fillcap_64
X_2129_ VDD VSS _2130_/A2 wire127/Z _2510_/A2 VDD VSS gf180mcu_fd_sc_mcu7t5v0__nand2_1
XFILLER_23_842 VDD VSS VDD VSS gf180mcu_fd_sc_mcu7t5v0__fillcap_32
XFILLER_50_661 VDD VSS VDD VSS gf180mcu_fd_sc_mcu7t5v0__fillcap_4
XFILLER_163_574 VDD VSS VDD VSS gf180mcu_fd_sc_mcu7t5v0__fillcap_32
XFILLER_135_276 VDD VSS VDD VSS gf180mcu_fd_sc_mcu7t5v0__fillcap_4
XFILLER_1_212 VDD VSS VDD VSS gf180mcu_fd_sc_mcu7t5v0__fillcap_64
XFILLER_238_807 VDD VSS VDD VSS gf180mcu_fd_sc_mcu7t5v0__fillcap_64
XFILLER_89_352 VDD VSS VDD VSS gf180mcu_fd_sc_mcu7t5v0__fillcap_64
XFILLER_265_626 VDD VSS VDD VSS gf180mcu_fd_sc_mcu7t5v0__fillcap_4
XFILLER_45_422 VDD VSS VDD VSS gf180mcu_fd_sc_mcu7t5v0__fillcap_64
XFILLER_218_597 VDD VSS VDD VSS gf180mcu_fd_sc_mcu7t5v0__fillcap_16
XFILLER_57_282 VDD VSS VDD VSS gf180mcu_fd_sc_mcu7t5v0__fillcap_64
XFILLER_72_241 VDD VSS VDD VSS gf180mcu_fd_sc_mcu7t5v0__fillcap_4
XFILLER_13_352 VDD VSS VDD VSS gf180mcu_fd_sc_mcu7t5v0__fillcap_64
XFILLER_40_171 VDD VSS VDD VSS gf180mcu_fd_sc_mcu7t5v0__fillcap_4
XFILLER_146_519 VDD VSS VDD VSS gf180mcu_fd_sc_mcu7t5v0__fillcap_4
XFILLER_126_232 VDD VSS VDD VSS gf180mcu_fd_sc_mcu7t5v0__fillcap_8
XFILLER_5_562 VDD VSS VDD VSS gf180mcu_fd_sc_mcu7t5v0__fillcap_64
X_2480_ _2482_/S VDD VSS _4103_/D _4103_/Q wire154/Z VDD VSS gf180mcu_fd_sc_mcu7t5v0__mux2_2
X_4150_ _4150_/D _4150_/Q _4473_/RN VSS _4477_/CLK VDD VDD VSS gf180mcu_fd_sc_mcu7t5v0__dffrnq_1
X_3101_ _3101_/B wire97/Z VDD VSS _3103_/B _3124_/A1 _3793_/A1 VDD VSS gf180mcu_fd_sc_mcu7t5v0__aoi211_1
XFILLER_228_317 VDD VSS VDD VSS gf180mcu_fd_sc_mcu7t5v0__fillcap_64
X_4081_ VDD _4081_/Q _4081_/CLK VSS _4081_/D VDD VSS gf180mcu_fd_sc_mcu7t5v0__dffq_1
XFILLER_209_553 VDD VSS VDD VSS gf180mcu_fd_sc_mcu7t5v0__fillcap_4
XFILLER_255_136 VDD VSS VDD VSS gf180mcu_fd_sc_mcu7t5v0__fillcap_4
X_3032_ _2992_/C _3032_/A4 VDD VSS _3033_/A2 _3032_/A1 _3032_/A2 VDD VSS gf180mcu_fd_sc_mcu7t5v0__nand4_1
XFILLER_49_772 VDD VSS VDD VSS gf180mcu_fd_sc_mcu7t5v0__fillcap_64
XFILLER_224_512 VDD VSS VDD VSS gf180mcu_fd_sc_mcu7t5v0__fillcap_8
XFILLER_209_586 VDD VSS VDD VSS gf180mcu_fd_sc_mcu7t5v0__fillcap_16
XFILLER_76_591 VDD VSS VDD VSS gf180mcu_fd_sc_mcu7t5v0__fillcap_4
XFILLER_64_731 VDD VSS VDD VSS gf180mcu_fd_sc_mcu7t5v0__fillcap_4
X_3934_ VDD _3934_/Q _3936_/CLK VSS _3934_/D VDD VSS gf180mcu_fd_sc_mcu7t5v0__dffq_1
XFILLER_196_419 VDD VSS VDD VSS gf180mcu_fd_sc_mcu7t5v0__fillcap_8
XFILLER_20_801 VDD VSS VDD VSS gf180mcu_fd_sc_mcu7t5v0__fillcap_4
XFILLER_32_661 VDD VSS VDD VSS gf180mcu_fd_sc_mcu7t5v0__fillcap_4
X_3865_ _3865_/D _3866_/D _4613_/RN VSS _4606_/CLK VDD VDD VSS gf180mcu_fd_sc_mcu7t5v0__dffrnq_1
XFILLER_177_666 VDD VSS VDD VSS gf180mcu_fd_sc_mcu7t5v0__fillcap_16
XFILLER_192_614 VDD VSS VDD VSS gf180mcu_fd_sc_mcu7t5v0__fillcap_32
XFILLER_137_508 VDD VSS VDD VSS gf180mcu_fd_sc_mcu7t5v0__fillcap_8
X_2816_ VDD VSS _3037_/A1 _3064_/A1 _3004_/C VDD VSS gf180mcu_fd_sc_mcu7t5v0__nand2_1
XFILLER_149_368 VDD VSS VDD VSS gf180mcu_fd_sc_mcu7t5v0__fillcap_8
X_3796_ VDD VSS _3797_/B _3845_/I0 wire16/Z VDD VSS gf180mcu_fd_sc_mcu7t5v0__nor2_1
X_2747_ _2754_/S VDD VSS _4281_/D _4281_/Q _2747_/I1 VDD VSS gf180mcu_fd_sc_mcu7t5v0__mux2_2
XFILLER_164_349 VDD VSS VDD VSS gf180mcu_fd_sc_mcu7t5v0__fillcap_16
XFILLER_118_777 VDD VSS VDD VSS gf180mcu_fd_sc_mcu7t5v0__fillcap_4
X_2678_ VDD VSS _2679_/B _4310_/Q _4503_/D VDD VSS gf180mcu_fd_sc_mcu7t5v0__nand2_1
XFILLER_118_799 VDD VSS VDD VSS gf180mcu_fd_sc_mcu7t5v0__fillcap_4
X_4417_ _4417_/D _4417_/Q wire210/Z VSS _4459_/CLK VDD VDD VSS gf180mcu_fd_sc_mcu7t5v0__dffrnq_1
XFILLER_160_577 VDD VSS VDD VSS gf180mcu_fd_sc_mcu7t5v0__fillcap_8
X_4348_ _4348_/D _4348_/Q wire199/Z VSS _4529_/CLK VDD VDD VSS gf180mcu_fd_sc_mcu7t5v0__dffrnq_1
XFILLER_86_311 VDD VSS VDD VSS gf180mcu_fd_sc_mcu7t5v0__fillcap_4
XFILLER_87_856 VDD VSS VDD VSS gf180mcu_fd_sc_mcu7t5v0__fillcap_32
XFILLER_247_626 VDD VSS VDD VSS gf180mcu_fd_sc_mcu7t5v0__fillcap_4
XFILLER_259_486 VDD VSS VDD VSS gf180mcu_fd_sc_mcu7t5v0__fillcap_4
X_4279_ _4279_/D _4279_/Q wire207/Z VSS _4283_/CLK VDD VDD VSS gf180mcu_fd_sc_mcu7t5v0__dffrnq_1
XFILLER_100_154 VDD VSS VDD VSS gf180mcu_fd_sc_mcu7t5v0__fillcap_16
XFILLER_27_422 VDD VSS VDD VSS gf180mcu_fd_sc_mcu7t5v0__fillcap_64
XFILLER_39_282 VDD VSS VDD VSS gf180mcu_fd_sc_mcu7t5v0__fillcap_64
XFILLER_215_556 VDD VSS VDD VSS gf180mcu_fd_sc_mcu7t5v0__fillcap_4
XFILLER_54_241 VDD VSS VDD VSS gf180mcu_fd_sc_mcu7t5v0__fillcap_4
XFILLER_230_559 VDD VSS VDD VSS gf180mcu_fd_sc_mcu7t5v0__fillcap_16
XFILLER_211_795 VDD VSS VDD VSS gf180mcu_fd_sc_mcu7t5v0__fillcap_8
XFILLER_210_261 VDD VSS VDD VSS gf180mcu_fd_sc_mcu7t5v0__fillcap_8
XFILLER_167_132 VDD VSS VDD VSS gf180mcu_fd_sc_mcu7t5v0__fillcap_8
XFILLER_10_311 VDD VSS VDD VSS gf180mcu_fd_sc_mcu7t5v0__fillcap_4
XFILLER_22_171 VDD VSS VDD VSS gf180mcu_fd_sc_mcu7t5v0__fillcap_4
XFILLER_151_500 VDD VSS VDD VSS gf180mcu_fd_sc_mcu7t5v0__fillcap_4
XFILLER_124_714 VDD VSS VDD VSS gf180mcu_fd_sc_mcu7t5v0__fillcap_4
XFILLER_191_691 VDD VSS VDD VSS gf180mcu_fd_sc_mcu7t5v0__fillcap_8
XFILLER_123_224 VDD VSS VDD VSS gf180mcu_fd_sc_mcu7t5v0__fillcap_8
XFILLER_2_521 VDD VSS VDD VSS gf180mcu_fd_sc_mcu7t5v0__fillcap_4
XFILLER_78_801 VDD VSS VDD VSS gf180mcu_fd_sc_mcu7t5v0__fillcap_4
XFILLER_93_815 VDD VSS VDD VSS gf180mcu_fd_sc_mcu7t5v0__fillcap_16
XFILLER_237_136 VDD VSS VDD VSS gf180mcu_fd_sc_mcu7t5v0__fillcap_4
XFILLER_58_591 VDD VSS VDD VSS gf180mcu_fd_sc_mcu7t5v0__fillcap_4
XFILLER_46_731 VDD VSS VDD VSS gf180mcu_fd_sc_mcu7t5v0__fillcap_4
X_1980_ VDD VSS _4382_/Q _3305_/C VDD VSS gf180mcu_fd_sc_mcu7t5v0__clkinv_1
XFILLER_14_661 VDD VSS VDD VSS gf180mcu_fd_sc_mcu7t5v0__fillcap_4
XFILLER_9_142 VDD VSS VDD VSS gf180mcu_fd_sc_mcu7t5v0__fillcap_64
X_3650_ _3650_/A3 VDD VSS _4485_/D _3681_/A1 _3650_/A2 VDD VSS gf180mcu_fd_sc_mcu7t5v0__nand3_1
XFILLER_228_37 VDD VSS VDD VSS gf180mcu_fd_sc_mcu7t5v0__fillcap_64
X_2601_ VDD _4206_/D _2601_/B _4206_/Q _2634_/A3 VSS _2601_/A3 VDD VSS gf180mcu_fd_sc_mcu7t5v0__oai31_1
XFILLER_127_552 VDD VSS VDD VSS gf180mcu_fd_sc_mcu7t5v0__fillcap_8
X_3581_ _3581_/A3 VDD VSS _3582_/B _4592_/Q _3581_/A2 VDD VSS gf180mcu_fd_sc_mcu7t5v0__nand3_1
X_2532_ _2535_/S VDD VSS _4158_/D _4158_/Q wire119/Z VDD VSS gf180mcu_fd_sc_mcu7t5v0__mux2_2
XFILLER_6_871 VDD VSS VDD VSS gf180mcu_fd_sc_mcu7t5v0__fillcap_4
XFILLER_142_577 VDD VSS VDD VSS gf180mcu_fd_sc_mcu7t5v0__fillcap_8
X_4202_ _4202_/D _4202_/Q _4527_/RN VSS _4468_/CLK VDD VDD VSS gf180mcu_fd_sc_mcu7t5v0__dffrnq_1
X_2463_ _2463_/S VDD VSS _4089_/D wire150/Z _4089_/Q VDD VSS gf180mcu_fd_sc_mcu7t5v0__mux2_2
XFILLER_47_2 VDD VSS VDD VSS gf180mcu_fd_sc_mcu7t5v0__fillcap_64
XFILLER_68_311 VDD VSS VDD VSS gf180mcu_fd_sc_mcu7t5v0__fillcap_4
X_2394_ VDD VSS _2423_/A2 _4580_/Q _2432_/A2 VDD VSS gf180mcu_fd_sc_mcu7t5v0__nor2_1
XFILLER_123_780 VDD VSS VDD VSS gf180mcu_fd_sc_mcu7t5v0__fillcap_4
XFILLER_229_626 VDD VSS VDD VSS gf180mcu_fd_sc_mcu7t5v0__fillcap_4
XFILLER_229_648 VDD VSS VDD VSS gf180mcu_fd_sc_mcu7t5v0__fillcap_8
X_4133_ _4133_/D _4133_/Q _4536_/RN VSS _4536_/CLK VDD VDD VSS gf180mcu_fd_sc_mcu7t5v0__dffrnq_1
XFILLER_3_72 VDD VSS VDD VSS gf180mcu_fd_sc_mcu7t5v0__fillcap_64
X_4064_ VDD _4064_/Q _4123_/CLK VSS _4064_/D VDD VSS gf180mcu_fd_sc_mcu7t5v0__dffq_1
X_3015_ _3015_/B _3015_/C VDD VSS _3016_/A2 _2813_/C _3017_/B1 VDD VSS gf180mcu_fd_sc_mcu7t5v0__aoi211_1
Xwire45 VSS wire45/Z wire45/I VDD VDD VSS gf180mcu_fd_sc_mcu7t5v0__buf_1
Xwire23 wire23/Z VSS VDD wire23/I VDD VSS gf180mcu_fd_sc_mcu7t5v0__clkbuf_3
XFILLER_36_241 VDD VSS VDD VSS gf180mcu_fd_sc_mcu7t5v0__fillcap_4
Xwire78 VSS wire78/Z wire78/I VDD VDD VSS gf180mcu_fd_sc_mcu7t5v0__buf_2
Xwire67 VDD wire67/I VSS wire67/Z VDD VSS gf180mcu_fd_sc_mcu7t5v0__dlyb_1
Xwire56 wire56/Z VSS VDD wire56/I VDD VSS gf180mcu_fd_sc_mcu7t5v0__clkbuf_8
XFILLER_197_717 VDD VSS VDD VSS gf180mcu_fd_sc_mcu7t5v0__fillcap_16
XFILLER_212_559 VDD VSS VDD VSS gf180mcu_fd_sc_mcu7t5v0__fillcap_4
XFILLER_196_238 VDD VSS VDD VSS gf180mcu_fd_sc_mcu7t5v0__fillcap_4
XFILLER_177_441 VDD VSS VDD VSS gf180mcu_fd_sc_mcu7t5v0__fillcap_8
X_3917_ VDD _3917_/Q _4001_/CLK VSS _3917_/D VDD VSS gf180mcu_fd_sc_mcu7t5v0__dffq_1
X_3848_ _3848_/S VDD VSS _4001_/D _3848_/I0 _4001_/Q VDD VSS gf180mcu_fd_sc_mcu7t5v0__mux2_2
XFILLER_22_37 VDD VSS VDD VSS gf180mcu_fd_sc_mcu7t5v0__fillcap_64
X_3779_ _3786_/S VDD VSS _3946_/D _4289_/Q _3946_/Q VDD VSS gf180mcu_fd_sc_mcu7t5v0__mux2_2
XFILLER_138_37 VDD VSS VDD VSS gf180mcu_fd_sc_mcu7t5v0__fillcap_8
XFILLER_160_330 VDD VSS VDD VSS gf180mcu_fd_sc_mcu7t5v0__fillcap_16
XFILLER_219_136 VDD VSS VDD VSS gf180mcu_fd_sc_mcu7t5v0__fillcap_4
XFILLER_28_731 VDD VSS VDD VSS gf180mcu_fd_sc_mcu7t5v0__fillcap_4
XFILLER_90_807 VDD VSS VDD VSS gf180mcu_fd_sc_mcu7t5v0__fillcap_4
XFILLER_170_79 VDD VSS VDD VSS gf180mcu_fd_sc_mcu7t5v0__fillcap_4
XFILLER_249_2 VDD VSS VDD VSS gf180mcu_fd_sc_mcu7t5v0__fillcap_64
XFILLER_70_597 VDD VSS VDD VSS gf180mcu_fd_sc_mcu7t5v0__fillcap_64
XFILLER_179_88 VDD VSS VDD VSS gf180mcu_fd_sc_mcu7t5v0__fillcap_8
XFILLER_183_400 VDD VSS VDD VSS gf180mcu_fd_sc_mcu7t5v0__fillcap_4
XFILLER_195_282 VDD VSS VDD VSS gf180mcu_fd_sc_mcu7t5v0__fillcap_32
XFILLER_6_101 VDD VSS VDD VSS gf180mcu_fd_sc_mcu7t5v0__fillcap_4
XFILLER_155_135 VDD VSS VDD VSS gf180mcu_fd_sc_mcu7t5v0__fillcap_4
Xmax_length131 VSS _2739_/I1 wire132/Z VDD VDD VSS gf180mcu_fd_sc_mcu7t5v0__clkbuf_1
Xmax_length175 VSS _3845_/I0 _4293_/Q VDD VDD VSS gf180mcu_fd_sc_mcu7t5v0__buf_2
XFILLER_143_319 VDD VSS VDD VSS gf180mcu_fd_sc_mcu7t5v0__fillcap_4
Xmax_length197 _4535_/RN _4536_/RN VDD VSS VDD VSS gf180mcu_fd_sc_mcu7t5v0__buf_4
XFILLER_88_30 VDD VSS VDD VSS gf180mcu_fd_sc_mcu7t5v0__fillcap_4
XFILLER_163_190 VDD VSS VDD VSS gf180mcu_fd_sc_mcu7t5v0__fillcap_4
XFILLER_151_352 VDD VSS VDD VSS gf180mcu_fd_sc_mcu7t5v0__fillcap_16
XFILLER_3_874 VDD VSS VDD VSS gf180mcu_fd_sc_mcu7t5v0__fillcap_16
XFILLER_105_780 VDD VSS VDD VSS gf180mcu_fd_sc_mcu7t5v0__fillcap_8
XFILLER_93_612 VDD VSS VDD VSS gf180mcu_fd_sc_mcu7t5v0__fillcap_16
XFILLER_207_821 VDD VSS VDD VSS gf180mcu_fd_sc_mcu7t5v0__fillcap_16
XFILLER_18_241 VDD VSS VDD VSS gf180mcu_fd_sc_mcu7t5v0__fillcap_4
XFILLER_92_177 VDD VSS VDD VSS gf180mcu_fd_sc_mcu7t5v0__fillcap_64
XFILLER_80_317 VDD VSS VDD VSS gf180mcu_fd_sc_mcu7t5v0__fillcap_64
XFILLER_261_492 VDD VSS VDD VSS gf180mcu_fd_sc_mcu7t5v0__fillcap_64
XFILLER_159_452 VDD VSS VDD VSS gf180mcu_fd_sc_mcu7t5v0__fillcap_8
X_1963_ VDD VSS _4237_/Q _2679_/A1 VDD VSS gf180mcu_fd_sc_mcu7t5v0__clkinv_1
X_3702_ _3706_/S VDD VSS _3885_/D _3885_/Q _3763_/I0 VDD VSS gf180mcu_fd_sc_mcu7t5v0__mux2_2
XFILLER_147_625 VDD VSS VDD VSS gf180mcu_fd_sc_mcu7t5v0__fillcap_4
X_3633_ VSS VDD _4346_/Q _3633_/C1 _4174_/Q _3685_/A2 _2039_/Z _4141_/Q _3634_/A2
+ VDD VSS gf180mcu_fd_sc_mcu7t5v0__aoi222_1
XFILLER_186_293 VDD VSS VDD VSS gf180mcu_fd_sc_mcu7t5v0__fillcap_4
XFILLER_143_842 VDD VSS VDD VSS gf180mcu_fd_sc_mcu7t5v0__fillcap_16
X_3564_ _3564_/S VDD VSS _3564_/Z _4063_/Q _4055_/Q VDD VSS gf180mcu_fd_sc_mcu7t5v0__mux2_2
X_2515_ _2731_/S VDD VSS _4144_/D _4144_/Q wire133/Z VDD VSS gf180mcu_fd_sc_mcu7t5v0__mux2_2
XFILLER_142_341 VDD VSS VDD VSS gf180mcu_fd_sc_mcu7t5v0__fillcap_4
X_3495_ _3495_/A3 VDD VSS _3495_/Z wire42/Z _3495_/A2 VDD VSS gf180mcu_fd_sc_mcu7t5v0__and3_1
X_2446_ _2446_/B VDD VSS _4075_/D _3462_/A2 _2454_/S VDD VSS gf180mcu_fd_sc_mcu7t5v0__aoi21_1
X_2377_ _2383_/S VDD VSS _4019_/D _4019_/Q _2466_/I0 VDD VSS gf180mcu_fd_sc_mcu7t5v0__mux2_2
XFILLER_111_772 VDD VSS VDD VSS gf180mcu_fd_sc_mcu7t5v0__fillcap_16
X_4116_ VDD _4116_/Q _4126_/CLK VSS _4116_/D VDD VSS gf180mcu_fd_sc_mcu7t5v0__dffq_1
XFILLER_209_180 VDD VSS VDD VSS gf180mcu_fd_sc_mcu7t5v0__fillcap_16
XFILLER_72_807 VDD VSS VDD VSS gf180mcu_fd_sc_mcu7t5v0__fillcap_64
X_4047_ VDD _4047_/Q _4047_/CLK VSS _4047_/D VDD VSS gf180mcu_fd_sc_mcu7t5v0__dffq_1
XFILLER_40_737 VDD VSS VDD VSS gf180mcu_fd_sc_mcu7t5v0__fillcap_64
XFILLER_52_597 VDD VSS VDD VSS gf180mcu_fd_sc_mcu7t5v0__fillcap_64
XFILLER_149_47 VDD VSS VDD VSS gf180mcu_fd_sc_mcu7t5v0__fillcap_16
XFILLER_165_422 VDD VSS VDD VSS gf180mcu_fd_sc_mcu7t5v0__fillcap_16
XFILLER_177_282 VDD VSS VDD VSS gf180mcu_fd_sc_mcu7t5v0__fillcap_16
XFILLER_153_617 VDD VSS VDD VSS gf180mcu_fd_sc_mcu7t5v0__fillcap_8
XFILLER_125_308 VDD VSS VDD VSS gf180mcu_fd_sc_mcu7t5v0__fillcap_8
XFILLER_133_352 VDD VSS VDD VSS gf180mcu_fd_sc_mcu7t5v0__fillcap_16
XFILLER_121_536 VDD VSS VDD VSS gf180mcu_fd_sc_mcu7t5v0__fillcap_8
XFILLER_181_34 VDD VSS VDD VSS gf180mcu_fd_sc_mcu7t5v0__fillcap_16
XFILLER_263_702 VDD VSS VDD VSS gf180mcu_fd_sc_mcu7t5v0__fillcap_64
XFILLER_101_282 VDD VSS VDD VSS gf180mcu_fd_sc_mcu7t5v0__fillcap_8
XFILLER_74_177 VDD VSS VDD VSS gf180mcu_fd_sc_mcu7t5v0__fillcap_64
XFILLER_62_317 VDD VSS VDD VSS gf180mcu_fd_sc_mcu7t5v0__fillcap_64
XFILLER_243_492 VDD VSS VDD VSS gf180mcu_fd_sc_mcu7t5v0__fillcap_64
XFILLER_231_632 VDD VSS VDD VSS gf180mcu_fd_sc_mcu7t5v0__fillcap_8
XFILLER_169_772 VDD VSS VDD VSS gf180mcu_fd_sc_mcu7t5v0__fillcap_64
XFILLER_129_625 VDD VSS VDD VSS gf180mcu_fd_sc_mcu7t5v0__fillcap_4
XFILLER_30_247 VDD VSS VDD VSS gf180mcu_fd_sc_mcu7t5v0__fillcap_64
XFILLER_137_691 VDD VSS VDD VSS gf180mcu_fd_sc_mcu7t5v0__fillcap_8
X_2300_ _4511_/Q VDD VSS _2301_/B _4534_/Q _4220_/Q VDD VSS gf180mcu_fd_sc_mcu7t5v0__aoi21_1
X_3280_ VDD VSS _3334_/A2 _4385_/Q _3331_/A2 VDD VSS gf180mcu_fd_sc_mcu7t5v0__nor2_1
X_2231_ VDD VSS _4535_/D _4322_/Q _3214_/A2 VDD VSS gf180mcu_fd_sc_mcu7t5v0__and2_1
X_2162_ VDD VSS wire56/I _3390_/A1 _3854_/Q VDD VSS gf180mcu_fd_sc_mcu7t5v0__nand2_2
X_2093_ VDD VSS _4583_/D _4579_/Q _2093_/A2 VDD VSS gf180mcu_fd_sc_mcu7t5v0__xnor2_1
XFILLER_253_212 VDD VSS VDD VSS gf180mcu_fd_sc_mcu7t5v0__fillcap_64
XFILLER_54_807 VDD VSS VDD VSS gf180mcu_fd_sc_mcu7t5v0__fillcap_64
XFILLER_66_667 VDD VSS VDD VSS gf180mcu_fd_sc_mcu7t5v0__fillcap_64
XFILLER_207_640 VDD VSS VDD VSS gf180mcu_fd_sc_mcu7t5v0__fillcap_4
XFILLER_93_486 VDD VSS VDD VSS gf180mcu_fd_sc_mcu7t5v0__fillcap_4
XFILLER_222_654 VDD VSS VDD VSS gf180mcu_fd_sc_mcu7t5v0__fillcap_8
XFILLER_179_569 VDD VSS VDD VSS gf180mcu_fd_sc_mcu7t5v0__fillcap_16
XFILLER_221_142 VDD VSS VDD VSS gf180mcu_fd_sc_mcu7t5v0__fillcap_64
XFILLER_34_597 VDD VSS VDD VSS gf180mcu_fd_sc_mcu7t5v0__fillcap_64
XFILLER_22_737 VDD VSS VDD VSS gf180mcu_fd_sc_mcu7t5v0__fillcap_64
X_2995_ _3241_/A1 _3223_/B VDD VSS _2996_/A2 _4524_/D _2995_/A2 _3241_/B2 VDD VSS
+ gf180mcu_fd_sc_mcu7t5v0__oai221_1
X_1946_ VDD VSS _4338_/Q _2868_/A1 VDD VSS gf180mcu_fd_sc_mcu7t5v0__clkinv_1
XFILLER_159_282 VDD VSS VDD VSS gf180mcu_fd_sc_mcu7t5v0__fillcap_16
XFILLER_147_422 VDD VSS VDD VSS gf180mcu_fd_sc_mcu7t5v0__fillcap_16
XFILLER_135_606 VDD VSS VDD VSS gf180mcu_fd_sc_mcu7t5v0__fillcap_8
XFILLER_174_241 VDD VSS VDD VSS gf180mcu_fd_sc_mcu7t5v0__fillcap_4
XFILLER_174_263 VDD VSS VDD VSS gf180mcu_fd_sc_mcu7t5v0__fillcap_8
XFILLER_162_447 VDD VSS VDD VSS gf180mcu_fd_sc_mcu7t5v0__fillcap_8
X_4596_ _4596_/D _4596_/Q _4613_/RN VSS _4606_/CLK VDD VDD VSS gf180mcu_fd_sc_mcu7t5v0__dffrnq_1
X_3616_ _4343_/Q _3622_/C VDD VSS _3618_/A1 _4171_/Q _3616_/A2 _3633_/C1 VDD VSS gf180mcu_fd_sc_mcu7t5v0__aoi221_1
XFILLER_115_352 VDD VSS VDD VSS gf180mcu_fd_sc_mcu7t5v0__fillcap_32
X_3547_ _3547_/B1 _3547_/B2 VDD VSS _4473_/D _3547_/A1 _3546_/B VDD VSS gf180mcu_fd_sc_mcu7t5v0__aoi22_1
XFILLER_116_864 VDD VSS VDD VSS gf180mcu_fd_sc_mcu7t5v0__fillcap_8
XFILLER_135_38 VDD VSS VDD VSS gf180mcu_fd_sc_mcu7t5v0__fillcap_32
X_3478_ _3478_/A3 VDD VSS _3479_/A2 _3478_/A1 _3478_/A2 VDD VSS gf180mcu_fd_sc_mcu7t5v0__nand3_1
XFILLER_130_322 VDD VSS VDD VSS gf180mcu_fd_sc_mcu7t5v0__fillcap_16
XFILLER_88_247 VDD VSS VDD VSS gf180mcu_fd_sc_mcu7t5v0__fillcap_64
X_2429_ _2431_/S VDD VSS _4063_/D wire154/Z _4063_/Q VDD VSS gf180mcu_fd_sc_mcu7t5v0__mux2_2
XFILLER_245_702 VDD VSS VDD VSS gf180mcu_fd_sc_mcu7t5v0__fillcap_64
XFILLER_257_562 VDD VSS VDD VSS gf180mcu_fd_sc_mcu7t5v0__fillcap_64
XFILLER_56_177 VDD VSS VDD VSS gf180mcu_fd_sc_mcu7t5v0__fillcap_64
XFILLER_44_317 VDD VSS VDD VSS gf180mcu_fd_sc_mcu7t5v0__fillcap_64
XFILLER_71_136 VDD VSS VDD VSS gf180mcu_fd_sc_mcu7t5v0__fillcap_4
XFILLER_213_632 VDD VSS VDD VSS gf180mcu_fd_sc_mcu7t5v0__fillcap_64
XFILLER_225_492 VDD VSS VDD VSS gf180mcu_fd_sc_mcu7t5v0__fillcap_32
XFILLER_198_845 VDD VSS VDD VSS gf180mcu_fd_sc_mcu7t5v0__fillcap_4
XFILLER_197_311 VDD VSS VDD VSS gf180mcu_fd_sc_mcu7t5v0__fillcap_8
XFILLER_240_451 VDD VSS VDD VSS gf180mcu_fd_sc_mcu7t5v0__fillcap_4
XFILLER_12_247 VDD VSS VDD VSS gf180mcu_fd_sc_mcu7t5v0__fillcap_64
XFILLER_178_591 VDD VSS VDD VSS gf180mcu_fd_sc_mcu7t5v0__fillcap_4
XFILLER_166_731 VDD VSS VDD VSS gf180mcu_fd_sc_mcu7t5v0__fillcap_4
XFILLER_4_457 VDD VSS VDD VSS gf180mcu_fd_sc_mcu7t5v0__fillcap_64
XFILLER_109_72 VDD VSS VDD VSS gf180mcu_fd_sc_mcu7t5v0__fillcap_4
XFILLER_106_363 VDD VSS VDD VSS gf180mcu_fd_sc_mcu7t5v0__fillcap_8
XFILLER_88_781 VDD VSS VDD VSS gf180mcu_fd_sc_mcu7t5v0__fillcap_16
XFILLER_235_212 VDD VSS VDD VSS gf180mcu_fd_sc_mcu7t5v0__fillcap_64
XFILLER_36_807 VDD VSS VDD VSS gf180mcu_fd_sc_mcu7t5v0__fillcap_64
XFILLER_48_667 VDD VSS VDD VSS gf180mcu_fd_sc_mcu7t5v0__fillcap_64
XFILLER_63_626 VDD VSS VDD VSS gf180mcu_fd_sc_mcu7t5v0__fillcap_4
XFILLER_75_486 VDD VSS VDD VSS gf180mcu_fd_sc_mcu7t5v0__fillcap_4
XFILLER_189_834 VDD VSS VDD VSS gf180mcu_fd_sc_mcu7t5v0__fillcap_4
XFILLER_90_489 VDD VSS VDD VSS gf180mcu_fd_sc_mcu7t5v0__fillcap_16
XFILLER_203_142 VDD VSS VDD VSS gf180mcu_fd_sc_mcu7t5v0__fillcap_64
XFILLER_16_597 VDD VSS VDD VSS gf180mcu_fd_sc_mcu7t5v0__fillcap_64
XFILLER_31_556 VDD VSS VDD VSS gf180mcu_fd_sc_mcu7t5v0__fillcap_4
X_2780_ _2780_/B VDD VSS _2971_/A3 _2898_/A2 _2898_/A3 VDD VSS gf180mcu_fd_sc_mcu7t5v0__aoi21_1
XFILLER_156_263 VDD VSS VDD VSS gf180mcu_fd_sc_mcu7t5v0__fillcap_4
Xwire193 wire193/Z VSS VDD wire193/I VDD VSS gf180mcu_fd_sc_mcu7t5v0__clkbuf_8
X_4450_ _4450_/D _4450_/Q _4498_/RN VSS _4492_/CLK VDD VDD VSS gf180mcu_fd_sc_mcu7t5v0__dffrnq_1
Xwire160 wire160/Z VSS VDD _4309_/Q VDD VSS gf180mcu_fd_sc_mcu7t5v0__clkbuf_2
XFILLER_236_37 VDD VSS VDD VSS gf180mcu_fd_sc_mcu7t5v0__fillcap_64
X_3401_ wire56/Z VDD VSS _4444_/D _4402_/Q _4444_/Q VDD VSS gf180mcu_fd_sc_mcu7t5v0__mux2_2
X_4381_ _4381_/D _4381_/Q wire186/Z VSS clkload9/I VDD VDD VSS gf180mcu_fd_sc_mcu7t5v0__dffrnq_1
XFILLER_131_108 VDD VSS VDD VSS gf180mcu_fd_sc_mcu7t5v0__fillcap_8
X_3332_ VDD VSS _3334_/B1 _3333_/B1 _3333_/B2 VDD VSS gf180mcu_fd_sc_mcu7t5v0__nand2_1
XFILLER_152_491 VDD VSS VDD VSS gf180mcu_fd_sc_mcu7t5v0__fillcap_16
XFILLER_124_193 VDD VSS VDD VSS gf180mcu_fd_sc_mcu7t5v0__fillcap_8
X_3263_ VDD VSS _3263_/I _4366_/D VDD VSS gf180mcu_fd_sc_mcu7t5v0__clkinv_1
XFILLER_85_206 VDD VSS VDD VSS gf180mcu_fd_sc_mcu7t5v0__fillcap_4
XFILLER_239_562 VDD VSS VDD VSS gf180mcu_fd_sc_mcu7t5v0__fillcap_64
X_2214_ _2685_/C _2213_/Z VDD VSS _2214_/Z wire58/Z _2669_/A1 VDD VSS gf180mcu_fd_sc_mcu7t5v0__and4_1
X_3194_ wire13/Z VDD VSS _4338_/D _3194_/I0 _4338_/Q VDD VSS gf180mcu_fd_sc_mcu7t5v0__mux2_2
X_2145_ VDD VSS wire58/I _4524_/Q _2318_/A2 VDD VSS gf180mcu_fd_sc_mcu7t5v0__or2_1
XFILLER_254_521 VDD VSS VDD VSS gf180mcu_fd_sc_mcu7t5v0__fillcap_4
XFILLER_266_381 VDD VSS VDD VSS gf180mcu_fd_sc_mcu7t5v0__fillcap_4
XFILLER_38_177 VDD VSS VDD VSS gf180mcu_fd_sc_mcu7t5v0__fillcap_64
XFILLER_26_317 VDD VSS VDD VSS gf180mcu_fd_sc_mcu7t5v0__fillcap_64
X_2076_ VDD VSS _4553_/D _2074_/Z _2113_/A2 VDD VSS gf180mcu_fd_sc_mcu7t5v0__nor2_1
XFILLER_53_136 VDD VSS VDD VSS gf180mcu_fd_sc_mcu7t5v0__fillcap_4
XFILLER_222_451 VDD VSS VDD VSS gf180mcu_fd_sc_mcu7t5v0__fillcap_4
XFILLER_210_635 VDD VSS VDD VSS gf180mcu_fd_sc_mcu7t5v0__fillcap_4
XFILLER_148_731 VDD VSS VDD VSS gf180mcu_fd_sc_mcu7t5v0__fillcap_4
X_2978_ VDD VSS _2978_/I _4319_/D VDD VSS gf180mcu_fd_sc_mcu7t5v0__clkinv_1
X_1929_ VDD VSS _4539_/Q _3707_/A1 VDD VSS gf180mcu_fd_sc_mcu7t5v0__clkinv_1
XFILLER_135_414 VDD VSS VDD VSS gf180mcu_fd_sc_mcu7t5v0__fillcap_4
XFILLER_30_37 VDD VSS VDD VSS gf180mcu_fd_sc_mcu7t5v0__fillcap_64
XFILLER_146_37 VDD VSS VDD VSS gf180mcu_fd_sc_mcu7t5v0__fillcap_32
XFILLER_116_650 VDD VSS VDD VSS gf180mcu_fd_sc_mcu7t5v0__fillcap_4
XFILLER_190_597 VDD VSS VDD VSS gf180mcu_fd_sc_mcu7t5v0__fillcap_64
X_4579_ _4579_/D _4579_/Q _4613_/RN VSS _4583_/CLK VDD VDD VSS gf180mcu_fd_sc_mcu7t5v0__dffrnq_1
XFILLER_1_416 VDD VSS VDD VSS gf180mcu_fd_sc_mcu7t5v0__fillcap_4
XFILLER_258_871 VDD VSS VDD VSS gf180mcu_fd_sc_mcu7t5v0__fillcap_4
XFILLER_190_6 VDD VSS VDD VSS gf180mcu_fd_sc_mcu7t5v0__fillcap_16
XFILLER_18_807 VDD VSS VDD VSS gf180mcu_fd_sc_mcu7t5v0__fillcap_64
XFILLER_45_626 VDD VSS VDD VSS gf180mcu_fd_sc_mcu7t5v0__fillcap_4
XFILLER_57_486 VDD VSS VDD VSS gf180mcu_fd_sc_mcu7t5v0__fillcap_4
XFILLER_231_2 VDD VSS VDD VSS gf180mcu_fd_sc_mcu7t5v0__fillcap_64
XFILLER_200_101 VDD VSS VDD VSS gf180mcu_fd_sc_mcu7t5v0__fillcap_4
XFILLER_13_556 VDD VSS VDD VSS gf180mcu_fd_sc_mcu7t5v0__fillcap_4
XFILLER_139_742 VDD VSS VDD VSS gf180mcu_fd_sc_mcu7t5v0__fillcap_4
XFILLER_200_123 VDD VSS VDD VSS gf180mcu_fd_sc_mcu7t5v0__fillcap_8
XFILLER_187_66 VDD VSS VDD VSS gf180mcu_fd_sc_mcu7t5v0__fillcap_4
XFILLER_138_241 VDD VSS VDD VSS gf180mcu_fd_sc_mcu7t5v0__fillcap_4
XFILLER_138_285 VDD VSS VDD VSS gf180mcu_fd_sc_mcu7t5v0__fillcap_16
XFILLER_154_756 VDD VSS VDD VSS gf180mcu_fd_sc_mcu7t5v0__fillcap_32
XFILLER_5_766 VDD VSS VDD VSS gf180mcu_fd_sc_mcu7t5v0__fillcap_4
XFILLER_126_447 VDD VSS VDD VSS gf180mcu_fd_sc_mcu7t5v0__fillcap_8
XFILLER_67_206 VDD VSS VDD VSS gf180mcu_fd_sc_mcu7t5v0__fillcap_4
XFILLER_209_702 VDD VSS VDD VSS gf180mcu_fd_sc_mcu7t5v0__fillcap_32
XFILLER_248_381 VDD VSS VDD VSS gf180mcu_fd_sc_mcu7t5v0__fillcap_4
XFILLER_91_710 VDD VSS VDD VSS gf180mcu_fd_sc_mcu7t5v0__fillcap_4
XFILLER_264_885 VDD VSS VDD VSS gf180mcu_fd_sc_mcu7t5v0__fillcap_4
XFILLER_35_136 VDD VSS VDD VSS gf180mcu_fd_sc_mcu7t5v0__fillcap_4
X_3950_ VDD _3950_/Q _3967_/CLK VSS _3950_/D VDD VSS gf180mcu_fd_sc_mcu7t5v0__dffq_1
X_2901_ _3004_/A2 VDD VSS _3037_/A2 _4328_/Q _4327_/Q VDD VSS gf180mcu_fd_sc_mcu7t5v0__nand3_1
X_3881_ VDD _3881_/Q _4541_/CLK VSS _3881_/D VDD VSS gf180mcu_fd_sc_mcu7t5v0__dffq_1
XFILLER_176_303 VDD VSS VDD VSS gf180mcu_fd_sc_mcu7t5v0__fillcap_4
X_2832_ _3201_/A2 _2892_/B VDD VSS _2833_/A3 _3024_/A2 _3040_/B _2832_/B1 VDD VSS
+ gf180mcu_fd_sc_mcu7t5v0__aoi221_1
X_2763_ _2763_/S VDD VSS _4296_/D wire118/Z _4296_/Q VDD VSS gf180mcu_fd_sc_mcu7t5v0__mux2_2
XFILLER_192_807 VDD VSS VDD VSS gf180mcu_fd_sc_mcu7t5v0__fillcap_32
XFILLER_77_2 VDD VSS VDD VSS gf180mcu_fd_sc_mcu7t5v0__fillcap_64
X_4502_ _4502_/D _4502_/Q wire187/Z VSS _4531_/CLK VDD VDD VSS gf180mcu_fd_sc_mcu7t5v0__dffrnq_1
XFILLER_145_745 VDD VSS VDD VSS gf180mcu_fd_sc_mcu7t5v0__fillcap_8
XFILLER_117_414 VDD VSS VDD VSS gf180mcu_fd_sc_mcu7t5v0__fillcap_4
X_2694_ _2695_/A2 VDD VSS _2699_/A2 _2695_/B _2698_/B VDD VSS gf180mcu_fd_sc_mcu7t5v0__nor3_1
Xclkbuf_leaf_94_clk_i _4441_/CLK VSS VDD clkload0/I VDD VSS gf180mcu_fd_sc_mcu7t5v0__clkbuf_2
XFILLER_172_597 VDD VSS VDD VSS gf180mcu_fd_sc_mcu7t5v0__fillcap_4
XFILLER_160_737 VDD VSS VDD VSS gf180mcu_fd_sc_mcu7t5v0__fillcap_64
X_4433_ _4433_/D _4433_/Q _4473_/RN VSS _4441_/CLK VDD VDD VSS gf180mcu_fd_sc_mcu7t5v0__dffrnq_1
X_4364_ _4364_/D _4364_/Q wire183/Z VSS _4364_/CLK VDD VDD VSS gf180mcu_fd_sc_mcu7t5v0__dffrnq_1
XFILLER_258_101 VDD VSS VDD VSS gf180mcu_fd_sc_mcu7t5v0__fillcap_4
X_4295_ _4295_/D _4295_/Q _4530_/RN VSS _4305_/CLK VDD VDD VSS gf180mcu_fd_sc_mcu7t5v0__dffrnq_1
X_3315_ _3325_/B VDD VSS _4378_/D _4377_/Q _4378_/Q VDD VSS gf180mcu_fd_sc_mcu7t5v0__mux2_2
X_3246_ _3245_/Z VDD VSS _3246_/Z _4337_/Q _1945_/I VDD VSS gf180mcu_fd_sc_mcu7t5v0__xor3_1
XFILLER_255_874 VDD VSS VDD VSS gf180mcu_fd_sc_mcu7t5v0__fillcap_16
X_3177_ _3177_/B wire94/Z VDD VSS _3189_/B1 _3180_/B _3176_/Z VDD VSS gf180mcu_fd_sc_mcu7t5v0__aoi211_1
Xclkbuf_leaf_32_clk_i _4522_/CLK VSS VDD clkload4/I VDD VSS gf180mcu_fd_sc_mcu7t5v0__clkbuf_2
XFILLER_94_581 VDD VSS VDD VSS gf180mcu_fd_sc_mcu7t5v0__fillcap_8
XFILLER_39_486 VDD VSS VDD VSS gf180mcu_fd_sc_mcu7t5v0__fillcap_4
XFILLER_27_626 VDD VSS VDD VSS gf180mcu_fd_sc_mcu7t5v0__fillcap_4
X_2128_ VDD VSS _2128_/I _4133_/D VDD VSS gf180mcu_fd_sc_mcu7t5v0__clkinv_1
X_2059_ VDD VSS _2374_/A2 _4578_/Q _2084_/A2 VDD VSS gf180mcu_fd_sc_mcu7t5v0__nand2_1
Xclkbuf_leaf_47_clk_i _4355_/CLK VSS VDD clkload6/I VDD VSS gf180mcu_fd_sc_mcu7t5v0__clkbuf_2
XFILLER_194_188 VDD VSS VDD VSS gf180mcu_fd_sc_mcu7t5v0__fillcap_32
XFILLER_182_317 VDD VSS VDD VSS gf180mcu_fd_sc_mcu7t5v0__fillcap_8
XFILLER_108_436 VDD VSS VDD VSS gf180mcu_fd_sc_mcu7t5v0__fillcap_16
XFILLER_135_244 VDD VSS VDD VSS gf180mcu_fd_sc_mcu7t5v0__fillcap_16
XFILLER_190_361 VDD VSS VDD VSS gf180mcu_fd_sc_mcu7t5v0__fillcap_8
XFILLER_151_748 VDD VSS VDD VSS gf180mcu_fd_sc_mcu7t5v0__fillcap_16
XFILLER_150_247 VDD VSS VDD VSS gf180mcu_fd_sc_mcu7t5v0__fillcap_32
XFILLER_150_225 VDD VSS VDD VSS gf180mcu_fd_sc_mcu7t5v0__fillcap_4
XFILLER_104_631 VDD VSS VDD VSS gf180mcu_fd_sc_mcu7t5v0__fillcap_8
XFILLER_103_130 VDD VSS VDD VSS gf180mcu_fd_sc_mcu7t5v0__fillcap_4
XFILLER_49_206 VDD VSS VDD VSS gf180mcu_fd_sc_mcu7t5v0__fillcap_4
XFILLER_181_2 VDD VSS VDD VSS gf180mcu_fd_sc_mcu7t5v0__fillcap_32
XFILLER_85_570 VDD VSS VDD VSS gf180mcu_fd_sc_mcu7t5v0__fillcap_4
XFILLER_246_885 VDD VSS VDD VSS gf180mcu_fd_sc_mcu7t5v0__fillcap_4
XFILLER_17_136 VDD VSS VDD VSS gf180mcu_fd_sc_mcu7t5v0__fillcap_4
XFILLER_260_387 VDD VSS VDD VSS gf180mcu_fd_sc_mcu7t5v0__fillcap_64
XFILLER_214_793 VDD VSS VDD VSS gf180mcu_fd_sc_mcu7t5v0__fillcap_8
XFILLER_198_450 VDD VSS VDD VSS gf180mcu_fd_sc_mcu7t5v0__fillcap_4
XFILLER_201_454 VDD VSS VDD VSS gf180mcu_fd_sc_mcu7t5v0__fillcap_16
XFILLER_186_656 VDD VSS VDD VSS gf180mcu_fd_sc_mcu7t5v0__fillcap_8
XFILLER_186_667 VDD VSS VDD VSS gf180mcu_fd_sc_mcu7t5v0__fillcap_16
XFILLER_185_166 VDD VSS VDD VSS gf180mcu_fd_sc_mcu7t5v0__fillcap_4
XFILLER_158_358 VDD VSS VDD VSS gf180mcu_fd_sc_mcu7t5v0__fillcap_8
XFILLER_9_346 VDD VSS VDD VSS gf180mcu_fd_sc_mcu7t5v0__fillcap_4
XFILLER_126_255 VDD VSS VDD VSS gf180mcu_fd_sc_mcu7t5v0__fillcap_4
XFILLER_268_410 VDD VSS VDD VSS gf180mcu_fd_sc_mcu7t5v0__fillcap_32
XFILLER_141_269 VDD VSS VDD VSS gf180mcu_fd_sc_mcu7t5v0__fillcap_8
X_3100_ VDD VSS _3101_/B _3124_/A1 _3964_/Q VDD VSS gf180mcu_fd_sc_mcu7t5v0__nor2_1
X_4080_ VDD _4080_/Q _4081_/CLK VSS _4080_/D VDD VSS gf180mcu_fd_sc_mcu7t5v0__dffq_1
XFILLER_110_667 VDD VSS VDD VSS gf180mcu_fd_sc_mcu7t5v0__fillcap_16
X_3031_ _3038_/B _3031_/B1 _3217_/A1 VDD VSS _4327_/D _2991_/C VDD VSS gf180mcu_fd_sc_mcu7t5v0__oai22_1
XFILLER_237_874 VDD VSS VDD VSS gf180mcu_fd_sc_mcu7t5v0__fillcap_16
XFILLER_91_562 VDD VSS VDD VSS gf180mcu_fd_sc_mcu7t5v0__fillcap_16
XFILLER_91_551 VDD VSS VDD VSS gf180mcu_fd_sc_mcu7t5v0__fillcap_8
XFILLER_252_877 VDD VSS VDD VSS gf180mcu_fd_sc_mcu7t5v0__fillcap_8
X_3933_ VDD _3933_/Q _4001_/CLK VSS _3933_/D VDD VSS gf180mcu_fd_sc_mcu7t5v0__dffq_1
XFILLER_189_472 VDD VSS VDD VSS gf180mcu_fd_sc_mcu7t5v0__fillcap_16
XFILLER_204_281 VDD VSS VDD VSS gf180mcu_fd_sc_mcu7t5v0__fillcap_32
X_3864_ _4298_/Q _3865_/D _4580_/RN VSS _4605_/CLK VDD VDD VSS gf180mcu_fd_sc_mcu7t5v0__dffrnq_1
XFILLER_165_829 VDD VSS VDD VSS gf180mcu_fd_sc_mcu7t5v0__fillcap_8
X_2815_ _4348_/Q _2321_/Z VDD VSS _3024_/B _4330_/Q _3039_/A1 VDD VSS gf180mcu_fd_sc_mcu7t5v0__nor4_1
X_3795_ _3795_/B VDD VSS _3957_/D _3795_/A1 wire16/Z VDD VSS gf180mcu_fd_sc_mcu7t5v0__aoi21_1
XFILLER_176_177 VDD VSS VDD VSS gf180mcu_fd_sc_mcu7t5v0__fillcap_16
XFILLER_164_317 VDD VSS VDD VSS gf180mcu_fd_sc_mcu7t5v0__fillcap_32
X_2746_ _2748_/S VDD VSS _4280_/D _4280_/Q _4454_/Q VDD VSS gf180mcu_fd_sc_mcu7t5v0__mux2_2
XFILLER_157_380 VDD VSS VDD VSS gf180mcu_fd_sc_mcu7t5v0__fillcap_32
X_2677_ VDD _2677_/B _4503_/D _4236_/D _2677_/A1 VSS VDD VSS gf180mcu_fd_sc_mcu7t5v0__oai21_1
XFILLER_127_39 VDD VSS VDD VSS gf180mcu_fd_sc_mcu7t5v0__fillcap_16
X_4416_ _4416_/D _4416_/Q wire209/Z VSS _4446_/CLK VDD VDD VSS gf180mcu_fd_sc_mcu7t5v0__dffrnq_1
XFILLER_132_236 VDD VSS VDD VSS gf180mcu_fd_sc_mcu7t5v0__fillcap_8
XFILLER_207_72 VDD VSS VDD VSS gf180mcu_fd_sc_mcu7t5v0__fillcap_32
XFILLER_132_247 VDD VSS VDD VSS gf180mcu_fd_sc_mcu7t5v0__fillcap_4
X_4347_ _4347_/D _4347_/Q wire199/Z VSS _4529_/CLK VDD VDD VSS gf180mcu_fd_sc_mcu7t5v0__dffrnq_1
X_4278_ _4278_/D _4278_/Q _4371_/RN VSS _4278_/CLK VDD VDD VSS gf180mcu_fd_sc_mcu7t5v0__dffrnq_1
XFILLER_100_122 VDD VSS VDD VSS gf180mcu_fd_sc_mcu7t5v0__fillcap_32
X_3229_ VDD VSS _3241_/A2 _3223_/B _3239_/A1 VDD VSS gf180mcu_fd_sc_mcu7t5v0__nand2_1
XFILLER_100_177 VDD VSS VDD VSS gf180mcu_fd_sc_mcu7t5v0__fillcap_16
XFILLER_228_885 VDD VSS VDD VSS gf180mcu_fd_sc_mcu7t5v0__fillcap_4
XFILLER_82_584 VDD VSS VDD VSS gf180mcu_fd_sc_mcu7t5v0__fillcap_8
XFILLER_242_387 VDD VSS VDD VSS gf180mcu_fd_sc_mcu7t5v0__fillcap_64
XFILLER_230_527 VDD VSS VDD VSS gf180mcu_fd_sc_mcu7t5v0__fillcap_32
XFILLER_211_741 VDD VSS VDD VSS gf180mcu_fd_sc_mcu7t5v0__fillcap_4
XFILLER_136_597 VDD VSS VDD VSS gf180mcu_fd_sc_mcu7t5v0__fillcap_32
XFILLER_151_556 VDD VSS VDD VSS gf180mcu_fd_sc_mcu7t5v0__fillcap_4
XFILLER_117_72 VDD VSS VDD VSS gf180mcu_fd_sc_mcu7t5v0__fillcap_64
XFILLER_7_2 VDD VSS VDD VSS gf180mcu_fd_sc_mcu7t5v0__fillcap_64
XFILLER_219_874 VDD VSS VDD VSS gf180mcu_fd_sc_mcu7t5v0__fillcap_16
XFILLER_252_107 VDD VSS VDD VSS gf180mcu_fd_sc_mcu7t5v0__fillcap_64
XFILLER_234_844 VDD VSS VDD VSS gf180mcu_fd_sc_mcu7t5v0__fillcap_16
XFILLER_61_702 VDD VSS VDD VSS gf180mcu_fd_sc_mcu7t5v0__fillcap_64
XFILLER_73_562 VDD VSS VDD VSS gf180mcu_fd_sc_mcu7t5v0__fillcap_64
XFILLER_234_877 VDD VSS VDD VSS gf180mcu_fd_sc_mcu7t5v0__fillcap_8
XFILLER_261_696 VDD VSS VDD VSS gf180mcu_fd_sc_mcu7t5v0__fillcap_4
XFILLER_198_291 VDD VSS VDD VSS gf180mcu_fd_sc_mcu7t5v0__fillcap_16
XFILLER_41_492 VDD VSS VDD VSS gf180mcu_fd_sc_mcu7t5v0__fillcap_64
XFILLER_146_306 VDD VSS VDD VSS gf180mcu_fd_sc_mcu7t5v0__fillcap_4
XFILLER_146_317 VDD VSS VDD VSS gf180mcu_fd_sc_mcu7t5v0__fillcap_16
X_2600_ _2620_/B _4206_/Q VDD VSS _2601_/B _2600_/A1 _2601_/A3 VDD VSS gf180mcu_fd_sc_mcu7t5v0__oai211_1
X_3580_ VDD VSS _3581_/A3 _4591_/Q _4008_/Q VDD VSS gf180mcu_fd_sc_mcu7t5v0__nand2_1
X_2531_ _2535_/S VDD VSS _4157_/D _4157_/Q wire121/Z VDD VSS gf180mcu_fd_sc_mcu7t5v0__mux2_2
XFILLER_244_37 VDD VSS VDD VSS gf180mcu_fd_sc_mcu7t5v0__fillcap_64
X_4201_ _4201_/D _4201_/Q _4535_/RN VSS _4528_/CLK VDD VDD VSS gf180mcu_fd_sc_mcu7t5v0__dffrnq_1
X_2462_ _2463_/S VDD VSS _4088_/D wire153/Z _4088_/Q VDD VSS gf180mcu_fd_sc_mcu7t5v0__mux2_2
XFILLER_268_240 VDD VSS VDD VSS gf180mcu_fd_sc_mcu7t5v0__fillcap_32
X_2393_ _2393_/S VDD VSS _4033_/D _2454_/I0 _4033_/Q VDD VSS gf180mcu_fd_sc_mcu7t5v0__mux2_2
X_4132_ _4132_/D _4132_/Q _4527_/RN VSS _4198_/CLK VDD VDD VSS gf180mcu_fd_sc_mcu7t5v0__dffrnq_1
XFILLER_256_457 VDD VSS VDD VSS gf180mcu_fd_sc_mcu7t5v0__fillcap_64
X_4063_ VDD _4063_/Q _4123_/CLK VSS _4063_/D VDD VSS gf180mcu_fd_sc_mcu7t5v0__dffq_1
X_3014_ _3014_/A3 _3012_/Z _3015_/C VDD VSS _4324_/D _3021_/B3 _3001_/I VDD VSS gf180mcu_fd_sc_mcu7t5v0__oai32_1
Xwire13 VSS wire13/Z wire13/I VDD VDD VSS gf180mcu_fd_sc_mcu7t5v0__buf_3
Xwire68 VDD wire68/I VSS wire68/Z VDD VSS gf180mcu_fd_sc_mcu7t5v0__dlyb_1
XFILLER_51_212 VDD VSS VDD VSS gf180mcu_fd_sc_mcu7t5v0__fillcap_64
XFILLER_224_387 VDD VSS VDD VSS gf180mcu_fd_sc_mcu7t5v0__fillcap_64
XFILLER_212_527 VDD VSS VDD VSS gf180mcu_fd_sc_mcu7t5v0__fillcap_32
XFILLER_212_516 VDD VSS VDD VSS gf180mcu_fd_sc_mcu7t5v0__fillcap_8
XFILLER_196_217 VDD VSS VDD VSS gf180mcu_fd_sc_mcu7t5v0__fillcap_8
X_3916_ VDD _3916_/Q _4001_/CLK VSS _3916_/D VDD VSS gf180mcu_fd_sc_mcu7t5v0__dffq_1
XFILLER_205_590 VDD VSS VDD VSS gf180mcu_fd_sc_mcu7t5v0__fillcap_8
X_3847_ _3848_/S VDD VSS _4000_/D wire172/Z _4000_/Q VDD VSS gf180mcu_fd_sc_mcu7t5v0__mux2_2
XFILLER_165_615 VDD VSS VDD VSS gf180mcu_fd_sc_mcu7t5v0__fillcap_8
XFILLER_137_306 VDD VSS VDD VSS gf180mcu_fd_sc_mcu7t5v0__fillcap_4
X_3778_ VDD VSS _3786_/S _3822_/A1 _3768_/Z VDD VSS gf180mcu_fd_sc_mcu7t5v0__nand2_1
XFILLER_165_648 VDD VSS VDD VSS gf180mcu_fd_sc_mcu7t5v0__fillcap_8
XFILLER_149_199 VDD VSS VDD VSS gf180mcu_fd_sc_mcu7t5v0__fillcap_8
XFILLER_164_158 VDD VSS VDD VSS gf180mcu_fd_sc_mcu7t5v0__fillcap_16
X_2729_ _2736_/S VDD VSS _4263_/D _4263_/Q wire117/Z VDD VSS gf180mcu_fd_sc_mcu7t5v0__mux2_2
XFILLER_161_876 VDD VSS VDD VSS gf180mcu_fd_sc_mcu7t5v0__fillcap_8
XFILLER_99_492 VDD VSS VDD VSS gf180mcu_fd_sc_mcu7t5v0__fillcap_8
XFILLER_87_632 VDD VSS VDD VSS gf180mcu_fd_sc_mcu7t5v0__fillcap_64
XFILLER_234_107 VDD VSS VDD VSS gf180mcu_fd_sc_mcu7t5v0__fillcap_64
XFILLER_101_486 VDD VSS VDD VSS gf180mcu_fd_sc_mcu7t5v0__fillcap_4
XFILLER_55_562 VDD VSS VDD VSS gf180mcu_fd_sc_mcu7t5v0__fillcap_64
XFILLER_43_702 VDD VSS VDD VSS gf180mcu_fd_sc_mcu7t5v0__fillcap_64
XFILLER_83_871 VDD VSS VDD VSS gf180mcu_fd_sc_mcu7t5v0__fillcap_16
XFILLER_216_877 VDD VSS VDD VSS gf180mcu_fd_sc_mcu7t5v0__fillcap_8
XFILLER_82_381 VDD VSS VDD VSS gf180mcu_fd_sc_mcu7t5v0__fillcap_4
XFILLER_70_521 VDD VSS VDD VSS gf180mcu_fd_sc_mcu7t5v0__fillcap_4
XFILLER_243_696 VDD VSS VDD VSS gf180mcu_fd_sc_mcu7t5v0__fillcap_4
XFILLER_187_206 VDD VSS VDD VSS gf180mcu_fd_sc_mcu7t5v0__fillcap_4
XFILLER_144_2 VDD VSS VDD VSS gf180mcu_fd_sc_mcu7t5v0__fillcap_16
XFILLER_187_228 VDD VSS VDD VSS gf180mcu_fd_sc_mcu7t5v0__fillcap_4
XFILLER_23_492 VDD VSS VDD VSS gf180mcu_fd_sc_mcu7t5v0__fillcap_64
XFILLER_129_818 VDD VSS VDD VSS gf180mcu_fd_sc_mcu7t5v0__fillcap_16
XFILLER_11_632 VDD VSS VDD VSS gf180mcu_fd_sc_mcu7t5v0__fillcap_64
XFILLER_168_486 VDD VSS VDD VSS gf180mcu_fd_sc_mcu7t5v0__fillcap_4
XFILLER_196_784 VDD VSS VDD VSS gf180mcu_fd_sc_mcu7t5v0__fillcap_8
Xmax_length176 _3763_/I0 _4292_/Q VDD VSS VDD VSS gf180mcu_fd_sc_mcu7t5v0__buf_4
XFILLER_171_618 VDD VSS VDD VSS gf180mcu_fd_sc_mcu7t5v0__fillcap_8
XFILLER_137_884 VDD VSS VDD VSS gf180mcu_fd_sc_mcu7t5v0__fillcap_4
Xmax_length165 VSS _2466_/I0 wire166/Z VDD VDD VSS gf180mcu_fd_sc_mcu7t5v0__buf_2
Xmax_length198 _4536_/RN _4498_/RN VDD VSS VDD VSS gf180mcu_fd_sc_mcu7t5v0__buf_8
XFILLER_3_842 VDD VSS VDD VSS gf180mcu_fd_sc_mcu7t5v0__fillcap_32
XFILLER_112_729 VDD VSS VDD VSS gf180mcu_fd_sc_mcu7t5v0__fillcap_4
XFILLER_238_457 VDD VSS VDD VSS gf180mcu_fd_sc_mcu7t5v0__fillcap_64
XFILLER_77_142 VDD VSS VDD VSS gf180mcu_fd_sc_mcu7t5v0__fillcap_64
XFILLER_253_416 VDD VSS VDD VSS gf180mcu_fd_sc_mcu7t5v0__fillcap_4
XFILLER_265_276 VDD VSS VDD VSS gf180mcu_fd_sc_mcu7t5v0__fillcap_4
XFILLER_206_310 VDD VSS VDD VSS gf180mcu_fd_sc_mcu7t5v0__fillcap_4
XFILLER_33_212 VDD VSS VDD VSS gf180mcu_fd_sc_mcu7t5v0__fillcap_64
XFILLER_74_871 VDD VSS VDD VSS gf180mcu_fd_sc_mcu7t5v0__fillcap_4
XFILLER_221_346 VDD VSS VDD VSS gf180mcu_fd_sc_mcu7t5v0__fillcap_4
X_1962_ VDD VSS _4236_/Q _2677_/A1 VDD VSS gf180mcu_fd_sc_mcu7t5v0__clkinv_1
XFILLER_187_784 VDD VSS VDD VSS gf180mcu_fd_sc_mcu7t5v0__fillcap_4
X_3701_ _3706_/S VDD VSS _3884_/D _3884_/Q _4291_/Q VDD VSS gf180mcu_fd_sc_mcu7t5v0__mux2_2
X_3632_ VDD VSS _3634_/A1 _4162_/Q _2040_/Z VDD VSS gf180mcu_fd_sc_mcu7t5v0__nand2_1
XFILLER_162_629 VDD VSS VDD VSS gf180mcu_fd_sc_mcu7t5v0__fillcap_8
XFILLER_143_832 VDD VSS VDD VSS gf180mcu_fd_sc_mcu7t5v0__fillcap_8
X_3563_ _3563_/B _3590_/C VDD VSS _3569_/A2 _3515_/C _3559_/Z VDD VSS gf180mcu_fd_sc_mcu7t5v0__oai211_1
X_2514_ _2730_/S VDD VSS _4143_/D _4143_/Q wire134/Z VDD VSS gf180mcu_fd_sc_mcu7t5v0__mux2_2
X_3494_ _3494_/A3 VDD VSS _3495_/A3 wire78/Z _3494_/A2 VDD VSS gf180mcu_fd_sc_mcu7t5v0__nand3_1
XFILLER_142_375 VDD VSS VDD VSS gf180mcu_fd_sc_mcu7t5v0__fillcap_8
X_2445_ VDD VSS _2446_/B wire166/Z _2454_/S VDD VSS gf180mcu_fd_sc_mcu7t5v0__nor2_1
XFILLER_115_578 VDD VSS VDD VSS gf180mcu_fd_sc_mcu7t5v0__fillcap_8
XFILLER_69_632 VDD VSS VDD VSS gf180mcu_fd_sc_mcu7t5v0__fillcap_64
XFILLER_257_766 VDD VSS VDD VSS gf180mcu_fd_sc_mcu7t5v0__fillcap_4
XFILLER_96_451 VDD VSS VDD VSS gf180mcu_fd_sc_mcu7t5v0__fillcap_4
X_2376_ _2383_/S VDD VSS _4018_/D _4018_/Q wire167/Z VDD VSS gf180mcu_fd_sc_mcu7t5v0__mux2_2
X_4115_ VDD _4115_/Q _4128_/CLK VSS _4115_/D VDD VSS gf180mcu_fd_sc_mcu7t5v0__dffq_1
XFILLER_216_107 VDD VSS VDD VSS gf180mcu_fd_sc_mcu7t5v0__fillcap_16
X_4046_ VDD _4046_/Q _4058_/CLK VSS _4046_/D VDD VSS gf180mcu_fd_sc_mcu7t5v0__dffq_1
XFILLER_37_562 VDD VSS VDD VSS gf180mcu_fd_sc_mcu7t5v0__fillcap_64
XFILLER_25_702 VDD VSS VDD VSS gf180mcu_fd_sc_mcu7t5v0__fillcap_64
XFILLER_213_836 VDD VSS VDD VSS gf180mcu_fd_sc_mcu7t5v0__fillcap_4
XFILLER_52_521 VDD VSS VDD VSS gf180mcu_fd_sc_mcu7t5v0__fillcap_4
XFILLER_64_381 VDD VSS VDD VSS gf180mcu_fd_sc_mcu7t5v0__fillcap_4
XFILLER_80_885 VDD VSS VDD VSS gf180mcu_fd_sc_mcu7t5v0__fillcap_4
XFILLER_177_250 VDD VSS VDD VSS gf180mcu_fd_sc_mcu7t5v0__fillcap_8
XFILLER_20_451 VDD VSS VDD VSS gf180mcu_fd_sc_mcu7t5v0__fillcap_4
XFILLER_137_136 VDD VSS VDD VSS gf180mcu_fd_sc_mcu7t5v0__fillcap_4
XFILLER_118_361 VDD VSS VDD VSS gf180mcu_fd_sc_mcu7t5v0__fillcap_4
XFILLER_165_58 VDD VSS VDD VSS gf180mcu_fd_sc_mcu7t5v0__fillcap_8
XFILLER_106_567 VDD VSS VDD VSS gf180mcu_fd_sc_mcu7t5v0__fillcap_16
XFILLER_161_695 VDD VSS VDD VSS gf180mcu_fd_sc_mcu7t5v0__fillcap_4
XFILLER_59_142 VDD VSS VDD VSS gf180mcu_fd_sc_mcu7t5v0__fillcap_64
XFILLER_235_416 VDD VSS VDD VSS gf180mcu_fd_sc_mcu7t5v0__fillcap_4
XFILLER_74_101 VDD VSS VDD VSS gf180mcu_fd_sc_mcu7t5v0__fillcap_4
XFILLER_247_276 VDD VSS VDD VSS gf180mcu_fd_sc_mcu7t5v0__fillcap_4
XFILLER_261_2 VDD VSS VDD VSS gf180mcu_fd_sc_mcu7t5v0__fillcap_64
XFILLER_56_871 VDD VSS VDD VSS gf180mcu_fd_sc_mcu7t5v0__fillcap_4
XFILLER_15_212 VDD VSS VDD VSS gf180mcu_fd_sc_mcu7t5v0__fillcap_64
XFILLER_71_874 VDD VSS VDD VSS gf180mcu_fd_sc_mcu7t5v0__fillcap_16
XFILLER_203_368 VDD VSS VDD VSS gf180mcu_fd_sc_mcu7t5v0__fillcap_8
XFILLER_130_94 VDD VSS VDD VSS gf180mcu_fd_sc_mcu7t5v0__fillcap_8
XFILLER_7_422 VDD VSS VDD VSS gf180mcu_fd_sc_mcu7t5v0__fillcap_64
XFILLER_183_275 VDD VSS VDD VSS gf180mcu_fd_sc_mcu7t5v0__fillcap_4
XFILLER_98_705 VDD VSS VDD VSS gf180mcu_fd_sc_mcu7t5v0__fillcap_8
X_2230_ VDD _2230_/B _2230_/A2 _3214_/A2 _4246_/Q VSS VDD VSS gf180mcu_fd_sc_mcu7t5v0__oai21_1
XFILLER_112_537 VDD VSS VDD VSS gf180mcu_fd_sc_mcu7t5v0__fillcap_8
XFILLER_2_171 VDD VSS VDD VSS gf180mcu_fd_sc_mcu7t5v0__fillcap_4
XFILLER_78_451 VDD VSS VDD VSS gf180mcu_fd_sc_mcu7t5v0__fillcap_4
XFILLER_239_766 VDD VSS VDD VSS gf180mcu_fd_sc_mcu7t5v0__fillcap_4
X_2161_ VDD VSS _4536_/D _4320_/Q _2232_/A2 VDD VSS gf180mcu_fd_sc_mcu7t5v0__nor2_1
X_2092_ VDD VSS _4538_/D _2090_/Z _2101_/A2 VDD VSS gf180mcu_fd_sc_mcu7t5v0__nor2_1
XFILLER_19_562 VDD VSS VDD VSS gf180mcu_fd_sc_mcu7t5v0__fillcap_64
XFILLER_34_521 VDD VSS VDD VSS gf180mcu_fd_sc_mcu7t5v0__fillcap_4
XFILLER_46_381 VDD VSS VDD VSS gf180mcu_fd_sc_mcu7t5v0__fillcap_4
XFILLER_179_548 VDD VSS VDD VSS gf180mcu_fd_sc_mcu7t5v0__fillcap_8
XFILLER_62_885 VDD VSS VDD VSS gf180mcu_fd_sc_mcu7t5v0__fillcap_4
X_2994_ _2993_/Z VDD VSS _3241_/A1 _4353_/Q _4352_/Q VDD VSS gf180mcu_fd_sc_mcu7t5v0__nand3_1
X_1945_ VDD VSS _1945_/I _2932_/B2 VDD VSS gf180mcu_fd_sc_mcu7t5v0__clkinv_1
XFILLER_9_72 VDD VSS VDD VSS gf180mcu_fd_sc_mcu7t5v0__fillcap_64
XFILLER_119_114 VDD VSS VDD VSS gf180mcu_fd_sc_mcu7t5v0__fillcap_16
XFILLER_162_415 VDD VSS VDD VSS gf180mcu_fd_sc_mcu7t5v0__fillcap_32
X_4595_ _4595_/D _4616_/D _4616_/RN VSS _4595_/CLK VDD VDD VSS gf180mcu_fd_sc_mcu7t5v0__dffrnq_1
X_3615_ _3615_/B1 _3615_/B2 VDD VSS _4476_/D _3615_/A1 _3619_/C VDD VSS gf180mcu_fd_sc_mcu7t5v0__aoi22_1
X_3546_ _3546_/B VDD VSS _3547_/B2 _3619_/B1 _3546_/A2 VDD VSS gf180mcu_fd_sc_mcu7t5v0__aoi21_1
X_3477_ _4364_/Q _3622_/C VDD VSS _3478_/A3 _4152_/Q _2040_/Z _3685_/C2 VDD VSS gf180mcu_fd_sc_mcu7t5v0__aoi221_1
XFILLER_103_548 VDD VSS VDD VSS gf180mcu_fd_sc_mcu7t5v0__fillcap_4
X_2428_ _2431_/S VDD VSS _4062_/D _2506_/I0 _4062_/Q VDD VSS gf180mcu_fd_sc_mcu7t5v0__mux2_2
XFILLER_215_72 VDD VSS VDD VSS gf180mcu_fd_sc_mcu7t5v0__fillcap_32
X_2359_ _2359_/S VDD VSS _4009_/D _4009_/Q _2454_/I0 VDD VSS gf180mcu_fd_sc_mcu7t5v0__mux2_2
XFILLER_28_37 VDD VSS VDD VSS gf180mcu_fd_sc_mcu7t5v0__fillcap_64
XFILLER_56_101 VDD VSS VDD VSS gf180mcu_fd_sc_mcu7t5v0__fillcap_4
XFILLER_229_276 VDD VSS VDD VSS gf180mcu_fd_sc_mcu7t5v0__fillcap_4
XFILLER_217_416 VDD VSS VDD VSS gf180mcu_fd_sc_mcu7t5v0__fillcap_4
XFILLER_151_38 VDD VSS VDD VSS gf180mcu_fd_sc_mcu7t5v0__fillcap_32
XFILLER_38_871 VDD VSS VDD VSS gf180mcu_fd_sc_mcu7t5v0__fillcap_4
X_4029_ VDD _4029_/Q _4612_/CLK VSS _4029_/D VDD VSS gf180mcu_fd_sc_mcu7t5v0__dffq_1
XFILLER_53_874 VDD VSS VDD VSS gf180mcu_fd_sc_mcu7t5v0__fillcap_16
XFILLER_197_345 VDD VSS VDD VSS gf180mcu_fd_sc_mcu7t5v0__fillcap_4
XFILLER_193_562 VDD VSS VDD VSS gf180mcu_fd_sc_mcu7t5v0__fillcap_16
XFILLER_193_540 VDD VSS VDD VSS gf180mcu_fd_sc_mcu7t5v0__fillcap_16
XFILLER_181_702 VDD VSS VDD VSS gf180mcu_fd_sc_mcu7t5v0__fillcap_16
XFILLER_165_297 VDD VSS VDD VSS gf180mcu_fd_sc_mcu7t5v0__fillcap_16
XFILLER_125_128 VDD VSS VDD VSS gf180mcu_fd_sc_mcu7t5v0__fillcap_8
XFILLER_107_832 VDD VSS VDD VSS gf180mcu_fd_sc_mcu7t5v0__fillcap_8
XFILLER_107_2 VDD VSS VDD VSS gf180mcu_fd_sc_mcu7t5v0__fillcap_8
XFILLER_69_66 VDD VSS VDD VSS gf180mcu_fd_sc_mcu7t5v0__fillcap_4
XFILLER_161_492 VDD VSS VDD VSS gf180mcu_fd_sc_mcu7t5v0__fillcap_32
XFILLER_94_218 VDD VSS VDD VSS gf180mcu_fd_sc_mcu7t5v0__fillcap_8
XFILLER_125_72 VDD VSS VDD VSS gf180mcu_fd_sc_mcu7t5v0__fillcap_16
XFILLER_208_438 VDD VSS VDD VSS gf180mcu_fd_sc_mcu7t5v0__fillcap_16
XFILLER_16_521 VDD VSS VDD VSS gf180mcu_fd_sc_mcu7t5v0__fillcap_4
XFILLER_90_457 VDD VSS VDD VSS gf180mcu_fd_sc_mcu7t5v0__fillcap_32
XFILLER_28_381 VDD VSS VDD VSS gf180mcu_fd_sc_mcu7t5v0__fillcap_4
XFILLER_44_885 VDD VSS VDD VSS gf180mcu_fd_sc_mcu7t5v0__fillcap_4
Xspi_opentarget_i3c_top_240 spi_miso_o_PDRV1 VDD VSS VDD VSS gf180mcu_fd_sc_mcu7t5v0__tiel
XFILLER_8_731 VDD VSS VDD VSS gf180mcu_fd_sc_mcu7t5v0__fillcap_4
XFILLER_184_551 VDD VSS VDD VSS gf180mcu_fd_sc_mcu7t5v0__fillcap_4
Xwire150 VSS wire150/Z wire150/I VDD VDD VSS gf180mcu_fd_sc_mcu7t5v0__buf_2
Xwire172 VSS wire172/Z _4295_/Q VDD VDD VSS gf180mcu_fd_sc_mcu7t5v0__buf_2
Xwire183 wire183/Z VSS VDD wire184/Z VDD VSS gf180mcu_fd_sc_mcu7t5v0__clkbuf_8
Xwire161 VSS wire161/Z wire163/Z VDD VDD VSS gf180mcu_fd_sc_mcu7t5v0__buf_2
XFILLER_144_448 VDD VSS VDD VSS gf180mcu_fd_sc_mcu7t5v0__fillcap_4
X_3400_ _3424_/S VDD VSS _4443_/D _4401_/Q _3400_/I1 VDD VSS gf180mcu_fd_sc_mcu7t5v0__mux2_2
X_4380_ _4380_/D _4380_/Q wire186/Z VSS _4427_/CLK VDD VDD VSS gf180mcu_fd_sc_mcu7t5v0__dffrnq_1
XFILLER_116_139 VDD VSS VDD VSS gf180mcu_fd_sc_mcu7t5v0__fillcap_16
XFILLER_171_267 VDD VSS VDD VSS gf180mcu_fd_sc_mcu7t5v0__fillcap_8
XFILLER_113_813 VDD VSS VDD VSS gf180mcu_fd_sc_mcu7t5v0__fillcap_4
X_3331_ VDD VSS _3333_/B2 _3347_/B _3331_/A2 VDD VSS gf180mcu_fd_sc_mcu7t5v0__nand2_1
XFILLER_113_835 VDD VSS VDD VSS gf180mcu_fd_sc_mcu7t5v0__fillcap_4
X_3262_ _3268_/B1 _4366_/Q VDD VSS _3263_/I _4359_/Q _4526_/D VDD VSS gf180mcu_fd_sc_mcu7t5v0__aoi22_1
XFILLER_112_367 VDD VSS VDD VSS gf180mcu_fd_sc_mcu7t5v0__fillcap_8
X_3193_ _3193_/B VDD VSS _3194_/I0 _3170_/B _3193_/A2 VDD VSS gf180mcu_fd_sc_mcu7t5v0__aoi21_1
X_2213_ VDD VSS _2213_/Z _2213_/A1 _2213_/A2 VDD VSS gf180mcu_fd_sc_mcu7t5v0__or2_1
XFILLER_252_37 VDD VSS VDD VSS gf180mcu_fd_sc_mcu7t5v0__fillcap_64
XFILLER_22_2 VDD VSS VDD VSS gf180mcu_fd_sc_mcu7t5v0__fillcap_32
XFILLER_38_101 VDD VSS VDD VSS gf180mcu_fd_sc_mcu7t5v0__fillcap_4
X_2144_ VDD VSS _2987_/B _4524_/Q _2318_/A2 VDD VSS gf180mcu_fd_sc_mcu7t5v0__nor2_1
X_2075_ VDD VSS _2113_/A2 wire96/Z _2075_/A2 VDD VSS gf180mcu_fd_sc_mcu7t5v0__nor2_1
XFILLER_35_874 VDD VSS VDD VSS gf180mcu_fd_sc_mcu7t5v0__fillcap_16
XFILLER_50_877 VDD VSS VDD VSS gf180mcu_fd_sc_mcu7t5v0__fillcap_8
X_2977_ _2977_/A2 _2977_/B1 _4319_/Q VDD VSS _2978_/I _2896_/B VDD VSS gf180mcu_fd_sc_mcu7t5v0__oai22_1
XFILLER_175_562 VDD VSS VDD VSS gf180mcu_fd_sc_mcu7t5v0__fillcap_4
X_1928_ VDD VSS _4315_/Q _2959_/B2 VDD VSS gf180mcu_fd_sc_mcu7t5v0__clkinv_1
XFILLER_175_540 VDD VSS VDD VSS gf180mcu_fd_sc_mcu7t5v0__fillcap_16
XFILLER_163_702 VDD VSS VDD VSS gf180mcu_fd_sc_mcu7t5v0__fillcap_16
XFILLER_194_359 VDD VSS VDD VSS gf180mcu_fd_sc_mcu7t5v0__fillcap_8
XFILLER_148_798 VDD VSS VDD VSS gf180mcu_fd_sc_mcu7t5v0__fillcap_4
XFILLER_162_223 VDD VSS VDD VSS gf180mcu_fd_sc_mcu7t5v0__fillcap_4
XFILLER_162_234 VDD VSS VDD VSS gf180mcu_fd_sc_mcu7t5v0__fillcap_8
X_4578_ _4578_/D _4578_/Q _4580_/RN VSS _4583_/CLK VDD VDD VSS gf180mcu_fd_sc_mcu7t5v0__dffrnq_1
XFILLER_143_492 VDD VSS VDD VSS gf180mcu_fd_sc_mcu7t5v0__fillcap_16
X_3529_ _4126_/Q VSS VDD _4110_/Q _4118_/Q wire88/Z _4102_/Q wire83/Z _3529_/Z VDD
+ VSS gf180mcu_fd_sc_mcu7t5v0__mux4_1
XFILLER_131_632 VDD VSS VDD VSS gf180mcu_fd_sc_mcu7t5v0__fillcap_8
XFILLER_162_37 VDD VSS VDD VSS gf180mcu_fd_sc_mcu7t5v0__fillcap_8
XFILLER_85_741 VDD VSS VDD VSS gf180mcu_fd_sc_mcu7t5v0__fillcap_16
XFILLER_233_717 VDD VSS VDD VSS gf180mcu_fd_sc_mcu7t5v0__fillcap_16
XFILLER_205_408 VDD VSS VDD VSS gf180mcu_fd_sc_mcu7t5v0__fillcap_8
XFILLER_226_780 VDD VSS VDD VSS gf180mcu_fd_sc_mcu7t5v0__fillcap_16
XFILLER_72_457 VDD VSS VDD VSS gf180mcu_fd_sc_mcu7t5v0__fillcap_64
XFILLER_241_772 VDD VSS VDD VSS gf180mcu_fd_sc_mcu7t5v0__fillcap_64
XFILLER_26_885 VDD VSS VDD VSS gf180mcu_fd_sc_mcu7t5v0__fillcap_4
XFILLER_197_142 VDD VSS VDD VSS gf180mcu_fd_sc_mcu7t5v0__fillcap_8
XFILLER_40_387 VDD VSS VDD VSS gf180mcu_fd_sc_mcu7t5v0__fillcap_64
XFILLER_197_186 VDD VSS VDD VSS gf180mcu_fd_sc_mcu7t5v0__fillcap_16
XFILLER_194_871 VDD VSS VDD VSS gf180mcu_fd_sc_mcu7t5v0__fillcap_4
XFILLER_193_392 VDD VSS VDD VSS gf180mcu_fd_sc_mcu7t5v0__fillcap_16
XFILLER_268_614 VDD VSS VDD VSS gf180mcu_fd_sc_mcu7t5v0__fillcap_32
XFILLER_121_142 VDD VSS VDD VSS gf180mcu_fd_sc_mcu7t5v0__fillcap_8
XFILLER_121_164 VDD VSS VDD VSS gf180mcu_fd_sc_mcu7t5v0__fillcap_16
XFILLER_263_352 VDD VSS VDD VSS gf180mcu_fd_sc_mcu7t5v0__fillcap_64
XFILLER_17_874 VDD VSS VDD VSS gf180mcu_fd_sc_mcu7t5v0__fillcap_16
XFILLER_189_632 VDD VSS VDD VSS gf180mcu_fd_sc_mcu7t5v0__fillcap_16
X_2900_ VDD VSS _3025_/A1 _4327_/Q _3004_/A2 VDD VSS gf180mcu_fd_sc_mcu7t5v0__nand2_1
XFILLER_50_107 VDD VSS VDD VSS gf180mcu_fd_sc_mcu7t5v0__fillcap_64
X_3880_ VDD _3880_/Q _3937_/CLK VSS _3880_/D VDD VSS gf180mcu_fd_sc_mcu7t5v0__dffq_1
XFILLER_231_282 VDD VSS VDD VSS gf180mcu_fd_sc_mcu7t5v0__fillcap_64
XFILLER_32_877 VDD VSS VDD VSS gf180mcu_fd_sc_mcu7t5v0__fillcap_8
X_2831_ _2831_/B VDD VSS _2892_/B _2967_/B _2951_/B VDD VSS gf180mcu_fd_sc_mcu7t5v0__aoi21_1
X_2762_ _2763_/S VDD VSS _4295_/D wire120/Z _4295_/Q VDD VSS gf180mcu_fd_sc_mcu7t5v0__mux2_2
XFILLER_145_702 VDD VSS VDD VSS gf180mcu_fd_sc_mcu7t5v0__fillcap_16
X_4501_ VSS _4530_/CLK VDD _4501_/D _4501_/Q wire187/Z VDD VSS gf180mcu_fd_sc_mcu7t5v0__dffsnq_1
XFILLER_172_521 VDD VSS VDD VSS gf180mcu_fd_sc_mcu7t5v0__fillcap_4
XFILLER_157_573 VDD VSS VDD VSS gf180mcu_fd_sc_mcu7t5v0__fillcap_4
XFILLER_172_543 VDD VSS VDD VSS gf180mcu_fd_sc_mcu7t5v0__fillcap_4
X_2693_ VDD _4242_/D _2693_/B _2693_/A1 _2698_/B VSS _2693_/A3 VDD VSS gf180mcu_fd_sc_mcu7t5v0__oai31_1
XFILLER_144_234 VDD VSS VDD VSS gf180mcu_fd_sc_mcu7t5v0__fillcap_8
X_4432_ _4432_/D _4432_/Q _4473_/RN VSS _4436_/CLK VDD VDD VSS gf180mcu_fd_sc_mcu7t5v0__dffrnq_1
X_4363_ _4363_/D _4363_/Q wire184/Z VSS _4363_/CLK VDD VDD VSS gf180mcu_fd_sc_mcu7t5v0__dffrnq_1
XFILLER_125_492 VDD VSS VDD VSS gf180mcu_fd_sc_mcu7t5v0__fillcap_64
XFILLER_113_632 VDD VSS VDD VSS gf180mcu_fd_sc_mcu7t5v0__fillcap_16
X_4294_ _4294_/D _4294_/Q _4530_/RN VSS _4305_/CLK VDD VDD VSS gf180mcu_fd_sc_mcu7t5v0__dffrnq_1
XFILLER_140_451 VDD VSS VDD VSS gf180mcu_fd_sc_mcu7t5v0__fillcap_4
X_3314_ _3325_/B VDD VSS _4377_/D _4376_/Q _4377_/Q VDD VSS gf180mcu_fd_sc_mcu7t5v0__mux2_2
XFILLER_112_131 VDD VSS VDD VSS gf180mcu_fd_sc_mcu7t5v0__fillcap_4
XFILLER_98_387 VDD VSS VDD VSS gf180mcu_fd_sc_mcu7t5v0__fillcap_64
X_3245_ _3244_/Z VDD VSS _3245_/Z _4334_/Q wire143/Z VDD VSS gf180mcu_fd_sc_mcu7t5v0__xor3_1
XFILLER_86_527 VDD VSS VDD VSS gf180mcu_fd_sc_mcu7t5v0__fillcap_16
XFILLER_101_827 VDD VSS VDD VSS gf180mcu_fd_sc_mcu7t5v0__fillcap_8
X_3176_ _3176_/S VDD VSS _3176_/Z _3920_/Q _3912_/Q VDD VSS gf180mcu_fd_sc_mcu7t5v0__mux2_2
XFILLER_255_842 VDD VSS VDD VSS gf180mcu_fd_sc_mcu7t5v0__fillcap_32
X_2127_ _4535_/Q VDD VSS _2128_/I _4133_/Q _2127_/A2 VDD VSS gf180mcu_fd_sc_mcu7t5v0__aoi21_1
X_2058_ VDD VSS _2084_/A2 _2925_/A1 _4577_/Q VDD VSS gf180mcu_fd_sc_mcu7t5v0__nor2_1
XFILLER_214_238 VDD VSS VDD VSS gf180mcu_fd_sc_mcu7t5v0__fillcap_4
XFILLER_54_457 VDD VSS VDD VSS gf180mcu_fd_sc_mcu7t5v0__fillcap_64
XFILLER_223_761 VDD VSS VDD VSS gf180mcu_fd_sc_mcu7t5v0__fillcap_8
XFILLER_81_276 VDD VSS VDD VSS gf180mcu_fd_sc_mcu7t5v0__fillcap_4
XFILLER_179_142 VDD VSS VDD VSS gf180mcu_fd_sc_mcu7t5v0__fillcap_64
XFILLER_210_422 VDD VSS VDD VSS gf180mcu_fd_sc_mcu7t5v0__fillcap_32
XFILLER_250_591 VDD VSS VDD VSS gf180mcu_fd_sc_mcu7t5v0__fillcap_4
XFILLER_22_387 VDD VSS VDD VSS gf180mcu_fd_sc_mcu7t5v0__fillcap_64
XFILLER_10_527 VDD VSS VDD VSS gf180mcu_fd_sc_mcu7t5v0__fillcap_64
XFILLER_163_510 VDD VSS VDD VSS gf180mcu_fd_sc_mcu7t5v0__fillcap_8
XFILLER_135_212 VDD VSS VDD VSS gf180mcu_fd_sc_mcu7t5v0__fillcap_32
XFILLER_151_716 VDD VSS VDD VSS gf180mcu_fd_sc_mcu7t5v0__fillcap_32
XFILLER_135_289 VDD VSS VDD VSS gf180mcu_fd_sc_mcu7t5v0__fillcap_32
XFILLER_2_737 VDD VSS VDD VSS gf180mcu_fd_sc_mcu7t5v0__fillcap_64
XFILLER_103_175 VDD VSS VDD VSS gf180mcu_fd_sc_mcu7t5v0__fillcap_32
XFILLER_106_52 VDD VSS VDD VSS gf180mcu_fd_sc_mcu7t5v0__fillcap_16
XFILLER_92_519 VDD VSS VDD VSS gf180mcu_fd_sc_mcu7t5v0__fillcap_4
XFILLER_245_352 VDD VSS VDD VSS gf180mcu_fd_sc_mcu7t5v0__fillcap_64
XFILLER_260_311 VDD VSS VDD VSS gf180mcu_fd_sc_mcu7t5v0__fillcap_4
XFILLER_73_766 VDD VSS VDD VSS gf180mcu_fd_sc_mcu7t5v0__fillcap_4
XFILLER_214_761 VDD VSS VDD VSS gf180mcu_fd_sc_mcu7t5v0__fillcap_32
XFILLER_198_22 VDD VSS VDD VSS gf180mcu_fd_sc_mcu7t5v0__fillcap_8
XFILLER_32_107 VDD VSS VDD VSS gf180mcu_fd_sc_mcu7t5v0__fillcap_64
XFILLER_159_827 VDD VSS VDD VSS gf180mcu_fd_sc_mcu7t5v0__fillcap_8
XFILLER_213_260 VDD VSS VDD VSS gf180mcu_fd_sc_mcu7t5v0__fillcap_4
XFILLER_201_422 VDD VSS VDD VSS gf180mcu_fd_sc_mcu7t5v0__fillcap_32
XFILLER_14_877 VDD VSS VDD VSS gf180mcu_fd_sc_mcu7t5v0__fillcap_8
XFILLER_41_696 VDD VSS VDD VSS gf180mcu_fd_sc_mcu7t5v0__fillcap_4
XFILLER_139_562 VDD VSS VDD VSS gf180mcu_fd_sc_mcu7t5v0__fillcap_8
XFILLER_185_178 VDD VSS VDD VSS gf180mcu_fd_sc_mcu7t5v0__fillcap_32
XFILLER_127_702 VDD VSS VDD VSS gf180mcu_fd_sc_mcu7t5v0__fillcap_16
XFILLER_154_587 VDD VSS VDD VSS gf180mcu_fd_sc_mcu7t5v0__fillcap_8
XFILLER_182_885 VDD VSS VDD VSS gf180mcu_fd_sc_mcu7t5v0__fillcap_4
XFILLER_141_237 VDD VSS VDD VSS gf180mcu_fd_sc_mcu7t5v0__fillcap_32
XFILLER_107_492 VDD VSS VDD VSS gf180mcu_fd_sc_mcu7t5v0__fillcap_8
XFILLER_268_444 VDD VSS VDD VSS gf180mcu_fd_sc_mcu7t5v0__fillcap_32
XFILLER_68_527 VDD VSS VDD VSS gf180mcu_fd_sc_mcu7t5v0__fillcap_64
XFILLER_237_842 VDD VSS VDD VSS gf180mcu_fd_sc_mcu7t5v0__fillcap_32
X_3030_ VDD _3031_/B1 _3038_/B _3213_/B _3030_/A2 VSS _3030_/A3 VDD VSS gf180mcu_fd_sc_mcu7t5v0__oai31_1
XFILLER_252_801 VDD VSS VDD VSS gf180mcu_fd_sc_mcu7t5v0__fillcap_4
XFILLER_264_661 VDD VSS VDD VSS gf180mcu_fd_sc_mcu7t5v0__fillcap_4
XFILLER_36_457 VDD VSS VDD VSS gf180mcu_fd_sc_mcu7t5v0__fillcap_64
XFILLER_63_276 VDD VSS VDD VSS gf180mcu_fd_sc_mcu7t5v0__fillcap_4
XFILLER_51_416 VDD VSS VDD VSS gf180mcu_fd_sc_mcu7t5v0__fillcap_4
XFILLER_205_772 VDD VSS VDD VSS gf180mcu_fd_sc_mcu7t5v0__fillcap_16
X_3932_ VDD _3932_/Q _3936_/CLK VSS _3932_/D VDD VSS gf180mcu_fd_sc_mcu7t5v0__dffq_1
XFILLER_232_591 VDD VSS VDD VSS gf180mcu_fd_sc_mcu7t5v0__fillcap_4
X_3863_ _3863_/D _3863_/Q _4573_/RN VSS _4573_/CLK VDD VDD VSS gf180mcu_fd_sc_mcu7t5v0__dffrnq_1
XFILLER_176_101 VDD VSS VDD VSS gf180mcu_fd_sc_mcu7t5v0__fillcap_4
XFILLER_176_156 VDD VSS VDD VSS gf180mcu_fd_sc_mcu7t5v0__fillcap_16
X_2814_ VDD VSS _3224_/A2 _3044_/A1 _3223_/B VDD VSS gf180mcu_fd_sc_mcu7t5v0__nand2_1
X_3794_ VDD VSS _3795_/B _4292_/Q wire16/Z VDD VSS gf180mcu_fd_sc_mcu7t5v0__nor2_1
XFILLER_191_104 VDD VSS VDD VSS gf180mcu_fd_sc_mcu7t5v0__fillcap_8
XFILLER_164_307 VDD VSS VDD VSS gf180mcu_fd_sc_mcu7t5v0__fillcap_8
XFILLER_118_702 VDD VSS VDD VSS gf180mcu_fd_sc_mcu7t5v0__fillcap_16
XFILLER_145_543 VDD VSS VDD VSS gf180mcu_fd_sc_mcu7t5v0__fillcap_16
X_2745_ _2754_/S VDD VSS _4279_/D _4279_/Q _4453_/Q VDD VSS gf180mcu_fd_sc_mcu7t5v0__mux2_2
XFILLER_117_212 VDD VSS VDD VSS gf180mcu_fd_sc_mcu7t5v0__fillcap_16
X_2676_ VDD VSS _2677_/B _4309_/Q _4503_/D VDD VSS gf180mcu_fd_sc_mcu7t5v0__nand2_1
X_4415_ _4415_/D _4415_/Q wire196/I VSS _4449_/CLK VDD VDD VSS gf180mcu_fd_sc_mcu7t5v0__dffrnq_1
XFILLER_259_422 VDD VSS VDD VSS gf180mcu_fd_sc_mcu7t5v0__fillcap_64
X_4346_ _4346_/D _4346_/Q _4371_/RN VSS _4346_/CLK VDD VDD VSS gf180mcu_fd_sc_mcu7t5v0__dffrnq_1
Xclkbuf_3_7__f_clk_i VDD VSS clkload6/I clkbuf_0_clk_i/Z VDD VSS gf180mcu_fd_sc_mcu7t5v0__clkbuf_16
XFILLER_87_836 VDD VSS VDD VSS gf180mcu_fd_sc_mcu7t5v0__fillcap_4
XFILLER_98_151 VDD VSS VDD VSS gf180mcu_fd_sc_mcu7t5v0__fillcap_16
X_4277_ _4277_/D _4277_/Q wire199/I VSS _4518_/CLK VDD VDD VSS gf180mcu_fd_sc_mcu7t5v0__dffrnq_1
X_3228_ VDD VSS _3228_/Z _2862_/B _4350_/Q VDD VSS gf180mcu_fd_sc_mcu7t5v0__xor2_1
XFILLER_95_880 VDD VSS VDD VSS gf180mcu_fd_sc_mcu7t5v0__fillcap_8
X_3159_ _3159_/B1 _3159_/C VDD VSS _3160_/B _3159_/A1 _3159_/A2 _3159_/B2 VDD VSS
+ gf180mcu_fd_sc_mcu7t5v0__oai221_1
XFILLER_227_352 VDD VSS VDD VSS gf180mcu_fd_sc_mcu7t5v0__fillcap_64
XFILLER_223_72 VDD VSS VDD VSS gf180mcu_fd_sc_mcu7t5v0__fillcap_64
XFILLER_36_26 VDD VSS VDD VSS gf180mcu_fd_sc_mcu7t5v0__fillcap_8
XFILLER_36_37 VDD VSS VDD VSS gf180mcu_fd_sc_mcu7t5v0__fillcap_64
XFILLER_242_311 VDD VSS VDD VSS gf180mcu_fd_sc_mcu7t5v0__fillcap_4
XFILLER_254_171 VDD VSS VDD VSS gf180mcu_fd_sc_mcu7t5v0__fillcap_4
XFILLER_55_766 VDD VSS VDD VSS gf180mcu_fd_sc_mcu7t5v0__fillcap_4
XFILLER_14_107 VDD VSS VDD VSS gf180mcu_fd_sc_mcu7t5v0__fillcap_64
XFILLER_230_517 VDD VSS VDD VSS gf180mcu_fd_sc_mcu7t5v0__fillcap_8
XFILLER_167_156 VDD VSS VDD VSS gf180mcu_fd_sc_mcu7t5v0__fillcap_4
XFILLER_11_836 VDD VSS VDD VSS gf180mcu_fd_sc_mcu7t5v0__fillcap_4
XFILLER_23_696 VDD VSS VDD VSS gf180mcu_fd_sc_mcu7t5v0__fillcap_4
XFILLER_109_702 VDD VSS VDD VSS gf180mcu_fd_sc_mcu7t5v0__fillcap_8
XFILLER_6_317 VDD VSS VDD VSS gf180mcu_fd_sc_mcu7t5v0__fillcap_64
XFILLER_148_381 VDD VSS VDD VSS gf180mcu_fd_sc_mcu7t5v0__fillcap_4
XFILLER_109_746 VDD VSS VDD VSS gf180mcu_fd_sc_mcu7t5v0__fillcap_8
XFILLER_164_885 VDD VSS VDD VSS gf180mcu_fd_sc_mcu7t5v0__fillcap_4
XFILLER_104_473 VDD VSS VDD VSS gf180mcu_fd_sc_mcu7t5v0__fillcap_8
XFILLER_104_451 VDD VSS VDD VSS gf180mcu_fd_sc_mcu7t5v0__fillcap_4
XFILLER_77_346 VDD VSS VDD VSS gf180mcu_fd_sc_mcu7t5v0__fillcap_4
XFILLER_77_66 VDD VSS VDD VSS gf180mcu_fd_sc_mcu7t5v0__fillcap_4
XFILLER_219_842 VDD VSS VDD VSS gf180mcu_fd_sc_mcu7t5v0__fillcap_32
XFILLER_246_661 VDD VSS VDD VSS gf180mcu_fd_sc_mcu7t5v0__fillcap_4
XFILLER_133_72 VDD VSS VDD VSS gf180mcu_fd_sc_mcu7t5v0__fillcap_8
Xclkbuf_leaf_93_clk_i _4477_/CLK VSS VDD clkload0/I VDD VSS gf180mcu_fd_sc_mcu7t5v0__clkbuf_2
XFILLER_18_457 VDD VSS VDD VSS gf180mcu_fd_sc_mcu7t5v0__fillcap_64
XFILLER_93_65 VDD VSS VDD VSS gf180mcu_fd_sc_mcu7t5v0__fillcap_4
XFILLER_45_276 VDD VSS VDD VSS gf180mcu_fd_sc_mcu7t5v0__fillcap_4
XFILLER_33_416 VDD VSS VDD VSS gf180mcu_fd_sc_mcu7t5v0__fillcap_4
XFILLER_202_753 VDD VSS VDD VSS gf180mcu_fd_sc_mcu7t5v0__fillcap_4
XFILLER_214_591 VDD VSS VDD VSS gf180mcu_fd_sc_mcu7t5v0__fillcap_4
X_2530_ _2535_/S VDD VSS _4156_/D _4156_/Q wire123/I VDD VSS gf180mcu_fd_sc_mcu7t5v0__mux2_2
XFILLER_155_874 VDD VSS VDD VSS gf180mcu_fd_sc_mcu7t5v0__fillcap_16
Xclkbuf_leaf_31_clk_i _4523_/CLK VSS VDD clkload4/I VDD VSS gf180mcu_fd_sc_mcu7t5v0__clkbuf_2
X_2461_ _2463_/S VDD VSS _4087_/D wire155/Z _4087_/Q VDD VSS gf180mcu_fd_sc_mcu7t5v0__mux2_2
XFILLER_170_877 VDD VSS VDD VSS gf180mcu_fd_sc_mcu7t5v0__fillcap_8
X_4200_ _4200_/D _4200_/Q _4535_/RN VSS _4369_/CLK VDD VDD VSS gf180mcu_fd_sc_mcu7t5v0__dffrnq_1
XFILLER_130_708 VDD VSS VDD VSS gf180mcu_fd_sc_mcu7t5v0__fillcap_4
Xclkbuf_leaf_46_clk_i _4338_/CLK VSS VDD clkload6/I VDD VSS gf180mcu_fd_sc_mcu7t5v0__clkbuf_2
XFILLER_69_836 VDD VSS VDD VSS gf180mcu_fd_sc_mcu7t5v0__fillcap_4
X_2392_ _2393_/S VDD VSS _4032_/D wire153/Z _4032_/Q VDD VSS gf180mcu_fd_sc_mcu7t5v0__mux2_2
X_4131_ _4131_/D _4131_/Q wire192/Z VSS _4269_/CLK VDD VDD VSS gf180mcu_fd_sc_mcu7t5v0__dffrnq_1
XFILLER_268_274 VDD VSS VDD VSS gf180mcu_fd_sc_mcu7t5v0__fillcap_32
XFILLER_123_793 VDD VSS VDD VSS gf180mcu_fd_sc_mcu7t5v0__fillcap_32
XFILLER_84_839 VDD VSS VDD VSS gf180mcu_fd_sc_mcu7t5v0__fillcap_4
XFILLER_96_699 VDD VSS VDD VSS gf180mcu_fd_sc_mcu7t5v0__fillcap_8
X_4062_ VDD _4062_/Q _4062_/CLK VSS _4062_/D VDD VSS gf180mcu_fd_sc_mcu7t5v0__dffq_1
XFILLER_237_661 VDD VSS VDD VSS gf180mcu_fd_sc_mcu7t5v0__fillcap_16
XFILLER_209_352 VDD VSS VDD VSS gf180mcu_fd_sc_mcu7t5v0__fillcap_32
XFILLER_260_37 VDD VSS VDD VSS gf180mcu_fd_sc_mcu7t5v0__fillcap_64
X_3013_ VDD VSS _3014_/A3 _2303_/Z _3013_/A2 VDD VSS gf180mcu_fd_sc_mcu7t5v0__nand2_1
Xwire25 VSS wire25/Z wire25/I VDD VDD VSS gf180mcu_fd_sc_mcu7t5v0__buf_2
XFILLER_224_311 VDD VSS VDD VSS gf180mcu_fd_sc_mcu7t5v0__fillcap_4
XFILLER_236_171 VDD VSS VDD VSS gf180mcu_fd_sc_mcu7t5v0__fillcap_4
Xwire36 VSS wire36/Z wire36/I VDD VDD VSS gf180mcu_fd_sc_mcu7t5v0__buf_3
XFILLER_37_766 VDD VSS VDD VSS gf180mcu_fd_sc_mcu7t5v0__fillcap_4
Xwire14 wire14/Z VSS VDD wire14/I VDD VSS gf180mcu_fd_sc_mcu7t5v0__clkbuf_3
Xwire58 VSS wire58/Z wire58/I VDD VDD VSS gf180mcu_fd_sc_mcu7t5v0__buf_2
Xwire69 VSS wire69/Z wire69/I VDD VDD VSS gf180mcu_fd_sc_mcu7t5v0__clkbuf_1
Xwire47 VSS wire47/Z wire48/Z VDD VDD VSS gf180mcu_fd_sc_mcu7t5v0__clkbuf_1
X_3915_ VDD _3915_/Q _3936_/CLK VSS _3915_/D VDD VSS gf180mcu_fd_sc_mcu7t5v0__dffq_1
X_3846_ _3848_/S VDD VSS _3999_/D _4294_/Q _3999_/Q VDD VSS gf180mcu_fd_sc_mcu7t5v0__mux2_2
XFILLER_192_413 VDD VSS VDD VSS gf180mcu_fd_sc_mcu7t5v0__fillcap_8
X_3777_ _3777_/S VDD VSS _3945_/D _4296_/Q _3945_/Q VDD VSS gf180mcu_fd_sc_mcu7t5v0__mux2_2
XFILLER_146_885 VDD VSS VDD VSS gf180mcu_fd_sc_mcu7t5v0__fillcap_4
X_2728_ _2728_/S VDD VSS _4262_/D _4262_/Q _4278_/Q VDD VSS gf180mcu_fd_sc_mcu7t5v0__mux2_2
XFILLER_160_310 VDD VSS VDD VSS gf180mcu_fd_sc_mcu7t5v0__fillcap_4
XFILLER_145_395 VDD VSS VDD VSS gf180mcu_fd_sc_mcu7t5v0__fillcap_8
XFILLER_105_204 VDD VSS VDD VSS gf180mcu_fd_sc_mcu7t5v0__fillcap_4
X_2659_ _4146_/Q _2666_/C VDD VSS _2660_/B2 _4267_/Q _2168_/Z _2666_/B1 VDD VSS gf180mcu_fd_sc_mcu7t5v0__aoi221_1
X_4329_ _4329_/D _4329_/Q wire206/Z VSS _4330_/CLK VDD VDD VSS gf180mcu_fd_sc_mcu7t5v0__dffrnq_1
XFILLER_59_346 VDD VSS VDD VSS gf180mcu_fd_sc_mcu7t5v0__fillcap_4
XFILLER_216_801 VDD VSS VDD VSS gf180mcu_fd_sc_mcu7t5v0__fillcap_4
XFILLER_15_416 VDD VSS VDD VSS gf180mcu_fd_sc_mcu7t5v0__fillcap_4
XFILLER_27_276 VDD VSS VDD VSS gf180mcu_fd_sc_mcu7t5v0__fillcap_4
XFILLER_203_506 VDD VSS VDD VSS gf180mcu_fd_sc_mcu7t5v0__fillcap_4
XFILLER_203_539 VDD VSS VDD VSS gf180mcu_fd_sc_mcu7t5v0__fillcap_16
XFILLER_168_410 VDD VSS VDD VSS gf180mcu_fd_sc_mcu7t5v0__fillcap_8
Xmax_length100 _3187_/C _3180_/B VDD VSS VDD VSS gf180mcu_fd_sc_mcu7t5v0__buf_4
XFILLER_137_2 VDD VSS VDD VSS gf180mcu_fd_sc_mcu7t5v0__fillcap_16
Xmax_length122 VSS _3400_/I1 _4443_/Q VDD VDD VSS gf180mcu_fd_sc_mcu7t5v0__buf_1
XFILLER_7_626 VDD VSS VDD VSS gf180mcu_fd_sc_mcu7t5v0__fillcap_4
XFILLER_170_107 VDD VSS VDD VSS gf180mcu_fd_sc_mcu7t5v0__fillcap_64
Xmax_length144 VSS _3497_/C1 _4329_/Q VDD VDD VSS gf180mcu_fd_sc_mcu7t5v0__buf_2
Xmax_length188 _4616_/RN _4534_/RN VDD VSS VDD VSS gf180mcu_fd_sc_mcu7t5v0__buf_12
XFILLER_152_877 VDD VSS VDD VSS gf180mcu_fd_sc_mcu7t5v0__fillcap_8
XFILLER_151_343 VDD VSS VDD VSS gf180mcu_fd_sc_mcu7t5v0__fillcap_4
XFILLER_218_171 VDD VSS VDD VSS gf180mcu_fd_sc_mcu7t5v0__fillcap_4
XFILLER_19_766 VDD VSS VDD VSS gf180mcu_fd_sc_mcu7t5v0__fillcap_4
XFILLER_81_809 VDD VSS VDD VSS gf180mcu_fd_sc_mcu7t5v0__fillcap_8
XFILLER_206_333 VDD VSS VDD VSS gf180mcu_fd_sc_mcu7t5v0__fillcap_8
XFILLER_234_675 VDD VSS VDD VSS gf180mcu_fd_sc_mcu7t5v0__fillcap_4
XFILLER_178_229 VDD VSS VDD VSS gf180mcu_fd_sc_mcu7t5v0__fillcap_16
X_3700_ _3706_/S VDD VSS _3883_/D _3883_/Q wire178/Z VDD VSS gf180mcu_fd_sc_mcu7t5v0__mux2_2
X_1961_ VDD VSS _4235_/Q _2675_/A1 VDD VSS gf180mcu_fd_sc_mcu7t5v0__clkinv_1
X_3631_ VDD VSS _3631_/I _4479_/D VDD VSS gf180mcu_fd_sc_mcu7t5v0__clkinv_1
X_3562_ _3562_/A3 VDD VSS _3563_/B _4592_/Q _3562_/A2 VDD VSS gf180mcu_fd_sc_mcu7t5v0__nand3_1
X_2513_ _2730_/S VDD VSS _4142_/D _4142_/Q wire137/Z VDD VSS gf180mcu_fd_sc_mcu7t5v0__mux2_2
XFILLER_155_671 VDD VSS VDD VSS gf180mcu_fd_sc_mcu7t5v0__fillcap_8
XFILLER_128_885 VDD VSS VDD VSS gf180mcu_fd_sc_mcu7t5v0__fillcap_4
XFILLER_52_2 VDD VSS VDD VSS gf180mcu_fd_sc_mcu7t5v0__fillcap_32
X_3493_ _3493_/B _4593_/Q VDD VSS _3494_/A3 wire82/I _3490_/Z VDD VSS gf180mcu_fd_sc_mcu7t5v0__oai211_1
XFILLER_142_387 VDD VSS VDD VSS gf180mcu_fd_sc_mcu7t5v0__fillcap_16
X_2444_ _2444_/B VDD VSS _4074_/D _3438_/A2 _2454_/S VDD VSS gf180mcu_fd_sc_mcu7t5v0__aoi21_1
X_2375_ _2492_/A1 VDD VSS _2383_/S _4580_/Q _4581_/Q VDD VSS gf180mcu_fd_sc_mcu7t5v0__and3_1
X_4114_ VDD _4114_/Q _4122_/CLK VSS _4114_/D VDD VSS gf180mcu_fd_sc_mcu7t5v0__dffq_1
X_4045_ VDD _4045_/Q _4061_/CLK VSS _4045_/D VDD VSS gf180mcu_fd_sc_mcu7t5v0__dffq_1
XFILLER_240_667 VDD VSS VDD VSS gf180mcu_fd_sc_mcu7t5v0__fillcap_64
XFILLER_178_796 VDD VSS VDD VSS gf180mcu_fd_sc_mcu7t5v0__fillcap_8
X_3829_ _3830_/S VDD VSS _3984_/D wire172/Z _3984_/Q VDD VSS gf180mcu_fd_sc_mcu7t5v0__mux2_2
XFILLER_137_148 VDD VSS VDD VSS gf180mcu_fd_sc_mcu7t5v0__fillcap_32
XFILLER_152_107 VDD VSS VDD VSS gf180mcu_fd_sc_mcu7t5v0__fillcap_8
XFILLER_106_546 VDD VSS VDD VSS gf180mcu_fd_sc_mcu7t5v0__fillcap_4
XFILLER_134_877 VDD VSS VDD VSS gf180mcu_fd_sc_mcu7t5v0__fillcap_8
XFILLER_161_663 VDD VSS VDD VSS gf180mcu_fd_sc_mcu7t5v0__fillcap_32
XFILLER_114_63 VDD VSS VDD VSS gf180mcu_fd_sc_mcu7t5v0__fillcap_4
XFILLER_262_247 VDD VSS VDD VSS gf180mcu_fd_sc_mcu7t5v0__fillcap_64
XFILLER_216_675 VDD VSS VDD VSS gf180mcu_fd_sc_mcu7t5v0__fillcap_4
XFILLER_254_2 VDD VSS VDD VSS gf180mcu_fd_sc_mcu7t5v0__fillcap_32
XFILLER_71_842 VDD VSS VDD VSS gf180mcu_fd_sc_mcu7t5v0__fillcap_32
XFILLER_188_527 VDD VSS VDD VSS gf180mcu_fd_sc_mcu7t5v0__fillcap_4
XFILLER_212_870 VDD VSS VDD VSS gf180mcu_fd_sc_mcu7t5v0__fillcap_4
XFILLER_230_177 VDD VSS VDD VSS gf180mcu_fd_sc_mcu7t5v0__fillcap_64
XFILLER_168_273 VDD VSS VDD VSS gf180mcu_fd_sc_mcu7t5v0__fillcap_8
XFILLER_156_435 VDD VSS VDD VSS gf180mcu_fd_sc_mcu7t5v0__fillcap_4
XFILLER_156_457 VDD VSS VDD VSS gf180mcu_fd_sc_mcu7t5v0__fillcap_16
XFILLER_171_416 VDD VSS VDD VSS gf180mcu_fd_sc_mcu7t5v0__fillcap_4
XFILLER_125_822 VDD VSS VDD VSS gf180mcu_fd_sc_mcu7t5v0__fillcap_8
XFILLER_136_192 VDD VSS VDD VSS gf180mcu_fd_sc_mcu7t5v0__fillcap_4
XFILLER_225_18 VDD VSS VDD VSS gf180mcu_fd_sc_mcu7t5v0__fillcap_32
XFILLER_98_728 VDD VSS VDD VSS gf180mcu_fd_sc_mcu7t5v0__fillcap_4
XFILLER_125_877 VDD VSS VDD VSS gf180mcu_fd_sc_mcu7t5v0__fillcap_8
XFILLER_124_387 VDD VSS VDD VSS gf180mcu_fd_sc_mcu7t5v0__fillcap_8
XFILLER_93_422 VDD VSS VDD VSS gf180mcu_fd_sc_mcu7t5v0__fillcap_64
X_2160_ VDD VSS _2232_/A2 _4321_/Q _4507_/Q VDD VSS gf180mcu_fd_sc_mcu7t5v0__nand2_1
XFILLER_254_737 VDD VSS VDD VSS gf180mcu_fd_sc_mcu7t5v0__fillcap_64
XFILLER_266_597 VDD VSS VDD VSS gf180mcu_fd_sc_mcu7t5v0__fillcap_64
X_2091_ _4538_/Q VDD VSS _2101_/A2 _2087_/Z _2102_/A4 VDD VSS gf180mcu_fd_sc_mcu7t5v0__aoi21_1
XFILLER_171_80 VDD VSS VDD VSS gf180mcu_fd_sc_mcu7t5v0__fillcap_4
XFILLER_61_352 VDD VSS VDD VSS gf180mcu_fd_sc_mcu7t5v0__fillcap_64
XFILLER_222_667 VDD VSS VDD VSS gf180mcu_fd_sc_mcu7t5v0__fillcap_64
X_2993_ _4350_/Q VDD VSS _2993_/Z _4351_/Q _4349_/Q VDD VSS gf180mcu_fd_sc_mcu7t5v0__and3_1
X_1944_ VDD VSS _4337_/Q _2939_/A1 VDD VSS gf180mcu_fd_sc_mcu7t5v0__clkinv_1
X_3614_ VDD VSS _3615_/B2 _3619_/C _3614_/A2 VDD VSS gf180mcu_fd_sc_mcu7t5v0__nor2_1
XFILLER_134_107 VDD VSS VDD VSS gf180mcu_fd_sc_mcu7t5v0__fillcap_16
X_4594_ _4594_/D wire78/I _4616_/RN VSS _4606_/CLK VDD VDD VSS gf180mcu_fd_sc_mcu7t5v0__dffrnq_1
XFILLER_174_298 VDD VSS VDD VSS gf180mcu_fd_sc_mcu7t5v0__fillcap_4
XFILLER_190_769 VDD VSS VDD VSS gf180mcu_fd_sc_mcu7t5v0__fillcap_16
X_3545_ _3545_/A3 VDD VSS _3547_/B1 wire42/Z _3545_/A2 VDD VSS gf180mcu_fd_sc_mcu7t5v0__nand3_1
X_3476_ VDD VSS _3478_/A2 _4131_/Q _2039_/Z VDD VSS gf180mcu_fd_sc_mcu7t5v0__nand2_1
XFILLER_116_877 VDD VSS VDD VSS gf180mcu_fd_sc_mcu7t5v0__fillcap_8
X_2427_ _2431_/S VDD VSS _4061_/D wire158/Z _4061_/Q VDD VSS gf180mcu_fd_sc_mcu7t5v0__mux2_2
XFILLER_130_346 VDD VSS VDD VSS gf180mcu_fd_sc_mcu7t5v0__fillcap_4
XFILLER_97_772 VDD VSS VDD VSS gf180mcu_fd_sc_mcu7t5v0__fillcap_8
X_2358_ _2359_/S VDD VSS _4008_/D _4008_/Q wire153/Z VDD VSS gf180mcu_fd_sc_mcu7t5v0__mux2_2
X_2289_ VDD VSS _2290_/B2 _4386_/Q _3347_/B VDD VSS gf180mcu_fd_sc_mcu7t5v0__nand2_1
XFILLER_244_247 VDD VSS VDD VSS gf180mcu_fd_sc_mcu7t5v0__fillcap_64
X_4028_ VDD _4028_/Q _4028_/CLK VSS _4028_/D VDD VSS gf180mcu_fd_sc_mcu7t5v0__dffq_1
XFILLER_231_72 VDD VSS VDD VSS gf180mcu_fd_sc_mcu7t5v0__fillcap_64
XFILLER_53_842 VDD VSS VDD VSS gf180mcu_fd_sc_mcu7t5v0__fillcap_32
XFILLER_80_661 VDD VSS VDD VSS gf180mcu_fd_sc_mcu7t5v0__fillcap_4
XFILLER_44_37 VDD VSS VDD VSS gf180mcu_fd_sc_mcu7t5v0__fillcap_64
XFILLER_80_683 VDD VSS VDD VSS gf180mcu_fd_sc_mcu7t5v0__fillcap_8
XFILLER_178_560 VDD VSS VDD VSS gf180mcu_fd_sc_mcu7t5v0__fillcap_4
XFILLER_212_177 VDD VSS VDD VSS gf180mcu_fd_sc_mcu7t5v0__fillcap_8
XFILLER_200_317 VDD VSS VDD VSS gf180mcu_fd_sc_mcu7t5v0__fillcap_32
XFILLER_226_6 VDD VSS VDD VSS gf180mcu_fd_sc_mcu7t5v0__fillcap_16
XFILLER_100_87 VDD VSS VDD VSS gf180mcu_fd_sc_mcu7t5v0__fillcap_16
XFILLER_21_772 VDD VSS VDD VSS gf180mcu_fd_sc_mcu7t5v0__fillcap_64
XFILLER_138_457 VDD VSS VDD VSS gf180mcu_fd_sc_mcu7t5v0__fillcap_16
XFILLER_268_818 VDD VSS VDD VSS gf180mcu_fd_sc_mcu7t5v0__fillcap_32
XFILLER_192_57 VDD VSS VDD VSS gf180mcu_fd_sc_mcu7t5v0__fillcap_8
XFILLER_121_335 VDD VSS VDD VSS gf180mcu_fd_sc_mcu7t5v0__fillcap_8
XFILLER_75_422 VDD VSS VDD VSS gf180mcu_fd_sc_mcu7t5v0__fillcap_64
XFILLER_248_597 VDD VSS VDD VSS gf180mcu_fd_sc_mcu7t5v0__fillcap_64
XFILLER_208_406 VDD VSS VDD VSS gf180mcu_fd_sc_mcu7t5v0__fillcap_32
XFILLER_87_282 VDD VSS VDD VSS gf180mcu_fd_sc_mcu7t5v0__fillcap_64
XFILLER_85_66 VDD VSS VDD VSS gf180mcu_fd_sc_mcu7t5v0__fillcap_4
XFILLER_263_556 VDD VSS VDD VSS gf180mcu_fd_sc_mcu7t5v0__fillcap_4
XFILLER_141_72 VDD VSS VDD VSS gf180mcu_fd_sc_mcu7t5v0__fillcap_16
XFILLER_141_61 VDD VSS VDD VSS gf180mcu_fd_sc_mcu7t5v0__fillcap_8
XFILLER_188_302 VDD VSS VDD VSS gf180mcu_fd_sc_mcu7t5v0__fillcap_8
XFILLER_43_352 VDD VSS VDD VSS gf180mcu_fd_sc_mcu7t5v0__fillcap_64
XFILLER_204_667 VDD VSS VDD VSS gf180mcu_fd_sc_mcu7t5v0__fillcap_8
XFILLER_188_357 VDD VSS VDD VSS gf180mcu_fd_sc_mcu7t5v0__fillcap_8
XFILLER_70_171 VDD VSS VDD VSS gf180mcu_fd_sc_mcu7t5v0__fillcap_4
XFILLER_231_486 VDD VSS VDD VSS gf180mcu_fd_sc_mcu7t5v0__fillcap_4
Xspi_opentarget_i3c_top_230 sda_pad_PDRV0 VDD VSS VDD VSS gf180mcu_fd_sc_mcu7t5v0__tiel
Xspi_opentarget_i3c_top_241 spi_miso_o_PU VDD VSS VDD VSS gf180mcu_fd_sc_mcu7t5v0__tiel
Xwire140 VSS wire140/Z _4372_/Q VDD VDD VSS gf180mcu_fd_sc_mcu7t5v0__clkbuf_1
XFILLER_11_282 VDD VSS VDD VSS gf180mcu_fd_sc_mcu7t5v0__fillcap_64
Xwire184 wire184/Z VSS VDD wire186/Z VDD VSS gf180mcu_fd_sc_mcu7t5v0__clkbuf_8
XFILLER_116_107 VDD VSS VDD VSS gf180mcu_fd_sc_mcu7t5v0__fillcap_32
XFILLER_172_758 VDD VSS VDD VSS gf180mcu_fd_sc_mcu7t5v0__fillcap_4
X_3330_ VDD _3330_/B _3333_/B1 _4383_/D _3336_/A1 VSS VDD VSS gf180mcu_fd_sc_mcu7t5v0__oai21_1
XFILLER_140_644 VDD VSS VDD VSS gf180mcu_fd_sc_mcu7t5v0__fillcap_8
XFILLER_258_317 VDD VSS VDD VSS gf180mcu_fd_sc_mcu7t5v0__fillcap_64
X_3261_ VDD VSS _3261_/I _4365_/D VDD VSS gf180mcu_fd_sc_mcu7t5v0__clkinv_1
XFILLER_3_492 VDD VSS VDD VSS gf180mcu_fd_sc_mcu7t5v0__fillcap_64
X_2212_ _2212_/A3 VDD VSS _2685_/C _4501_/Q wire58/Z VDD VSS gf180mcu_fd_sc_mcu7t5v0__nand3_1
X_3192_ VDD VSS _3193_/B _4337_/Q _3170_/B VDD VSS gf180mcu_fd_sc_mcu7t5v0__nor2_1
XFILLER_79_772 VDD VSS VDD VSS gf180mcu_fd_sc_mcu7t5v0__fillcap_64
X_2143_ VDD VSS _2318_/A2 _4524_/D _4529_/D VDD VSS gf180mcu_fd_sc_mcu7t5v0__nand2_1
XFILLER_15_2 VDD VSS VDD VSS gf180mcu_fd_sc_mcu7t5v0__fillcap_64
XFILLER_226_247 VDD VSS VDD VSS gf180mcu_fd_sc_mcu7t5v0__fillcap_64
X_2074_ VDD VSS _2074_/Z wire96/Z _2075_/A2 VDD VSS gf180mcu_fd_sc_mcu7t5v0__and2_1
XFILLER_241_206 VDD VSS VDD VSS gf180mcu_fd_sc_mcu7t5v0__fillcap_4
XFILLER_35_842 VDD VSS VDD VSS gf180mcu_fd_sc_mcu7t5v0__fillcap_32
XFILLER_62_661 VDD VSS VDD VSS gf180mcu_fd_sc_mcu7t5v0__fillcap_4
XFILLER_50_801 VDD VSS VDD VSS gf180mcu_fd_sc_mcu7t5v0__fillcap_4
X_2976_ VDD _2977_/B1 _3211_/B _4371_/Q _3210_/A2 VSS _3209_/B VDD VSS gf180mcu_fd_sc_mcu7t5v0__oai31_1
X_1927_ VDD VSS _4529_/D _2795_/A1 VDD VSS gf180mcu_fd_sc_mcu7t5v0__clkinv_1
XFILLER_30_591 VDD VSS VDD VSS gf180mcu_fd_sc_mcu7t5v0__fillcap_4
XFILLER_147_276 VDD VSS VDD VSS gf180mcu_fd_sc_mcu7t5v0__fillcap_4
XFILLER_108_619 VDD VSS VDD VSS gf180mcu_fd_sc_mcu7t5v0__fillcap_32
X_4577_ _4577_/D _4577_/Q _4616_/RN VSS _4614_/CLK VDD VDD VSS gf180mcu_fd_sc_mcu7t5v0__dffrnq_1
X_3528_ _3528_/A3 VDD VSS _3546_/A2 _3451_/B _3528_/A2 VDD VSS gf180mcu_fd_sc_mcu7t5v0__nand3_1
XFILLER_103_346 VDD VSS VDD VSS gf180mcu_fd_sc_mcu7t5v0__fillcap_4
X_3459_ VDD VSS _3464_/A2 wire74/Z _3458_/Z VDD VSS gf180mcu_fd_sc_mcu7t5v0__nand2_1
XFILLER_57_422 VDD VSS VDD VSS gf180mcu_fd_sc_mcu7t5v0__fillcap_64
XFILLER_218_737 VDD VSS VDD VSS gf180mcu_fd_sc_mcu7t5v0__fillcap_8
XFILLER_69_282 VDD VSS VDD VSS gf180mcu_fd_sc_mcu7t5v0__fillcap_64
XFILLER_245_556 VDD VSS VDD VSS gf180mcu_fd_sc_mcu7t5v0__fillcap_4
XFILLER_84_241 VDD VSS VDD VSS gf180mcu_fd_sc_mcu7t5v0__fillcap_4
XFILLER_25_352 VDD VSS VDD VSS gf180mcu_fd_sc_mcu7t5v0__fillcap_64
XFILLER_40_311 VDD VSS VDD VSS gf180mcu_fd_sc_mcu7t5v0__fillcap_4
XFILLER_52_171 VDD VSS VDD VSS gf180mcu_fd_sc_mcu7t5v0__fillcap_4
XFILLER_154_725 VDD VSS VDD VSS gf180mcu_fd_sc_mcu7t5v0__fillcap_8
XFILLER_5_702 VDD VSS VDD VSS gf180mcu_fd_sc_mcu7t5v0__fillcap_64
XFILLER_153_224 VDD VSS VDD VSS gf180mcu_fd_sc_mcu7t5v0__fillcap_4
XFILLER_107_674 VDD VSS VDD VSS gf180mcu_fd_sc_mcu7t5v0__fillcap_16
XFILLER_268_648 VDD VSS VDD VSS gf180mcu_fd_sc_mcu7t5v0__fillcap_32
XFILLER_267_136 VDD VSS VDD VSS gf180mcu_fd_sc_mcu7t5v0__fillcap_4
XFILLER_122_699 VDD VSS VDD VSS gf180mcu_fd_sc_mcu7t5v0__fillcap_8
XFILLER_88_591 VDD VSS VDD VSS gf180mcu_fd_sc_mcu7t5v0__fillcap_4
XFILLER_76_731 VDD VSS VDD VSS gf180mcu_fd_sc_mcu7t5v0__fillcap_4
XFILLER_96_98 VDD VSS VDD VSS gf180mcu_fd_sc_mcu7t5v0__fillcap_4
XFILLER_236_556 VDD VSS VDD VSS gf180mcu_fd_sc_mcu7t5v0__fillcap_8
XFILLER_223_206 VDD VSS VDD VSS gf180mcu_fd_sc_mcu7t5v0__fillcap_4
Xclkbuf_4_12_0_host_clk_i _3968_/CLK VSS VDD clkbuf_0_host_clk_i/Z VDD VSS gf180mcu_fd_sc_mcu7t5v0__clkbuf_2
XFILLER_17_842 VDD VSS VDD VSS gf180mcu_fd_sc_mcu7t5v0__fillcap_32
XFILLER_44_661 VDD VSS VDD VSS gf180mcu_fd_sc_mcu7t5v0__fillcap_4
XFILLER_32_801 VDD VSS VDD VSS gf180mcu_fd_sc_mcu7t5v0__fillcap_4
XFILLER_232_784 VDD VSS VDD VSS gf180mcu_fd_sc_mcu7t5v0__fillcap_4
X_2830_ _3271_/C _2821_/Z VDD VSS _2893_/A1 _2985_/C _2778_/B VDD VSS gf180mcu_fd_sc_mcu7t5v0__aoi22_1
X_2761_ _2763_/S VDD VSS _4294_/D wire123/Z _4294_/Q VDD VSS gf180mcu_fd_sc_mcu7t5v0__mux2_2
XFILLER_12_591 VDD VSS VDD VSS gf180mcu_fd_sc_mcu7t5v0__fillcap_4
XFILLER_185_883 VDD VSS VDD VSS gf180mcu_fd_sc_mcu7t5v0__fillcap_4
X_2692_ VDD VSS _2693_/B _4242_/Q _2698_/B VDD VSS gf180mcu_fd_sc_mcu7t5v0__nand2_1
X_4500_ _4500_/D _4500_/Q wire186/Z VSS _4500_/CLK VDD VDD VSS gf180mcu_fd_sc_mcu7t5v0__dffrnq_1
XFILLER_117_438 VDD VSS VDD VSS gf180mcu_fd_sc_mcu7t5v0__fillcap_4
X_4431_ _4431_/D _4431_/Q wire193/I VSS _4436_/CLK VDD VDD VSS gf180mcu_fd_sc_mcu7t5v0__dffrnq_1
XFILLER_172_588 VDD VSS VDD VSS gf180mcu_fd_sc_mcu7t5v0__fillcap_4
XFILLER_132_419 VDD VSS VDD VSS gf180mcu_fd_sc_mcu7t5v0__fillcap_4
X_4362_ _4362_/D _4362_/Q wire183/Z VSS _4369_/CLK VDD VDD VSS gf180mcu_fd_sc_mcu7t5v0__dffrnq_1
XFILLER_153_780 VDD VSS VDD VSS gf180mcu_fd_sc_mcu7t5v0__fillcap_4
XFILLER_98_311 VDD VSS VDD VSS gf180mcu_fd_sc_mcu7t5v0__fillcap_4
XFILLER_259_626 VDD VSS VDD VSS gf180mcu_fd_sc_mcu7t5v0__fillcap_4
X_4293_ _4293_/D _4293_/Q _4525_/RN VSS _4305_/CLK VDD VDD VSS gf180mcu_fd_sc_mcu7t5v0__dffrnq_1
X_3313_ _3325_/B VDD VSS _4376_/D _4375_/Q _4376_/Q VDD VSS gf180mcu_fd_sc_mcu7t5v0__mux2_2
X_3244_ _3243_/Z VDD VSS _3244_/Z _3244_/A1 _3244_/A2 VDD VSS gf180mcu_fd_sc_mcu7t5v0__xor3_1
XFILLER_39_422 VDD VSS VDD VSS gf180mcu_fd_sc_mcu7t5v0__fillcap_64
XFILLER_140_496 VDD VSS VDD VSS gf180mcu_fd_sc_mcu7t5v0__fillcap_16
X_3175_ _3175_/B _3180_/B VDD VSS _3177_/B _3176_/S _3757_/A1 VDD VSS gf180mcu_fd_sc_mcu7t5v0__aoi211_1
XFILLER_66_241 VDD VSS VDD VSS gf180mcu_fd_sc_mcu7t5v0__fillcap_4
X_2126_ VDD VSS _2127_/A2 _4440_/Q _2510_/A2 VDD VSS gf180mcu_fd_sc_mcu7t5v0__nand2_1
XFILLER_82_745 VDD VSS VDD VSS gf180mcu_fd_sc_mcu7t5v0__fillcap_4
X_2057_ VDD VSS _4595_/D _4616_/D _2057_/A2 VDD VSS gf180mcu_fd_sc_mcu7t5v0__xnor2_1
XFILLER_22_311 VDD VSS VDD VSS gf180mcu_fd_sc_mcu7t5v0__fillcap_4
XFILLER_34_171 VDD VSS VDD VSS gf180mcu_fd_sc_mcu7t5v0__fillcap_4
X_2959_ _3207_/A3 _2959_/B1 _2959_/B2 VDD VSS _4315_/D _2883_/C _2829_/C VDD VSS gf180mcu_fd_sc_mcu7t5v0__oai32_1
XFILLER_210_489 VDD VSS VDD VSS gf180mcu_fd_sc_mcu7t5v0__fillcap_4
XFILLER_135_202 VDD VSS VDD VSS gf180mcu_fd_sc_mcu7t5v0__fillcap_8
XFILLER_191_886 VDD VSS VDD VSS gf180mcu_fd_sc_mcu7t5v0__fillcap_4
XFILLER_249_136 VDD VSS VDD VSS gf180mcu_fd_sc_mcu7t5v0__fillcap_4
XFILLER_58_731 VDD VSS VDD VSS gf180mcu_fd_sc_mcu7t5v0__fillcap_4
XFILLER_205_206 VDD VSS VDD VSS gf180mcu_fd_sc_mcu7t5v0__fillcap_4
XFILLER_167_2 VDD VSS VDD VSS gf180mcu_fd_sc_mcu7t5v0__fillcap_32
XFILLER_26_661 VDD VSS VDD VSS gf180mcu_fd_sc_mcu7t5v0__fillcap_4
XFILLER_14_801 VDD VSS VDD VSS gf180mcu_fd_sc_mcu7t5v0__fillcap_4
XFILLER_15_72 VDD VSS VDD VSS gf180mcu_fd_sc_mcu7t5v0__fillcap_64
XFILLER_181_352 VDD VSS VDD VSS gf180mcu_fd_sc_mcu7t5v0__fillcap_16
XFILLER_141_205 VDD VSS VDD VSS gf180mcu_fd_sc_mcu7t5v0__fillcap_4
XFILLER_96_815 VDD VSS VDD VSS gf180mcu_fd_sc_mcu7t5v0__fillcap_4
XFILLER_96_848 VDD VSS VDD VSS gf180mcu_fd_sc_mcu7t5v0__fillcap_8
XFILLER_268_478 VDD VSS VDD VSS gf180mcu_fd_sc_mcu7t5v0__fillcap_32
XFILLER_48_241 VDD VSS VDD VSS gf180mcu_fd_sc_mcu7t5v0__fillcap_4
X_3931_ VDD _3931_/Q _3936_/CLK VSS _3931_/D VDD VSS gf180mcu_fd_sc_mcu7t5v0__dffq_1
XFILLER_16_171 VDD VSS VDD VSS gf180mcu_fd_sc_mcu7t5v0__fillcap_4
X_3862_ _3862_/D _3862_/Q _4573_/RN VSS _4574_/CLK VDD VDD VSS gf180mcu_fd_sc_mcu7t5v0__dffrnq_1
XFILLER_258_37 VDD VSS VDD VSS gf180mcu_fd_sc_mcu7t5v0__fillcap_64
X_2813_ _2967_/B _2813_/C VDD VSS _2818_/A3 _2156_/B _2813_/A2 _3208_/A2 VDD VSS gf180mcu_fd_sc_mcu7t5v0__aoi221_1
XFILLER_82_2 VDD VSS VDD VSS gf180mcu_fd_sc_mcu7t5v0__fillcap_32
X_3793_ _3793_/B VDD VSS _3956_/D _3793_/A1 wire16/Z VDD VSS gf180mcu_fd_sc_mcu7t5v0__aoi21_1
XFILLER_158_861 VDD VSS VDD VSS gf180mcu_fd_sc_mcu7t5v0__fillcap_8
XFILLER_173_842 VDD VSS VDD VSS gf180mcu_fd_sc_mcu7t5v0__fillcap_4
X_2744_ wire36/Z VDD VSS _4278_/D _4278_/Q _4444_/Q VDD VSS gf180mcu_fd_sc_mcu7t5v0__mux2_2
XFILLER_8_381 VDD VSS VDD VSS gf180mcu_fd_sc_mcu7t5v0__fillcap_4
X_2675_ VDD _2675_/B _4503_/D _4235_/D _2675_/A1 VSS VDD VSS gf180mcu_fd_sc_mcu7t5v0__oai21_1
XFILLER_133_717 VDD VSS VDD VSS gf180mcu_fd_sc_mcu7t5v0__fillcap_4
X_4414_ _4414_/D _4414_/Q wire210/Z VSS _4499_/CLK VDD VDD VSS gf180mcu_fd_sc_mcu7t5v0__dffrnq_1
XFILLER_207_63 VDD VSS VDD VSS gf180mcu_fd_sc_mcu7t5v0__fillcap_4
X_4345_ _4345_/D _4345_/Q wire206/Z VSS _4345_/CLK VDD VDD VSS gf180mcu_fd_sc_mcu7t5v0__dffrnq_1
XFILLER_141_772 VDD VSS VDD VSS gf180mcu_fd_sc_mcu7t5v0__fillcap_4
X_4276_ _4276_/D _4276_/Q _4371_/RN VSS _4278_/CLK VDD VDD VSS gf180mcu_fd_sc_mcu7t5v0__dffrnq_1
X_3227_ VDD _3227_/B _3239_/A1 _4349_/D _2862_/B VSS VDD VSS gf180mcu_fd_sc_mcu7t5v0__oai21_1
XFILLER_101_669 VDD VSS VDD VSS gf180mcu_fd_sc_mcu7t5v0__fillcap_16
X_3158_ VDD _3158_/B _3903_/Q _3159_/B2 _4551_/Q VSS VDD VSS gf180mcu_fd_sc_mcu7t5v0__oai21_1
X_2109_ _4541_/Q VDD VSS _3849_/A1 _4540_/Q _2102_/Z VDD VSS gf180mcu_fd_sc_mcu7t5v0__aoi21_1
X_3089_ VDD _4333_/D _3089_/B wire13/Z _3089_/A2 VSS _3089_/A3 VDD VSS gf180mcu_fd_sc_mcu7t5v0__oai31_1
XFILLER_70_737 VDD VSS VDD VSS gf180mcu_fd_sc_mcu7t5v0__fillcap_64
XFILLER_195_422 VDD VSS VDD VSS gf180mcu_fd_sc_mcu7t5v0__fillcap_16
XFILLER_52_37 VDD VSS VDD VSS gf180mcu_fd_sc_mcu7t5v0__fillcap_64
XFILLER_168_37 VDD VSS VDD VSS gf180mcu_fd_sc_mcu7t5v0__fillcap_16
XFILLER_139_6 VDD VSS VDD VSS gf180mcu_fd_sc_mcu7t5v0__fillcap_16
XFILLER_109_736 VDD VSS VDD VSS gf180mcu_fd_sc_mcu7t5v0__fillcap_4
XFILLER_163_352 VDD VSS VDD VSS gf180mcu_fd_sc_mcu7t5v0__fillcap_64
XFILLER_163_341 VDD VSS VDD VSS gf180mcu_fd_sc_mcu7t5v0__fillcap_8
XFILLER_136_588 VDD VSS VDD VSS gf180mcu_fd_sc_mcu7t5v0__fillcap_4
XFILLER_191_672 VDD VSS VDD VSS gf180mcu_fd_sc_mcu7t5v0__fillcap_4
XFILLER_131_282 VDD VSS VDD VSS gf180mcu_fd_sc_mcu7t5v0__fillcap_8
XFILLER_92_317 VDD VSS VDD VSS gf180mcu_fd_sc_mcu7t5v0__fillcap_64
XFILLER_261_632 VDD VSS VDD VSS gf180mcu_fd_sc_mcu7t5v0__fillcap_64
XFILLER_234_868 VDD VSS VDD VSS gf180mcu_fd_sc_mcu7t5v0__fillcap_4
XFILLER_199_772 VDD VSS VDD VSS gf180mcu_fd_sc_mcu7t5v0__fillcap_64
XFILLER_60_247 VDD VSS VDD VSS gf180mcu_fd_sc_mcu7t5v0__fillcap_64
XFILLER_159_614 VDD VSS VDD VSS gf180mcu_fd_sc_mcu7t5v0__fillcap_4
XFILLER_201_220 VDD VSS VDD VSS gf180mcu_fd_sc_mcu7t5v0__fillcap_8
XFILLER_173_105 VDD VSS VDD VSS gf180mcu_fd_sc_mcu7t5v0__fillcap_32
XFILLER_155_842 VDD VSS VDD VSS gf180mcu_fd_sc_mcu7t5v0__fillcap_32
XFILLER_170_801 VDD VSS VDD VSS gf180mcu_fd_sc_mcu7t5v0__fillcap_4
XFILLER_6_885 VDD VSS VDD VSS gf180mcu_fd_sc_mcu7t5v0__fillcap_4
X_2460_ _2463_/S VDD VSS _4086_/D wire157/Z _4086_/Q VDD VSS gf180mcu_fd_sc_mcu7t5v0__mux2_2
XFILLER_115_739 VDD VSS VDD VSS gf180mcu_fd_sc_mcu7t5v0__fillcap_16
XFILLER_170_867 VDD VSS VDD VSS gf180mcu_fd_sc_mcu7t5v0__fillcap_8
XFILLER_114_238 VDD VSS VDD VSS gf180mcu_fd_sc_mcu7t5v0__fillcap_4
XFILLER_107_290 VDD VSS VDD VSS gf180mcu_fd_sc_mcu7t5v0__fillcap_4
X_4130_ _4130_/D _4130_/Q wire192/Z VSS _4265_/CLK VDD VDD VSS gf180mcu_fd_sc_mcu7t5v0__dffrnq_1
XFILLER_123_772 VDD VSS VDD VSS gf180mcu_fd_sc_mcu7t5v0__fillcap_8
X_2391_ _2393_/S VDD VSS _4031_/D wire155/Z _4031_/Q VDD VSS gf180mcu_fd_sc_mcu7t5v0__mux2_2
XFILLER_150_580 VDD VSS VDD VSS gf180mcu_fd_sc_mcu7t5v0__fillcap_8
X_4061_ VDD _4061_/Q _4061_/CLK VSS _4061_/D VDD VSS gf180mcu_fd_sc_mcu7t5v0__dffq_1
XFILLER_96_667 VDD VSS VDD VSS gf180mcu_fd_sc_mcu7t5v0__fillcap_32
X_3012_ _3012_/A3 VDD VSS _3012_/Z _3019_/A2 _3019_/A3 VDD VSS gf180mcu_fd_sc_mcu7t5v0__and3_1
Xwire15 wire15/Z VSS VDD wire15/I VDD VSS gf180mcu_fd_sc_mcu7t5v0__clkbuf_3
XFILLER_237_695 VDD VSS VDD VSS gf180mcu_fd_sc_mcu7t5v0__fillcap_4
Xwire59 VSS wire59/Z wire59/I VDD VDD VSS gf180mcu_fd_sc_mcu7t5v0__buf_1
Xwire48 VSS wire48/Z wire48/I VDD VDD VSS gf180mcu_fd_sc_mcu7t5v0__clkbuf_1
XFILLER_205_570 VDD VSS VDD VSS gf180mcu_fd_sc_mcu7t5v0__fillcap_4
XFILLER_251_142 VDD VSS VDD VSS gf180mcu_fd_sc_mcu7t5v0__fillcap_64
XFILLER_64_597 VDD VSS VDD VSS gf180mcu_fd_sc_mcu7t5v0__fillcap_64
XFILLER_52_737 VDD VSS VDD VSS gf180mcu_fd_sc_mcu7t5v0__fillcap_64
X_3914_ VDD _3914_/Q _3968_/CLK VSS _3914_/D VDD VSS gf180mcu_fd_sc_mcu7t5v0__dffq_1
XFILLER_149_135 VDD VSS VDD VSS gf180mcu_fd_sc_mcu7t5v0__fillcap_4
XFILLER_189_282 VDD VSS VDD VSS gf180mcu_fd_sc_mcu7t5v0__fillcap_16
X_3845_ _3848_/S VDD VSS _3998_/D _3845_/I0 _3998_/Q VDD VSS gf180mcu_fd_sc_mcu7t5v0__mux2_2
XFILLER_149_157 VDD VSS VDD VSS gf180mcu_fd_sc_mcu7t5v0__fillcap_8
XFILLER_192_403 VDD VSS VDD VSS gf180mcu_fd_sc_mcu7t5v0__fillcap_4
XFILLER_20_667 VDD VSS VDD VSS gf180mcu_fd_sc_mcu7t5v0__fillcap_64
X_3776_ _3777_/S VDD VSS _3944_/D wire172/Z _3944_/Q VDD VSS gf180mcu_fd_sc_mcu7t5v0__mux2_2
X_2727_ _2728_/S VDD VSS _4261_/D _4261_/Q _4277_/Q VDD VSS gf180mcu_fd_sc_mcu7t5v0__mux2_2
XFILLER_106_706 VDD VSS VDD VSS gf180mcu_fd_sc_mcu7t5v0__fillcap_4
XFILLER_161_812 VDD VSS VDD VSS gf180mcu_fd_sc_mcu7t5v0__fillcap_16
XFILLER_172_171 VDD VSS VDD VSS gf180mcu_fd_sc_mcu7t5v0__fillcap_4
XFILLER_145_374 VDD VSS VDD VSS gf180mcu_fd_sc_mcu7t5v0__fillcap_4
XFILLER_106_717 VDD VSS VDD VSS gf180mcu_fd_sc_mcu7t5v0__fillcap_16
X_2658_ _2658_/B1 _2658_/B2 VDD VSS _4227_/D _3128_/A2 _2666_/C VDD VSS gf180mcu_fd_sc_mcu7t5v0__aoi22_1
X_2589_ VDD VSS _2590_/B _4203_/Q _2587_/Z VDD VSS gf180mcu_fd_sc_mcu7t5v0__nor2_1
XFILLER_114_772 VDD VSS VDD VSS gf180mcu_fd_sc_mcu7t5v0__fillcap_4
XFILLER_101_422 VDD VSS VDD VSS gf180mcu_fd_sc_mcu7t5v0__fillcap_64
X_4328_ _4328_/D _4328_/Q wire206/Z VSS _4354_/CLK VDD VDD VSS gf180mcu_fd_sc_mcu7t5v0__dffrnq_1
XFILLER_113_282 VDD VSS VDD VSS gf180mcu_fd_sc_mcu7t5v0__fillcap_4
X_4259_ _4259_/D _4259_/Q _4371_/RN VSS _4278_/CLK VDD VDD VSS gf180mcu_fd_sc_mcu7t5v0__dffrnq_1
XFILLER_86_177 VDD VSS VDD VSS gf180mcu_fd_sc_mcu7t5v0__fillcap_64
XFILLER_74_317 VDD VSS VDD VSS gf180mcu_fd_sc_mcu7t5v0__fillcap_64
XFILLER_243_632 VDD VSS VDD VSS gf180mcu_fd_sc_mcu7t5v0__fillcap_64
XFILLER_255_492 VDD VSS VDD VSS gf180mcu_fd_sc_mcu7t5v0__fillcap_64
XFILLER_103_65 VDD VSS VDD VSS gf180mcu_fd_sc_mcu7t5v0__fillcap_4
XFILLER_231_816 VDD VSS VDD VSS gf180mcu_fd_sc_mcu7t5v0__fillcap_4
XFILLER_42_247 VDD VSS VDD VSS gf180mcu_fd_sc_mcu7t5v0__fillcap_64
XFILLER_211_562 VDD VSS VDD VSS gf180mcu_fd_sc_mcu7t5v0__fillcap_4
XFILLER_211_595 VDD VSS VDD VSS gf180mcu_fd_sc_mcu7t5v0__fillcap_8
Xmax_length101 VSS _3180_/B wire97/I VDD VDD VSS gf180mcu_fd_sc_mcu7t5v0__buf_2
XFILLER_10_177 VDD VSS VDD VSS gf180mcu_fd_sc_mcu7t5v0__fillcap_64
XFILLER_152_801 VDD VSS VDD VSS gf180mcu_fd_sc_mcu7t5v0__fillcap_4
Xmax_length156 VSS _2506_/I0 wire157/Z VDD VDD VSS gf180mcu_fd_sc_mcu7t5v0__buf_2
Xmax_length189 _4613_/RN _4580_/RN VDD VSS VDD VSS gf180mcu_fd_sc_mcu7t5v0__buf_8
XFILLER_128_51 VDD VSS VDD VSS gf180mcu_fd_sc_mcu7t5v0__fillcap_8
XFILLER_88_22 VDD VSS VDD VSS gf180mcu_fd_sc_mcu7t5v0__fillcap_8
XFILLER_124_558 VDD VSS VDD VSS gf180mcu_fd_sc_mcu7t5v0__fillcap_8
XFILLER_2_387 VDD VSS VDD VSS gf180mcu_fd_sc_mcu7t5v0__fillcap_64
XFILLER_132_591 VDD VSS VDD VSS gf180mcu_fd_sc_mcu7t5v0__fillcap_4
XFILLER_265_212 VDD VSS VDD VSS gf180mcu_fd_sc_mcu7t5v0__fillcap_64
XFILLER_66_807 VDD VSS VDD VSS gf180mcu_fd_sc_mcu7t5v0__fillcap_64
XFILLER_78_667 VDD VSS VDD VSS gf180mcu_fd_sc_mcu7t5v0__fillcap_64
XFILLER_93_648 VDD VSS VDD VSS gf180mcu_fd_sc_mcu7t5v0__fillcap_4
XFILLER_233_142 VDD VSS VDD VSS gf180mcu_fd_sc_mcu7t5v0__fillcap_64
XFILLER_160_93 VDD VSS VDD VSS gf180mcu_fd_sc_mcu7t5v0__fillcap_8
XFILLER_46_597 VDD VSS VDD VSS gf180mcu_fd_sc_mcu7t5v0__fillcap_64
XFILLER_34_737 VDD VSS VDD VSS gf180mcu_fd_sc_mcu7t5v0__fillcap_64
XFILLER_199_580 VDD VSS VDD VSS gf180mcu_fd_sc_mcu7t5v0__fillcap_32
XFILLER_61_556 VDD VSS VDD VSS gf180mcu_fd_sc_mcu7t5v0__fillcap_4
X_1960_ VDD VSS _4234_/Q _2673_/A1 VDD VSS gf180mcu_fd_sc_mcu7t5v0__clkinv_1
XFILLER_230_871 VDD VSS VDD VSS gf180mcu_fd_sc_mcu7t5v0__fillcap_4
XFILLER_186_263 VDD VSS VDD VSS gf180mcu_fd_sc_mcu7t5v0__fillcap_8
XFILLER_174_436 VDD VSS VDD VSS gf180mcu_fd_sc_mcu7t5v0__fillcap_4
X_3630_ _3644_/A2 _3630_/B2 VDD VSS _3631_/I _4479_/Q _3479_/C VDD VSS gf180mcu_fd_sc_mcu7t5v0__aoi22_1
X_3561_ VDD VSS _3562_/A3 _4591_/Q _4007_/Q VDD VSS gf180mcu_fd_sc_mcu7t5v0__nand2_1
X_2512_ VDD VSS _2731_/S _2292_/Z _3444_/A1 VDD VSS gf180mcu_fd_sc_mcu7t5v0__nor2_1
XFILLER_127_363 VDD VSS VDD VSS gf180mcu_fd_sc_mcu7t5v0__fillcap_16
XFILLER_142_333 VDD VSS VDD VSS gf180mcu_fd_sc_mcu7t5v0__fillcap_8
X_3492_ _3492_/B wire82/I VDD VSS _3493_/B _3564_/S _3492_/A2 VDD VSS gf180mcu_fd_sc_mcu7t5v0__oai211_1
X_2443_ VDD VSS _2444_/B wire168/Z _2454_/S VDD VSS gf180mcu_fd_sc_mcu7t5v0__nor2_1
XFILLER_45_2 VDD VSS VDD VSS gf180mcu_fd_sc_mcu7t5v0__fillcap_64
XFILLER_257_702 VDD VSS VDD VSS gf180mcu_fd_sc_mcu7t5v0__fillcap_64
XFILLER_111_731 VDD VSS VDD VSS gf180mcu_fd_sc_mcu7t5v0__fillcap_16
X_2374_ VDD VSS _2492_/A1 _4579_/Q _2374_/A2 VDD VSS gf180mcu_fd_sc_mcu7t5v0__nor2_1
X_4113_ VDD _4113_/Q _4129_/CLK VSS _4113_/D VDD VSS gf180mcu_fd_sc_mcu7t5v0__dffq_1
XFILLER_68_177 VDD VSS VDD VSS gf180mcu_fd_sc_mcu7t5v0__fillcap_64
XFILLER_96_497 VDD VSS VDD VSS gf180mcu_fd_sc_mcu7t5v0__fillcap_4
XFILLER_56_317 VDD VSS VDD VSS gf180mcu_fd_sc_mcu7t5v0__fillcap_64
XFILLER_209_150 VDD VSS VDD VSS gf180mcu_fd_sc_mcu7t5v0__fillcap_4
X_4044_ VDD _4044_/Q _4062_/CLK VSS _4044_/D VDD VSS gf180mcu_fd_sc_mcu7t5v0__dffq_1
XFILLER_83_136 VDD VSS VDD VSS gf180mcu_fd_sc_mcu7t5v0__fillcap_4
XFILLER_237_492 VDD VSS VDD VSS gf180mcu_fd_sc_mcu7t5v0__fillcap_8
XFILLER_225_632 VDD VSS VDD VSS gf180mcu_fd_sc_mcu7t5v0__fillcap_16
XFILLER_252_451 VDD VSS VDD VSS gf180mcu_fd_sc_mcu7t5v0__fillcap_4
XFILLER_24_247 VDD VSS VDD VSS gf180mcu_fd_sc_mcu7t5v0__fillcap_64
XFILLER_178_753 VDD VSS VDD VSS gf180mcu_fd_sc_mcu7t5v0__fillcap_4
X_3828_ _3830_/S VDD VSS _3983_/D _4294_/Q _3983_/Q VDD VSS gf180mcu_fd_sc_mcu7t5v0__mux2_2
XFILLER_193_734 VDD VSS VDD VSS gf180mcu_fd_sc_mcu7t5v0__fillcap_4
XFILLER_220_381 VDD VSS VDD VSS gf180mcu_fd_sc_mcu7t5v0__fillcap_4
XFILLER_146_650 VDD VSS VDD VSS gf180mcu_fd_sc_mcu7t5v0__fillcap_8
XFILLER_229_72 VDD VSS VDD VSS gf180mcu_fd_sc_mcu7t5v0__fillcap_64
XFILLER_192_233 VDD VSS VDD VSS gf180mcu_fd_sc_mcu7t5v0__fillcap_4
XFILLER_118_341 VDD VSS VDD VSS gf180mcu_fd_sc_mcu7t5v0__fillcap_4
XFILLER_134_801 VDD VSS VDD VSS gf180mcu_fd_sc_mcu7t5v0__fillcap_4
X_3759_ VDD VSS _3767_/S _3759_/A1 _3759_/A2 VDD VSS gf180mcu_fd_sc_mcu7t5v0__nand2_1
Xclkbuf_leaf_92_clk_i _4436_/CLK VSS VDD clkload0/I VDD VSS gf180mcu_fd_sc_mcu7t5v0__clkbuf_2
XFILLER_160_152 VDD VSS VDD VSS gf180mcu_fd_sc_mcu7t5v0__fillcap_8
XFILLER_114_591 VDD VSS VDD VSS gf180mcu_fd_sc_mcu7t5v0__fillcap_4
XFILLER_247_212 VDD VSS VDD VSS gf180mcu_fd_sc_mcu7t5v0__fillcap_64
XFILLER_48_807 VDD VSS VDD VSS gf180mcu_fd_sc_mcu7t5v0__fillcap_64
XFILLER_75_626 VDD VSS VDD VSS gf180mcu_fd_sc_mcu7t5v0__fillcap_4
XFILLER_87_486 VDD VSS VDD VSS gf180mcu_fd_sc_mcu7t5v0__fillcap_4
Xclkbuf_leaf_30_clk_i _4330_/CLK VSS VDD clkload4/I VDD VSS gf180mcu_fd_sc_mcu7t5v0__clkbuf_2
XFILLER_28_597 VDD VSS VDD VSS gf180mcu_fd_sc_mcu7t5v0__fillcap_64
XFILLER_16_737 VDD VSS VDD VSS gf180mcu_fd_sc_mcu7t5v0__fillcap_64
XFILLER_230_101 VDD VSS VDD VSS gf180mcu_fd_sc_mcu7t5v0__fillcap_4
XFILLER_43_556 VDD VSS VDD VSS gf180mcu_fd_sc_mcu7t5v0__fillcap_4
XFILLER_247_2 VDD VSS VDD VSS gf180mcu_fd_sc_mcu7t5v0__fillcap_64
Xclkbuf_leaf_45_clk_i _4305_/CLK VSS VDD clkload5/I VDD VSS gf180mcu_fd_sc_mcu7t5v0__clkbuf_2
XFILLER_23_72 VDD VSS VDD VSS gf180mcu_fd_sc_mcu7t5v0__fillcap_64
XFILLER_184_778 VDD VSS VDD VSS gf180mcu_fd_sc_mcu7t5v0__fillcap_16
XFILLER_139_72 VDD VSS VDD VSS gf180mcu_fd_sc_mcu7t5v0__fillcap_64
XFILLER_109_330 VDD VSS VDD VSS gf180mcu_fd_sc_mcu7t5v0__fillcap_8
XFILLER_11_486 VDD VSS VDD VSS gf180mcu_fd_sc_mcu7t5v0__fillcap_4
XFILLER_99_10 VDD VSS VDD VSS gf180mcu_fd_sc_mcu7t5v0__fillcap_4
XFILLER_109_352 VDD VSS VDD VSS gf180mcu_fd_sc_mcu7t5v0__fillcap_16
XFILLER_152_653 VDD VSS VDD VSS gf180mcu_fd_sc_mcu7t5v0__fillcap_4
XFILLER_140_826 VDD VSS VDD VSS gf180mcu_fd_sc_mcu7t5v0__fillcap_4
XFILLER_239_702 VDD VSS VDD VSS gf180mcu_fd_sc_mcu7t5v0__fillcap_64
XFILLER_3_696 VDD VSS VDD VSS gf180mcu_fd_sc_mcu7t5v0__fillcap_4
XFILLER_266_521 VDD VSS VDD VSS gf180mcu_fd_sc_mcu7t5v0__fillcap_4
XFILLER_38_317 VDD VSS VDD VSS gf180mcu_fd_sc_mcu7t5v0__fillcap_64
X_2090_ _2102_/A4 VDD VSS _2090_/Z _4538_/Q _2087_/Z VDD VSS gf180mcu_fd_sc_mcu7t5v0__and3_1
XFILLER_65_136 VDD VSS VDD VSS gf180mcu_fd_sc_mcu7t5v0__fillcap_4
XFILLER_219_492 VDD VSS VDD VSS gf180mcu_fd_sc_mcu7t5v0__fillcap_8
XFILLER_207_632 VDD VSS VDD VSS gf180mcu_fd_sc_mcu7t5v0__fillcap_8
XFILLER_234_451 VDD VSS VDD VSS gf180mcu_fd_sc_mcu7t5v0__fillcap_4
XFILLER_222_613 VDD VSS VDD VSS gf180mcu_fd_sc_mcu7t5v0__fillcap_8
XFILLER_179_506 VDD VSS VDD VSS gf180mcu_fd_sc_mcu7t5v0__fillcap_16
X_2992_ _2992_/B _2992_/C VDD VSS _2997_/A2 _2886_/C _3064_/A2 VDD VSS gf180mcu_fd_sc_mcu7t5v0__oai211_1
XFILLER_21_206 VDD VSS VDD VSS gf180mcu_fd_sc_mcu7t5v0__fillcap_4
X_1943_ VDD VSS _4334_/Q _2944_/A1 VDD VSS gf180mcu_fd_sc_mcu7t5v0__clkinv_1
XFILLER_187_594 VDD VSS VDD VSS gf180mcu_fd_sc_mcu7t5v0__fillcap_4
XFILLER_266_37 VDD VSS VDD VSS gf180mcu_fd_sc_mcu7t5v0__fillcap_64
X_3613_ VDD VSS _3614_/A2 _2522_/B _3613_/A2 VDD VSS gf180mcu_fd_sc_mcu7t5v0__nor2_1
XFILLER_190_737 VDD VSS VDD VSS gf180mcu_fd_sc_mcu7t5v0__fillcap_32
XFILLER_116_801 VDD VSS VDD VSS gf180mcu_fd_sc_mcu7t5v0__fillcap_4
X_4593_ _4593_/D _4593_/Q _4613_/RN VSS _4606_/CLK VDD VDD VSS gf180mcu_fd_sc_mcu7t5v0__dffrnq_1
X_3544_ _3544_/A3 VDD VSS _3545_/A3 wire78/Z _3544_/A2 VDD VSS gf180mcu_fd_sc_mcu7t5v0__nand3_1
X_3475_ VSS VDD _3633_/C1 _4328_/Q _4196_/Q _3685_/B1 _3685_/A2 _4164_/Q _3478_/A1
+ VDD VSS gf180mcu_fd_sc_mcu7t5v0__aoi222_1
X_2426_ _2431_/S VDD VSS _4060_/D wire161/Z _4060_/Q VDD VSS gf180mcu_fd_sc_mcu7t5v0__mux2_2
XFILLER_229_212 VDD VSS VDD VSS gf180mcu_fd_sc_mcu7t5v0__fillcap_64
XFILLER_142_196 VDD VSS VDD VSS gf180mcu_fd_sc_mcu7t5v0__fillcap_4
XFILLER_57_626 VDD VSS VDD VSS gf180mcu_fd_sc_mcu7t5v0__fillcap_4
XFILLER_69_486 VDD VSS VDD VSS gf180mcu_fd_sc_mcu7t5v0__fillcap_4
X_2357_ _2357_/S VDD VSS _4007_/D _4007_/Q wire155/Z VDD VSS gf180mcu_fd_sc_mcu7t5v0__mux2_2
X_2288_ _3347_/B VDD VSS _2290_/B1 _4383_/Q _3338_/A2 VDD VSS gf180mcu_fd_sc_mcu7t5v0__nand3_1
XFILLER_84_489 VDD VSS VDD VSS gf180mcu_fd_sc_mcu7t5v0__fillcap_4
X_4027_ VDD _4027_/Q _4032_/CLK VSS _4027_/D VDD VSS gf180mcu_fd_sc_mcu7t5v0__dffq_1
XFILLER_198_837 VDD VSS VDD VSS gf180mcu_fd_sc_mcu7t5v0__fillcap_8
XFILLER_212_101 VDD VSS VDD VSS gf180mcu_fd_sc_mcu7t5v0__fillcap_4
XFILLER_25_556 VDD VSS VDD VSS gf180mcu_fd_sc_mcu7t5v0__fillcap_4
XFILLER_212_123 VDD VSS VDD VSS gf180mcu_fd_sc_mcu7t5v0__fillcap_8
XFILLER_166_723 VDD VSS VDD VSS gf180mcu_fd_sc_mcu7t5v0__fillcap_8
XFILLER_60_37 VDD VSS VDD VSS gf180mcu_fd_sc_mcu7t5v0__fillcap_64
XFILLER_176_37 VDD VSS VDD VSS gf180mcu_fd_sc_mcu7t5v0__fillcap_64
XFILLER_193_586 VDD VSS VDD VSS gf180mcu_fd_sc_mcu7t5v0__fillcap_4
XFILLER_180_247 VDD VSS VDD VSS gf180mcu_fd_sc_mcu7t5v0__fillcap_8
XFILLER_119_694 VDD VSS VDD VSS gf180mcu_fd_sc_mcu7t5v0__fillcap_4
XFILLER_134_675 VDD VSS VDD VSS gf180mcu_fd_sc_mcu7t5v0__fillcap_4
XFILLER_161_461 VDD VSS VDD VSS gf180mcu_fd_sc_mcu7t5v0__fillcap_4
XFILLER_79_206 VDD VSS VDD VSS gf180mcu_fd_sc_mcu7t5v0__fillcap_4
XFILLER_248_521 VDD VSS VDD VSS gf180mcu_fd_sc_mcu7t5v0__fillcap_4
XFILLER_125_96 VDD VSS VDD VSS gf180mcu_fd_sc_mcu7t5v0__fillcap_4
XFILLER_47_136 VDD VSS VDD VSS gf180mcu_fd_sc_mcu7t5v0__fillcap_4
XFILLER_216_451 VDD VSS VDD VSS gf180mcu_fd_sc_mcu7t5v0__fillcap_4
XFILLER_216_473 VDD VSS VDD VSS gf180mcu_fd_sc_mcu7t5v0__fillcap_8
XFILLER_204_613 VDD VSS VDD VSS gf180mcu_fd_sc_mcu7t5v0__fillcap_8
XFILLER_188_325 VDD VSS VDD VSS gf180mcu_fd_sc_mcu7t5v0__fillcap_32
Xspi_opentarget_i3c_top_220 irq_o_PDRV0 VDD VSS VDD VSS gf180mcu_fd_sc_mcu7t5v0__tiel
Xspi_opentarget_i3c_top_231 sda_pad_PDRV1 VDD VSS VDD VSS gf180mcu_fd_sc_mcu7t5v0__tiel
Xspi_opentarget_i3c_top_242 spi_miso_o_SL VDD VSS VDD VSS gf180mcu_fd_sc_mcu7t5v0__tiel
XFILLER_200_885 VDD VSS VDD VSS gf180mcu_fd_sc_mcu7t5v0__fillcap_4
Xwire141 wire141/Z VSS VDD _4341_/Q VDD VSS gf180mcu_fd_sc_mcu7t5v0__clkbuf_2
Xwire163 VSS wire163/Z _4308_/Q VDD VDD VSS gf180mcu_fd_sc_mcu7t5v0__buf_2
Xwire174 VSS wire174/Z _4293_/Q VDD VDD VSS gf180mcu_fd_sc_mcu7t5v0__buf_2
Xwire152 VSS wire152/Z wire153/Z VDD VDD VSS gf180mcu_fd_sc_mcu7t5v0__buf_2
XFILLER_7_276 VDD VSS VDD VSS gf180mcu_fd_sc_mcu7t5v0__fillcap_4
Xwire196 wire196/Z VSS VDD wire196/I VDD VSS gf180mcu_fd_sc_mcu7t5v0__clkbuf_8
XFILLER_140_612 VDD VSS VDD VSS gf180mcu_fd_sc_mcu7t5v0__fillcap_32
XFILLER_140_667 VDD VSS VDD VSS gf180mcu_fd_sc_mcu7t5v0__fillcap_16
X_3260_ _3268_/B1 _4365_/Q VDD VSS _3261_/I _4358_/Q _4526_/D VDD VSS gf180mcu_fd_sc_mcu7t5v0__aoi22_1
X_3191_ VSS VDD _3169_/B wire63/Z _3191_/B2 _2854_/B _4230_/Q _4341_/Q _3193_/A2 VDD
+ VSS gf180mcu_fd_sc_mcu7t5v0__aoi222_1
X_2211_ VDD _2211_/B _2211_/A2 _2669_/A1 _2644_/A1 VSS VDD VSS gf180mcu_fd_sc_mcu7t5v0__oai21_1
XFILLER_39_626 VDD VSS VDD VSS gf180mcu_fd_sc_mcu7t5v0__fillcap_4
XFILLER_267_874 VDD VSS VDD VSS gf180mcu_fd_sc_mcu7t5v0__fillcap_16
XFILLER_93_220 VDD VSS VDD VSS gf180mcu_fd_sc_mcu7t5v0__fillcap_4
X_2142_ VDD VSS _2146_/A1 _4138_/Q _2142_/A2 VDD VSS gf180mcu_fd_sc_mcu7t5v0__nand2_1
X_2073_ VDD VSS _4552_/D _2075_/A2 _2112_/A2 VDD VSS gf180mcu_fd_sc_mcu7t5v0__nor2_1
XFILLER_210_627 VDD VSS VDD VSS gf180mcu_fd_sc_mcu7t5v0__fillcap_8
XFILLER_167_509 VDD VSS VDD VSS gf180mcu_fd_sc_mcu7t5v0__fillcap_32
XFILLER_188_870 VDD VSS VDD VSS gf180mcu_fd_sc_mcu7t5v0__fillcap_4
XFILLER_194_317 VDD VSS VDD VSS gf180mcu_fd_sc_mcu7t5v0__fillcap_4
X_2975_ _2975_/A3 _3213_/B VDD VSS _3211_/B _2975_/A1 _4521_/Q VDD VSS gf180mcu_fd_sc_mcu7t5v0__nand4_1
X_1926_ VDD VSS _1926_/I _3271_/A1 VDD VSS gf180mcu_fd_sc_mcu7t5v0__clkinv_1
XFILLER_148_745 VDD VSS VDD VSS gf180mcu_fd_sc_mcu7t5v0__fillcap_4
XFILLER_163_726 VDD VSS VDD VSS gf180mcu_fd_sc_mcu7t5v0__fillcap_4
X_4576_ _4576_/D _4576_/Q wire187/Z VSS _4595_/CLK VDD VDD VSS gf180mcu_fd_sc_mcu7t5v0__dffrnq_1
X_3527_ VSS VDD _3685_/C2 _4367_/Q _4199_/Q _3685_/B1 _3616_/A2 _4167_/Q _3528_/A3
+ VDD VSS gf180mcu_fd_sc_mcu7t5v0__aoi222_1
XFILLER_116_642 VDD VSS VDD VSS gf180mcu_fd_sc_mcu7t5v0__fillcap_8
XFILLER_115_185 VDD VSS VDD VSS gf180mcu_fd_sc_mcu7t5v0__fillcap_16
X_3458_ _4123_/Q VSS VDD _4107_/Q _4115_/Q wire88/I _4099_/Q wire83/I _3458_/Z VDD
+ VSS gf180mcu_fd_sc_mcu7t5v0__mux4_1
X_3389_ wire56/I VDD VSS _4434_/D _4394_/Q _4434_/Q VDD VSS gf180mcu_fd_sc_mcu7t5v0__mux2_2
X_2409_ _2413_/S VDD VSS _4045_/D wire158/Z _4045_/Q VDD VSS gf180mcu_fd_sc_mcu7t5v0__mux2_2
XFILLER_258_885 VDD VSS VDD VSS gf180mcu_fd_sc_mcu7t5v0__fillcap_4
XFILLER_29_136 VDD VSS VDD VSS gf180mcu_fd_sc_mcu7t5v0__fillcap_4
XFILLER_85_765 VDD VSS VDD VSS gf180mcu_fd_sc_mcu7t5v0__fillcap_4
XFILLER_85_798 VDD VSS VDD VSS gf180mcu_fd_sc_mcu7t5v0__fillcap_32
XFILLER_260_527 VDD VSS VDD VSS gf180mcu_fd_sc_mcu7t5v0__fillcap_64
XFILLER_186_807 VDD VSS VDD VSS gf180mcu_fd_sc_mcu7t5v0__fillcap_16
XFILLER_71_47 VDD VSS VDD VSS gf180mcu_fd_sc_mcu7t5v0__fillcap_16
XFILLER_139_734 VDD VSS VDD VSS gf180mcu_fd_sc_mcu7t5v0__fillcap_8
XFILLER_197_177 VDD VSS VDD VSS gf180mcu_fd_sc_mcu7t5v0__fillcap_4
XFILLER_138_255 VDD VSS VDD VSS gf180mcu_fd_sc_mcu7t5v0__fillcap_4
XFILLER_112_2 VDD VSS VDD VSS gf180mcu_fd_sc_mcu7t5v0__fillcap_16
XFILLER_110_807 VDD VSS VDD VSS gf180mcu_fd_sc_mcu7t5v0__fillcap_16
XFILLER_122_667 VDD VSS VDD VSS gf180mcu_fd_sc_mcu7t5v0__fillcap_32
XFILLER_249_874 VDD VSS VDD VSS gf180mcu_fd_sc_mcu7t5v0__fillcap_16
XFILLER_91_702 VDD VSS VDD VSS gf180mcu_fd_sc_mcu7t5v0__fillcap_8
XFILLER_264_877 VDD VSS VDD VSS gf180mcu_fd_sc_mcu7t5v0__fillcap_8
XFILLER_91_746 VDD VSS VDD VSS gf180mcu_fd_sc_mcu7t5v0__fillcap_8
XFILLER_189_623 VDD VSS VDD VSS gf180mcu_fd_sc_mcu7t5v0__fillcap_4
XFILLER_216_281 VDD VSS VDD VSS gf180mcu_fd_sc_mcu7t5v0__fillcap_32
XFILLER_204_487 VDD VSS VDD VSS gf180mcu_fd_sc_mcu7t5v0__fillcap_32
XFILLER_71_492 VDD VSS VDD VSS gf180mcu_fd_sc_mcu7t5v0__fillcap_64
XFILLER_188_177 VDD VSS VDD VSS gf180mcu_fd_sc_mcu7t5v0__fillcap_16
XFILLER_176_317 VDD VSS VDD VSS gf180mcu_fd_sc_mcu7t5v0__fillcap_4
X_2760_ _2763_/S VDD VSS _4293_/D wire125/Z _4293_/Q VDD VSS gf180mcu_fd_sc_mcu7t5v0__mux2_2
X_2691_ _2695_/A2 VDD VSS _2693_/A3 _2691_/A1 _2689_/Z VDD VSS gf180mcu_fd_sc_mcu7t5v0__nand3_1
XFILLER_177_80 VDD VSS VDD VSS gf180mcu_fd_sc_mcu7t5v0__fillcap_4
X_4430_ _4430_/D _4430_/Q wire193/I VSS _4430_/CLK VDD VDD VSS gf180mcu_fd_sc_mcu7t5v0__dffrnq_1
XFILLER_172_556 VDD VSS VDD VSS gf180mcu_fd_sc_mcu7t5v0__fillcap_32
XFILLER_144_247 VDD VSS VDD VSS gf180mcu_fd_sc_mcu7t5v0__fillcap_4
X_4361_ _4361_/D _4361_/Q wire183/Z VSS _4371_/CLK VDD VDD VSS gf180mcu_fd_sc_mcu7t5v0__dffrnq_1
XFILLER_125_472 VDD VSS VDD VSS gf180mcu_fd_sc_mcu7t5v0__fillcap_16
X_4292_ _4292_/D _4292_/Q _4525_/RN VSS _4338_/CLK VDD VDD VSS gf180mcu_fd_sc_mcu7t5v0__dffrnq_1
X_3312_ _3325_/B VDD VSS _4375_/D _4374_/Q _4375_/Q VDD VSS gf180mcu_fd_sc_mcu7t5v0__mux2_2
X_3243_ VDD VSS _3243_/Z _1926_/I _4332_/Q VDD VSS gf180mcu_fd_sc_mcu7t5v0__xor2_1
XFILLER_100_317 VDD VSS VDD VSS gf180mcu_fd_sc_mcu7t5v0__fillcap_16
XFILLER_112_177 VDD VSS VDD VSS gf180mcu_fd_sc_mcu7t5v0__fillcap_16
X_3174_ VDD VSS _3175_/B _3176_/S _3936_/Q VDD VSS gf180mcu_fd_sc_mcu7t5v0__nor2_1
X_2125_ VDD VSS _2125_/I _4132_/D VDD VSS gf180mcu_fd_sc_mcu7t5v0__clkinv_1
XFILLER_81_212 VDD VSS VDD VSS gf180mcu_fd_sc_mcu7t5v0__fillcap_64
XFILLER_254_387 VDD VSS VDD VSS gf180mcu_fd_sc_mcu7t5v0__fillcap_64
XFILLER_208_771 VDD VSS VDD VSS gf180mcu_fd_sc_mcu7t5v0__fillcap_4
XFILLER_242_527 VDD VSS VDD VSS gf180mcu_fd_sc_mcu7t5v0__fillcap_64
X_2056_ VDD VSS _4594_/D wire78/I _2051_/Z VDD VSS gf180mcu_fd_sc_mcu7t5v0__xor2_1
XFILLER_214_207 VDD VSS VDD VSS gf180mcu_fd_sc_mcu7t5v0__fillcap_4
XFILLER_168_807 VDD VSS VDD VSS gf180mcu_fd_sc_mcu7t5v0__fillcap_16
XFILLER_210_457 VDD VSS VDD VSS gf180mcu_fd_sc_mcu7t5v0__fillcap_32
X_2958_ _2958_/B _2958_/C VDD VSS _3207_/A3 _3214_/A1 _3209_/B VDD VSS gf180mcu_fd_sc_mcu7t5v0__oai211_1
XFILLER_136_704 VDD VSS VDD VSS gf180mcu_fd_sc_mcu7t5v0__fillcap_4
X_1909_ VDD VSS _3853_/Q _3390_/A1 VDD VSS gf180mcu_fd_sc_mcu7t5v0__clkinv_1
XFILLER_108_417 VDD VSS VDD VSS gf180mcu_fd_sc_mcu7t5v0__fillcap_4
XFILLER_148_597 VDD VSS VDD VSS gf180mcu_fd_sc_mcu7t5v0__fillcap_16
XFILLER_136_737 VDD VSS VDD VSS gf180mcu_fd_sc_mcu7t5v0__fillcap_8
XFILLER_175_383 VDD VSS VDD VSS gf180mcu_fd_sc_mcu7t5v0__fillcap_8
X_2889_ VDD VSS _2891_/B _3040_/B _3024_/B VDD VSS gf180mcu_fd_sc_mcu7t5v0__nor2_1
XFILLER_237_72 VDD VSS VDD VSS gf180mcu_fd_sc_mcu7t5v0__fillcap_64
XFILLER_116_450 VDD VSS VDD VSS gf180mcu_fd_sc_mcu7t5v0__fillcap_4
X_4559_ _4559_/D _4559_/Q _4616_/RN VSS _4565_/CLK VDD VDD VSS gf180mcu_fd_sc_mcu7t5v0__dffrnq_1
XFILLER_264_107 VDD VSS VDD VSS gf180mcu_fd_sc_mcu7t5v0__fillcap_64
XFILLER_131_486 VDD VSS VDD VSS gf180mcu_fd_sc_mcu7t5v0__fillcap_4
XFILLER_85_562 VDD VSS VDD VSS gf180mcu_fd_sc_mcu7t5v0__fillcap_8
XFILLER_73_702 VDD VSS VDD VSS gf180mcu_fd_sc_mcu7t5v0__fillcap_64
XFILLER_246_877 VDD VSS VDD VSS gf180mcu_fd_sc_mcu7t5v0__fillcap_8
XFILLER_261_836 VDD VSS VDD VSS gf180mcu_fd_sc_mcu7t5v0__fillcap_4
XFILLER_233_549 VDD VSS VDD VSS gf180mcu_fd_sc_mcu7t5v0__fillcap_8
XFILLER_53_492 VDD VSS VDD VSS gf180mcu_fd_sc_mcu7t5v0__fillcap_64
XFILLER_41_632 VDD VSS VDD VSS gf180mcu_fd_sc_mcu7t5v0__fillcap_64
XFILLER_158_317 VDD VSS VDD VSS gf180mcu_fd_sc_mcu7t5v0__fillcap_4
XFILLER_185_158 VDD VSS VDD VSS gf180mcu_fd_sc_mcu7t5v0__fillcap_8
XFILLER_31_72 VDD VSS VDD VSS gf180mcu_fd_sc_mcu7t5v0__fillcap_64
XFILLER_147_72 VDD VSS VDD VSS gf180mcu_fd_sc_mcu7t5v0__fillcap_64
XFILLER_181_386 VDD VSS VDD VSS gf180mcu_fd_sc_mcu7t5v0__fillcap_16
XFILLER_1_772 VDD VSS VDD VSS gf180mcu_fd_sc_mcu7t5v0__fillcap_64
XFILLER_63_212 VDD VSS VDD VSS gf180mcu_fd_sc_mcu7t5v0__fillcap_64
XFILLER_236_387 VDD VSS VDD VSS gf180mcu_fd_sc_mcu7t5v0__fillcap_64
X_3930_ VDD _3930_/Q _3968_/CLK VSS _3930_/D VDD VSS gf180mcu_fd_sc_mcu7t5v0__dffq_1
XFILLER_251_346 VDD VSS VDD VSS gf180mcu_fd_sc_mcu7t5v0__fillcap_4
XFILLER_205_763 VDD VSS VDD VSS gf180mcu_fd_sc_mcu7t5v0__fillcap_4
X_3861_ _4297_/Q _3861_/Q _4573_/RN VSS _4574_/CLK VDD VDD VSS gf180mcu_fd_sc_mcu7t5v0__dffrnq_1
XFILLER_205_796 VDD VSS VDD VSS gf180mcu_fd_sc_mcu7t5v0__fillcap_4
XFILLER_177_615 VDD VSS VDD VSS gf180mcu_fd_sc_mcu7t5v0__fillcap_8
XFILLER_31_142 VDD VSS VDD VSS gf180mcu_fd_sc_mcu7t5v0__fillcap_64
X_3792_ VDD VSS _3793_/B _4291_/Q wire16/Z VDD VSS gf180mcu_fd_sc_mcu7t5v0__nor2_1
X_2812_ VDD VSS _2813_/C _2967_/B _2951_/B VDD VSS gf180mcu_fd_sc_mcu7t5v0__and2_1
X_2743_ _2748_/S VDD VSS _4277_/D _4277_/Q _3400_/I1 VDD VSS gf180mcu_fd_sc_mcu7t5v0__mux2_2
XFILLER_75_2 VDD VSS VDD VSS gf180mcu_fd_sc_mcu7t5v0__fillcap_64
X_2674_ VDD VSS _2675_/B _4308_/Q _4503_/D VDD VSS gf180mcu_fd_sc_mcu7t5v0__nand2_1
XFILLER_117_269 VDD VSS VDD VSS gf180mcu_fd_sc_mcu7t5v0__fillcap_8
X_4413_ _4413_/D _4413_/Q wire210/Z VSS clkload8/I VDD VDD VSS gf180mcu_fd_sc_mcu7t5v0__dffrnq_1
XFILLER_207_42 VDD VSS VDD VSS gf180mcu_fd_sc_mcu7t5v0__fillcap_4
X_4344_ _4344_/D _4344_/Q _4371_/RN VSS _4345_/CLK VDD VDD VSS gf180mcu_fd_sc_mcu7t5v0__dffrnq_1
XFILLER_172_397 VDD VSS VDD VSS gf180mcu_fd_sc_mcu7t5v0__fillcap_16
XFILLER_141_784 VDD VSS VDD VSS gf180mcu_fd_sc_mcu7t5v0__fillcap_8
XFILLER_99_665 VDD VSS VDD VSS gf180mcu_fd_sc_mcu7t5v0__fillcap_8
XFILLER_228_800 VDD VSS VDD VSS gf180mcu_fd_sc_mcu7t5v0__fillcap_4
XFILLER_246_107 VDD VSS VDD VSS gf180mcu_fd_sc_mcu7t5v0__fillcap_64
X_4275_ _4275_/D _4275_/Q _4371_/RN VSS _4278_/CLK VDD VDD VSS gf180mcu_fd_sc_mcu7t5v0__dffrnq_1
XFILLER_140_272 VDD VSS VDD VSS gf180mcu_fd_sc_mcu7t5v0__fillcap_4
XFILLER_101_626 VDD VSS VDD VSS gf180mcu_fd_sc_mcu7t5v0__fillcap_4
XFILLER_101_637 VDD VSS VDD VSS gf180mcu_fd_sc_mcu7t5v0__fillcap_32
X_3226_ _3239_/A1 VDD VSS _3227_/B _3226_/A1 _2862_/B VDD VSS gf180mcu_fd_sc_mcu7t5v0__nand3_1
XFILLER_55_702 VDD VSS VDD VSS gf180mcu_fd_sc_mcu7t5v0__fillcap_64
XFILLER_67_562 VDD VSS VDD VSS gf180mcu_fd_sc_mcu7t5v0__fillcap_64
XFILLER_228_877 VDD VSS VDD VSS gf180mcu_fd_sc_mcu7t5v0__fillcap_8
X_3157_ VDD VSS _3159_/B1 _3157_/A1 _3895_/Q VDD VSS gf180mcu_fd_sc_mcu7t5v0__nor2_1
XFILLER_82_521 VDD VSS VDD VSS gf180mcu_fd_sc_mcu7t5v0__fillcap_4
XFILLER_243_836 VDD VSS VDD VSS gf180mcu_fd_sc_mcu7t5v0__fillcap_4
XFILLER_255_696 VDD VSS VDD VSS gf180mcu_fd_sc_mcu7t5v0__fillcap_4
X_2108_ VDD VSS _4545_/D _3768_/A2 _2108_/A2 VDD VSS gf180mcu_fd_sc_mcu7t5v0__xor2_1
X_3088_ VDD VSS _3089_/A3 _4332_/Q _3170_/B VDD VSS gf180mcu_fd_sc_mcu7t5v0__nor2_1
X_2039_ VDD VSS _2039_/Z _3383_/A1 _2035_/Z VDD VSS gf180mcu_fd_sc_mcu7t5v0__and2_1
XFILLER_35_492 VDD VSS VDD VSS gf180mcu_fd_sc_mcu7t5v0__fillcap_64
XFILLER_23_632 VDD VSS VDD VSS gf180mcu_fd_sc_mcu7t5v0__fillcap_64
XFILLER_211_733 VDD VSS VDD VSS gf180mcu_fd_sc_mcu7t5v0__fillcap_8
XFILLER_168_637 VDD VSS VDD VSS gf180mcu_fd_sc_mcu7t5v0__fillcap_16
XFILLER_50_451 VDD VSS VDD VSS gf180mcu_fd_sc_mcu7t5v0__fillcap_4
XFILLER_108_247 VDD VSS VDD VSS gf180mcu_fd_sc_mcu7t5v0__fillcap_4
XFILLER_184_37 VDD VSS VDD VSS gf180mcu_fd_sc_mcu7t5v0__fillcap_32
XFILLER_151_548 VDD VSS VDD VSS gf180mcu_fd_sc_mcu7t5v0__fillcap_8
XFILLER_89_142 VDD VSS VDD VSS gf180mcu_fd_sc_mcu7t5v0__fillcap_64
XFILLER_265_416 VDD VSS VDD VSS gf180mcu_fd_sc_mcu7t5v0__fillcap_4
XFILLER_218_387 VDD VSS VDD VSS gf180mcu_fd_sc_mcu7t5v0__fillcap_64
XFILLER_45_212 VDD VSS VDD VSS gf180mcu_fd_sc_mcu7t5v0__fillcap_64
XFILLER_233_346 VDD VSS VDD VSS gf180mcu_fd_sc_mcu7t5v0__fillcap_4
XFILLER_159_626 VDD VSS VDD VSS gf180mcu_fd_sc_mcu7t5v0__fillcap_4
XFILLER_13_142 VDD VSS VDD VSS gf180mcu_fd_sc_mcu7t5v0__fillcap_64
XFILLER_10_871 VDD VSS VDD VSS gf180mcu_fd_sc_mcu7t5v0__fillcap_4
XFILLER_127_578 VDD VSS VDD VSS gf180mcu_fd_sc_mcu7t5v0__fillcap_8
XFILLER_5_352 VDD VSS VDD VSS gf180mcu_fd_sc_mcu7t5v0__fillcap_64
XFILLER_181_194 VDD VSS VDD VSS gf180mcu_fd_sc_mcu7t5v0__fillcap_16
XFILLER_96_613 VDD VSS VDD VSS gf180mcu_fd_sc_mcu7t5v0__fillcap_4
X_2390_ _2393_/S VDD VSS _4030_/D wire157/Z _4030_/Q VDD VSS gf180mcu_fd_sc_mcu7t5v0__mux2_2
XFILLER_228_107 VDD VSS VDD VSS gf180mcu_fd_sc_mcu7t5v0__fillcap_64
X_4060_ VDD _4060_/Q _4062_/CLK VSS _4060_/D VDD VSS gf180mcu_fd_sc_mcu7t5v0__dffq_1
X_3011_ VDD VSS _3012_/A3 _3209_/B _3017_/B1 VDD VSS gf180mcu_fd_sc_mcu7t5v0__nand2_1
XFILLER_49_562 VDD VSS VDD VSS gf180mcu_fd_sc_mcu7t5v0__fillcap_64
XFILLER_37_702 VDD VSS VDD VSS gf180mcu_fd_sc_mcu7t5v0__fillcap_64
Xwire16 wire16/Z VSS VDD wire16/I VDD VSS gf180mcu_fd_sc_mcu7t5v0__clkbuf_3
Xwire27 wire27/Z wire27/I VDD VSS VDD VSS gf180mcu_fd_sc_mcu7t5v0__buf_4
XFILLER_76_381 VDD VSS VDD VSS gf180mcu_fd_sc_mcu7t5v0__fillcap_4
XFILLER_64_521 VDD VSS VDD VSS gf180mcu_fd_sc_mcu7t5v0__fillcap_4
XFILLER_92_885 VDD VSS VDD VSS gf180mcu_fd_sc_mcu7t5v0__fillcap_4
XFILLER_17_492 VDD VSS VDD VSS gf180mcu_fd_sc_mcu7t5v0__fillcap_64
X_3913_ VDD _3913_/Q _3937_/CLK VSS _3913_/D VDD VSS gf180mcu_fd_sc_mcu7t5v0__dffq_1
XFILLER_32_451 VDD VSS VDD VSS gf180mcu_fd_sc_mcu7t5v0__fillcap_4
X_3844_ _3848_/S VDD VSS _3997_/D _4292_/Q _3997_/Q VDD VSS gf180mcu_fd_sc_mcu7t5v0__mux2_2
XFILLER_165_607 VDD VSS VDD VSS gf180mcu_fd_sc_mcu7t5v0__fillcap_4
X_3775_ _3777_/S VDD VSS _3943_/D _4294_/Q _3943_/Q VDD VSS gf180mcu_fd_sc_mcu7t5v0__mux2_2
XFILLER_158_681 VDD VSS VDD VSS gf180mcu_fd_sc_mcu7t5v0__fillcap_16
XFILLER_146_865 VDD VSS VDD VSS gf180mcu_fd_sc_mcu7t5v0__fillcap_8
XFILLER_145_331 VDD VSS VDD VSS gf180mcu_fd_sc_mcu7t5v0__fillcap_8
X_2726_ _2728_/S VDD VSS _4260_/D _4260_/Q _4276_/Q VDD VSS gf180mcu_fd_sc_mcu7t5v0__mux2_2
X_2657_ _4233_/Q _2666_/C VDD VSS _2658_/B2 _4266_/Q _2168_/Z _2664_/A2 VDD VSS gf180mcu_fd_sc_mcu7t5v0__aoi221_1
X_2588_ VDD VSS _2634_/A3 _2638_/A1 _2588_/A2 VDD VSS gf180mcu_fd_sc_mcu7t5v0__nand2_1
XFILLER_141_570 VDD VSS VDD VSS gf180mcu_fd_sc_mcu7t5v0__fillcap_4
X_4327_ _4327_/D _4327_/Q wire206/Z VSS _4346_/CLK VDD VDD VSS gf180mcu_fd_sc_mcu7t5v0__dffrnq_1
XFILLER_86_101 VDD VSS VDD VSS gf180mcu_fd_sc_mcu7t5v0__fillcap_4
XFILLER_247_416 VDD VSS VDD VSS gf180mcu_fd_sc_mcu7t5v0__fillcap_4
XFILLER_259_276 VDD VSS VDD VSS gf180mcu_fd_sc_mcu7t5v0__fillcap_4
X_4258_ _4258_/D _4258_/Q _4284_/RN VSS _4330_/CLK VDD VDD VSS gf180mcu_fd_sc_mcu7t5v0__dffrnq_1
X_3209_ VDD _3211_/A2 _3209_/B _2780_/B _2821_/Z VSS _3209_/A3 VDD VSS gf180mcu_fd_sc_mcu7t5v0__oai31_1
XFILLER_68_871 VDD VSS VDD VSS gf180mcu_fd_sc_mcu7t5v0__fillcap_4
XFILLER_27_212 VDD VSS VDD VSS gf180mcu_fd_sc_mcu7t5v0__fillcap_64
X_4189_ _4189_/D _4189_/Q wire212/Z VSS clkload7/I VDD VDD VSS gf180mcu_fd_sc_mcu7t5v0__dffrnq_1
XFILLER_215_346 VDD VSS VDD VSS gf180mcu_fd_sc_mcu7t5v0__fillcap_4
XFILLER_103_88 VDD VSS VDD VSS gf180mcu_fd_sc_mcu7t5v0__fillcap_8
XFILLER_179_26 VDD VSS VDD VSS gf180mcu_fd_sc_mcu7t5v0__fillcap_4
XFILLER_10_101 VDD VSS VDD VSS gf180mcu_fd_sc_mcu7t5v0__fillcap_4
Xmax_length102 _3124_/A1 _3122_/S VDD VSS VDD VSS gf180mcu_fd_sc_mcu7t5v0__buf_4
XFILLER_156_629 VDD VSS VDD VSS gf180mcu_fd_sc_mcu7t5v0__fillcap_16
Xmax_length124 VSS wire123/I _4442_/Q VDD VDD VSS gf180mcu_fd_sc_mcu7t5v0__buf_2
XFILLER_12_30 VDD VSS VDD VSS gf180mcu_fd_sc_mcu7t5v0__fillcap_4
Xmax_length113 VSS _2747_/I1 _4455_/Q VDD VDD VSS gf180mcu_fd_sc_mcu7t5v0__clkbuf_1
Xmax_length146 VSS _1911_/I _4327_/Q VDD VDD VSS gf180mcu_fd_sc_mcu7t5v0__buf_2
Xmax_length135 wire134/I VSS VDD _4438_/Q VDD VSS gf180mcu_fd_sc_mcu7t5v0__clkbuf_2
XFILLER_109_556 VDD VSS VDD VSS gf180mcu_fd_sc_mcu7t5v0__fillcap_4
XFILLER_137_876 VDD VSS VDD VSS gf180mcu_fd_sc_mcu7t5v0__fillcap_8
XFILLER_191_492 VDD VSS VDD VSS gf180mcu_fd_sc_mcu7t5v0__fillcap_16
XFILLER_2_311 VDD VSS VDD VSS gf180mcu_fd_sc_mcu7t5v0__fillcap_4
XFILLER_5_2 VDD VSS VDD VSS gf180mcu_fd_sc_mcu7t5v0__fillcap_64
XFILLER_19_702 VDD VSS VDD VSS gf180mcu_fd_sc_mcu7t5v0__fillcap_64
XFILLER_120_798 VDD VSS VDD VSS gf180mcu_fd_sc_mcu7t5v0__fillcap_4
XFILLER_219_696 VDD VSS VDD VSS gf180mcu_fd_sc_mcu7t5v0__fillcap_4
XFILLER_219_663 VDD VSS VDD VSS gf180mcu_fd_sc_mcu7t5v0__fillcap_4
XFILLER_46_521 VDD VSS VDD VSS gf180mcu_fd_sc_mcu7t5v0__fillcap_4
XFILLER_58_381 VDD VSS VDD VSS gf180mcu_fd_sc_mcu7t5v0__fillcap_4
XFILLER_74_885 VDD VSS VDD VSS gf180mcu_fd_sc_mcu7t5v0__fillcap_4
XFILLER_187_732 VDD VSS VDD VSS gf180mcu_fd_sc_mcu7t5v0__fillcap_8
XFILLER_159_412 VDD VSS VDD VSS gf180mcu_fd_sc_mcu7t5v0__fillcap_8
XFILLER_14_451 VDD VSS VDD VSS gf180mcu_fd_sc_mcu7t5v0__fillcap_4
XFILLER_202_574 VDD VSS VDD VSS gf180mcu_fd_sc_mcu7t5v0__fillcap_16
X_3560_ VDD VSS _3562_/A2 wire75/I _4015_/Q VDD VSS gf180mcu_fd_sc_mcu7t5v0__nand2_1
X_2511_ _2511_/A3 VDD VSS _3444_/A1 _4430_/Q _4429_/Q VDD VSS gf180mcu_fd_sc_mcu7t5v0__nand3_1
XFILLER_6_661 VDD VSS VDD VSS gf180mcu_fd_sc_mcu7t5v0__fillcap_4
X_3491_ VDD VSS _3492_/B _3564_/S _4004_/Q VDD VSS gf180mcu_fd_sc_mcu7t5v0__nand2_1
X_2442_ VDD VSS _2454_/S _2483_/A1 _2432_/Z VDD VSS gf180mcu_fd_sc_mcu7t5v0__nand2_1
X_2373_ wire14/I VDD VSS _4017_/D _4017_/Q _2454_/I0 VDD VSS gf180mcu_fd_sc_mcu7t5v0__mux2_2
XFILLER_38_2 VDD VSS VDD VSS gf180mcu_fd_sc_mcu7t5v0__fillcap_32
XFILLER_68_101 VDD VSS VDD VSS gf180mcu_fd_sc_mcu7t5v0__fillcap_4
XFILLER_229_416 VDD VSS VDD VSS gf180mcu_fd_sc_mcu7t5v0__fillcap_4
X_4112_ VDD _4112_/Q _4122_/CLK VSS _4112_/D VDD VSS gf180mcu_fd_sc_mcu7t5v0__dffq_1
X_4043_ VDD _4043_/Q _4062_/CLK VSS _4043_/D VDD VSS gf180mcu_fd_sc_mcu7t5v0__dffq_1
XFILLER_65_874 VDD VSS VDD VSS gf180mcu_fd_sc_mcu7t5v0__fillcap_16
XFILLER_80_877 VDD VSS VDD VSS gf180mcu_fd_sc_mcu7t5v0__fillcap_8
XFILLER_193_702 VDD VSS VDD VSS gf180mcu_fd_sc_mcu7t5v0__fillcap_32
XFILLER_178_765 VDD VSS VDD VSS gf180mcu_fd_sc_mcu7t5v0__fillcap_8
X_3827_ _3830_/S VDD VSS _3982_/D _3845_/I0 _3982_/Q VDD VSS gf180mcu_fd_sc_mcu7t5v0__mux2_2
X_3758_ _3758_/S VDD VSS _3929_/D _3848_/I0 _3929_/Q VDD VSS gf180mcu_fd_sc_mcu7t5v0__mux2_2
X_2709_ _2713_/B1 _4281_/Q VDD VSS _2710_/I _4249_/Q _2226_/B VDD VSS gf180mcu_fd_sc_mcu7t5v0__aoi22_1
XFILLER_173_492 VDD VSS VDD VSS gf180mcu_fd_sc_mcu7t5v0__fillcap_16
XFILLER_161_632 VDD VSS VDD VSS gf180mcu_fd_sc_mcu7t5v0__fillcap_16
X_3689_ _3696_/S VDD VSS _3876_/D _3876_/Q _4291_/Q VDD VSS gf180mcu_fd_sc_mcu7t5v0__mux2_2
XFILLER_133_345 VDD VSS VDD VSS gf180mcu_fd_sc_mcu7t5v0__fillcap_4
XFILLER_245_72 VDD VSS VDD VSS gf180mcu_fd_sc_mcu7t5v0__fillcap_64
XFILLER_58_37 VDD VSS VDD VSS gf180mcu_fd_sc_mcu7t5v0__fillcap_64
XFILLER_28_521 VDD VSS VDD VSS gf180mcu_fd_sc_mcu7t5v0__fillcap_4
XFILLER_56_885 VDD VSS VDD VSS gf180mcu_fd_sc_mcu7t5v0__fillcap_4
XFILLER_130_53 VDD VSS VDD VSS gf180mcu_fd_sc_mcu7t5v0__fillcap_4
XFILLER_70_387 VDD VSS VDD VSS gf180mcu_fd_sc_mcu7t5v0__fillcap_64
XFILLER_142_2 VDD VSS VDD VSS gf180mcu_fd_sc_mcu7t5v0__fillcap_16
XFILLER_183_212 VDD VSS VDD VSS gf180mcu_fd_sc_mcu7t5v0__fillcap_8
XFILLER_183_267 VDD VSS VDD VSS gf180mcu_fd_sc_mcu7t5v0__fillcap_8
XFILLER_151_142 VDD VSS VDD VSS gf180mcu_fd_sc_mcu7t5v0__fillcap_4
XFILLER_151_197 VDD VSS VDD VSS gf180mcu_fd_sc_mcu7t5v0__fillcap_8
XFILLER_81_619 VDD VSS VDD VSS gf180mcu_fd_sc_mcu7t5v0__fillcap_8
XFILLER_47_874 VDD VSS VDD VSS gf180mcu_fd_sc_mcu7t5v0__fillcap_16
XFILLER_207_655 VDD VSS VDD VSS gf180mcu_fd_sc_mcu7t5v0__fillcap_32
XFILLER_206_143 VDD VSS VDD VSS gf180mcu_fd_sc_mcu7t5v0__fillcap_32
XFILLER_80_107 VDD VSS VDD VSS gf180mcu_fd_sc_mcu7t5v0__fillcap_64
XFILLER_261_282 VDD VSS VDD VSS gf180mcu_fd_sc_mcu7t5v0__fillcap_64
XFILLER_62_877 VDD VSS VDD VSS gf180mcu_fd_sc_mcu7t5v0__fillcap_8
X_2991_ _4329_/Q _2991_/C VDD VSS _3064_/A2 _4328_/Q _4330_/Q VDD VSS gf180mcu_fd_sc_mcu7t5v0__aoi211_1
XFILLER_187_562 VDD VSS VDD VSS gf180mcu_fd_sc_mcu7t5v0__fillcap_32
X_1942_ VDD VSS _4333_/Q _3244_/A1 VDD VSS gf180mcu_fd_sc_mcu7t5v0__clkinv_1
XFILLER_202_360 VDD VSS VDD VSS gf180mcu_fd_sc_mcu7t5v0__fillcap_4
XFILLER_202_371 VDD VSS VDD VSS gf180mcu_fd_sc_mcu7t5v0__fillcap_4
XFILLER_147_415 VDD VSS VDD VSS gf180mcu_fd_sc_mcu7t5v0__fillcap_4
XFILLER_175_746 VDD VSS VDD VSS gf180mcu_fd_sc_mcu7t5v0__fillcap_16
X_3612_ VSS VDD _4170_/Q _3616_/A2 _4158_/Q _2040_/Z _2039_/Z _4137_/Q _3613_/A2 VDD
+ VSS gf180mcu_fd_sc_mcu7t5v0__aoi222_1
XFILLER_128_651 VDD VSS VDD VSS gf180mcu_fd_sc_mcu7t5v0__fillcap_8
X_4592_ _4592_/D _4592_/Q _4613_/RN VSS _4606_/CLK VDD VDD VSS gf180mcu_fd_sc_mcu7t5v0__dffrnq_1
XFILLER_155_492 VDD VSS VDD VSS gf180mcu_fd_sc_mcu7t5v0__fillcap_64
XFILLER_143_632 VDD VSS VDD VSS gf180mcu_fd_sc_mcu7t5v0__fillcap_8
X_3543_ VDD VSS _3544_/A3 _3596_/A1 _3542_/Z VDD VSS gf180mcu_fd_sc_mcu7t5v0__nand2_1
X_3474_ _3474_/A3 VDD VSS _3479_/B wire42/Z _3474_/A2 VDD VSS gf180mcu_fd_sc_mcu7t5v0__and3_1
XFILLER_130_304 VDD VSS VDD VSS gf180mcu_fd_sc_mcu7t5v0__fillcap_8
X_2425_ _2431_/S VDD VSS _4059_/D wire164/Z _4059_/Q VDD VSS gf180mcu_fd_sc_mcu7t5v0__mux2_2
XFILLER_215_42 VDD VSS VDD VSS gf180mcu_fd_sc_mcu7t5v0__fillcap_16
XFILLER_97_763 VDD VSS VDD VSS gf180mcu_fd_sc_mcu7t5v0__fillcap_4
XFILLER_97_796 VDD VSS VDD VSS gf180mcu_fd_sc_mcu7t5v0__fillcap_16
X_2356_ _2359_/S VDD VSS _4006_/D _4006_/Q wire157/Z VDD VSS gf180mcu_fd_sc_mcu7t5v0__mux2_2
X_2287_ VDD VSS _3333_/A2 _4383_/Q _3347_/B VDD VSS gf180mcu_fd_sc_mcu7t5v0__nand2_1
XFILLER_84_457 VDD VSS VDD VSS gf180mcu_fd_sc_mcu7t5v0__fillcap_32
X_4026_ VDD _4026_/Q _4047_/CLK VSS _4026_/D VDD VSS gf180mcu_fd_sc_mcu7t5v0__dffq_1
XFILLER_253_772 VDD VSS VDD VSS gf180mcu_fd_sc_mcu7t5v0__fillcap_64
XFILLER_38_885 VDD VSS VDD VSS gf180mcu_fd_sc_mcu7t5v0__fillcap_4
XFILLER_213_625 VDD VSS VDD VSS gf180mcu_fd_sc_mcu7t5v0__fillcap_4
XFILLER_52_387 VDD VSS VDD VSS gf180mcu_fd_sc_mcu7t5v0__fillcap_64
XFILLER_201_809 VDD VSS VDD VSS gf180mcu_fd_sc_mcu7t5v0__fillcap_4
XFILLER_40_527 VDD VSS VDD VSS gf180mcu_fd_sc_mcu7t5v0__fillcap_64
XFILLER_165_212 VDD VSS VDD VSS gf180mcu_fd_sc_mcu7t5v0__fillcap_32
XFILLER_119_640 VDD VSS VDD VSS gf180mcu_fd_sc_mcu7t5v0__fillcap_8
XFILLER_114_6 VDD VSS VDD VSS gf180mcu_fd_sc_mcu7t5v0__fillcap_8
XFILLER_133_142 VDD VSS VDD VSS gf180mcu_fd_sc_mcu7t5v0__fillcap_64
XFILLER_192_37 VDD VSS VDD VSS gf180mcu_fd_sc_mcu7t5v0__fillcap_4
XFILLER_102_573 VDD VSS VDD VSS gf180mcu_fd_sc_mcu7t5v0__fillcap_16
XFILLER_130_871 VDD VSS VDD VSS gf180mcu_fd_sc_mcu7t5v0__fillcap_4
XFILLER_29_874 VDD VSS VDD VSS gf180mcu_fd_sc_mcu7t5v0__fillcap_16
XFILLER_62_107 VDD VSS VDD VSS gf180mcu_fd_sc_mcu7t5v0__fillcap_64
XFILLER_231_422 VDD VSS VDD VSS gf180mcu_fd_sc_mcu7t5v0__fillcap_64
XFILLER_243_282 VDD VSS VDD VSS gf180mcu_fd_sc_mcu7t5v0__fillcap_64
XFILLER_44_877 VDD VSS VDD VSS gf180mcu_fd_sc_mcu7t5v0__fillcap_8
Xspi_opentarget_i3c_top_221 irq_o_PDRV1 VDD VSS VDD VSS gf180mcu_fd_sc_mcu7t5v0__tiel
Xspi_opentarget_i3c_top_232 sda_pad_PU VDD VSS VDD VSS gf180mcu_fd_sc_mcu7t5v0__tiel
XFILLER_71_696 VDD VSS VDD VSS gf180mcu_fd_sc_mcu7t5v0__fillcap_4
XFILLER_169_562 VDD VSS VDD VSS gf180mcu_fd_sc_mcu7t5v0__fillcap_64
XFILLER_197_882 VDD VSS VDD VSS gf180mcu_fd_sc_mcu7t5v0__fillcap_8
Xspi_opentarget_i3c_top_243 spi_mosi_i_PD VDD VSS VDD VSS gf180mcu_fd_sc_mcu7t5v0__tiel
XFILLER_184_543 VDD VSS VDD VSS gf180mcu_fd_sc_mcu7t5v0__fillcap_8
Xwire120 VSS wire120/Z wire121/Z VDD VDD VSS gf180mcu_fd_sc_mcu7t5v0__buf_1
XFILLER_211_190 VDD VSS VDD VSS gf180mcu_fd_sc_mcu7t5v0__fillcap_8
Xwire142 VSS _1945_/I _4336_/Q VDD VDD VSS gf180mcu_fd_sc_mcu7t5v0__buf_2
Xwire153 VSS wire153/Z _4312_/Q VDD VDD VSS gf180mcu_fd_sc_mcu7t5v0__buf_2
Xwire164 VSS wire164/Z wire166/Z VDD VDD VSS gf180mcu_fd_sc_mcu7t5v0__buf_2
XFILLER_137_492 VDD VSS VDD VSS gf180mcu_fd_sc_mcu7t5v0__fillcap_16
Xwire186 wire186/Z wire196/I VDD VSS VDD VSS gf180mcu_fd_sc_mcu7t5v0__buf_8
XFILLER_125_610 VDD VSS VDD VSS gf180mcu_fd_sc_mcu7t5v0__fillcap_4
XFILLER_124_131 VDD VSS VDD VSS gf180mcu_fd_sc_mcu7t5v0__fillcap_8
XFILLER_124_153 VDD VSS VDD VSS gf180mcu_fd_sc_mcu7t5v0__fillcap_16
X_2210_ _2210_/A3 VDD VSS _2210_/Z _2182_/B _2210_/A2 VDD VSS gf180mcu_fd_sc_mcu7t5v0__or3_1
XFILLER_267_842 VDD VSS VDD VSS gf180mcu_fd_sc_mcu7t5v0__fillcap_32
X_3190_ _4508_/Q VDD VSS wire63/I _4253_/Q _4261_/Q VDD VSS gf180mcu_fd_sc_mcu7t5v0__mux2_2
XFILLER_120_381 VDD VSS VDD VSS gf180mcu_fd_sc_mcu7t5v0__fillcap_4
X_2141_ VDD VSS _2142_/A2 wire117/Z _2141_/A2 VDD VSS gf180mcu_fd_sc_mcu7t5v0__nand2_1
X_2072_ VDD VSS _2112_/A2 wire97/I _2082_/A1 VDD VSS gf180mcu_fd_sc_mcu7t5v0__nor2_1
XFILLER_66_457 VDD VSS VDD VSS gf180mcu_fd_sc_mcu7t5v0__fillcap_64
XFILLER_93_276 VDD VSS VDD VSS gf180mcu_fd_sc_mcu7t5v0__fillcap_4
XFILLER_81_416 VDD VSS VDD VSS gf180mcu_fd_sc_mcu7t5v0__fillcap_4
XFILLER_235_772 VDD VSS VDD VSS gf180mcu_fd_sc_mcu7t5v0__fillcap_16
Xclkbuf_leaf_91_clk_i _4430_/CLK VSS VDD clkload0/I VDD VSS gf180mcu_fd_sc_mcu7t5v0__clkbuf_2
XFILLER_250_731 VDD VSS VDD VSS gf180mcu_fd_sc_mcu7t5v0__fillcap_4
XFILLER_262_591 VDD VSS VDD VSS gf180mcu_fd_sc_mcu7t5v0__fillcap_4
XFILLER_34_387 VDD VSS VDD VSS gf180mcu_fd_sc_mcu7t5v0__fillcap_64
XFILLER_201_66 VDD VSS VDD VSS gf180mcu_fd_sc_mcu7t5v0__fillcap_4
X_2974_ _2974_/A3 VDD VSS _2982_/S _2980_/A2 _2974_/A2 VDD VSS gf180mcu_fd_sc_mcu7t5v0__nand3_1
XFILLER_22_527 VDD VSS VDD VSS gf180mcu_fd_sc_mcu7t5v0__fillcap_64
X_1925_ VDD VSS _4436_/Q _3426_/A3 VDD VSS gf180mcu_fd_sc_mcu7t5v0__clkinv_1
XFILLER_147_212 VDD VSS VDD VSS gf180mcu_fd_sc_mcu7t5v0__fillcap_16
X_4575_ _4575_/D _4575_/Q _4616_/RN VSS _4604_/CLK VDD VDD VSS gf180mcu_fd_sc_mcu7t5v0__dffrnq_1
XFILLER_116_621 VDD VSS VDD VSS gf180mcu_fd_sc_mcu7t5v0__fillcap_4
X_3526_ _2040_/Z _4155_/Q VDD VSS _3528_/A2 _4134_/Q _2039_/Z VDD VSS gf180mcu_fd_sc_mcu7t5v0__aoi22_1
XFILLER_115_142 VDD VSS VDD VSS gf180mcu_fd_sc_mcu7t5v0__fillcap_16
XFILLER_226_30 VDD VSS VDD VSS gf180mcu_fd_sc_mcu7t5v0__fillcap_4
X_3457_ _3457_/B1 _3457_/B2 VDD VSS _4469_/D _3457_/A1 _3546_/B VDD VSS gf180mcu_fd_sc_mcu7t5v0__aoi22_1
Xclkbuf_leaf_44_clk_i _4337_/CLK VSS VDD clkload6/I VDD VSS gf180mcu_fd_sc_mcu7t5v0__clkbuf_2
X_3388_ wire56/I VDD VSS _4433_/D _4393_/Q _4433_/Q VDD VSS gf180mcu_fd_sc_mcu7t5v0__mux2_2
X_2408_ _2413_/S VDD VSS _4044_/D wire161/Z _4044_/Q VDD VSS gf180mcu_fd_sc_mcu7t5v0__mux2_2
XFILLER_257_352 VDD VSS VDD VSS gf180mcu_fd_sc_mcu7t5v0__fillcap_64
X_2339_ _4329_/Q VDD VSS _2341_/A2 _1911_/I _4330_/Q VDD VSS gf180mcu_fd_sc_mcu7t5v0__nor3_1
X_4009_ VDD _4009_/Q _4076_/CLK VSS _4009_/D VDD VSS gf180mcu_fd_sc_mcu7t5v0__dffq_1
XFILLER_44_107 VDD VSS VDD VSS gf180mcu_fd_sc_mcu7t5v0__fillcap_64
Xclkbuf_leaf_59_clk_i _4269_/CLK VSS VDD clkload2/I VDD VSS gf180mcu_fd_sc_mcu7t5v0__clkbuf_2
XFILLER_213_422 VDD VSS VDD VSS gf180mcu_fd_sc_mcu7t5v0__fillcap_32
XFILLER_225_282 VDD VSS VDD VSS gf180mcu_fd_sc_mcu7t5v0__fillcap_64
XFILLER_26_877 VDD VSS VDD VSS gf180mcu_fd_sc_mcu7t5v0__fillcap_8
XFILLER_201_606 VDD VSS VDD VSS gf180mcu_fd_sc_mcu7t5v0__fillcap_16
XFILLER_198_657 VDD VSS VDD VSS gf180mcu_fd_sc_mcu7t5v0__fillcap_8
XFILLER_240_241 VDD VSS VDD VSS gf180mcu_fd_sc_mcu7t5v0__fillcap_4
XFILLER_41_836 VDD VSS VDD VSS gf180mcu_fd_sc_mcu7t5v0__fillcap_4
XFILLER_53_696 VDD VSS VDD VSS gf180mcu_fd_sc_mcu7t5v0__fillcap_4
XFILLER_111_66 VDD VSS VDD VSS gf180mcu_fd_sc_mcu7t5v0__fillcap_4
XFILLER_139_702 VDD VSS VDD VSS gf180mcu_fd_sc_mcu7t5v0__fillcap_32
XFILLER_166_521 VDD VSS VDD VSS gf180mcu_fd_sc_mcu7t5v0__fillcap_4
XFILLER_166_543 VDD VSS VDD VSS gf180mcu_fd_sc_mcu7t5v0__fillcap_4
XFILLER_194_885 VDD VSS VDD VSS gf180mcu_fd_sc_mcu7t5v0__fillcap_4
XFILLER_153_204 VDD VSS VDD VSS gf180mcu_fd_sc_mcu7t5v0__fillcap_4
XFILLER_107_632 VDD VSS VDD VSS gf180mcu_fd_sc_mcu7t5v0__fillcap_16
XFILLER_119_492 VDD VSS VDD VSS gf180mcu_fd_sc_mcu7t5v0__fillcap_16
XFILLER_4_247 VDD VSS VDD VSS gf180mcu_fd_sc_mcu7t5v0__fillcap_64
XFILLER_249_842 VDD VSS VDD VSS gf180mcu_fd_sc_mcu7t5v0__fillcap_32
XFILLER_264_801 VDD VSS VDD VSS gf180mcu_fd_sc_mcu7t5v0__fillcap_4
XFILLER_102_370 VDD VSS VDD VSS gf180mcu_fd_sc_mcu7t5v0__fillcap_4
XFILLER_48_457 VDD VSS VDD VSS gf180mcu_fd_sc_mcu7t5v0__fillcap_64
XFILLER_29_72 VDD VSS VDD VSS gf180mcu_fd_sc_mcu7t5v0__fillcap_64
XFILLER_75_276 VDD VSS VDD VSS gf180mcu_fd_sc_mcu7t5v0__fillcap_4
XFILLER_63_416 VDD VSS VDD VSS gf180mcu_fd_sc_mcu7t5v0__fillcap_4
XFILLER_244_591 VDD VSS VDD VSS gf180mcu_fd_sc_mcu7t5v0__fillcap_4
XFILLER_188_101 VDD VSS VDD VSS gf180mcu_fd_sc_mcu7t5v0__fillcap_4
XFILLER_16_387 VDD VSS VDD VSS gf180mcu_fd_sc_mcu7t5v0__fillcap_64
XFILLER_31_346 VDD VSS VDD VSS gf180mcu_fd_sc_mcu7t5v0__fillcap_4
XFILLER_129_212 VDD VSS VDD VSS gf180mcu_fd_sc_mcu7t5v0__fillcap_16
XFILLER_200_661 VDD VSS VDD VSS gf180mcu_fd_sc_mcu7t5v0__fillcap_4
X_2690_ VDD VSS _2695_/A2 _4241_/Q _4242_/Q VDD VSS gf180mcu_fd_sc_mcu7t5v0__nand2_1
XFILLER_8_597 VDD VSS VDD VSS gf180mcu_fd_sc_mcu7t5v0__fillcap_64
X_4360_ _4360_/D _4360_/Q wire184/Z VSS _4526_/CLK VDD VDD VSS gf180mcu_fd_sc_mcu7t5v0__dffrnq_1
XFILLER_160_708 VDD VSS VDD VSS gf180mcu_fd_sc_mcu7t5v0__fillcap_16
X_3311_ _3325_/B VDD VSS _4374_/D _4373_/Q _4374_/Q VDD VSS gf180mcu_fd_sc_mcu7t5v0__mux2_2
X_4291_ _4291_/D _4291_/Q _4525_/RN VSS _4338_/CLK VDD VDD VSS gf180mcu_fd_sc_mcu7t5v0__dffrnq_1
XFILLER_112_123 VDD VSS VDD VSS gf180mcu_fd_sc_mcu7t5v0__fillcap_8
X_3242_ _3271_/B VDD VSS wire23/I _2985_/C wire45/I VDD VSS gf180mcu_fd_sc_mcu7t5v0__nand3_1
X_3173_ VDD _4337_/D _3173_/B wire13/Z _3173_/A2 VSS _3173_/A3 VDD VSS gf180mcu_fd_sc_mcu7t5v0__oai31_1
XFILLER_239_352 VDD VSS VDD VSS gf180mcu_fd_sc_mcu7t5v0__fillcap_64
XFILLER_20_2 VDD VSS VDD VSS gf180mcu_fd_sc_mcu7t5v0__fillcap_32
XFILLER_254_311 VDD VSS VDD VSS gf180mcu_fd_sc_mcu7t5v0__fillcap_4
XFILLER_266_171 VDD VSS VDD VSS gf180mcu_fd_sc_mcu7t5v0__fillcap_4
X_2124_ _4528_/Q VDD VSS _2125_/I _4132_/Q _2124_/A2 VDD VSS gf180mcu_fd_sc_mcu7t5v0__aoi21_1
XFILLER_67_766 VDD VSS VDD VSS gf180mcu_fd_sc_mcu7t5v0__fillcap_4
XFILLER_26_107 VDD VSS VDD VSS gf180mcu_fd_sc_mcu7t5v0__fillcap_64
X_2055_ VDD VSS _2057_/A2 wire78/I _2051_/Z VDD VSS gf180mcu_fd_sc_mcu7t5v0__nand2_1
XFILLER_235_591 VDD VSS VDD VSS gf180mcu_fd_sc_mcu7t5v0__fillcap_8
XFILLER_207_282 VDD VSS VDD VSS gf180mcu_fd_sc_mcu7t5v0__fillcap_32
XFILLER_222_241 VDD VSS VDD VSS gf180mcu_fd_sc_mcu7t5v0__fillcap_4
XFILLER_35_696 VDD VSS VDD VSS gf180mcu_fd_sc_mcu7t5v0__fillcap_4
XFILLER_23_836 VDD VSS VDD VSS gf180mcu_fd_sc_mcu7t5v0__fillcap_4
X_2957_ VDD _2958_/C _2957_/B _1926_/I _2957_/A2 VSS _2936_/B VDD VSS gf180mcu_fd_sc_mcu7t5v0__oai31_1
XFILLER_191_811 VDD VSS VDD VSS gf180mcu_fd_sc_mcu7t5v0__fillcap_16
XFILLER_176_885 VDD VSS VDD VSS gf180mcu_fd_sc_mcu7t5v0__fillcap_4
X_2888_ VDD _2888_/B _2888_/A2 _4303_/D _2888_/A1 VSS VDD VSS gf180mcu_fd_sc_mcu7t5v0__oai21_1
X_1908_ VDD VSS _4150_/Q _2041_/B VDD VSS gf180mcu_fd_sc_mcu7t5v0__clkinv_1
XFILLER_175_373 VDD VSS VDD VSS gf180mcu_fd_sc_mcu7t5v0__fillcap_4
X_4558_ _4558_/D _4558_/Q wire187/Z VSS _4562_/CLK VDD VDD VSS gf180mcu_fd_sc_mcu7t5v0__dffrnq_1
XFILLER_190_387 VDD VSS VDD VSS gf180mcu_fd_sc_mcu7t5v0__fillcap_16
XFILLER_1_206 VDD VSS VDD VSS gf180mcu_fd_sc_mcu7t5v0__fillcap_4
XFILLER_144_793 VDD VSS VDD VSS gf180mcu_fd_sc_mcu7t5v0__fillcap_8
XFILLER_89_346 VDD VSS VDD VSS gf180mcu_fd_sc_mcu7t5v0__fillcap_4
X_4489_ _4489_/D _4489_/Q wire209/Z VSS clkload9/I VDD VDD VSS gf180mcu_fd_sc_mcu7t5v0__dffrnq_1
X_3509_ VDD VSS _3510_/A3 wire74/Z _3508_/Z VDD VSS gf180mcu_fd_sc_mcu7t5v0__nand2_1
XFILLER_246_801 VDD VSS VDD VSS gf180mcu_fd_sc_mcu7t5v0__fillcap_4
XFILLER_258_661 VDD VSS VDD VSS gf180mcu_fd_sc_mcu7t5v0__fillcap_4
XFILLER_253_72 VDD VSS VDD VSS gf180mcu_fd_sc_mcu7t5v0__fillcap_64
XFILLER_66_37 VDD VSS VDD VSS gf180mcu_fd_sc_mcu7t5v0__fillcap_64
XFILLER_100_885 VDD VSS VDD VSS gf180mcu_fd_sc_mcu7t5v0__fillcap_4
XFILLER_57_276 VDD VSS VDD VSS gf180mcu_fd_sc_mcu7t5v0__fillcap_4
XFILLER_45_416 VDD VSS VDD VSS gf180mcu_fd_sc_mcu7t5v0__fillcap_4
XFILLER_13_346 VDD VSS VDD VSS gf180mcu_fd_sc_mcu7t5v0__fillcap_4
XFILLER_139_532 VDD VSS VDD VSS gf180mcu_fd_sc_mcu7t5v0__fillcap_16
XFILLER_222_2 VDD VSS VDD VSS gf180mcu_fd_sc_mcu7t5v0__fillcap_32
XFILLER_182_877 VDD VSS VDD VSS gf180mcu_fd_sc_mcu7t5v0__fillcap_8
XFILLER_147_40 VDD VSS VDD VSS gf180mcu_fd_sc_mcu7t5v0__fillcap_8
XFILLER_5_556 VDD VSS VDD VSS gf180mcu_fd_sc_mcu7t5v0__fillcap_4
XFILLER_122_432 VDD VSS VDD VSS gf180mcu_fd_sc_mcu7t5v0__fillcap_16
XFILLER_163_72 VDD VSS VDD VSS gf180mcu_fd_sc_mcu7t5v0__fillcap_32
XFILLER_236_311 VDD VSS VDD VSS gf180mcu_fd_sc_mcu7t5v0__fillcap_4
XFILLER_248_171 VDD VSS VDD VSS gf180mcu_fd_sc_mcu7t5v0__fillcap_4
XFILLER_49_766 VDD VSS VDD VSS gf180mcu_fd_sc_mcu7t5v0__fillcap_4
XFILLER_204_241 VDD VSS VDD VSS gf180mcu_fd_sc_mcu7t5v0__fillcap_4
XFILLER_17_696 VDD VSS VDD VSS gf180mcu_fd_sc_mcu7t5v0__fillcap_4
XFILLER_232_583 VDD VSS VDD VSS gf180mcu_fd_sc_mcu7t5v0__fillcap_8
X_3860_ _3860_/D _3867_/D _4535_/RN VSS _4468_/CLK VDD VDD VSS gf180mcu_fd_sc_mcu7t5v0__dffrnq_1
X_3791_ _3791_/B VDD VSS _3955_/D _3791_/A1 wire16/Z VDD VSS gf180mcu_fd_sc_mcu7t5v0__aoi21_1
X_2811_ _3043_/A1 _3497_/C1 VDD VSS _2951_/B _3226_/A1 _4327_/Q VDD VSS gf180mcu_fd_sc_mcu7t5v0__nand4_1
XFILLER_158_885 VDD VSS VDD VSS gf180mcu_fd_sc_mcu7t5v0__fillcap_4
X_2742_ wire36/Z VDD VSS _4276_/D _4276_/Q _4442_/Q VDD VSS gf180mcu_fd_sc_mcu7t5v0__mux2_2
XFILLER_157_340 VDD VSS VDD VSS gf180mcu_fd_sc_mcu7t5v0__fillcap_8
XFILLER_145_524 VDD VSS VDD VSS gf180mcu_fd_sc_mcu7t5v0__fillcap_4
X_2673_ VDD _2673_/B _4503_/D _4234_/D _2673_/A1 VSS VDD VSS gf180mcu_fd_sc_mcu7t5v0__oai21_1
XFILLER_184_192 VDD VSS VDD VSS gf180mcu_fd_sc_mcu7t5v0__fillcap_16
X_4412_ _4412_/D _4412_/Q wire210/Z VSS _4462_/CLK VDD VDD VSS gf180mcu_fd_sc_mcu7t5v0__dffrnq_1
XFILLER_68_2 VDD VSS VDD VSS gf180mcu_fd_sc_mcu7t5v0__fillcap_32
X_4343_ _4343_/D _4343_/Q _4371_/RN VSS _4345_/CLK VDD VDD VSS gf180mcu_fd_sc_mcu7t5v0__dffrnq_1
X_4274_ _4274_/D _4274_/Q _4284_/RN VSS _4330_/CLK VDD VDD VSS gf180mcu_fd_sc_mcu7t5v0__dffrnq_1
X_3225_ _3225_/B VDD VSS _3239_/A1 _3225_/A1 _3225_/A2 VDD VSS gf180mcu_fd_sc_mcu7t5v0__aoi21_1
X_3156_ VDD wire97/I _3879_/Q _3159_/A2 _3157_/A1 VSS VDD VSS gf180mcu_fd_sc_mcu7t5v0__oai21_1
XFILLER_27_416 VDD VSS VDD VSS gf180mcu_fd_sc_mcu7t5v0__fillcap_4
XFILLER_39_276 VDD VSS VDD VSS gf180mcu_fd_sc_mcu7t5v0__fillcap_4
X_3087_ _3169_/B _3087_/C VDD VSS _3089_/A2 _2854_/B _3087_/A2 wire67/Z VDD VSS gf180mcu_fd_sc_mcu7t5v0__aoi221_1
X_2107_ VDD VSS _4540_/D _4540_/Q _2102_/Z VDD VSS gf180mcu_fd_sc_mcu7t5v0__xor2_1
X_2038_ VDD VSS _3637_/A1 _3383_/A1 _3449_/A2 VDD VSS gf180mcu_fd_sc_mcu7t5v0__nand2_1
XFILLER_195_413 VDD VSS VDD VSS gf180mcu_fd_sc_mcu7t5v0__fillcap_4
X_3989_ VDD _3989_/Q _3989_/CLK VSS _3989_/D VDD VSS gf180mcu_fd_sc_mcu7t5v0__dffq_1
XFILLER_167_148 VDD VSS VDD VSS gf180mcu_fd_sc_mcu7t5v0__fillcap_8
XFILLER_148_373 VDD VSS VDD VSS gf180mcu_fd_sc_mcu7t5v0__fillcap_8
XFILLER_164_877 VDD VSS VDD VSS gf180mcu_fd_sc_mcu7t5v0__fillcap_8
XFILLER_132_730 VDD VSS VDD VSS gf180mcu_fd_sc_mcu7t5v0__fillcap_4
XFILLER_104_443 VDD VSS VDD VSS gf180mcu_fd_sc_mcu7t5v0__fillcap_8
XFILLER_131_273 VDD VSS VDD VSS gf180mcu_fd_sc_mcu7t5v0__fillcap_4
XFILLER_172_2 VDD VSS VDD VSS gf180mcu_fd_sc_mcu7t5v0__fillcap_32
XFILLER_93_57 VDD VSS VDD VSS gf180mcu_fd_sc_mcu7t5v0__fillcap_8
XFILLER_199_730 VDD VSS VDD VSS gf180mcu_fd_sc_mcu7t5v0__fillcap_4
XFILLER_202_712 VDD VSS VDD VSS gf180mcu_fd_sc_mcu7t5v0__fillcap_16
XFILLER_214_583 VDD VSS VDD VSS gf180mcu_fd_sc_mcu7t5v0__fillcap_8
XFILLER_260_177 VDD VSS VDD VSS gf180mcu_fd_sc_mcu7t5v0__fillcap_64
XFILLER_186_457 VDD VSS VDD VSS gf180mcu_fd_sc_mcu7t5v0__fillcap_64
XFILLER_9_136 VDD VSS VDD VSS gf180mcu_fd_sc_mcu7t5v0__fillcap_4
XFILLER_154_310 VDD VSS VDD VSS gf180mcu_fd_sc_mcu7t5v0__fillcap_4
XFILLER_154_332 VDD VSS VDD VSS gf180mcu_fd_sc_mcu7t5v0__fillcap_8
Xmax_length90 _3605_/S _3564_/S VDD VSS VDD VSS gf180mcu_fd_sc_mcu7t5v0__buf_4
XFILLER_154_354 VDD VSS VDD VSS gf180mcu_fd_sc_mcu7t5v0__fillcap_16
XFILLER_154_387 VDD VSS VDD VSS gf180mcu_fd_sc_mcu7t5v0__fillcap_8
XFILLER_107_270 VDD VSS VDD VSS gf180mcu_fd_sc_mcu7t5v0__fillcap_8
XFILLER_96_647 VDD VSS VDD VSS gf180mcu_fd_sc_mcu7t5v0__fillcap_16
XFILLER_3_66 VDD VSS VDD VSS gf180mcu_fd_sc_mcu7t5v0__fillcap_4
XFILLER_95_146 VDD VSS VDD VSS gf180mcu_fd_sc_mcu7t5v0__fillcap_4
X_3010_ _2998_/Z _3021_/B3 _3009_/Z VDD VSS _4323_/D _3015_/B VDD VSS gf180mcu_fd_sc_mcu7t5v0__oai22_1
XFILLER_92_831 VDD VSS VDD VSS gf180mcu_fd_sc_mcu7t5v0__fillcap_4
Xwire28 wire28/Z wire28/I VDD VSS VDD VSS gf180mcu_fd_sc_mcu7t5v0__buf_4
XFILLER_91_352 VDD VSS VDD VSS gf180mcu_fd_sc_mcu7t5v0__fillcap_64
XFILLER_252_667 VDD VSS VDD VSS gf180mcu_fd_sc_mcu7t5v0__fillcap_64
XFILLER_240_807 VDD VSS VDD VSS gf180mcu_fd_sc_mcu7t5v0__fillcap_64
X_3912_ VDD _3912_/Q _3936_/CLK VSS _3912_/D VDD VSS gf180mcu_fd_sc_mcu7t5v0__dffq_1
X_3843_ _3848_/S VDD VSS _3996_/D wire177/Z _3996_/Q VDD VSS gf180mcu_fd_sc_mcu7t5v0__mux2_2
X_3774_ _3777_/S VDD VSS _3942_/D _3845_/I0 _3942_/Q VDD VSS gf180mcu_fd_sc_mcu7t5v0__mux2_2
XFILLER_164_107 VDD VSS VDD VSS gf180mcu_fd_sc_mcu7t5v0__fillcap_16
X_2725_ _2728_/S VDD VSS _4259_/D _4259_/Q _4275_/Q VDD VSS gf180mcu_fd_sc_mcu7t5v0__mux2_2
XFILLER_118_535 VDD VSS VDD VSS gf180mcu_fd_sc_mcu7t5v0__fillcap_4
X_2656_ VDD VSS _2658_/B1 _4145_/Q _2666_/B1 VDD VSS gf180mcu_fd_sc_mcu7t5v0__nand2_1
XFILLER_146_877 VDD VSS VDD VSS gf180mcu_fd_sc_mcu7t5v0__fillcap_8
XFILLER_161_836 VDD VSS VDD VSS gf180mcu_fd_sc_mcu7t5v0__fillcap_4
X_2587_ VDD VSS _2587_/Z _2638_/A1 _2588_/A2 VDD VSS gf180mcu_fd_sc_mcu7t5v0__and2_1
XFILLER_160_346 VDD VSS VDD VSS gf180mcu_fd_sc_mcu7t5v0__fillcap_4
X_4326_ _4326_/D _4326_/Q wire199/Z VSS _4525_/CLK VDD VDD VSS gf180mcu_fd_sc_mcu7t5v0__dffrnq_1
X_4257_ _4257_/D _4257_/Q _4284_/RN VSS _4330_/CLK VDD VDD VSS gf180mcu_fd_sc_mcu7t5v0__dffrnq_1
XFILLER_228_653 VDD VSS VDD VSS gf180mcu_fd_sc_mcu7t5v0__fillcap_4
X_4188_ _4188_/D _4188_/Q wire210/Z VSS _4462_/CLK VDD VDD VSS gf180mcu_fd_sc_mcu7t5v0__dffrnq_1
X_3208_ VDD VSS _3209_/A3 _3217_/A1 _3208_/A2 VDD VSS gf180mcu_fd_sc_mcu7t5v0__nor2_1
X_3139_ _3139_/B _3182_/B VDD VSS _3146_/B _3159_/C _3133_/Z VDD VSS gf180mcu_fd_sc_mcu7t5v0__oai211_1
XFILLER_216_859 VDD VSS VDD VSS gf180mcu_fd_sc_mcu7t5v0__fillcap_16
XFILLER_103_34 VDD VSS VDD VSS gf180mcu_fd_sc_mcu7t5v0__fillcap_8
XFILLER_242_177 VDD VSS VDD VSS gf180mcu_fd_sc_mcu7t5v0__fillcap_64
XFILLER_230_317 VDD VSS VDD VSS gf180mcu_fd_sc_mcu7t5v0__fillcap_64
XFILLER_51_772 VDD VSS VDD VSS gf180mcu_fd_sc_mcu7t5v0__fillcap_64
Xmax_length103 _3185_/S _3122_/S VDD VSS VDD VSS gf180mcu_fd_sc_mcu7t5v0__buf_4
Xmax_length136 VSS _3395_/I1 _4438_/Q VDD VDD VSS gf180mcu_fd_sc_mcu7t5v0__buf_2
Xmax_length169 VSS wire168/I _4306_/Q VDD VDD VSS gf180mcu_fd_sc_mcu7t5v0__buf_2
XFILLER_136_365 VDD VSS VDD VSS gf180mcu_fd_sc_mcu7t5v0__fillcap_4
XFILLER_136_387 VDD VSS VDD VSS gf180mcu_fd_sc_mcu7t5v0__fillcap_16
XFILLER_151_368 VDD VSS VDD VSS gf180mcu_fd_sc_mcu7t5v0__fillcap_4
XFILLER_266_737 VDD VSS VDD VSS gf180mcu_fd_sc_mcu7t5v0__fillcap_64
XFILLER_73_352 VDD VSS VDD VSS gf180mcu_fd_sc_mcu7t5v0__fillcap_64
XFILLER_37_72 VDD VSS VDD VSS gf180mcu_fd_sc_mcu7t5v0__fillcap_64
XFILLER_234_667 VDD VSS VDD VSS gf180mcu_fd_sc_mcu7t5v0__fillcap_8
XFILLER_222_807 VDD VSS VDD VSS gf180mcu_fd_sc_mcu7t5v0__fillcap_64
XFILLER_234_656 VDD VSS VDD VSS gf180mcu_fd_sc_mcu7t5v0__fillcap_8
XFILLER_261_486 VDD VSS VDD VSS gf180mcu_fd_sc_mcu7t5v0__fillcap_4
XFILLER_202_553 VDD VSS VDD VSS gf180mcu_fd_sc_mcu7t5v0__fillcap_4
XFILLER_41_282 VDD VSS VDD VSS gf180mcu_fd_sc_mcu7t5v0__fillcap_64
XFILLER_146_107 VDD VSS VDD VSS gf180mcu_fd_sc_mcu7t5v0__fillcap_64
XFILLER_139_192 VDD VSS VDD VSS gf180mcu_fd_sc_mcu7t5v0__fillcap_16
X_2510_ _2510_/B VDD VSS _4141_/D _4448_/Q _2510_/A2 VDD VSS gf180mcu_fd_sc_mcu7t5v0__aoi21_1
XFILLER_115_516 VDD VSS VDD VSS gf180mcu_fd_sc_mcu7t5v0__fillcap_4
X_3490_ _3605_/S VDD VSS _3490_/Z _4028_/Q _4020_/Q VDD VSS gf180mcu_fd_sc_mcu7t5v0__mux2_2
XFILLER_128_877 VDD VSS VDD VSS gf180mcu_fd_sc_mcu7t5v0__fillcap_8
XFILLER_143_858 VDD VSS VDD VSS gf180mcu_fd_sc_mcu7t5v0__fillcap_4
XFILLER_127_398 VDD VSS VDD VSS gf180mcu_fd_sc_mcu7t5v0__fillcap_4
XFILLER_115_538 VDD VSS VDD VSS gf180mcu_fd_sc_mcu7t5v0__fillcap_16
XFILLER_108_590 VDD VSS VDD VSS gf180mcu_fd_sc_mcu7t5v0__fillcap_4
X_2441_ _2441_/S VDD VSS _4073_/D _4073_/Q wire150/Z VDD VSS gf180mcu_fd_sc_mcu7t5v0__mux2_2
X_2372_ wire14/Z VDD VSS _4016_/D _4016_/Q wire153/Z VDD VSS gf180mcu_fd_sc_mcu7t5v0__mux2_2
X_4111_ VDD _4111_/Q _4128_/CLK VSS _4111_/D VDD VSS gf180mcu_fd_sc_mcu7t5v0__dffq_1
XFILLER_256_247 VDD VSS VDD VSS gf180mcu_fd_sc_mcu7t5v0__fillcap_64
XFILLER_111_788 VDD VSS VDD VSS gf180mcu_fd_sc_mcu7t5v0__fillcap_8
X_4042_ VDD _4042_/Q _4058_/CLK VSS _4042_/D VDD VSS gf180mcu_fd_sc_mcu7t5v0__dffq_1
XFILLER_65_842 VDD VSS VDD VSS gf180mcu_fd_sc_mcu7t5v0__fillcap_32
XFILLER_80_801 VDD VSS VDD VSS gf180mcu_fd_sc_mcu7t5v0__fillcap_4
XFILLER_224_177 VDD VSS VDD VSS gf180mcu_fd_sc_mcu7t5v0__fillcap_64
XFILLER_212_317 VDD VSS VDD VSS gf180mcu_fd_sc_mcu7t5v0__fillcap_64
XFILLER_33_772 VDD VSS VDD VSS gf180mcu_fd_sc_mcu7t5v0__fillcap_64
XFILLER_60_591 VDD VSS VDD VSS gf180mcu_fd_sc_mcu7t5v0__fillcap_4
X_3826_ _3830_/S VDD VSS _3981_/D _4292_/Q _3981_/Q VDD VSS gf180mcu_fd_sc_mcu7t5v0__mux2_2
XFILLER_177_276 VDD VSS VDD VSS gf180mcu_fd_sc_mcu7t5v0__fillcap_4
XFILLER_165_416 VDD VSS VDD VSS gf180mcu_fd_sc_mcu7t5v0__fillcap_4
X_3757_ _3757_/B VDD VSS _3928_/D _3757_/A1 _3758_/S VDD VSS gf180mcu_fd_sc_mcu7t5v0__aoi21_1
XFILLER_158_490 VDD VSS VDD VSS gf180mcu_fd_sc_mcu7t5v0__fillcap_4
XFILLER_165_438 VDD VSS VDD VSS gf180mcu_fd_sc_mcu7t5v0__fillcap_4
X_2708_ VDD VSS _2708_/I _4248_/D VDD VSS gf180mcu_fd_sc_mcu7t5v0__clkinv_1
XFILLER_173_482 VDD VSS VDD VSS gf180mcu_fd_sc_mcu7t5v0__fillcap_8
X_3688_ _3696_/S VDD VSS _3875_/D _3875_/Q wire178/Z VDD VSS gf180mcu_fd_sc_mcu7t5v0__mux2_2
XFILLER_118_387 VDD VSS VDD VSS gf180mcu_fd_sc_mcu7t5v0__fillcap_4
XFILLER_106_527 VDD VSS VDD VSS gf180mcu_fd_sc_mcu7t5v0__fillcap_4
XFILLER_106_538 VDD VSS VDD VSS gf180mcu_fd_sc_mcu7t5v0__fillcap_8
X_2639_ _4534_/D VDD VSS _4220_/D _4220_/Q _4306_/Q VDD VSS gf180mcu_fd_sc_mcu7t5v0__mux2_2
XFILLER_87_422 VDD VSS VDD VSS gf180mcu_fd_sc_mcu7t5v0__fillcap_64
XFILLER_248_737 VDD VSS VDD VSS gf180mcu_fd_sc_mcu7t5v0__fillcap_64
X_4309_ VDD _4309_/Q _4363_/CLK VSS _4309_/D VDD VSS gf180mcu_fd_sc_mcu7t5v0__dffq_1
XFILLER_101_254 VDD VSS VDD VSS gf180mcu_fd_sc_mcu7t5v0__fillcap_16
XFILLER_261_72 VDD VSS VDD VSS gf180mcu_fd_sc_mcu7t5v0__fillcap_64
XFILLER_55_352 VDD VSS VDD VSS gf180mcu_fd_sc_mcu7t5v0__fillcap_64
XFILLER_74_37 VDD VSS VDD VSS gf180mcu_fd_sc_mcu7t5v0__fillcap_64
XFILLER_216_667 VDD VSS VDD VSS gf180mcu_fd_sc_mcu7t5v0__fillcap_8
XFILLER_204_807 VDD VSS VDD VSS gf180mcu_fd_sc_mcu7t5v0__fillcap_16
XFILLER_70_311 VDD VSS VDD VSS gf180mcu_fd_sc_mcu7t5v0__fillcap_4
XFILLER_82_171 VDD VSS VDD VSS gf180mcu_fd_sc_mcu7t5v0__fillcap_4
XFILLER_243_486 VDD VSS VDD VSS gf180mcu_fd_sc_mcu7t5v0__fillcap_4
Xclkbuf_3_0__f_clk_i VDD VSS clkload0/I clkbuf_0_clk_i/Z VDD VSS gf180mcu_fd_sc_mcu7t5v0__clkbuf_16
XFILLER_11_422 VDD VSS VDD VSS gf180mcu_fd_sc_mcu7t5v0__fillcap_64
XFILLER_169_766 VDD VSS VDD VSS gf180mcu_fd_sc_mcu7t5v0__fillcap_4
XFILLER_23_282 VDD VSS VDD VSS gf180mcu_fd_sc_mcu7t5v0__fillcap_64
XFILLER_139_30 VDD VSS VDD VSS gf180mcu_fd_sc_mcu7t5v0__fillcap_4
XFILLER_136_184 VDD VSS VDD VSS gf180mcu_fd_sc_mcu7t5v0__fillcap_8
XFILLER_3_632 VDD VSS VDD VSS gf180mcu_fd_sc_mcu7t5v0__fillcap_64
XFILLER_97_219 VDD VSS VDD VSS gf180mcu_fd_sc_mcu7t5v0__fillcap_16
XFILLER_105_593 VDD VSS VDD VSS gf180mcu_fd_sc_mcu7t5v0__fillcap_4
XFILLER_238_247 VDD VSS VDD VSS gf180mcu_fd_sc_mcu7t5v0__fillcap_64
XFILLER_253_206 VDD VSS VDD VSS gf180mcu_fd_sc_mcu7t5v0__fillcap_4
XFILLER_171_61 VDD VSS VDD VSS gf180mcu_fd_sc_mcu7t5v0__fillcap_8
XFILLER_171_72 VDD VSS VDD VSS gf180mcu_fd_sc_mcu7t5v0__fillcap_8
XFILLER_47_842 VDD VSS VDD VSS gf180mcu_fd_sc_mcu7t5v0__fillcap_32
XFILLER_74_661 VDD VSS VDD VSS gf180mcu_fd_sc_mcu7t5v0__fillcap_4
XFILLER_62_801 VDD VSS VDD VSS gf180mcu_fd_sc_mcu7t5v0__fillcap_4
XFILLER_206_177 VDD VSS VDD VSS gf180mcu_fd_sc_mcu7t5v0__fillcap_64
XFILLER_221_136 VDD VSS VDD VSS gf180mcu_fd_sc_mcu7t5v0__fillcap_4
X_2990_ VDD _3004_/C _3024_/A2 _2992_/B _4348_/Q VSS VDD VSS gf180mcu_fd_sc_mcu7t5v0__oai21_1
XFILLER_15_772 VDD VSS VDD VSS gf180mcu_fd_sc_mcu7t5v0__fillcap_64
X_1941_ VDD VSS _4332_/Q _2942_/A1 VDD VSS gf180mcu_fd_sc_mcu7t5v0__clkinv_1
XFILLER_199_390 VDD VSS VDD VSS gf180mcu_fd_sc_mcu7t5v0__fillcap_8
XFILLER_42_591 VDD VSS VDD VSS gf180mcu_fd_sc_mcu7t5v0__fillcap_4
XFILLER_30_731 VDD VSS VDD VSS gf180mcu_fd_sc_mcu7t5v0__fillcap_4
XFILLER_175_714 VDD VSS VDD VSS gf180mcu_fd_sc_mcu7t5v0__fillcap_32
XFILLER_159_276 VDD VSS VDD VSS gf180mcu_fd_sc_mcu7t5v0__fillcap_4
XFILLER_159_298 VDD VSS VDD VSS gf180mcu_fd_sc_mcu7t5v0__fillcap_8
X_3611_ _3611_/A3 VDD VSS _3615_/B1 wire42/Z _3611_/A2 VDD VSS gf180mcu_fd_sc_mcu7t5v0__nand3_1
XFILLER_190_728 VDD VSS VDD VSS gf180mcu_fd_sc_mcu7t5v0__fillcap_4
X_4591_ _4591_/D _4591_/Q _4613_/RN VDD VSS _4606_/CLK VDD VSS gf180mcu_fd_sc_mcu7t5v0__dffrnq_2
XFILLER_143_622 VDD VSS VDD VSS gf180mcu_fd_sc_mcu7t5v0__fillcap_8
X_3542_ _4062_/Q VSS VDD _4046_/Q _4054_/Q wire88/Z _4038_/Q wire83/Z _3542_/Z VDD
+ VSS gf180mcu_fd_sc_mcu7t5v0__mux4_1
XFILLER_50_2 VDD VSS VDD VSS gf180mcu_fd_sc_mcu7t5v0__fillcap_32
XFILLER_103_508 VDD VSS VDD VSS gf180mcu_fd_sc_mcu7t5v0__fillcap_32
X_3473_ _3473_/A3 VDD VSS _3474_/A3 wire78/Z _3473_/A2 VDD VSS gf180mcu_fd_sc_mcu7t5v0__nand3_1
XFILLER_215_10 VDD VSS VDD VSS gf180mcu_fd_sc_mcu7t5v0__fillcap_32
X_2424_ _2431_/S VDD VSS _4058_/D wire167/Z _4058_/Q VDD VSS gf180mcu_fd_sc_mcu7t5v0__mux2_2
XFILLER_69_422 VDD VSS VDD VSS gf180mcu_fd_sc_mcu7t5v0__fillcap_64
XFILLER_130_338 VDD VSS VDD VSS gf180mcu_fd_sc_mcu7t5v0__fillcap_8
X_2355_ _2357_/S VDD VSS _4005_/D _4005_/Q wire158/Z VDD VSS gf180mcu_fd_sc_mcu7t5v0__mux2_2
XFILLER_257_556 VDD VSS VDD VSS gf180mcu_fd_sc_mcu7t5v0__fillcap_4
XFILLER_96_296 VDD VSS VDD VSS gf180mcu_fd_sc_mcu7t5v0__fillcap_4
X_2286_ VDD VSS _3347_/B _3329_/A1 _3325_/B VDD VSS gf180mcu_fd_sc_mcu7t5v0__nor2_1
X_4025_ VDD _4025_/Q _4076_/CLK VSS _4025_/D VDD VSS gf180mcu_fd_sc_mcu7t5v0__dffq_1
XFILLER_52_311 VDD VSS VDD VSS gf180mcu_fd_sc_mcu7t5v0__fillcap_4
XFILLER_37_352 VDD VSS VDD VSS gf180mcu_fd_sc_mcu7t5v0__fillcap_64
XFILLER_225_486 VDD VSS VDD VSS gf180mcu_fd_sc_mcu7t5v0__fillcap_4
XFILLER_64_171 VDD VSS VDD VSS gf180mcu_fd_sc_mcu7t5v0__fillcap_4
XFILLER_197_327 VDD VSS VDD VSS gf180mcu_fd_sc_mcu7t5v0__fillcap_8
XFILLER_20_241 VDD VSS VDD VSS gf180mcu_fd_sc_mcu7t5v0__fillcap_4
X_3809_ wire15/Z VDD VSS _3967_/D _4294_/Q _3967_/Q VDD VSS gf180mcu_fd_sc_mcu7t5v0__mux2_2
XFILLER_138_449 VDD VSS VDD VSS gf180mcu_fd_sc_mcu7t5v0__fillcap_4
XFILLER_173_290 VDD VSS VDD VSS gf180mcu_fd_sc_mcu7t5v0__fillcap_4
XFILLER_88_731 VDD VSS VDD VSS gf180mcu_fd_sc_mcu7t5v0__fillcap_4
XFILLER_125_65 VDD VSS VDD VSS gf180mcu_fd_sc_mcu7t5v0__fillcap_4
XFILLER_235_206 VDD VSS VDD VSS gf180mcu_fd_sc_mcu7t5v0__fillcap_4
XFILLER_88_797 VDD VSS VDD VSS gf180mcu_fd_sc_mcu7t5v0__fillcap_8
XFILLER_29_842 VDD VSS VDD VSS gf180mcu_fd_sc_mcu7t5v0__fillcap_32
XFILLER_141_42 VDD VSS VDD VSS gf180mcu_fd_sc_mcu7t5v0__fillcap_4
XFILLER_56_661 VDD VSS VDD VSS gf180mcu_fd_sc_mcu7t5v0__fillcap_4
XFILLER_44_801 VDD VSS VDD VSS gf180mcu_fd_sc_mcu7t5v0__fillcap_4
XFILLER_252_2 VDD VSS VDD VSS gf180mcu_fd_sc_mcu7t5v0__fillcap_32
XFILLER_203_136 VDD VSS VDD VSS gf180mcu_fd_sc_mcu7t5v0__fillcap_4
Xspi_opentarget_i3c_top_222 irq_o_PU VDD VSS VDD VSS gf180mcu_fd_sc_mcu7t5v0__tiel
XFILLER_24_591 VDD VSS VDD VSS gf180mcu_fd_sc_mcu7t5v0__fillcap_4
XFILLER_12_731 VDD VSS VDD VSS gf180mcu_fd_sc_mcu7t5v0__fillcap_4
XFILLER_212_681 VDD VSS VDD VSS gf180mcu_fd_sc_mcu7t5v0__fillcap_4
Xspi_opentarget_i3c_top_233 sda_pad_SL VDD VSS VDD VSS gf180mcu_fd_sc_mcu7t5v0__tiel
Xspi_opentarget_i3c_top_244 spi_mosi_i_PU VDD VSS VDD VSS gf180mcu_fd_sc_mcu7t5v0__tiel
XFILLER_196_360 VDD VSS VDD VSS gf180mcu_fd_sc_mcu7t5v0__fillcap_16
Xwire110 VSS _4529_/D _4520_/Q VDD VDD VSS gf180mcu_fd_sc_mcu7t5v0__buf_2
Xwire121 VSS wire121/Z _4443_/Q VDD VDD VSS gf180mcu_fd_sc_mcu7t5v0__buf_2
Xwire132 VSS wire132/Z wire133/Z VDD VDD VSS gf180mcu_fd_sc_mcu7t5v0__buf_1
XFILLER_7_212 VDD VSS VDD VSS gf180mcu_fd_sc_mcu7t5v0__fillcap_64
Xwire143 VSS wire143/Z _4335_/Q VDD VDD VSS gf180mcu_fd_sc_mcu7t5v0__buf_2
Xwire154 VSS wire154/Z wire155/Z VDD VDD VSS gf180mcu_fd_sc_mcu7t5v0__buf_2
Xwire187 wire187/Z wire192/Z VDD VSS VDD VSS gf180mcu_fd_sc_mcu7t5v0__buf_8
Xclkbuf_4_3_0_host_clk_i _4541_/CLK VSS VDD clkbuf_0_host_clk_i/Z VDD VSS gf180mcu_fd_sc_mcu7t5v0__clkbuf_2
XFILLER_112_349 VDD VSS VDD VSS gf180mcu_fd_sc_mcu7t5v0__fillcap_8
XFILLER_78_241 VDD VSS VDD VSS gf180mcu_fd_sc_mcu7t5v0__fillcap_4
XFILLER_121_861 VDD VSS VDD VSS gf180mcu_fd_sc_mcu7t5v0__fillcap_8
XFILLER_239_556 VDD VSS VDD VSS gf180mcu_fd_sc_mcu7t5v0__fillcap_4
X_2140_ VDD VSS _2140_/I _4137_/D VDD VSS gf180mcu_fd_sc_mcu7t5v0__clkinv_1
XFILLER_121_883 VDD VSS VDD VSS gf180mcu_fd_sc_mcu7t5v0__fillcap_4
X_2071_ _2899_/B2 _4566_/Q VDD VSS _2075_/A2 _3158_/B _3157_/A1 VDD VSS gf180mcu_fd_sc_mcu7t5v0__nor4_1
XFILLER_19_352 VDD VSS VDD VSS gf180mcu_fd_sc_mcu7t5v0__fillcap_64
XFILLER_207_486 VDD VSS VDD VSS gf180mcu_fd_sc_mcu7t5v0__fillcap_4
XFILLER_34_311 VDD VSS VDD VSS gf180mcu_fd_sc_mcu7t5v0__fillcap_4
XFILLER_46_171 VDD VSS VDD VSS gf180mcu_fd_sc_mcu7t5v0__fillcap_4
XFILLER_179_327 VDD VSS VDD VSS gf180mcu_fd_sc_mcu7t5v0__fillcap_16
X_2973_ VDD VSS _2974_/A3 _3271_/C _2973_/A2 VDD VSS gf180mcu_fd_sc_mcu7t5v0__nand2_1
XFILLER_98_2 VDD VSS VDD VSS gf180mcu_fd_sc_mcu7t5v0__fillcap_32
X_1924_ VDD VSS wire93/I _2853_/C VDD VSS gf180mcu_fd_sc_mcu7t5v0__clkinv_1
XFILLER_187_393 VDD VSS VDD VSS gf180mcu_fd_sc_mcu7t5v0__fillcap_8
XFILLER_156_780 VDD VSS VDD VSS gf180mcu_fd_sc_mcu7t5v0__fillcap_16
X_4574_ _4574_/D _4574_/Q wire187/Z VSS _4574_/CLK VDD VDD VSS gf180mcu_fd_sc_mcu7t5v0__dffrnq_1
X_3525_ _3525_/B1 _3525_/B2 VDD VSS _4472_/D _3525_/A1 _3619_/C VDD VSS gf180mcu_fd_sc_mcu7t5v0__aoi22_1
XFILLER_171_772 VDD VSS VDD VSS gf180mcu_fd_sc_mcu7t5v0__fillcap_8
XFILLER_170_260 VDD VSS VDD VSS gf180mcu_fd_sc_mcu7t5v0__fillcap_32
XFILLER_89_517 VDD VSS VDD VSS gf180mcu_fd_sc_mcu7t5v0__fillcap_16
XFILLER_116_699 VDD VSS VDD VSS gf180mcu_fd_sc_mcu7t5v0__fillcap_16
X_3456_ VDD VSS _3457_/B2 _3456_/A1 _3619_/B1 VDD VSS gf180mcu_fd_sc_mcu7t5v0__nand2_1
X_3387_ wire56/I VDD VSS _4432_/D _4392_/Q _4432_/Q VDD VSS gf180mcu_fd_sc_mcu7t5v0__mux2_2
X_2407_ _2407_/B VDD VSS _4043_/D _3467_/A2 _2413_/S VDD VSS gf180mcu_fd_sc_mcu7t5v0__aoi21_1
X_2338_ VDD VSS _3004_/A2 _4330_/Q _4329_/Q VDD VSS gf180mcu_fd_sc_mcu7t5v0__nor2_1
XFILLER_97_594 VDD VSS VDD VSS gf180mcu_fd_sc_mcu7t5v0__fillcap_8
X_2269_ VDD VSS _2269_/Z _4609_/Q _4585_/D VDD VSS gf180mcu_fd_sc_mcu7t5v0__xor2_1
XFILLER_217_217 VDD VSS VDD VSS gf180mcu_fd_sc_mcu7t5v0__fillcap_16
XFILLER_38_661 VDD VSS VDD VSS gf180mcu_fd_sc_mcu7t5v0__fillcap_4
XFILLER_26_801 VDD VSS VDD VSS gf180mcu_fd_sc_mcu7t5v0__fillcap_4
X_4008_ VDD _4008_/Q _4583_/CLK VSS _4008_/D VDD VSS gf180mcu_fd_sc_mcu7t5v0__dffq_1
XFILLER_178_360 VDD VSS VDD VSS gf180mcu_fd_sc_mcu7t5v0__fillcap_8
XFILLER_224_6 VDD VSS VDD VSS gf180mcu_fd_sc_mcu7t5v0__fillcap_16
XFILLER_193_352 VDD VSS VDD VSS gf180mcu_fd_sc_mcu7t5v0__fillcap_16
XFILLER_181_536 VDD VSS VDD VSS gf180mcu_fd_sc_mcu7t5v0__fillcap_16
XFILLER_161_282 VDD VSS VDD VSS gf180mcu_fd_sc_mcu7t5v0__fillcap_8
XFILLER_0_410 VDD VSS VDD VSS gf180mcu_fd_sc_mcu7t5v0__fillcap_32
XFILLER_103_883 VDD VSS VDD VSS gf180mcu_fd_sc_mcu7t5v0__fillcap_4
XFILLER_236_515 VDD VSS VDD VSS gf180mcu_fd_sc_mcu7t5v0__fillcap_8
XFILLER_232_710 VDD VSS VDD VSS gf180mcu_fd_sc_mcu7t5v0__fillcap_16
XFILLER_90_247 VDD VSS VDD VSS gf180mcu_fd_sc_mcu7t5v0__fillcap_64
XFILLER_16_311 VDD VSS VDD VSS gf180mcu_fd_sc_mcu7t5v0__fillcap_4
XFILLER_28_171 VDD VSS VDD VSS gf180mcu_fd_sc_mcu7t5v0__fillcap_4
XFILLER_204_412 VDD VSS VDD VSS gf180mcu_fd_sc_mcu7t5v0__fillcap_4
XFILLER_45_72 VDD VSS VDD VSS gf180mcu_fd_sc_mcu7t5v0__fillcap_64
XFILLER_8_521 VDD VSS VDD VSS gf180mcu_fd_sc_mcu7t5v0__fillcap_4
XFILLER_185_875 VDD VSS VDD VSS gf180mcu_fd_sc_mcu7t5v0__fillcap_8
XFILLER_153_772 VDD VSS VDD VSS gf180mcu_fd_sc_mcu7t5v0__fillcap_8
XFILLER_153_761 VDD VSS VDD VSS gf180mcu_fd_sc_mcu7t5v0__fillcap_8
X_3310_ _3325_/B VDD VSS _4373_/D _3856_/Q _4373_/Q VDD VSS gf180mcu_fd_sc_mcu7t5v0__mux2_2
X_4290_ _4290_/D _4290_/Q _4525_/RN VSS _4338_/CLK VDD VDD VSS gf180mcu_fd_sc_mcu7t5v0__dffrnq_1
XFILLER_152_293 VDD VSS VDD VSS gf180mcu_fd_sc_mcu7t5v0__fillcap_4
X_3241_ _3241_/A2 _3240_/B _3241_/B2 VDD VSS _4354_/D _3241_/A1 VDD VSS gf180mcu_fd_sc_mcu7t5v0__oai22_1
X_3172_ VDD VSS _3173_/A3 _4336_/Q _3170_/B VDD VSS gf180mcu_fd_sc_mcu7t5v0__nor2_1
X_2123_ VDD VSS _2124_/A2 wire133/Z _2510_/A2 VDD VSS gf180mcu_fd_sc_mcu7t5v0__nand2_1
XFILLER_13_2 VDD VSS VDD VSS gf180mcu_fd_sc_mcu7t5v0__fillcap_64
XFILLER_94_597 VDD VSS VDD VSS gf180mcu_fd_sc_mcu7t5v0__fillcap_4
XFILLER_82_737 VDD VSS VDD VSS gf180mcu_fd_sc_mcu7t5v0__fillcap_8
XFILLER_223_710 VDD VSS VDD VSS gf180mcu_fd_sc_mcu7t5v0__fillcap_4
X_2054_ VDD VSS _2100_/A2 wire78/I _2051_/Z VDD VSS gf180mcu_fd_sc_mcu7t5v0__nor2_1
XFILLER_223_787 VDD VSS VDD VSS gf180mcu_fd_sc_mcu7t5v0__fillcap_4
XFILLER_50_667 VDD VSS VDD VSS gf180mcu_fd_sc_mcu7t5v0__fillcap_64
XFILLER_176_831 VDD VSS VDD VSS gf180mcu_fd_sc_mcu7t5v0__fillcap_4
X_2956_ VDD VSS _2957_/B _2829_/C _3201_/A2 VDD VSS gf180mcu_fd_sc_mcu7t5v0__nor2_1
X_2887_ _2887_/A3 VDD VSS _2888_/A2 _2887_/A1 _2869_/Z VDD VSS gf180mcu_fd_sc_mcu7t5v0__nor3_1
X_1907_ VDD VSS _4431_/Q _3386_/A1 VDD VSS gf180mcu_fd_sc_mcu7t5v0__clkinv_1
XFILLER_144_761 VDD VSS VDD VSS gf180mcu_fd_sc_mcu7t5v0__fillcap_32
X_4557_ _4557_/D _4557_/Q _4573_/RN VSS _4562_/CLK VDD VDD VSS gf180mcu_fd_sc_mcu7t5v0__dffrnq_1
XFILLER_131_422 VDD VSS VDD VSS gf180mcu_fd_sc_mcu7t5v0__fillcap_64
XFILLER_143_282 VDD VSS VDD VSS gf180mcu_fd_sc_mcu7t5v0__fillcap_16
X_4488_ _4488_/D _4488_/Q wire209/Z VSS _4494_/CLK VDD VDD VSS gf180mcu_fd_sc_mcu7t5v0__dffrnq_1
X_3508_ _4061_/Q VSS VDD _4045_/Q _4053_/Q wire88/I _4037_/Q wire83/I _3508_/Z VDD
+ VSS gf180mcu_fd_sc_mcu7t5v0__mux4_1
X_3439_ _3439_/B _3609_/C VDD VSS _3440_/A3 wire82/Z _3436_/Z VDD VSS gf180mcu_fd_sc_mcu7t5v0__oai211_1
XFILLER_72_247 VDD VSS VDD VSS gf180mcu_fd_sc_mcu7t5v0__fillcap_64
XFILLER_82_37 VDD VSS VDD VSS gf180mcu_fd_sc_mcu7t5v0__fillcap_64
XFILLER_241_562 VDD VSS VDD VSS gf180mcu_fd_sc_mcu7t5v0__fillcap_64
XFILLER_198_37 VDD VSS VDD VSS gf180mcu_fd_sc_mcu7t5v0__fillcap_64
XFILLER_139_500 VDD VSS VDD VSS gf180mcu_fd_sc_mcu7t5v0__fillcap_16
XFILLER_40_177 VDD VSS VDD VSS gf180mcu_fd_sc_mcu7t5v0__fillcap_64
XFILLER_194_661 VDD VSS VDD VSS gf180mcu_fd_sc_mcu7t5v0__fillcap_4
XFILLER_135_772 VDD VSS VDD VSS gf180mcu_fd_sc_mcu7t5v0__fillcap_4
Xoutput6 VDD _4512_/Q VSS irq_o_OUT VDD VSS gf180mcu_fd_sc_mcu7t5v0__dlyb_1
Xclkbuf_leaf_90_clk_i _4500_/CLK VSS VDD clkload1/I VDD VSS gf180mcu_fd_sc_mcu7t5v0__clkbuf_2
XFILLER_150_753 VDD VSS VDD VSS gf180mcu_fd_sc_mcu7t5v0__fillcap_8
XFILLER_96_807 VDD VSS VDD VSS gf180mcu_fd_sc_mcu7t5v0__fillcap_8
XFILLER_150_797 VDD VSS VDD VSS gf180mcu_fd_sc_mcu7t5v0__fillcap_8
XFILLER_0_240 VDD VSS VDD VSS gf180mcu_fd_sc_mcu7t5v0__fillcap_32
XFILLER_209_537 VDD VSS VDD VSS gf180mcu_fd_sc_mcu7t5v0__fillcap_16
XFILLER_263_142 VDD VSS VDD VSS gf180mcu_fd_sc_mcu7t5v0__fillcap_64
XFILLER_64_737 VDD VSS VDD VSS gf180mcu_fd_sc_mcu7t5v0__fillcap_64
XFILLER_76_597 VDD VSS VDD VSS gf180mcu_fd_sc_mcu7t5v0__fillcap_64
XFILLER_91_578 VDD VSS VDD VSS gf180mcu_fd_sc_mcu7t5v0__fillcap_4
XFILLER_260_871 VDD VSS VDD VSS gf180mcu_fd_sc_mcu7t5v0__fillcap_4
XFILLER_189_422 VDD VSS VDD VSS gf180mcu_fd_sc_mcu7t5v0__fillcap_16
XFILLER_149_308 VDD VSS VDD VSS gf180mcu_fd_sc_mcu7t5v0__fillcap_32
XFILLER_20_807 VDD VSS VDD VSS gf180mcu_fd_sc_mcu7t5v0__fillcap_64
XFILLER_32_667 VDD VSS VDD VSS gf180mcu_fd_sc_mcu7t5v0__fillcap_64
X_3790_ VDD VSS _3791_/B wire179/Z wire16/Z VDD VSS gf180mcu_fd_sc_mcu7t5v0__nor2_1
X_2810_ _4330_/Q _3039_/A1 VDD VSS _3023_/A3 _4328_/Q _2991_/C VDD VSS gf180mcu_fd_sc_mcu7t5v0__nor4_1
Xclkbuf_leaf_43_clk_i _4365_/CLK VSS VDD clkload6/I VDD VSS gf180mcu_fd_sc_mcu7t5v0__clkbuf_2
X_2741_ wire36/Z VDD VSS _4275_/D _4275_/Q wire127/Z VDD VSS gf180mcu_fd_sc_mcu7t5v0__mux2_2
XFILLER_157_352 VDD VSS VDD VSS gf180mcu_fd_sc_mcu7t5v0__fillcap_16
XFILLER_9_874 VDD VSS VDD VSS gf180mcu_fd_sc_mcu7t5v0__fillcap_16
X_2672_ VDD VSS _2673_/B wire166/Z _4503_/D VDD VSS gf180mcu_fd_sc_mcu7t5v0__nand2_1
X_4411_ _4411_/D _4411_/Q wire210/Z VSS _4485_/CLK VDD VDD VSS gf180mcu_fd_sc_mcu7t5v0__dffrnq_1
XFILLER_172_366 VDD VSS VDD VSS gf180mcu_fd_sc_mcu7t5v0__fillcap_8
X_4342_ _4342_/D _4342_/Q _4525_/RN VSS _4355_/CLK VDD VDD VSS gf180mcu_fd_sc_mcu7t5v0__dffrnq_1
Xclkbuf_leaf_58_clk_i _4364_/CLK VSS VDD clkload2/I VDD VSS gf180mcu_fd_sc_mcu7t5v0__clkbuf_2
XFILLER_113_411 VDD VSS VDD VSS gf180mcu_fd_sc_mcu7t5v0__fillcap_8
XFILLER_125_282 VDD VSS VDD VSS gf180mcu_fd_sc_mcu7t5v0__fillcap_8
XFILLER_141_764 VDD VSS VDD VSS gf180mcu_fd_sc_mcu7t5v0__fillcap_4
X_4273_ _4273_/D _4273_/Q _4284_/RN VSS _4330_/CLK VDD VDD VSS gf180mcu_fd_sc_mcu7t5v0__dffrnq_1
X_3224_ _2992_/C VDD VSS _3225_/B _3038_/C _3224_/A2 VDD VSS gf180mcu_fd_sc_mcu7t5v0__nand3_1
XFILLER_86_317 VDD VSS VDD VSS gf180mcu_fd_sc_mcu7t5v0__fillcap_64
XFILLER_98_177 VDD VSS VDD VSS gf180mcu_fd_sc_mcu7t5v0__fillcap_4
.ends
